* NGSPICE file created from bary_pipe_m.ext - technology: sky130A

* Black-box entry subcircuit for sky130_fd_sc_hd__nand2_1 abstract view
.subckt sky130_fd_sc_hd__nand2_1 A B VGND VNB VPB VPWR Y
.ends

* Black-box entry subcircuit for sky130_fd_sc_hd__a22o_1 abstract view
.subckt sky130_fd_sc_hd__a22o_1 A1 A2 B1 B2 VGND VNB VPB VPWR X
.ends

* Black-box entry subcircuit for sky130_fd_sc_hd__decap_8 abstract view
.subckt sky130_fd_sc_hd__decap_8 VGND VNB VPB VPWR
.ends

* Black-box entry subcircuit for sky130_fd_sc_hd__and2b_1 abstract view
.subckt sky130_fd_sc_hd__and2b_1 A_N B VGND VNB VPB VPWR X
.ends

* Black-box entry subcircuit for sky130_fd_sc_hd__decap_6 abstract view
.subckt sky130_fd_sc_hd__decap_6 VGND VNB VPB VPWR
.ends

* Black-box entry subcircuit for sky130_fd_sc_hd__and3_1 abstract view
.subckt sky130_fd_sc_hd__and3_1 A B C VGND VNB VPB VPWR X
.ends

* Black-box entry subcircuit for sky130_fd_sc_hd__decap_4 abstract view
.subckt sky130_fd_sc_hd__decap_4 VGND VNB VPB VPWR
.ends

* Black-box entry subcircuit for sky130_fd_sc_hd__a211o_1 abstract view
.subckt sky130_fd_sc_hd__a211o_1 A1 A2 B1 C1 VGND VNB VPB VPWR X
.ends

* Black-box entry subcircuit for sky130_fd_sc_hd__fill_2 abstract view
.subckt sky130_fd_sc_hd__fill_2 VGND VNB VPB VPWR
.ends

* Black-box entry subcircuit for sky130_fd_sc_hd__and4_1 abstract view
.subckt sky130_fd_sc_hd__and4_1 A B C D VGND VNB VPB VPWR X
.ends

* Black-box entry subcircuit for sky130_fd_sc_hd__fill_1 abstract view
.subckt sky130_fd_sc_hd__fill_1 VGND VNB VPB VPWR
.ends

* Black-box entry subcircuit for sky130_fd_sc_hd__decap_3 abstract view
.subckt sky130_fd_sc_hd__decap_3 VGND VNB VPB VPWR
.ends

* Black-box entry subcircuit for sky130_ef_sc_hd__decap_12 abstract view
.subckt sky130_ef_sc_hd__decap_12 VGND VNB VPB VPWR
.ends

* Black-box entry subcircuit for sky130_fd_sc_hd__a31o_1 abstract view
.subckt sky130_fd_sc_hd__a31o_1 A1 A2 A3 B1 VGND VNB VPB VPWR X
.ends

* Black-box entry subcircuit for sky130_fd_sc_hd__nand2_2 abstract view
.subckt sky130_fd_sc_hd__nand2_2 A B VGND VNB VPB VPWR Y
.ends

* Black-box entry subcircuit for sky130_fd_sc_hd__a21o_1 abstract view
.subckt sky130_fd_sc_hd__a21o_1 A1 A2 B1 VGND VNB VPB VPWR X
.ends

* Black-box entry subcircuit for sky130_fd_sc_hd__a211oi_2 abstract view
.subckt sky130_fd_sc_hd__a211oi_2 A1 A2 B1 C1 VGND VNB VPB VPWR Y
.ends

* Black-box entry subcircuit for sky130_fd_sc_hd__dlygate4sd3_1 abstract view
.subckt sky130_fd_sc_hd__dlygate4sd3_1 A VGND VNB VPB VPWR X
.ends

* Black-box entry subcircuit for sky130_fd_sc_hd__buf_2 abstract view
.subckt sky130_fd_sc_hd__buf_2 A VGND VNB VPB VPWR X
.ends

* Black-box entry subcircuit for sky130_fd_sc_hd__clkbuf_4 abstract view
.subckt sky130_fd_sc_hd__clkbuf_4 A VGND VNB VPB VPWR X
.ends

* Black-box entry subcircuit for sky130_fd_sc_hd__a21bo_1 abstract view
.subckt sky130_fd_sc_hd__a21bo_1 A1 A2 B1_N VGND VNB VPB VPWR X
.ends

* Black-box entry subcircuit for sky130_fd_sc_hd__mux2_1 abstract view
.subckt sky130_fd_sc_hd__mux2_1 A0 A1 S VGND VNB VPB VPWR X
.ends

* Black-box entry subcircuit for sky130_fd_sc_hd__dfxtp_1 abstract view
.subckt sky130_fd_sc_hd__dfxtp_1 CLK D VGND VNB VPB VPWR Q
.ends

* Black-box entry subcircuit for sky130_fd_sc_hd__tapvpwrvgnd_1 abstract view
.subckt sky130_fd_sc_hd__tapvpwrvgnd_1 VGND VPWR
.ends

* Black-box entry subcircuit for sky130_fd_sc_hd__a221o_1 abstract view
.subckt sky130_fd_sc_hd__a221o_1 A1 A2 B1 B2 C1 VGND VNB VPB VPWR X
.ends

* Black-box entry subcircuit for sky130_fd_sc_hd__nand4_4 abstract view
.subckt sky130_fd_sc_hd__nand4_4 A B C D VGND VNB VPB VPWR Y
.ends

* Black-box entry subcircuit for sky130_fd_sc_hd__a21o_2 abstract view
.subckt sky130_fd_sc_hd__a21o_2 A1 A2 B1 VGND VNB VPB VPWR X
.ends

* Black-box entry subcircuit for sky130_fd_sc_hd__o21ai_2 abstract view
.subckt sky130_fd_sc_hd__o21ai_2 A1 A2 B1 VGND VNB VPB VPWR Y
.ends

* Black-box entry subcircuit for sky130_fd_sc_hd__xnor2_4 abstract view
.subckt sky130_fd_sc_hd__xnor2_4 A B VGND VNB VPB VPWR Y
.ends

* Black-box entry subcircuit for sky130_fd_sc_hd__xnor2_1 abstract view
.subckt sky130_fd_sc_hd__xnor2_1 A B VGND VNB VPB VPWR Y
.ends

* Black-box entry subcircuit for sky130_fd_sc_hd__and2_1 abstract view
.subckt sky130_fd_sc_hd__and2_1 A B VGND VNB VPB VPWR X
.ends

* Black-box entry subcircuit for sky130_fd_sc_hd__nand3_1 abstract view
.subckt sky130_fd_sc_hd__nand3_1 A B C VGND VNB VPB VPWR Y
.ends

* Black-box entry subcircuit for sky130_fd_sc_hd__nor2_1 abstract view
.subckt sky130_fd_sc_hd__nor2_1 A B VGND VNB VPB VPWR Y
.ends

* Black-box entry subcircuit for sky130_fd_sc_hd__o211ai_2 abstract view
.subckt sky130_fd_sc_hd__o211ai_2 A1 A2 B1 C1 VGND VNB VPB VPWR Y
.ends

* Black-box entry subcircuit for sky130_fd_sc_hd__or2_1 abstract view
.subckt sky130_fd_sc_hd__or2_1 A B VGND VNB VPB VPWR X
.ends

* Black-box entry subcircuit for sky130_fd_sc_hd__nand3b_1 abstract view
.subckt sky130_fd_sc_hd__nand3b_1 A_N B C VGND VNB VPB VPWR Y
.ends

* Black-box entry subcircuit for sky130_fd_sc_hd__nor3_1 abstract view
.subckt sky130_fd_sc_hd__nor3_1 A B C VGND VNB VPB VPWR Y
.ends

* Black-box entry subcircuit for sky130_fd_sc_hd__a21oi_2 abstract view
.subckt sky130_fd_sc_hd__a21oi_2 A1 A2 B1 VGND VNB VPB VPWR Y
.ends

* Black-box entry subcircuit for sky130_fd_sc_hd__a211oi_4 abstract view
.subckt sky130_fd_sc_hd__a211oi_4 A1 A2 B1 C1 VGND VNB VPB VPWR Y
.ends

* Black-box entry subcircuit for sky130_fd_sc_hd__or2_2 abstract view
.subckt sky130_fd_sc_hd__or2_2 A B VGND VNB VPB VPWR X
.ends

* Black-box entry subcircuit for sky130_fd_sc_hd__buf_4 abstract view
.subckt sky130_fd_sc_hd__buf_4 A VGND VNB VPB VPWR X
.ends

* Black-box entry subcircuit for sky130_fd_sc_hd__dfrtp_1 abstract view
.subckt sky130_fd_sc_hd__dfrtp_1 CLK D RESET_B VGND VNB VPB VPWR Q
.ends

* Black-box entry subcircuit for sky130_fd_sc_hd__a22oi_1 abstract view
.subckt sky130_fd_sc_hd__a22oi_1 A1 A2 B1 B2 VGND VNB VPB VPWR Y
.ends

* Black-box entry subcircuit for sky130_fd_sc_hd__nand3_2 abstract view
.subckt sky130_fd_sc_hd__nand3_2 A B C VGND VNB VPB VPWR Y
.ends

* Black-box entry subcircuit for sky130_fd_sc_hd__o211a_1 abstract view
.subckt sky130_fd_sc_hd__o211a_1 A1 A2 B1 C1 VGND VNB VPB VPWR X
.ends

* Black-box entry subcircuit for sky130_fd_sc_hd__nand4_1 abstract view
.subckt sky130_fd_sc_hd__nand4_1 A B C D VGND VNB VPB VPWR Y
.ends

* Black-box entry subcircuit for sky130_fd_sc_hd__inv_2 abstract view
.subckt sky130_fd_sc_hd__inv_2 A VGND VNB VPB VPWR Y
.ends

* Black-box entry subcircuit for sky130_fd_sc_hd__a22oi_2 abstract view
.subckt sky130_fd_sc_hd__a22oi_2 A1 A2 B1 B2 VGND VNB VPB VPWR Y
.ends

* Black-box entry subcircuit for sky130_fd_sc_hd__a21boi_4 abstract view
.subckt sky130_fd_sc_hd__a21boi_4 A1 A2 B1_N VGND VNB VPB VPWR Y
.ends

* Black-box entry subcircuit for sky130_fd_sc_hd__o221a_1 abstract view
.subckt sky130_fd_sc_hd__o221a_1 A1 A2 B1 B2 C1 VGND VNB VPB VPWR X
.ends

* Black-box entry subcircuit for sky130_fd_sc_hd__o31ai_2 abstract view
.subckt sky130_fd_sc_hd__o31ai_2 A1 A2 A3 B1 VGND VNB VPB VPWR Y
.ends

* Black-box entry subcircuit for sky130_fd_sc_hd__xnor2_2 abstract view
.subckt sky130_fd_sc_hd__xnor2_2 A B VGND VNB VPB VPWR Y
.ends

* Black-box entry subcircuit for sky130_fd_sc_hd__or3_1 abstract view
.subckt sky130_fd_sc_hd__or3_1 A B C VGND VNB VPB VPWR X
.ends

* Black-box entry subcircuit for sky130_fd_sc_hd__clkbuf_2 abstract view
.subckt sky130_fd_sc_hd__clkbuf_2 A VGND VNB VPB VPWR X
.ends

* Black-box entry subcircuit for sky130_fd_sc_hd__buf_1 abstract view
.subckt sky130_fd_sc_hd__buf_1 A VGND VNB VPB VPWR X
.ends

* Black-box entry subcircuit for sky130_fd_sc_hd__dfxtp_4 abstract view
.subckt sky130_fd_sc_hd__dfxtp_4 CLK D VGND VNB VPB VPWR Q
.ends

* Black-box entry subcircuit for sky130_fd_sc_hd__or2_4 abstract view
.subckt sky130_fd_sc_hd__or2_4 A B VGND VNB VPB VPWR X
.ends

* Black-box entry subcircuit for sky130_fd_sc_hd__a211oi_1 abstract view
.subckt sky130_fd_sc_hd__a211oi_1 A1 A2 B1 C1 VGND VNB VPB VPWR Y
.ends

* Black-box entry subcircuit for sky130_fd_sc_hd__a21oi_1 abstract view
.subckt sky130_fd_sc_hd__a21oi_1 A1 A2 B1 VGND VNB VPB VPWR Y
.ends

* Black-box entry subcircuit for sky130_fd_sc_hd__a32o_1 abstract view
.subckt sky130_fd_sc_hd__a32o_1 A1 A2 A3 B1 B2 VGND VNB VPB VPWR X
.ends

* Black-box entry subcircuit for sky130_fd_sc_hd__o22a_1 abstract view
.subckt sky130_fd_sc_hd__o22a_1 A1 A2 B1 B2 VGND VNB VPB VPWR X
.ends

* Black-box entry subcircuit for sky130_fd_sc_hd__nand2_4 abstract view
.subckt sky130_fd_sc_hd__nand2_4 A B VGND VNB VPB VPWR Y
.ends

* Black-box entry subcircuit for sky130_fd_sc_hd__o211ai_1 abstract view
.subckt sky130_fd_sc_hd__o211ai_1 A1 A2 B1 C1 VGND VNB VPB VPWR Y
.ends

* Black-box entry subcircuit for sky130_fd_sc_hd__nand4_2 abstract view
.subckt sky130_fd_sc_hd__nand4_2 A B C D VGND VNB VPB VPWR Y
.ends

* Black-box entry subcircuit for sky130_fd_sc_hd__dfrtp_4 abstract view
.subckt sky130_fd_sc_hd__dfrtp_4 CLK D RESET_B VGND VNB VPB VPWR Q
.ends

* Black-box entry subcircuit for sky130_fd_sc_hd__conb_1 abstract view
.subckt sky130_fd_sc_hd__conb_1 VGND VNB VPB VPWR HI LO
.ends

* Black-box entry subcircuit for sky130_fd_sc_hd__or3_4 abstract view
.subckt sky130_fd_sc_hd__or3_4 A B C VGND VNB VPB VPWR X
.ends

* Black-box entry subcircuit for sky130_fd_sc_hd__clkbuf_1 abstract view
.subckt sky130_fd_sc_hd__clkbuf_1 A VGND VNB VPB VPWR X
.ends

* Black-box entry subcircuit for sky130_fd_sc_hd__o21bai_1 abstract view
.subckt sky130_fd_sc_hd__o21bai_1 A1 A2 B1_N VGND VNB VPB VPWR Y
.ends

* Black-box entry subcircuit for sky130_fd_sc_hd__or4bb_4 abstract view
.subckt sky130_fd_sc_hd__or4bb_4 A B C_N D_N VGND VNB VPB VPWR X
.ends

* Black-box entry subcircuit for sky130_fd_sc_hd__xor2_1 abstract view
.subckt sky130_fd_sc_hd__xor2_1 A B VGND VNB VPB VPWR X
.ends

* Black-box entry subcircuit for sky130_fd_sc_hd__diode_2 abstract view
.subckt sky130_fd_sc_hd__diode_2 DIODE VGND VNB VPB VPWR
.ends

* Black-box entry subcircuit for sky130_fd_sc_hd__xor2_2 abstract view
.subckt sky130_fd_sc_hd__xor2_2 A B VGND VNB VPB VPWR X
.ends

* Black-box entry subcircuit for sky130_fd_sc_hd__and3_2 abstract view
.subckt sky130_fd_sc_hd__and3_2 A B C VGND VNB VPB VPWR X
.ends

* Black-box entry subcircuit for sky130_fd_sc_hd__nand2b_1 abstract view
.subckt sky130_fd_sc_hd__nand2b_1 A_N B VGND VNB VPB VPWR Y
.ends

* Black-box entry subcircuit for sky130_fd_sc_hd__and2_2 abstract view
.subckt sky130_fd_sc_hd__and2_2 A B VGND VNB VPB VPWR X
.ends

* Black-box entry subcircuit for sky130_fd_sc_hd__o31a_1 abstract view
.subckt sky130_fd_sc_hd__o31a_1 A1 A2 A3 B1 VGND VNB VPB VPWR X
.ends

* Black-box entry subcircuit for sky130_fd_sc_hd__and4b_1 abstract view
.subckt sky130_fd_sc_hd__and4b_1 A_N B C D VGND VNB VPB VPWR X
.ends

* Black-box entry subcircuit for sky130_fd_sc_hd__a31o_4 abstract view
.subckt sky130_fd_sc_hd__a31o_4 A1 A2 A3 B1 VGND VNB VPB VPWR X
.ends

* Black-box entry subcircuit for sky130_fd_sc_hd__o21ai_1 abstract view
.subckt sky130_fd_sc_hd__o21ai_1 A1 A2 B1 VGND VNB VPB VPWR Y
.ends

* Black-box entry subcircuit for sky130_fd_sc_hd__o211ai_4 abstract view
.subckt sky130_fd_sc_hd__o211ai_4 A1 A2 B1 C1 VGND VNB VPB VPWR Y
.ends

* Black-box entry subcircuit for sky130_fd_sc_hd__and4bb_1 abstract view
.subckt sky130_fd_sc_hd__and4bb_1 A_N B_N C D VGND VNB VPB VPWR X
.ends

* Black-box entry subcircuit for sky130_fd_sc_hd__a2111o_1 abstract view
.subckt sky130_fd_sc_hd__a2111o_1 A1 A2 B1 C1 D1 VGND VNB VPB VPWR X
.ends

* Black-box entry subcircuit for sky130_fd_sc_hd__o21a_1 abstract view
.subckt sky130_fd_sc_hd__o21a_1 A1 A2 B1 VGND VNB VPB VPWR X
.ends

* Black-box entry subcircuit for sky130_fd_sc_hd__clkbuf_16 abstract view
.subckt sky130_fd_sc_hd__clkbuf_16 A VGND VNB VPB VPWR X
.ends

* Black-box entry subcircuit for sky130_fd_sc_hd__a21oi_4 abstract view
.subckt sky130_fd_sc_hd__a21oi_4 A1 A2 B1 VGND VNB VPB VPWR Y
.ends

* Black-box entry subcircuit for sky130_fd_sc_hd__nor2_2 abstract view
.subckt sky130_fd_sc_hd__nor2_2 A B VGND VNB VPB VPWR Y
.ends

* Black-box entry subcircuit for sky130_fd_sc_hd__o2bb2a_1 abstract view
.subckt sky130_fd_sc_hd__o2bb2a_1 A1_N A2_N B1 B2 VGND VNB VPB VPWR X
.ends

* Black-box entry subcircuit for sky130_fd_sc_hd__o21a_2 abstract view
.subckt sky130_fd_sc_hd__o21a_2 A1 A2 B1 VGND VNB VPB VPWR X
.ends

* Black-box entry subcircuit for sky130_fd_sc_hd__xor2_4 abstract view
.subckt sky130_fd_sc_hd__xor2_4 A B VGND VNB VPB VPWR X
.ends

* Black-box entry subcircuit for sky130_fd_sc_hd__dfrtp_2 abstract view
.subckt sky130_fd_sc_hd__dfrtp_2 CLK D RESET_B VGND VNB VPB VPWR Q
.ends

* Black-box entry subcircuit for sky130_fd_sc_hd__nand3_4 abstract view
.subckt sky130_fd_sc_hd__nand3_4 A B C VGND VNB VPB VPWR Y
.ends

* Black-box entry subcircuit for sky130_fd_sc_hd__o2bb2ai_1 abstract view
.subckt sky130_fd_sc_hd__o2bb2ai_1 A1_N A2_N B1 B2 VGND VNB VPB VPWR Y
.ends

* Black-box entry subcircuit for sky130_fd_sc_hd__a211o_2 abstract view
.subckt sky130_fd_sc_hd__a211o_2 A1 A2 B1 C1 VGND VNB VPB VPWR X
.ends

* Black-box entry subcircuit for sky130_fd_sc_hd__o211a_2 abstract view
.subckt sky130_fd_sc_hd__o211a_2 A1 A2 B1 C1 VGND VNB VPB VPWR X
.ends

* Black-box entry subcircuit for sky130_fd_sc_hd__a2111oi_1 abstract view
.subckt sky130_fd_sc_hd__a2111oi_1 A1 A2 B1 C1 D1 VGND VNB VPB VPWR Y
.ends

* Black-box entry subcircuit for sky130_fd_sc_hd__dlymetal6s2s_1 abstract view
.subckt sky130_fd_sc_hd__dlymetal6s2s_1 A VGND VNB VPB VPWR X
.ends

* Black-box entry subcircuit for sky130_fd_sc_hd__buf_6 abstract view
.subckt sky130_fd_sc_hd__buf_6 A VGND VNB VPB VPWR X
.ends

* Black-box entry subcircuit for sky130_fd_sc_hd__o21ba_1 abstract view
.subckt sky130_fd_sc_hd__o21ba_1 A1 A2 B1_N VGND VNB VPB VPWR X
.ends

* Black-box entry subcircuit for sky130_fd_sc_hd__or4_1 abstract view
.subckt sky130_fd_sc_hd__or4_1 A B C D VGND VNB VPB VPWR X
.ends

* Black-box entry subcircuit for sky130_fd_sc_hd__nand2b_4 abstract view
.subckt sky130_fd_sc_hd__nand2b_4 A_N B VGND VNB VPB VPWR Y
.ends

* Black-box entry subcircuit for sky130_fd_sc_hd__o22ai_2 abstract view
.subckt sky130_fd_sc_hd__o22ai_2 A1 A2 B1 B2 VGND VNB VPB VPWR Y
.ends

* Black-box entry subcircuit for sky130_fd_sc_hd__nor4_1 abstract view
.subckt sky130_fd_sc_hd__nor4_1 A B C D VGND VNB VPB VPWR Y
.ends

* Black-box entry subcircuit for sky130_fd_sc_hd__o32a_2 abstract view
.subckt sky130_fd_sc_hd__o32a_2 A1 A2 A3 B1 B2 VGND VNB VPB VPWR X
.ends

* Black-box entry subcircuit for sky130_fd_sc_hd__nor2_4 abstract view
.subckt sky130_fd_sc_hd__nor2_4 A B VGND VNB VPB VPWR Y
.ends

* Black-box entry subcircuit for sky130_fd_sc_hd__nor3_2 abstract view
.subckt sky130_fd_sc_hd__nor3_2 A B C VGND VNB VPB VPWR Y
.ends

* Black-box entry subcircuit for sky130_fd_sc_hd__nor3b_2 abstract view
.subckt sky130_fd_sc_hd__nor3b_2 A B C_N VGND VNB VPB VPWR Y
.ends

* Black-box entry subcircuit for sky130_fd_sc_hd__a31o_2 abstract view
.subckt sky130_fd_sc_hd__a31o_2 A1 A2 A3 B1 VGND VNB VPB VPWR X
.ends

* Black-box entry subcircuit for sky130_fd_sc_hd__or4_2 abstract view
.subckt sky130_fd_sc_hd__or4_2 A B C D VGND VNB VPB VPWR X
.ends

* Black-box entry subcircuit for sky130_fd_sc_hd__nor3b_1 abstract view
.subckt sky130_fd_sc_hd__nor3b_1 A B C_N VGND VNB VPB VPWR Y
.ends

* Black-box entry subcircuit for sky130_fd_sc_hd__a2bb2o_1 abstract view
.subckt sky130_fd_sc_hd__a2bb2o_1 A1_N A2_N B1 B2 VGND VNB VPB VPWR X
.ends

* Black-box entry subcircuit for sky130_fd_sc_hd__dfxtp_2 abstract view
.subckt sky130_fd_sc_hd__dfxtp_2 CLK D VGND VNB VPB VPWR Q
.ends

* Black-box entry subcircuit for sky130_fd_sc_hd__o32a_1 abstract view
.subckt sky130_fd_sc_hd__o32a_1 A1 A2 A3 B1 B2 VGND VNB VPB VPWR X
.ends

* Black-box entry subcircuit for sky130_fd_sc_hd__o21ai_4 abstract view
.subckt sky130_fd_sc_hd__o21ai_4 A1 A2 B1 VGND VNB VPB VPWR Y
.ends

* Black-box entry subcircuit for sky130_fd_sc_hd__nand3b_2 abstract view
.subckt sky130_fd_sc_hd__nand3b_2 A_N B C VGND VNB VPB VPWR Y
.ends

* Black-box entry subcircuit for sky130_fd_sc_hd__dfstp_1 abstract view
.subckt sky130_fd_sc_hd__dfstp_1 CLK D SET_B VGND VNB VPB VPWR Q
.ends

* Black-box entry subcircuit for sky130_fd_sc_hd__o22ai_4 abstract view
.subckt sky130_fd_sc_hd__o22ai_4 A1 A2 B1 B2 VGND VNB VPB VPWR Y
.ends

* Black-box entry subcircuit for sky130_fd_sc_hd__nand2b_2 abstract view
.subckt sky130_fd_sc_hd__nand2b_2 A_N B VGND VNB VPB VPWR Y
.ends

* Black-box entry subcircuit for sky130_fd_sc_hd__o21bai_4 abstract view
.subckt sky130_fd_sc_hd__o21bai_4 A1 A2 B1_N VGND VNB VPB VPWR Y
.ends

* Black-box entry subcircuit for sky130_fd_sc_hd__a2111o_2 abstract view
.subckt sky130_fd_sc_hd__a2111o_2 A1 A2 B1 C1 D1 VGND VNB VPB VPWR X
.ends

* Black-box entry subcircuit for sky130_fd_sc_hd__clkbuf_8 abstract view
.subckt sky130_fd_sc_hd__clkbuf_8 A VGND VNB VPB VPWR X
.ends

* Black-box entry subcircuit for sky130_fd_sc_hd__or4_4 abstract view
.subckt sky130_fd_sc_hd__or4_4 A B C D VGND VNB VPB VPWR X
.ends

* Black-box entry subcircuit for sky130_fd_sc_hd__or3b_1 abstract view
.subckt sky130_fd_sc_hd__or3b_1 A B C_N VGND VNB VPB VPWR X
.ends

* Black-box entry subcircuit for sky130_fd_sc_hd__a21bo_2 abstract view
.subckt sky130_fd_sc_hd__a21bo_2 A1 A2 B1_N VGND VNB VPB VPWR X
.ends

* Black-box entry subcircuit for sky130_fd_sc_hd__o22ai_1 abstract view
.subckt sky130_fd_sc_hd__o22ai_1 A1 A2 B1 B2 VGND VNB VPB VPWR Y
.ends

* Black-box entry subcircuit for sky130_fd_sc_hd__nor3_4 abstract view
.subckt sky130_fd_sc_hd__nor3_4 A B C VGND VNB VPB VPWR Y
.ends

* Black-box entry subcircuit for sky130_fd_sc_hd__and4b_2 abstract view
.subckt sky130_fd_sc_hd__and4b_2 A_N B C D VGND VNB VPB VPWR X
.ends

* Black-box entry subcircuit for sky130_fd_sc_hd__o21ba_2 abstract view
.subckt sky130_fd_sc_hd__o21ba_2 A1 A2 B1_N VGND VNB VPB VPWR X
.ends

* Black-box entry subcircuit for sky130_fd_sc_hd__or4b_2 abstract view
.subckt sky130_fd_sc_hd__or4b_2 A B C D_N VGND VNB VPB VPWR X
.ends

* Black-box entry subcircuit for sky130_fd_sc_hd__and2_4 abstract view
.subckt sky130_fd_sc_hd__and2_4 A B VGND VNB VPB VPWR X
.ends

* Black-box entry subcircuit for sky130_fd_sc_hd__or4bb_2 abstract view
.subckt sky130_fd_sc_hd__or4bb_2 A B C_N D_N VGND VNB VPB VPWR X
.ends

* Black-box entry subcircuit for sky130_fd_sc_hd__a31oi_2 abstract view
.subckt sky130_fd_sc_hd__a31oi_2 A1 A2 A3 B1 VGND VNB VPB VPWR Y
.ends

* Black-box entry subcircuit for sky130_fd_sc_hd__nand3b_4 abstract view
.subckt sky130_fd_sc_hd__nand3b_4 A_N B C VGND VNB VPB VPWR Y
.ends

* Black-box entry subcircuit for sky130_fd_sc_hd__and3b_1 abstract view
.subckt sky130_fd_sc_hd__and3b_1 A_N B C VGND VNB VPB VPWR X
.ends

* Black-box entry subcircuit for sky130_fd_sc_hd__o211a_4 abstract view
.subckt sky130_fd_sc_hd__o211a_4 A1 A2 B1 C1 VGND VNB VPB VPWR X
.ends

* Black-box entry subcircuit for sky130_fd_sc_hd__or3b_4 abstract view
.subckt sky130_fd_sc_hd__or3b_4 A B C_N VGND VNB VPB VPWR X
.ends

* Black-box entry subcircuit for sky130_fd_sc_hd__or3_2 abstract view
.subckt sky130_fd_sc_hd__or3_2 A B C VGND VNB VPB VPWR X
.ends

* Black-box entry subcircuit for sky130_fd_sc_hd__a31oi_1 abstract view
.subckt sky130_fd_sc_hd__a31oi_1 A1 A2 A3 B1 VGND VNB VPB VPWR Y
.ends

* Black-box entry subcircuit for sky130_fd_sc_hd__a22oi_4 abstract view
.subckt sky130_fd_sc_hd__a22oi_4 A1 A2 B1 B2 VGND VNB VPB VPWR Y
.ends

* Black-box entry subcircuit for sky130_fd_sc_hd__o41a_1 abstract view
.subckt sky130_fd_sc_hd__o41a_1 A1 A2 A3 A4 B1 VGND VNB VPB VPWR X
.ends

* Black-box entry subcircuit for sky130_fd_sc_hd__nor4_2 abstract view
.subckt sky130_fd_sc_hd__nor4_2 A B C D VGND VNB VPB VPWR Y
.ends

* Black-box entry subcircuit for sky130_fd_sc_hd__o31a_2 abstract view
.subckt sky130_fd_sc_hd__o31a_2 A1 A2 A3 B1 VGND VNB VPB VPWR X
.ends

* Black-box entry subcircuit for sky130_fd_sc_hd__or4bb_1 abstract view
.subckt sky130_fd_sc_hd__or4bb_1 A B C_N D_N VGND VNB VPB VPWR X
.ends

* Black-box entry subcircuit for sky130_fd_sc_hd__and2b_2 abstract view
.subckt sky130_fd_sc_hd__and2b_2 A_N B VGND VNB VPB VPWR X
.ends

* Black-box entry subcircuit for sky130_fd_sc_hd__a21boi_2 abstract view
.subckt sky130_fd_sc_hd__a21boi_2 A1 A2 B1_N VGND VNB VPB VPWR Y
.ends

* Black-box entry subcircuit for sky130_fd_sc_hd__o21bai_2 abstract view
.subckt sky130_fd_sc_hd__o21bai_2 A1 A2 B1_N VGND VNB VPB VPWR Y
.ends

* Black-box entry subcircuit for sky130_fd_sc_hd__nor3b_4 abstract view
.subckt sky130_fd_sc_hd__nor3b_4 A B C_N VGND VNB VPB VPWR Y
.ends

* Black-box entry subcircuit for sky130_fd_sc_hd__and3b_2 abstract view
.subckt sky130_fd_sc_hd__and3b_2 A_N B C VGND VNB VPB VPWR X
.ends

* Black-box entry subcircuit for sky130_fd_sc_hd__a32oi_4 abstract view
.subckt sky130_fd_sc_hd__a32oi_4 A1 A2 A3 B1 B2 VGND VNB VPB VPWR Y
.ends

* Black-box entry subcircuit for sky130_fd_sc_hd__and4_2 abstract view
.subckt sky130_fd_sc_hd__and4_2 A B C D VGND VNB VPB VPWR X
.ends

* Black-box entry subcircuit for sky130_fd_sc_hd__a2bb2oi_1 abstract view
.subckt sky130_fd_sc_hd__a2bb2oi_1 A1_N A2_N B1 B2 VGND VNB VPB VPWR Y
.ends

* Black-box entry subcircuit for sky130_fd_sc_hd__o31ai_4 abstract view
.subckt sky130_fd_sc_hd__o31ai_4 A1 A2 A3 B1 VGND VNB VPB VPWR Y
.ends

* Black-box entry subcircuit for sky130_fd_sc_hd__and4bb_2 abstract view
.subckt sky130_fd_sc_hd__and4bb_2 A_N B_N C D VGND VNB VPB VPWR X
.ends

* Black-box entry subcircuit for sky130_fd_sc_hd__a41o_1 abstract view
.subckt sky130_fd_sc_hd__a41o_1 A1 A2 A3 A4 B1 VGND VNB VPB VPWR X
.ends

* Black-box entry subcircuit for sky130_fd_sc_hd__o32ai_2 abstract view
.subckt sky130_fd_sc_hd__o32ai_2 A1 A2 A3 B1 B2 VGND VNB VPB VPWR Y
.ends

* Black-box entry subcircuit for sky130_fd_sc_hd__or4b_4 abstract view
.subckt sky130_fd_sc_hd__or4b_4 A B C D_N VGND VNB VPB VPWR X
.ends

* Black-box entry subcircuit for sky130_fd_sc_hd__a21boi_1 abstract view
.subckt sky130_fd_sc_hd__a21boi_1 A1 A2 B1_N VGND VNB VPB VPWR Y
.ends

* Black-box entry subcircuit for sky130_fd_sc_hd__o311a_1 abstract view
.subckt sky130_fd_sc_hd__o311a_1 A1 A2 A3 B1 C1 VGND VNB VPB VPWR X
.ends

* Black-box entry subcircuit for sky130_fd_sc_hd__a311o_2 abstract view
.subckt sky130_fd_sc_hd__a311o_2 A1 A2 A3 B1 C1 VGND VNB VPB VPWR X
.ends

* Black-box entry subcircuit for sky130_fd_sc_hd__or3b_2 abstract view
.subckt sky130_fd_sc_hd__or3b_2 A B C_N VGND VNB VPB VPWR X
.ends

* Black-box entry subcircuit for sky130_fd_sc_hd__a311o_4 abstract view
.subckt sky130_fd_sc_hd__a311o_4 A1 A2 A3 B1 C1 VGND VNB VPB VPWR X
.ends

* Black-box entry subcircuit for sky130_fd_sc_hd__o221a_2 abstract view
.subckt sky130_fd_sc_hd__o221a_2 A1 A2 B1 B2 C1 VGND VNB VPB VPWR X
.ends

* Black-box entry subcircuit for sky130_fd_sc_hd__o2111a_1 abstract view
.subckt sky130_fd_sc_hd__o2111a_1 A1 A2 B1 C1 D1 VGND VNB VPB VPWR X
.ends

* Black-box entry subcircuit for sky130_fd_sc_hd__or4b_1 abstract view
.subckt sky130_fd_sc_hd__or4b_1 A B C D_N VGND VNB VPB VPWR X
.ends

.subckt bary_pipe_m busy_o clk_i discard_o div_mstream_i div_mstream_o[0] div_mstream_o[10]
+ div_mstream_o[11] div_mstream_o[12] div_mstream_o[13] div_mstream_o[14] div_mstream_o[15]
+ div_mstream_o[16] div_mstream_o[17] div_mstream_o[18] div_mstream_o[19] div_mstream_o[1]
+ div_mstream_o[20] div_mstream_o[21] div_mstream_o[22] div_mstream_o[23] div_mstream_o[24]
+ div_mstream_o[25] div_mstream_o[26] div_mstream_o[27] div_mstream_o[28] div_mstream_o[29]
+ div_mstream_o[2] div_mstream_o[30] div_mstream_o[31] div_mstream_o[32] div_mstream_o[33]
+ div_mstream_o[34] div_mstream_o[35] div_mstream_o[36] div_mstream_o[37] div_mstream_o[38]
+ div_mstream_o[39] div_mstream_o[3] div_mstream_o[40] div_mstream_o[41] div_mstream_o[42]
+ div_mstream_o[43] div_mstream_o[44] div_mstream_o[45] div_mstream_o[46] div_mstream_o[47]
+ div_mstream_o[4] div_mstream_o[50] div_mstream_o[51] div_mstream_o[52] div_mstream_o[53]
+ div_mstream_o[54] div_mstream_o[55] div_mstream_o[56] div_mstream_o[57] div_mstream_o[5]
+ div_mstream_o[60] div_mstream_o[61] div_mstream_o[62] div_mstream_o[63] div_mstream_o[64]
+ div_mstream_o[65] div_mstream_o[66] div_mstream_o[67] div_mstream_o[68] div_mstream_o[69]
+ div_mstream_o[6] div_mstream_o[70] div_mstream_o[71] div_mstream_o[72] div_mstream_o[73]
+ div_mstream_o[74] div_mstream_o[75] div_mstream_o[76] div_mstream_o[77] div_mstream_o[78]
+ div_mstream_o[79] div_mstream_o[7] div_mstream_o[80] div_mstream_o[81] div_mstream_o[82]
+ div_mstream_o[83] div_mstream_o[84] div_mstream_o[85] div_mstream_o[86] div_mstream_o[87]
+ div_mstream_o[88] div_mstream_o[89] div_mstream_o[8] div_mstream_o[90] div_mstream_o[91]
+ div_mstream_o[92] div_mstream_o[93] div_mstream_o[94] div_mstream_o[95] div_mstream_o[96]
+ div_mstream_o[97] div_mstream_o[9] div_sstream_i[0] div_sstream_i[10] div_sstream_i[11]
+ div_sstream_i[12] div_sstream_i[13] div_sstream_i[14] div_sstream_i[15] div_sstream_i[16]
+ div_sstream_i[17] div_sstream_i[18] div_sstream_i[19] div_sstream_i[1] div_sstream_i[20]
+ div_sstream_i[21] div_sstream_i[22] div_sstream_i[23] div_sstream_i[24] div_sstream_i[25]
+ div_sstream_i[26] div_sstream_i[27] div_sstream_i[28] div_sstream_i[29] div_sstream_i[2]
+ div_sstream_i[30] div_sstream_i[31] div_sstream_i[32] div_sstream_i[33] div_sstream_i[34]
+ div_sstream_i[35] div_sstream_i[36] div_sstream_i[37] div_sstream_i[38] div_sstream_i[39]
+ div_sstream_i[3] div_sstream_i[40] div_sstream_i[41] div_sstream_i[42] div_sstream_i[43]
+ div_sstream_i[44] div_sstream_i[45] div_sstream_i[46] div_sstream_i[47] div_sstream_i[48]
+ div_sstream_i[49] div_sstream_i[4] div_sstream_i[5] div_sstream_i[6] div_sstream_i[7]
+ div_sstream_i[8] div_sstream_i[9] div_sstream_o init_o mstream_i mstream_o[0] mstream_o[100]
+ mstream_o[101] mstream_o[102] mstream_o[103] mstream_o[104] mstream_o[105] mstream_o[106]
+ mstream_o[107] mstream_o[108] mstream_o[109] mstream_o[10] mstream_o[110] mstream_o[111]
+ mstream_o[112] mstream_o[113] mstream_o[114] mstream_o[115] mstream_o[11] mstream_o[12]
+ mstream_o[13] mstream_o[14] mstream_o[15] mstream_o[16] mstream_o[17] mstream_o[18]
+ mstream_o[19] mstream_o[1] mstream_o[20] mstream_o[21] mstream_o[22] mstream_o[23]
+ mstream_o[24] mstream_o[25] mstream_o[26] mstream_o[27] mstream_o[28] mstream_o[29]
+ mstream_o[2] mstream_o[30] mstream_o[31] mstream_o[32] mstream_o[33] mstream_o[34]
+ mstream_o[35] mstream_o[36] mstream_o[37] mstream_o[38] mstream_o[39] mstream_o[3]
+ mstream_o[40] mstream_o[41] mstream_o[42] mstream_o[43] mstream_o[44] mstream_o[45]
+ mstream_o[46] mstream_o[47] mstream_o[48] mstream_o[49] mstream_o[4] mstream_o[50]
+ mstream_o[51] mstream_o[52] mstream_o[53] mstream_o[54] mstream_o[55] mstream_o[56]
+ mstream_o[57] mstream_o[58] mstream_o[59] mstream_o[5] mstream_o[60] mstream_o[61]
+ mstream_o[62] mstream_o[63] mstream_o[64] mstream_o[65] mstream_o[66] mstream_o[67]
+ mstream_o[68] mstream_o[69] mstream_o[6] mstream_o[70] mstream_o[71] mstream_o[72]
+ mstream_o[73] mstream_o[74] mstream_o[75] mstream_o[76] mstream_o[77] mstream_o[78]
+ mstream_o[79] mstream_o[7] mstream_o[80] mstream_o[81] mstream_o[82] mstream_o[83]
+ mstream_o[84] mstream_o[85] mstream_o[86] mstream_o[87] mstream_o[88] mstream_o[89]
+ mstream_o[8] mstream_o[90] mstream_o[91] mstream_o[92] mstream_o[93] mstream_o[94]
+ mstream_o[95] mstream_o[96] mstream_o[97] mstream_o[98] mstream_o[99] mstream_o[9]
+ nrst_i run_i sstream_i[0] sstream_i[10] sstream_i[11] sstream_i[12] sstream_i[13]
+ sstream_i[14] sstream_i[15] sstream_i[16] sstream_i[17] sstream_i[18] sstream_i[19]
+ sstream_i[1] sstream_i[2] sstream_i[3] sstream_i[4] sstream_i[5] sstream_i[6] sstream_i[7]
+ sstream_i[8] sstream_i[9] sstream_o v0x[0] v0x[10] v0x[11] v0x[12] v0x[13] v0x[14]
+ v0x[15] v0x[16] v0x[17] v0x[18] v0x[19] v0x[1] v0x[20] v0x[21] v0x[22] v0x[23] v0x[24]
+ v0x[25] v0x[26] v0x[27] v0x[28] v0x[29] v0x[2] v0x[30] v0x[31] v0x[3] v0x[4] v0x[5]
+ v0x[6] v0x[7] v0x[8] v0x[9] v0y[0] v0y[10] v0y[11] v0y[12] v0y[13] v0y[14] v0y[15]
+ v0y[16] v0y[17] v0y[18] v0y[19] v0y[1] v0y[20] v0y[21] v0y[22] v0y[23] v0y[24] v0y[25]
+ v0y[26] v0y[27] v0y[28] v0y[29] v0y[2] v0y[30] v0y[31] v0y[3] v0y[4] v0y[5] v0y[6]
+ v0y[7] v0y[8] v0y[9] v1x[0] v1x[10] v1x[11] v1x[12] v1x[13] v1x[14] v1x[15] v1x[16]
+ v1x[17] v1x[18] v1x[19] v1x[1] v1x[20] v1x[21] v1x[22] v1x[23] v1x[24] v1x[25] v1x[26]
+ v1x[27] v1x[28] v1x[29] v1x[2] v1x[30] v1x[31] v1x[3] v1x[4] v1x[5] v1x[6] v1x[7]
+ v1x[8] v1x[9] v1y[0] v1y[10] v1y[11] v1y[12] v1y[13] v1y[14] v1y[15] v1y[16] v1y[17]
+ v1y[18] v1y[19] v1y[1] v1y[20] v1y[21] v1y[22] v1y[23] v1y[24] v1y[25] v1y[26] v1y[27]
+ v1y[28] v1y[29] v1y[2] v1y[30] v1y[31] v1y[3] v1y[4] v1y[5] v1y[6] v1y[7] v1y[8]
+ v1y[9] v2x[0] v2x[10] v2x[11] v2x[12] v2x[13] v2x[14] v2x[15] v2x[16] v2x[17] v2x[18]
+ v2x[19] v2x[1] v2x[20] v2x[21] v2x[22] v2x[23] v2x[24] v2x[25] v2x[26] v2x[27] v2x[28]
+ v2x[29] v2x[2] v2x[30] v2x[31] v2x[3] v2x[4] v2x[5] v2x[6] v2x[7] v2x[8] v2x[9]
+ v2y[0] v2y[10] v2y[11] v2y[12] v2y[13] v2y[14] v2y[15] v2y[16] v2y[17] v2y[18] v2y[19]
+ v2y[1] v2y[20] v2y[21] v2y[22] v2y[23] v2y[24] v2y[25] v2y[26] v2y[27] v2y[28] v2y[29]
+ v2y[2] v2y[30] v2y[31] v2y[3] v2y[4] v2y[5] v2y[6] v2y[7] v2y[8] v2y[9] vccd1 vssd1
+ div_mstream_o[58] div_mstream_o[49] div_mstream_o[48] div_mstream_o[59]
X_09671_ net1093 net719 vssd1 vssd1 vccd1 vccd1 _03779_ sky130_fd_sc_hd__nand2_1
X_06883_ state\[3\] _00983_ _01008_ _01010_ vssd1 vssd1 vccd1 vccd1 _00120_ sky130_fd_sc_hd__a22o_1
X_08622_ net1052 net812 vssd1 vssd1 vccd1 vccd1 _02737_ sky130_fd_sc_hd__nand2_1
XFILLER_0_76_100 vssd1 vssd1 vccd1 vccd1 sky130_fd_sc_hd__decap_8
X_08553_ _02545_ _02668_ vssd1 vssd1 vccd1 vccd1 _02669_ sky130_fd_sc_hd__and2b_1
XFILLER_0_49_314 vssd1 vssd1 vccd1 vccd1 sky130_fd_sc_hd__decap_6
X_08484_ net1044 net1051 net815 vssd1 vssd1 vccd1 vccd1 _02600_ sky130_fd_sc_hd__and3_1
XFILLER_0_77_667 vssd1 vssd1 vccd1 vccd1 sky130_fd_sc_hd__decap_4
X_07504_ _01593_ _01620_ _01621_ _01624_ vssd1 vssd1 vccd1 vccd1 _01629_ sky130_fd_sc_hd__a211o_1
XFILLER_0_92_626 vssd1 vssd1 vccd1 vccd1 sky130_fd_sc_hd__decap_4
XFILLER_0_65_829 vssd1 vssd1 vccd1 vccd1 sky130_fd_sc_hd__fill_2
X_07435_ net904 net1119 _01558_ _01559_ vssd1 vssd1 vccd1 vccd1 _01560_ sky130_fd_sc_hd__and4_1
XFILLER_0_119_279 vssd1 vssd1 vccd1 vccd1 sky130_fd_sc_hd__fill_1
XFILLER_0_91_169 vssd1 vssd1 vccd1 vccd1 sky130_fd_sc_hd__decap_3
XFILLER_0_72_350 vssd1 vssd1 vccd1 vccd1 sky130_ef_sc_hd__decap_12
X_07366_ net854 net1143 _01489_ _01487_ vssd1 vssd1 vccd1 vccd1 _01491_ sky130_fd_sc_hd__a31o_1
XFILLER_0_115_441 vssd1 vssd1 vccd1 vccd1 sky130_fd_sc_hd__decap_6
X_09105_ _03215_ _03216_ vssd1 vssd1 vccd1 vccd1 _03217_ sky130_fd_sc_hd__and2b_1
X_06317_ _00627_ _00628_ vssd1 vssd1 vccd1 vccd1 _00629_ sky130_fd_sc_hd__nand2_2
X_07297_ _01278_ _01415_ _01414_ vssd1 vssd1 vccd1 vccd1 _01422_ sky130_fd_sc_hd__a21o_1
XFILLER_0_115_485 vssd1 vssd1 vccd1 vccd1 sky130_ef_sc_hd__decap_12
X_09036_ _03025_ _03029_ _03145_ _03146_ vssd1 vssd1 vccd1 vccd1 _03148_ sky130_fd_sc_hd__a211oi_2
XFILLER_0_103_647 vssd1 vssd1 vccd1 vccd1 sky130_fd_sc_hd__fill_1
XFILLER_0_60_589 vssd1 vssd1 vccd1 vccd1 sky130_fd_sc_hd__decap_8
XFILLER_0_130_477 vssd1 vssd1 vccd1 vccd1 sky130_fd_sc_hd__decap_3
Xhold351 l1\[15\] vssd1 vssd1 vccd1 vccd1 net1566 sky130_fd_sc_hd__dlygate4sd3_1
Xhold362 x0mx2\[5\] vssd1 vssd1 vccd1 vccd1 net1577 sky130_fd_sc_hd__dlygate4sd3_1
Xhold340 y2my0\[13\] vssd1 vssd1 vccd1 vccd1 net1555 sky130_fd_sc_hd__dlygate4sd3_1
Xhold384 add1.b_i\[3\] vssd1 vssd1 vccd1 vccd1 net1599 sky130_fd_sc_hd__dlygate4sd3_1
Xhold373 net368 vssd1 vssd1 vccd1 vccd1 net1588 sky130_fd_sc_hd__dlygate4sd3_1
Xhold395 mul1.a\[30\] vssd1 vssd1 vccd1 vccd1 net1610 sky130_fd_sc_hd__dlygate4sd3_1
X_09938_ _04043_ _04044_ vssd1 vssd1 vccd1 vccd1 _04045_ sky130_fd_sc_hd__nand2_1
Xfanout842 net844 vssd1 vssd1 vccd1 vccd1 net842 sky130_fd_sc_hd__buf_2
Xfanout831 mul1.b\[11\] vssd1 vssd1 vccd1 vccd1 net831 sky130_fd_sc_hd__clkbuf_4
Xfanout820 mul1.b\[12\] vssd1 vssd1 vccd1 vccd1 net820 sky130_fd_sc_hd__buf_2
Xfanout864 net865 vssd1 vssd1 vccd1 vccd1 net864 sky130_fd_sc_hd__buf_2
Xfanout875 net876 vssd1 vssd1 vccd1 vccd1 net875 sky130_fd_sc_hd__clkbuf_4
Xfanout853 mul1.b\[9\] vssd1 vssd1 vccd1 vccd1 net853 sky130_fd_sc_hd__clkbuf_4
XFILLER_0_99_225 vssd1 vssd1 vccd1 vccd1 sky130_ef_sc_hd__decap_12
X_09869_ _03972_ _03973_ _03974_ vssd1 vssd1 vccd1 vccd1 _03976_ sky130_fd_sc_hd__a21bo_1
Xfanout897 net900 vssd1 vssd1 vccd1 vccd1 net897 sky130_fd_sc_hd__buf_2
Xfanout886 mul1.b\[5\] vssd1 vssd1 vccd1 vccd1 net886 sky130_fd_sc_hd__clkbuf_4
X_11900_ net1676 _05929_ net483 vssd1 vssd1 vccd1 vccd1 _00218_ sky130_fd_sc_hd__mux2_1
X_12880_ clknet_leaf_46_clk_i _00266_ vssd1 vssd1 vccd1 vccd1 mul1.a\[15\] sky130_fd_sc_hd__dfxtp_1
XTAP_1800 vssd1 vccd1 sky130_fd_sc_hd__tapvpwrvgnd_1
X_11831_ temp1\[21\] net615 net610 net199 vssd1 vssd1 vccd1 vccd1 _05871_ sky130_fd_sc_hd__a22o_1
XTAP_1833 vssd1 vccd1 sky130_fd_sc_hd__tapvpwrvgnd_1
XTAP_1822 vssd1 vccd1 sky130_fd_sc_hd__tapvpwrvgnd_1
XTAP_1811 vssd1 vccd1 sky130_fd_sc_hd__tapvpwrvgnd_1
XFILLER_0_67_111 vssd1 vssd1 vccd1 vccd1 sky130_fd_sc_hd__fill_1
XTAP_1866 vssd1 vccd1 sky130_fd_sc_hd__tapvpwrvgnd_1
XTAP_1855 vssd1 vccd1 sky130_fd_sc_hd__tapvpwrvgnd_1
XTAP_1844 vssd1 vccd1 sky130_fd_sc_hd__tapvpwrvgnd_1
XFILLER_0_83_615 vssd1 vssd1 vccd1 vccd1 sky130_fd_sc_hd__fill_1
XFILLER_0_68_678 vssd1 vssd1 vccd1 vccd1 sky130_fd_sc_hd__decap_8
XFILLER_0_67_144 vssd1 vssd1 vccd1 vccd1 sky130_fd_sc_hd__fill_2
X_11762_ net219 net599 net579 net123 _05812_ vssd1 vssd1 vccd1 vccd1 _05813_ sky130_fd_sc_hd__a221o_1
XTAP_1899 vssd1 vccd1 sky130_fd_sc_hd__tapvpwrvgnd_1
XTAP_1888 vssd1 vccd1 sky130_fd_sc_hd__tapvpwrvgnd_1
XTAP_1877 vssd1 vccd1 sky130_fd_sc_hd__tapvpwrvgnd_1
X_10713_ net1665 _04814_ net525 vssd1 vssd1 vccd1 vccd1 _00146_ sky130_fd_sc_hd__mux2_1
X_11693_ net1312 _05671_ net539 vssd1 vssd1 vccd1 vccd1 _00185_ sky130_fd_sc_hd__mux2_1
X_10644_ _04707_ _04708_ _04744_ _04745_ vssd1 vssd1 vccd1 vccd1 _04746_ sky130_fd_sc_hd__nand4_4
X_10575_ _04673_ _04674_ _04432_ vssd1 vssd1 vccd1 vccd1 _04677_ sky130_fd_sc_hd__a21o_2
XFILLER_0_23_203 vssd1 vssd1 vccd1 vccd1 sky130_fd_sc_hd__decap_3
XFILLER_0_36_586 vssd1 vssd1 vccd1 vccd1 sky130_fd_sc_hd__fill_2
X_12314_ net1647 _00813_ net666 vssd1 vssd1 vccd1 vccd1 _00366_ sky130_fd_sc_hd__mux2_1
XFILLER_0_23_225 vssd1 vssd1 vccd1 vccd1 sky130_fd_sc_hd__fill_1
XFILLER_0_24_748 vssd1 vssd1 vccd1 vccd1 sky130_fd_sc_hd__fill_2
XFILLER_0_51_578 vssd1 vssd1 vccd1 vccd1 sky130_fd_sc_hd__fill_1
XFILLER_0_48_15 vssd1 vssd1 vccd1 vccd1 sky130_fd_sc_hd__fill_1
X_12245_ net718 _06183_ net517 vssd1 vssd1 vccd1 vccd1 _00309_ sky130_fd_sc_hd__mux2_1
XFILLER_0_32_792 vssd1 vssd1 vccd1 vccd1 sky130_fd_sc_hd__fill_1
XFILLER_0_48_37 vssd1 vssd1 vccd1 vccd1 sky130_fd_sc_hd__fill_2
XFILLER_0_48_26 vssd1 vssd1 vccd1 vccd1 sky130_fd_sc_hd__fill_2
X_12176_ mul1.b\[3\] _06137_ net515 vssd1 vssd1 vccd1 vccd1 _00286_ sky130_fd_sc_hd__mux2_1
X_11127_ net982 net750 net975 net742 vssd1 vssd1 vccd1 vccd1 _05225_ sky130_fd_sc_hd__and4_1
X_11058_ _05030_ _05035_ _05156_ vssd1 vssd1 vccd1 vccd1 _05157_ sky130_fd_sc_hd__o21ai_2
XFILLER_0_3_39 vssd1 vssd1 vccd1 vccd1 sky130_ef_sc_hd__decap_12
X_10009_ _04070_ _04113_ vssd1 vssd1 vccd1 vccd1 _04115_ sky130_fd_sc_hd__xnor2_4
XFILLER_0_99_770 vssd1 vssd1 vccd1 vccd1 sky130_fd_sc_hd__decap_4
XFILLER_0_129_500 vssd1 vssd1 vccd1 vccd1 sky130_fd_sc_hd__decap_4
XFILLER_0_58_133 vssd1 vssd1 vccd1 vccd1 sky130_fd_sc_hd__decap_4
XFILLER_0_80_57 vssd1 vssd1 vccd1 vccd1 sky130_fd_sc_hd__fill_1
XFILLER_0_104_53 vssd1 vssd1 vccd1 vccd1 sky130_ef_sc_hd__decap_12
XFILLER_0_74_637 vssd1 vssd1 vccd1 vccd1 sky130_fd_sc_hd__decap_6
XFILLER_0_46_339 vssd1 vssd1 vccd1 vccd1 sky130_fd_sc_hd__decap_4
XFILLER_0_13_51 vssd1 vssd1 vccd1 vccd1 sky130_fd_sc_hd__decap_4
XFILLER_0_39_380 vssd1 vssd1 vccd1 vccd1 sky130_fd_sc_hd__fill_1
XFILLER_0_104_97 vssd1 vssd1 vccd1 vccd1 sky130_ef_sc_hd__decap_12
X_07220_ _01342_ _01343_ vssd1 vssd1 vccd1 vccd1 _01345_ sky130_fd_sc_hd__xnor2_1
XFILLER_0_13_95 vssd1 vssd1 vccd1 vccd1 sky130_ef_sc_hd__decap_12
X_07151_ net904 net1088 vssd1 vssd1 vccd1 vccd1 _01276_ sky130_fd_sc_hd__and2_1
XFILLER_0_42_523 vssd1 vssd1 vccd1 vccd1 sky130_fd_sc_hd__decap_3
XFILLER_0_125_783 vssd1 vssd1 vccd1 vccd1 sky130_fd_sc_hd__fill_1
XFILLER_0_120_41 vssd1 vssd1 vccd1 vccd1 sky130_ef_sc_hd__decap_12
XFILLER_0_89_55 vssd1 vssd1 vccd1 vccd1 sky130_fd_sc_hd__fill_1
XFILLER_0_112_433 vssd1 vssd1 vccd1 vccd1 sky130_ef_sc_hd__decap_12
XFILLER_0_89_77 vssd1 vssd1 vccd1 vccd1 sky130_fd_sc_hd__decap_3
Xoutput401 net401 vssd1 vssd1 vccd1 vccd1 mstream_o[56] sky130_fd_sc_hd__clkbuf_4
X_07082_ _01204_ _01205_ _01206_ vssd1 vssd1 vccd1 vccd1 _01207_ sky130_fd_sc_hd__nand3_1
XFILLER_0_120_85 vssd1 vssd1 vccd1 vccd1 sky130_ef_sc_hd__decap_12
XFILLER_0_112_477 vssd1 vssd1 vccd1 vccd1 sky130_ef_sc_hd__decap_12
Xoutput434 net434 vssd1 vssd1 vccd1 vccd1 mstream_o[86] sky130_fd_sc_hd__clkbuf_4
XFILLER_0_100_606 vssd1 vssd1 vccd1 vccd1 sky130_fd_sc_hd__decap_6
Xoutput423 net423 vssd1 vssd1 vccd1 vccd1 mstream_o[76] sky130_fd_sc_hd__clkbuf_4
Xoutput412 net412 vssd1 vssd1 vccd1 vccd1 mstream_o[66] sky130_fd_sc_hd__clkbuf_4
Xoutput445 net445 vssd1 vssd1 vccd1 vccd1 mstream_o[96] sky130_fd_sc_hd__clkbuf_4
X_07984_ _02102_ _02103_ vssd1 vssd1 vccd1 vccd1 _02104_ sky130_fd_sc_hd__nor2_1
XFILLER_0_38_81 vssd1 vssd1 vccd1 vccd1 sky130_fd_sc_hd__decap_3
X_09723_ _03828_ _03829_ _03689_ _03692_ vssd1 vssd1 vccd1 vccd1 _03831_ sky130_fd_sc_hd__o211ai_2
X_06935_ _01056_ _01059_ vssd1 vssd1 vccd1 vccd1 _01060_ sky130_fd_sc_hd__or2_1
X_09654_ _03759_ _03760_ vssd1 vssd1 vccd1 vccd1 _03762_ sky130_fd_sc_hd__xnor2_1
X_06866_ net1150 _00995_ _00982_ vssd1 vssd1 vccd1 vccd1 _00118_ sky130_fd_sc_hd__mux2_1
XFILLER_0_97_729 vssd1 vssd1 vccd1 vccd1 sky130_ef_sc_hd__decap_12
X_08605_ _02719_ _02718_ _02717_ vssd1 vssd1 vccd1 vccd1 _02720_ sky130_fd_sc_hd__nand3b_1
X_06797_ net1378 l0\[4\] net644 vssd1 vssd1 vccd1 vccd1 _00071_ sky130_fd_sc_hd__mux2_1
XFILLER_0_77_420 vssd1 vssd1 vccd1 vccd1 sky130_fd_sc_hd__decap_3
X_09585_ _03528_ _03529_ vssd1 vssd1 vccd1 vccd1 _03694_ sky130_fd_sc_hd__nand2_1
XTAP_1129 vssd1 vccd1 sky130_fd_sc_hd__tapvpwrvgnd_1
XTAP_1118 vssd1 vccd1 sky130_fd_sc_hd__tapvpwrvgnd_1
XTAP_1107 vssd1 vccd1 sky130_fd_sc_hd__tapvpwrvgnd_1
X_08536_ _02616_ _02649_ _02650_ vssd1 vssd1 vccd1 vccd1 _02652_ sky130_fd_sc_hd__nor3_1
X_08467_ _02580_ _02581_ _02576_ vssd1 vssd1 vccd1 vccd1 _02583_ sky130_fd_sc_hd__a21o_1
XFILLER_0_107_205 vssd1 vssd1 vccd1 vccd1 sky130_fd_sc_hd__decap_8
X_08398_ _02513_ _02514_ _02496_ vssd1 vssd1 vccd1 vccd1 _02515_ sky130_fd_sc_hd__a21oi_2
X_07418_ _01541_ _01542_ vssd1 vssd1 vccd1 vccd1 _01543_ sky130_fd_sc_hd__nor2_1
XFILLER_0_123_709 vssd1 vssd1 vccd1 vccd1 sky130_ef_sc_hd__decap_12
XFILLER_0_116_750 vssd1 vssd1 vccd1 vccd1 sky130_fd_sc_hd__decap_6
XFILLER_0_70_90 vssd1 vssd1 vccd1 vccd1 sky130_fd_sc_hd__fill_1
XFILLER_0_64_169 vssd1 vssd1 vccd1 vccd1 sky130_fd_sc_hd__fill_1
XFILLER_0_61_810 vssd1 vssd1 vccd1 vccd1 sky130_fd_sc_hd__decap_3
X_07349_ net895 net887 net1104 net1111 vssd1 vssd1 vccd1 vccd1 _01474_ sky130_fd_sc_hd__and4_1
XFILLER_0_33_523 vssd1 vssd1 vccd1 vccd1 sky130_fd_sc_hd__fill_1
XFILLER_0_33_545 vssd1 vssd1 vccd1 vccd1 sky130_fd_sc_hd__fill_1
XFILLER_0_115_293 vssd1 vssd1 vccd1 vccd1 sky130_ef_sc_hd__decap_12
X_10360_ _04344_ _04347_ _04461_ _04462_ vssd1 vssd1 vccd1 vccd1 _04464_ sky130_fd_sc_hd__a211oi_4
XFILLER_0_5_480 vssd1 vssd1 vccd1 vccd1 sky130_fd_sc_hd__fill_2
X_09019_ _03129_ _03130_ vssd1 vssd1 vccd1 vccd1 _03131_ sky130_fd_sc_hd__xnor2_1
XFILLER_0_103_455 vssd1 vssd1 vccd1 vccd1 sky130_fd_sc_hd__fill_1
X_10291_ _04392_ _04393_ vssd1 vssd1 vccd1 vccd1 _04395_ sky130_fd_sc_hd__nor2_1
XFILLER_0_60_397 vssd1 vssd1 vccd1 vccd1 sky130_fd_sc_hd__decap_3
Xhold170 add1.b_i\[29\] vssd1 vssd1 vccd1 vccd1 net1385 sky130_fd_sc_hd__dlygate4sd3_1
X_12030_ _00997_ net581 vssd1 vssd1 vccd1 vccd1 _06027_ sky130_fd_sc_hd__or2_2
Xhold181 add1.a_i\[28\] vssd1 vssd1 vccd1 vccd1 net1396 sky130_fd_sc_hd__dlygate4sd3_1
Xhold192 y2my0\[12\] vssd1 vssd1 vccd1 vccd1 net1407 sky130_fd_sc_hd__dlygate4sd3_1
XFILLER_0_18_29 vssd1 vssd1 vccd1 vccd1 sky130_ef_sc_hd__decap_12
Xfanout650 _00801_ vssd1 vssd1 vccd1 vccd1 net650 sky130_fd_sc_hd__clkbuf_4
Xfanout694 _00591_ vssd1 vssd1 vccd1 vccd1 net694 sky130_fd_sc_hd__clkbuf_4
Xfanout672 net673 vssd1 vssd1 vccd1 vccd1 net672 sky130_fd_sc_hd__buf_2
Xfanout661 net663 vssd1 vssd1 vccd1 vccd1 net661 sky130_fd_sc_hd__buf_4
Xfanout683 net684 vssd1 vssd1 vccd1 vccd1 net683 sky130_fd_sc_hd__buf_2
X_12932_ clknet_leaf_8_clk_i _00318_ net1193 vssd1 vssd1 vccd1 vccd1 posx\[3\] sky130_fd_sc_hd__dfrtp_1
X_12863_ clknet_leaf_28_clk_i _00249_ vssd1 vssd1 vccd1 vccd1 sub1.b_i\[30\] sky130_fd_sc_hd__dfxtp_1
XFILLER_0_34_39 vssd1 vssd1 vccd1 vccd1 sky130_fd_sc_hd__fill_1
XTAP_1641 vssd1 vccd1 sky130_fd_sc_hd__tapvpwrvgnd_1
XTAP_1630 vssd1 vccd1 sky130_fd_sc_hd__tapvpwrvgnd_1
XFILLER_0_68_453 vssd1 vssd1 vccd1 vccd1 sky130_fd_sc_hd__fill_1
X_12794_ clknet_leaf_18_clk_i _00180_ vssd1 vssd1 vccd1 vccd1 add1.b_i\[25\] sky130_fd_sc_hd__dfxtp_1
X_11814_ net654 _00903_ net475 _05856_ vssd1 vssd1 vccd1 vccd1 _05857_ sky130_fd_sc_hd__a211o_1
XTAP_1685 vssd1 vccd1 sky130_fd_sc_hd__tapvpwrvgnd_1
XTAP_1663 vssd1 vccd1 sky130_fd_sc_hd__tapvpwrvgnd_1
XTAP_1674 vssd1 vccd1 sky130_fd_sc_hd__tapvpwrvgnd_1
XTAP_1652 vssd1 vccd1 sky130_fd_sc_hd__tapvpwrvgnd_1
XFILLER_0_83_412 vssd1 vssd1 vccd1 vccd1 sky130_fd_sc_hd__fill_1
X_11745_ net651 _00846_ net473 _05798_ vssd1 vssd1 vccd1 vccd1 _05799_ sky130_fd_sc_hd__a211o_1
XTAP_1696 vssd1 vccd1 sky130_fd_sc_hd__tapvpwrvgnd_1
XFILLER_0_56_659 vssd1 vssd1 vccd1 vccd1 sky130_fd_sc_hd__fill_1
XFILLER_0_126_569 vssd1 vssd1 vccd1 vccd1 sky130_ef_sc_hd__decap_12
XFILLER_0_55_169 vssd1 vssd1 vccd1 vccd1 sky130_fd_sc_hd__decap_4
XFILLER_0_52_821 vssd1 vssd1 vccd1 vccd1 sky130_fd_sc_hd__fill_1
X_11676_ net1326 _03263_ net537 vssd1 vssd1 vccd1 vccd1 _00168_ sky130_fd_sc_hd__mux2_1
X_10627_ net790 net970 net965 net800 vssd1 vssd1 vccd1 vccd1 _04729_ sky130_fd_sc_hd__a22oi_1
XFILLER_0_107_794 vssd1 vssd1 vccd1 vccd1 sky130_fd_sc_hd__decap_4
X_10558_ _04658_ _04659_ vssd1 vssd1 vccd1 vccd1 _04661_ sky130_fd_sc_hd__xnor2_1
XFILLER_0_59_25 vssd1 vssd1 vccd1 vccd1 sky130_fd_sc_hd__fill_2
XFILLER_0_11_206 vssd1 vssd1 vccd1 vccd1 sky130_fd_sc_hd__fill_2
XFILLER_0_24_589 vssd1 vssd1 vccd1 vccd1 sky130_ef_sc_hd__decap_12
X_10489_ _04582_ _04589_ _04590_ vssd1 vssd1 vccd1 vccd1 _04592_ sky130_fd_sc_hd__nand3_2
X_12228_ x2mx1\[21\] net606 net589 temp1\[21\] vssd1 vssd1 vccd1 vccd1 _06172_ sky130_fd_sc_hd__a22o_1
X_12159_ net1610 _06125_ net518 vssd1 vssd1 vccd1 vccd1 _00281_ sky130_fd_sc_hd__mux2_1
XFILLER_0_75_57 vssd1 vssd1 vccd1 vccd1 sky130_ef_sc_hd__decap_12
X_06720_ _00938_ _00939_ vssd1 vssd1 vccd1 vccd1 _00940_ sky130_fd_sc_hd__xnor2_4
X_06651_ _00880_ _00881_ vssd1 vssd1 vccd1 vccd1 _00882_ sky130_fd_sc_hd__xnor2_4
X_09370_ _03311_ _03313_ _03478_ _03479_ vssd1 vssd1 vccd1 vccd1 _03480_ sky130_fd_sc_hd__o211a_1
XFILLER_0_93_209 vssd1 vssd1 vccd1 vccd1 sky130_fd_sc_hd__decap_4
XFILLER_0_91_89 vssd1 vssd1 vccd1 vccd1 sky130_fd_sc_hd__decap_3
XFILLER_0_86_250 vssd1 vssd1 vccd1 vccd1 sky130_fd_sc_hd__fill_2
XFILLER_0_47_615 vssd1 vssd1 vccd1 vccd1 sky130_fd_sc_hd__fill_1
X_06582_ net1730 _00823_ net633 vssd1 vssd1 vccd1 vccd1 _00006_ sky130_fd_sc_hd__mux2_1
X_08321_ _02301_ _02302_ vssd1 vssd1 vccd1 vccd1 _02438_ sky130_fd_sc_hd__nor2_1
XFILLER_0_117_503 vssd1 vssd1 vccd1 vccd1 sky130_fd_sc_hd__fill_1
X_08252_ _02245_ _02246_ _02247_ vssd1 vssd1 vccd1 vccd1 _02370_ sky130_fd_sc_hd__a21bo_1
XFILLER_0_55_670 vssd1 vssd1 vccd1 vccd1 sky130_fd_sc_hd__fill_2
X_07203_ net1137 net1144 net798 net788 vssd1 vssd1 vccd1 vccd1 _01328_ sky130_fd_sc_hd__nand4_1
X_08183_ net1106 net1114 net772 net763 vssd1 vssd1 vccd1 vccd1 _02301_ sky130_fd_sc_hd__and4_1
X_07134_ net1127 _01016_ _01186_ vssd1 vssd1 vccd1 vccd1 _01259_ sky130_fd_sc_hd__a21o_1
XFILLER_0_40_93 vssd1 vssd1 vccd1 vccd1 sky130_fd_sc_hd__decap_4
XFILLER_0_113_753 vssd1 vssd1 vccd1 vccd1 sky130_fd_sc_hd__decap_8
XFILLER_0_71_3 vssd1 vssd1 vccd1 vccd1 sky130_ef_sc_hd__decap_12
X_07065_ _01183_ _01188_ vssd1 vssd1 vccd1 vccd1 _01190_ sky130_fd_sc_hd__xnor2_1
Xoutput253 net253 vssd1 vssd1 vccd1 vccd1 div_mstream_o[10] sky130_fd_sc_hd__clkbuf_4
Xoutput286 net286 vssd1 vssd1 vccd1 vccd1 div_mstream_o[40] sky130_fd_sc_hd__clkbuf_4
Xoutput275 net275 vssd1 vssd1 vccd1 vccd1 div_mstream_o[30] sky130_fd_sc_hd__clkbuf_4
Xoutput264 net264 vssd1 vssd1 vccd1 vccd1 div_mstream_o[20] sky130_fd_sc_hd__clkbuf_4
XFILLER_0_10_250 vssd1 vssd1 vccd1 vccd1 sky130_fd_sc_hd__fill_2
XFILLER_0_11_773 vssd1 vssd1 vccd1 vccd1 sky130_fd_sc_hd__decap_8
Xoutput297 net297 vssd1 vssd1 vccd1 vccd1 div_mstream_o[65] sky130_fd_sc_hd__clkbuf_4
X_07967_ _02085_ _02086_ vssd1 vssd1 vccd1 vccd1 _02087_ sky130_fd_sc_hd__and2b_1
X_09706_ _03654_ _03656_ vssd1 vssd1 vccd1 vccd1 _03814_ sky130_fd_sc_hd__nand2_1
X_06918_ _01042_ vssd1 vssd1 vccd1 vccd1 _01043_ sky130_fd_sc_hd__inv_2
X_07898_ net1015 net889 net1007 net898 vssd1 vssd1 vccd1 vccd1 _02019_ sky130_fd_sc_hd__a22oi_2
X_09637_ _03279_ _03574_ _03573_ vssd1 vssd1 vccd1 vccd1 _03746_ sky130_fd_sc_hd__a21boi_4
XFILLER_0_78_740 vssd1 vssd1 vccd1 vccd1 sky130_fd_sc_hd__decap_8
X_06849_ net28 _00602_ _00605_ net47 _00979_ vssd1 vssd1 vccd1 vccd1 _00980_ sky130_fd_sc_hd__o221a_1
X_09568_ net809 net1006 vssd1 vssd1 vccd1 vccd1 _03677_ sky130_fd_sc_hd__nand2_1
XFILLER_0_93_721 vssd1 vssd1 vccd1 vccd1 sky130_fd_sc_hd__decap_6
X_08519_ net921 net913 net961 net955 vssd1 vssd1 vccd1 vccd1 _02635_ sky130_fd_sc_hd__nand4_1
X_09499_ _03431_ _03439_ _03605_ vssd1 vssd1 vccd1 vccd1 _03608_ sky130_fd_sc_hd__nand3_1
XFILLER_0_92_242 vssd1 vssd1 vccd1 vccd1 sky130_fd_sc_hd__fill_1
XFILLER_0_65_445 vssd1 vssd1 vccd1 vccd1 sky130_fd_sc_hd__decap_3
X_11530_ _05514_ _05515_ _05516_ _05513_ vssd1 vssd1 vccd1 vccd1 _05625_ sky130_fd_sc_hd__o31ai_2
XFILLER_0_80_404 vssd1 vssd1 vccd1 vccd1 sky130_fd_sc_hd__fill_1
XFILLER_0_52_117 vssd1 vssd1 vccd1 vccd1 sky130_fd_sc_hd__decap_4
XFILLER_0_123_517 vssd1 vssd1 vccd1 vccd1 sky130_ef_sc_hd__decap_12
XFILLER_0_52_139 vssd1 vssd1 vccd1 vccd1 sky130_fd_sc_hd__fill_1
X_11461_ _05554_ _05555_ _05402_ _05405_ vssd1 vssd1 vccd1 vccd1 _05557_ sky130_fd_sc_hd__o211a_1
X_10412_ _04384_ _04515_ vssd1 vssd1 vccd1 vccd1 _04516_ sky130_fd_sc_hd__xnor2_2
X_13200_ clknet_leaf_15_clk_i _00586_ net1183 vssd1 vssd1 vccd1 vccd1 l1\[29\] sky130_fd_sc_hd__dfrtp_1
X_11392_ _05487_ _05482_ vssd1 vssd1 vccd1 vccd1 _05488_ sky130_fd_sc_hd__and2b_1
X_13131_ clknet_leaf_4_clk_i _00517_ vssd1 vssd1 vccd1 vccd1 det_t\[24\] sky130_fd_sc_hd__dfxtp_1
XFILLER_0_104_775 vssd1 vssd1 vccd1 vccd1 sky130_fd_sc_hd__fill_2
XFILLER_0_104_764 vssd1 vssd1 vccd1 vccd1 sky130_fd_sc_hd__fill_2
X_10343_ net817 net964 net958 net826 vssd1 vssd1 vccd1 vccd1 _04447_ sky130_fd_sc_hd__a22o_1
X_10274_ _03748_ _03903_ _04376_ vssd1 vssd1 vccd1 vccd1 _04379_ sky130_fd_sc_hd__or3_1
X_13062_ clknet_leaf_37_clk_i _00448_ net1162 vssd1 vssd1 vccd1 vccd1 y2my0\[19\]
+ sky130_fd_sc_hd__dfrtp_1
X_12013_ net1291 _06014_ net483 vssd1 vssd1 vccd1 vccd1 _00246_ sky130_fd_sc_hd__mux2_1
XFILLER_0_45_38 vssd1 vssd1 vccd1 vccd1 sky130_fd_sc_hd__decap_6
Xfanout480 net485 vssd1 vssd1 vccd1 vccd1 net480 sky130_fd_sc_hd__clkbuf_2
Xmax_cap5 _04795_ vssd1 vssd1 vccd1 vccd1 net1746 sky130_fd_sc_hd__buf_1
X_12915_ clknet_leaf_37_clk_i _00301_ vssd1 vssd1 vccd1 vccd1 mul1.b\[18\] sky130_fd_sc_hd__dfxtp_4
XTAP_2161 vssd1 vccd1 sky130_fd_sc_hd__tapvpwrvgnd_1
XTAP_2150 vssd1 vccd1 sky130_fd_sc_hd__tapvpwrvgnd_1
XFILLER_0_68_250 vssd1 vssd1 vccd1 vccd1 sky130_fd_sc_hd__fill_2
XFILLER_0_61_15 vssd1 vssd1 vccd1 vccd1 sky130_fd_sc_hd__decap_6
X_12846_ clknet_leaf_50_clk_i _00232_ vssd1 vssd1 vccd1 vccd1 sub1.b_i\[13\] sky130_fd_sc_hd__dfxtp_1
XTAP_2194 vssd1 vccd1 sky130_fd_sc_hd__tapvpwrvgnd_1
XTAP_2183 vssd1 vccd1 sky130_fd_sc_hd__tapvpwrvgnd_1
XTAP_2172 vssd1 vccd1 sky130_fd_sc_hd__tapvpwrvgnd_1
XTAP_1460 vssd1 vccd1 sky130_fd_sc_hd__tapvpwrvgnd_1
XTAP_1493 vssd1 vccd1 sky130_fd_sc_hd__tapvpwrvgnd_1
XTAP_1471 vssd1 vccd1 sky130_fd_sc_hd__tapvpwrvgnd_1
XTAP_1482 vssd1 vccd1 sky130_fd_sc_hd__tapvpwrvgnd_1
X_12777_ clknet_leaf_58_clk_i _00163_ vssd1 vssd1 vccd1 vccd1 add1.b_i\[8\] sky130_fd_sc_hd__dfxtp_1
XFILLER_0_28_136 vssd1 vssd1 vccd1 vccd1 sky130_fd_sc_hd__decap_4
XFILLER_0_83_264 vssd1 vssd1 vccd1 vccd1 sky130_fd_sc_hd__fill_2
XFILLER_0_71_404 vssd1 vssd1 vccd1 vccd1 sky130_fd_sc_hd__fill_1
X_11728_ temp1\[4\] net611 net668 net116 _05784_ vssd1 vssd1 vccd1 vccd1 _05785_ sky130_fd_sc_hd__a221o_1
XFILLER_0_28_169 vssd1 vssd1 vccd1 vccd1 sky130_fd_sc_hd__decap_8
XFILLER_0_126_377 vssd1 vssd1 vccd1 vccd1 sky130_fd_sc_hd__decap_6
XFILLER_0_9_27 vssd1 vssd1 vccd1 vccd1 sky130_ef_sc_hd__decap_12
X_11659_ net1151 _00607_ vssd1 vssd1 vccd1 vccd1 _05752_ sky130_fd_sc_hd__or2_4
XFILLER_0_52_640 vssd1 vssd1 vccd1 vccd1 sky130_fd_sc_hd__decap_4
XFILLER_0_4_737 vssd1 vssd1 vccd1 vccd1 sky130_fd_sc_hd__fill_2
XFILLER_0_3_225 vssd1 vssd1 vccd1 vccd1 sky130_fd_sc_hd__fill_1
XFILLER_0_12_504 vssd1 vssd1 vccd1 vccd1 sky130_fd_sc_hd__fill_1
XFILLER_0_10_41 vssd1 vssd1 vccd1 vccd1 sky130_ef_sc_hd__decap_12
XFILLER_0_110_701 vssd1 vssd1 vccd1 vccd1 sky130_ef_sc_hd__decap_12
XFILLER_0_10_85 vssd1 vssd1 vccd1 vccd1 sky130_fd_sc_hd__fill_1
X_08870_ _02833_ _02835_ _02979_ _02981_ vssd1 vssd1 vccd1 vccd1 _02983_ sky130_fd_sc_hd__a211oi_1
X_07821_ _01855_ _01942_ vssd1 vssd1 vccd1 vccd1 _01943_ sky130_fd_sc_hd__xnor2_2
XFILLER_0_43_7 vssd1 vssd1 vccd1 vccd1 sky130_fd_sc_hd__fill_1
X_07752_ _01801_ _01805_ _01873_ vssd1 vssd1 vccd1 vccd1 _01874_ sky130_fd_sc_hd__a21oi_1
X_07683_ net1074 net856 _01706_ _01707_ net873 vssd1 vssd1 vccd1 vccd1 _01806_ sky130_fd_sc_hd__a32o_1
X_06703_ sub1.a_i\[23\] sub1.b_i\[23\] vssd1 vssd1 vccd1 vccd1 _00925_ sky130_fd_sc_hd__and2b_1
X_09422_ _03529_ _03530_ _03373_ _03376_ vssd1 vssd1 vccd1 vccd1 _03532_ sky130_fd_sc_hd__a211o_1
X_06634_ net1724 _00867_ net633 vssd1 vssd1 vccd1 vccd1 _00014_ sky130_fd_sc_hd__mux2_1
X_09353_ _03442_ _03443_ _03461_ _03462_ vssd1 vssd1 vccd1 vccd1 _03463_ sky130_fd_sc_hd__o22a_1
XFILLER_0_19_103 vssd1 vssd1 vccd1 vccd1 sky130_fd_sc_hd__decap_4
X_08304_ _02306_ _02308_ _02419_ vssd1 vssd1 vccd1 vccd1 _02421_ sky130_fd_sc_hd__and3_1
X_06565_ _00808_ _00809_ vssd1 vssd1 vccd1 vccd1 _00810_ sky130_fd_sc_hd__nand2_4
X_06496_ det_t\[6\] net527 vssd1 vssd1 vccd1 vccd1 net302 sky130_fd_sc_hd__and2_1
X_09284_ _03391_ _03392_ _03235_ _03239_ vssd1 vssd1 vccd1 vccd1 _03395_ sky130_fd_sc_hd__o211ai_1
XFILLER_0_19_169 vssd1 vssd1 vccd1 vccd1 sky130_fd_sc_hd__fill_2
X_08235_ net1015 net875 net865 net1007 vssd1 vssd1 vccd1 vccd1 _02353_ sky130_fd_sc_hd__nand4_2
XFILLER_0_51_92 vssd1 vssd1 vccd1 vccd1 sky130_fd_sc_hd__decap_8
XFILLER_0_27_180 vssd1 vssd1 vccd1 vccd1 sky130_fd_sc_hd__decap_4
XFILLER_0_34_139 vssd1 vssd1 vccd1 vccd1 sky130_fd_sc_hd__fill_1
XFILLER_0_105_539 vssd1 vssd1 vccd1 vccd1 sky130_fd_sc_hd__fill_2
X_08166_ temp1\[6\] _02284_ net540 vssd1 vssd1 vccd1 vccd1 _02285_ sky130_fd_sc_hd__mux2_1
X_07117_ net820 net1120 net1129 net813 vssd1 vssd1 vccd1 vccd1 _01242_ sky130_fd_sc_hd__a22o_1
XFILLER_0_113_561 vssd1 vssd1 vccd1 vccd1 sky130_ef_sc_hd__decap_12
X_08097_ net1043 net1051 net839 vssd1 vssd1 vccd1 vccd1 _02216_ sky130_fd_sc_hd__and3_1
XFILLER_0_42_194 vssd1 vssd1 vccd1 vccd1 sky130_fd_sc_hd__fill_2
X_07048_ _01158_ _01159_ _01170_ vssd1 vssd1 vccd1 vccd1 _01173_ sky130_fd_sc_hd__a21oi_2
XFILLER_0_101_789 vssd1 vssd1 vccd1 vccd1 sky130_fd_sc_hd__fill_1
X_08999_ temp1\[12\] _03111_ net541 vssd1 vssd1 vccd1 vccd1 _03112_ sky130_fd_sc_hd__mux2_1
X_10961_ _04887_ _04890_ _05058_ _05059_ vssd1 vssd1 vccd1 vccd1 _05061_ sky130_fd_sc_hd__o211ai_1
X_12700_ clknet_leaf_13_clk_i net1430 net1187 vssd1 vssd1 vccd1 vccd1 net431 sky130_fd_sc_hd__dfrtp_1
XFILLER_0_85_518 vssd1 vssd1 vccd1 vccd1 sky130_fd_sc_hd__decap_3
XFILLER_0_97_389 vssd1 vssd1 vccd1 vccd1 sky130_fd_sc_hd__decap_3
XFILLER_0_66_732 vssd1 vssd1 vccd1 vccd1 sky130_ef_sc_hd__decap_12
X_10892_ net758 net984 vssd1 vssd1 vccd1 vccd1 _04992_ sky130_fd_sc_hd__nand2_1
X_12631_ clknet_leaf_47_clk_i _00017_ net1160 vssd1 vssd1 vccd1 vccd1 net355 sky130_fd_sc_hd__dfrtp_4
XFILLER_0_38_445 vssd1 vssd1 vccd1 vccd1 sky130_ef_sc_hd__decap_12
XFILLER_0_108_333 vssd1 vssd1 vccd1 vccd1 sky130_fd_sc_hd__fill_2
X_12562_ net1556 net6 net559 vssd1 vssd1 vccd1 vccd1 _00538_ sky130_fd_sc_hd__mux2_1
X_12493_ _00789_ net568 _06243_ vssd1 vssd1 vccd1 vccd1 _00497_ sky130_fd_sc_hd__a21oi_1
XFILLER_0_81_735 vssd1 vssd1 vccd1 vccd1 sky130_ef_sc_hd__decap_12
X_11513_ _05605_ _05606_ _05607_ vssd1 vssd1 vccd1 vccd1 _05608_ sky130_fd_sc_hd__and3_1
XFILLER_0_108_388 vssd1 vssd1 vccd1 vccd1 sky130_fd_sc_hd__fill_2
X_11444_ _05537_ _05538_ _05418_ _05421_ vssd1 vssd1 vccd1 vccd1 _05540_ sky130_fd_sc_hd__o211a_1
Xbary_pipe_m_1201 vssd1 vssd1 vccd1 vccd1 bary_pipe_m_1201/HI div_mstream_o[51] sky130_fd_sc_hd__conb_1
XFILLER_0_33_161 vssd1 vssd1 vccd1 vccd1 sky130_fd_sc_hd__decap_6
Xbary_pipe_m_1212 vssd1 vssd1 vccd1 vccd1 bary_pipe_m_1212/HI div_mstream_o[62] sky130_fd_sc_hd__conb_1
X_11375_ net775 net765 net952 net946 vssd1 vssd1 vccd1 vccd1 _05471_ sky130_fd_sc_hd__and4_1
XFILLER_0_33_183 vssd1 vssd1 vccd1 vccd1 sky130_fd_sc_hd__decap_3
X_13114_ clknet_leaf_2_clk_i _00500_ vssd1 vssd1 vccd1 vccd1 det_t\[7\] sky130_fd_sc_hd__dfxtp_1
X_10326_ net692 _04311_ _04428_ vssd1 vssd1 vccd1 vccd1 _04430_ sky130_fd_sc_hd__a21o_1
XTAP_507 vssd1 vccd1 sky130_fd_sc_hd__tapvpwrvgnd_1
X_10257_ _04359_ _04360_ vssd1 vssd1 vccd1 vccd1 _04362_ sky130_fd_sc_hd__xnor2_4
X_13045_ clknet_leaf_49_clk_i _00431_ net1159 vssd1 vssd1 vccd1 vccd1 y2my0\[2\] sky130_fd_sc_hd__dfrtp_1
XTAP_518 vssd1 vccd1 sky130_fd_sc_hd__tapvpwrvgnd_1
XTAP_529 vssd1 vccd1 sky130_fd_sc_hd__tapvpwrvgnd_1
X_10188_ _04289_ _04290_ _04291_ vssd1 vssd1 vccd1 vccd1 _04293_ sky130_fd_sc_hd__a21bo_1
XFILLER_0_56_59 vssd1 vssd1 vccd1 vccd1 sky130_fd_sc_hd__fill_2
XFILLER_0_76_518 vssd1 vssd1 vccd1 vccd1 sky130_fd_sc_hd__fill_1
XFILLER_0_119_609 vssd1 vssd1 vccd1 vccd1 sky130_fd_sc_hd__decap_6
XFILLER_0_88_389 vssd1 vssd1 vccd1 vccd1 sky130_fd_sc_hd__decap_3
X_12829_ clknet_leaf_29_clk_i _00215_ vssd1 vssd1 vccd1 vccd1 sub1.a_i\[28\] sky130_fd_sc_hd__dfxtp_1
XFILLER_0_127_631 vssd1 vssd1 vccd1 vccd1 sky130_fd_sc_hd__decap_3
XTAP_1290 vssd1 vccd1 sky130_fd_sc_hd__tapvpwrvgnd_1
X_06350_ add1.a_i\[6\] add1.b_i\[6\] _00661_ vssd1 vssd1 vccd1 vccd1 _00662_ sky130_fd_sc_hd__a21o_1
XFILLER_0_126_141 vssd1 vssd1 vccd1 vccd1 sky130_fd_sc_hd__decap_8
XFILLER_0_112_53 vssd1 vssd1 vccd1 vccd1 sky130_ef_sc_hd__decap_12
XFILLER_0_72_757 vssd1 vssd1 vccd1 vccd1 sky130_fd_sc_hd__fill_2
XFILLER_0_71_201 vssd1 vssd1 vccd1 vccd1 sky130_fd_sc_hd__decap_3
X_06281_ state\[2\] state\[3\] _00589_ vssd1 vssd1 vccd1 vccd1 _00597_ sky130_fd_sc_hd__or3_4
XFILLER_0_71_256 vssd1 vssd1 vccd1 vccd1 sky130_fd_sc_hd__fill_1
X_08020_ _02137_ _02138_ _02130_ vssd1 vssd1 vccd1 vccd1 _02140_ sky130_fd_sc_hd__a21o_1
XFILLER_0_21_51 vssd1 vssd1 vccd1 vccd1 sky130_fd_sc_hd__decap_4
XFILLER_0_21_73 vssd1 vssd1 vccd1 vccd1 sky130_fd_sc_hd__fill_1
XFILLER_0_112_97 vssd1 vssd1 vccd1 vccd1 sky130_ef_sc_hd__decap_12
XFILLER_0_40_621 vssd1 vssd1 vccd1 vccd1 sky130_fd_sc_hd__fill_1
XFILLER_0_130_829 vssd1 vssd1 vccd1 vccd1 sky130_fd_sc_hd__decap_8
XFILLER_0_97_55 vssd1 vssd1 vccd1 vccd1 sky130_fd_sc_hd__fill_1
XFILLER_0_24_194 vssd1 vssd1 vccd1 vccd1 sky130_fd_sc_hd__fill_2
XFILLER_0_40_632 vssd1 vssd1 vccd1 vccd1 sky130_ef_sc_hd__decap_12
XFILLER_0_110_531 vssd1 vssd1 vccd1 vccd1 sky130_fd_sc_hd__fill_1
X_09971_ net1109 net704 _03911_ _03912_ net714 vssd1 vssd1 vccd1 vccd1 _04077_ sky130_fd_sc_hd__a32o_1
Xmax_cap455 _02951_ vssd1 vssd1 vccd1 vccd1 net455 sky130_fd_sc_hd__buf_1
XFILLER_0_12_389 vssd1 vssd1 vccd1 vccd1 sky130_fd_sc_hd__fill_1
X_08922_ _03033_ _03034_ vssd1 vssd1 vccd1 vccd1 _03035_ sky130_fd_sc_hd__xnor2_1
Xmax_cap488 _03243_ vssd1 vssd1 vccd1 vccd1 net488 sky130_fd_sc_hd__clkbuf_1
XFILLER_0_0_773 vssd1 vssd1 vccd1 vccd1 sky130_fd_sc_hd__fill_2
X_08853_ net1141 net1148 net716 net707 vssd1 vssd1 vccd1 vccd1 _02966_ sky130_fd_sc_hd__and4_1
XFILLER_0_34_3 vssd1 vssd1 vccd1 vccd1 sky130_ef_sc_hd__decap_12
X_08784_ _02896_ _02897_ vssd1 vssd1 vccd1 vccd1 _02898_ sky130_fd_sc_hd__and2_1
X_07804_ _01922_ _01923_ _01924_ vssd1 vssd1 vccd1 vccd1 _01926_ sky130_fd_sc_hd__a21o_1
X_07735_ net1139 net1147 net774 net771 vssd1 vssd1 vccd1 vccd1 _01857_ sky130_fd_sc_hd__nand4_2
X_09405_ _03512_ _03513_ _03511_ vssd1 vssd1 vccd1 vccd1 _03515_ sky130_fd_sc_hd__a21o_1
XFILLER_0_67_529 vssd1 vssd1 vccd1 vccd1 sky130_ef_sc_hd__decap_12
X_07666_ _01786_ _01788_ vssd1 vssd1 vccd1 vccd1 _01789_ sky130_fd_sc_hd__nand2_1
XFILLER_0_1_61 vssd1 vssd1 vccd1 vccd1 sky130_fd_sc_hd__fill_2
XFILLER_0_62_80 vssd1 vssd1 vccd1 vccd1 sky130_fd_sc_hd__decap_4
X_07597_ net1026 net906 vssd1 vssd1 vccd1 vccd1 _01721_ sky130_fd_sc_hd__and2_1
X_06617_ sub1.a_i\[9\] sub1.b_i\[9\] vssd1 vssd1 vccd1 vccd1 _00853_ sky130_fd_sc_hd__xnor2_4
X_09336_ _03305_ _03308_ _03306_ vssd1 vssd1 vccd1 vccd1 _03446_ sky130_fd_sc_hd__o21bai_1
XFILLER_0_63_724 vssd1 vssd1 vccd1 vccd1 sky130_fd_sc_hd__fill_1
X_06548_ _00672_ _00797_ vssd1 vssd1 vccd1 vccd1 _00798_ sky130_fd_sc_hd__nand2_4
X_09267_ net907 net939 vssd1 vssd1 vccd1 vccd1 _03378_ sky130_fd_sc_hd__and2_1
X_06479_ net547 _00774_ vssd1 vssd1 vccd1 vccd1 net328 sky130_fd_sc_hd__nor2_1
X_08218_ net1051 net831 vssd1 vssd1 vccd1 vccd1 _02336_ sky130_fd_sc_hd__and2_1
X_09198_ _03307_ _03308_ vssd1 vssd1 vccd1 vccd1 _03309_ sky130_fd_sc_hd__xnor2_2
X_08149_ _02207_ _02208_ _02266_ _02267_ vssd1 vssd1 vccd1 vccd1 _02268_ sky130_fd_sc_hd__or4bb_4
XFILLER_0_43_492 vssd1 vssd1 vccd1 vccd1 sky130_fd_sc_hd__decap_4
XFILLER_0_30_131 vssd1 vssd1 vccd1 vccd1 sky130_fd_sc_hd__decap_8
XFILLER_0_113_391 vssd1 vssd1 vccd1 vccd1 sky130_fd_sc_hd__fill_1
X_11160_ _05093_ _05096_ _05255_ _05257_ vssd1 vssd1 vccd1 vccd1 _05258_ sky130_fd_sc_hd__a211oi_2
X_10111_ _04068_ _04216_ vssd1 vssd1 vccd1 vccd1 _04217_ sky130_fd_sc_hd__xnor2_4
X_11091_ _05187_ _05188_ _05022_ net1745 vssd1 vssd1 vccd1 vccd1 _05190_ sky130_fd_sc_hd__a211o_1
XFILLER_0_30_186 vssd1 vssd1 vccd1 vccd1 sky130_fd_sc_hd__decap_8
XFILLER_0_101_597 vssd1 vssd1 vccd1 vccd1 sky130_fd_sc_hd__fill_2
X_10042_ _04131_ _04144_ _04146_ vssd1 vssd1 vccd1 vccd1 _04148_ sky130_fd_sc_hd__and3_1
Xhold41 det_t\[2\] vssd1 vssd1 vccd1 vccd1 net1256 sky130_fd_sc_hd__dlygate4sd3_1
Xhold30 det_t\[22\] vssd1 vssd1 vccd1 vccd1 net1245 sky130_fd_sc_hd__dlygate4sd3_1
Xhold52 det_t\[31\] vssd1 vssd1 vccd1 vccd1 net1267 sky130_fd_sc_hd__dlygate4sd3_1
Xhold74 add1.b_i\[27\] vssd1 vssd1 vccd1 vccd1 net1289 sky130_fd_sc_hd__dlygate4sd3_1
Xhold63 sub1.b_i\[24\] vssd1 vssd1 vccd1 vccd1 net1278 sky130_fd_sc_hd__dlygate4sd3_1
XFILLER_0_26_29 vssd1 vssd1 vccd1 vccd1 sky130_ef_sc_hd__decap_12
Xhold96 add1.a_i\[10\] vssd1 vssd1 vccd1 vccd1 net1311 sky130_fd_sc_hd__dlygate4sd3_1
Xhold85 sub1.a_i\[28\] vssd1 vssd1 vccd1 vccd1 net1300 sky130_fd_sc_hd__dlygate4sd3_1
X_11993_ net1274 _05999_ net484 vssd1 vssd1 vccd1 vccd1 _00241_ sky130_fd_sc_hd__mux2_1
X_10944_ net1012 net730 net722 net1020 vssd1 vssd1 vccd1 vccd1 _05044_ sky130_fd_sc_hd__a22oi_1
XFILLER_0_85_337 vssd1 vssd1 vccd1 vccd1 sky130_fd_sc_hd__fill_2
X_10875_ _04966_ _04973_ vssd1 vssd1 vccd1 vccd1 _04975_ sky130_fd_sc_hd__xor2_1
X_12614_ clknet_leaf_8_clk_i _00000_ net1194 vssd1 vssd1 vccd1 vccd1 net351 sky130_fd_sc_hd__dfrtp_1
XFILLER_0_38_242 vssd1 vssd1 vccd1 vccd1 sky130_fd_sc_hd__fill_1
X_12545_ net1226 net567 _06269_ vssd1 vssd1 vccd1 vccd1 _00523_ sky130_fd_sc_hd__a21o_1
XFILLER_0_124_601 vssd1 vssd1 vccd1 vccd1 sky130_ef_sc_hd__decap_12
XFILLER_0_109_653 vssd1 vssd1 vccd1 vccd1 sky130_ef_sc_hd__decap_12
XFILLER_0_108_141 vssd1 vssd1 vccd1 vccd1 sky130_ef_sc_hd__decap_12
XFILLER_0_123_111 vssd1 vssd1 vccd1 vccd1 sky130_fd_sc_hd__fill_1
XFILLER_0_109_697 vssd1 vssd1 vccd1 vccd1 sky130_ef_sc_hd__decap_12
XFILLER_0_124_645 vssd1 vssd1 vccd1 vccd1 sky130_ef_sc_hd__decap_12
X_12476_ _00965_ net617 _05563_ net576 vssd1 vssd1 vccd1 vccd1 _06234_ sky130_fd_sc_hd__a22o_1
XANTENNA_5 _00699_ vssd1 vssd1 vccd1 vccd1 sky130_fd_sc_hd__diode_2
XFILLER_0_111_317 vssd1 vssd1 vccd1 vccd1 sky130_ef_sc_hd__decap_12
X_11427_ _05397_ _05521_ vssd1 vssd1 vccd1 vccd1 _05523_ sky130_fd_sc_hd__xor2_1
XFILLER_0_22_665 vssd1 vssd1 vccd1 vccd1 sky130_fd_sc_hd__decap_6
X_11358_ _05331_ _05453_ vssd1 vssd1 vccd1 vccd1 _05454_ sky130_fd_sc_hd__xor2_2
X_10309_ _04401_ _04411_ _04412_ vssd1 vssd1 vccd1 vccd1 _04413_ sky130_fd_sc_hd__and3_2
XTAP_315 vssd1 vccd1 sky130_fd_sc_hd__tapvpwrvgnd_1
XTAP_304 vssd1 vccd1 sky130_fd_sc_hd__tapvpwrvgnd_1
X_11289_ _05298_ _05300_ vssd1 vssd1 vccd1 vccd1 _05386_ sky130_fd_sc_hd__nand2b_1
XTAP_348 vssd1 vccd1 sky130_fd_sc_hd__tapvpwrvgnd_1
XTAP_337 vssd1 vccd1 sky130_fd_sc_hd__tapvpwrvgnd_1
XTAP_326 vssd1 vccd1 sky130_fd_sc_hd__tapvpwrvgnd_1
XTAP_359 vssd1 vccd1 sky130_fd_sc_hd__tapvpwrvgnd_1
X_13028_ clknet_leaf_47_clk_i _00414_ net1160 vssd1 vssd1 vccd1 vccd1 x0mx2\[17\]
+ sky130_fd_sc_hd__dfrtp_1
Xfanout1072 mul1.a\[10\] vssd1 vssd1 vccd1 vccd1 net1072 sky130_fd_sc_hd__clkbuf_4
Xfanout1050 net1056 vssd1 vssd1 vccd1 vccd1 net1050 sky130_fd_sc_hd__clkbuf_2
Xfanout1083 mul1.a\[8\] vssd1 vssd1 vccd1 vccd1 net1083 sky130_fd_sc_hd__clkbuf_4
Xfanout1061 mul1.a\[11\] vssd1 vssd1 vccd1 vccd1 net1061 sky130_fd_sc_hd__clkbuf_4
Xfanout1094 mul1.a\[7\] vssd1 vssd1 vccd1 vccd1 net1094 sky130_fd_sc_hd__clkbuf_4
XFILLER_0_89_632 vssd1 vssd1 vccd1 vccd1 sky130_fd_sc_hd__fill_2
XFILLER_0_83_57 vssd1 vssd1 vccd1 vccd1 sky130_ef_sc_hd__decap_12
XFILLER_0_20_9 vssd1 vssd1 vccd1 vccd1 sky130_ef_sc_hd__decap_12
XFILLER_0_88_131 vssd1 vssd1 vccd1 vccd1 sky130_fd_sc_hd__decap_6
X_07520_ net896 net1145 _01642_ _01643_ vssd1 vssd1 vccd1 vccd1 _01645_ sky130_fd_sc_hd__and4_1
XFILLER_0_88_175 vssd1 vssd1 vccd1 vccd1 sky130_ef_sc_hd__decap_12
XFILLER_0_88_164 vssd1 vssd1 vccd1 vccd1 sky130_fd_sc_hd__fill_1
XFILLER_0_119_417 vssd1 vssd1 vccd1 vccd1 sky130_ef_sc_hd__decap_12
XFILLER_0_88_197 vssd1 vssd1 vccd1 vccd1 sky130_fd_sc_hd__fill_2
X_07451_ _01572_ _01574_ vssd1 vssd1 vccd1 vccd1 _01576_ sky130_fd_sc_hd__nor2_1
X_06402_ add1.a_i\[19\] add1.b_i\[19\] vssd1 vssd1 vccd1 vccd1 _00708_ sky130_fd_sc_hd__and2_1
X_07382_ _01464_ _01505_ vssd1 vssd1 vccd1 vccd1 _01507_ sky130_fd_sc_hd__xnor2_1
X_09121_ _03223_ _03230_ _03231_ vssd1 vssd1 vccd1 vccd1 _03233_ sky130_fd_sc_hd__nand3_1
XFILLER_0_44_201 vssd1 vssd1 vccd1 vccd1 sky130_fd_sc_hd__fill_1
XFILLER_0_32_72 vssd1 vssd1 vccd1 vccd1 sky130_fd_sc_hd__fill_2
X_06333_ add1.a_i\[2\] add1.b_i\[2\] vssd1 vssd1 vccd1 vccd1 _00645_ sky130_fd_sc_hd__nand2_1
XFILLER_0_127_461 vssd1 vssd1 vccd1 vccd1 sky130_ef_sc_hd__decap_12
XFILLER_0_114_133 vssd1 vssd1 vccd1 vccd1 sky130_fd_sc_hd__decap_6
X_09052_ _03162_ _03163_ vssd1 vssd1 vccd1 vccd1 _03164_ sky130_fd_sc_hd__nand2_1
XFILLER_0_72_576 vssd1 vssd1 vccd1 vccd1 sky130_ef_sc_hd__decap_12
XFILLER_0_4_342 vssd1 vssd1 vccd1 vccd1 sky130_fd_sc_hd__fill_1
XFILLER_0_114_177 vssd1 vssd1 vccd1 vccd1 sky130_ef_sc_hd__decap_12
X_08003_ _02116_ _02121_ vssd1 vssd1 vccd1 vccd1 _02123_ sky130_fd_sc_hd__xnor2_2
Xhold500 posy\[7\] vssd1 vssd1 vccd1 vccd1 net1715 sky130_fd_sc_hd__dlygate4sd3_1
Xhold511 net356 vssd1 vssd1 vccd1 vccd1 net1726 sky130_fd_sc_hd__dlygate4sd3_1
XFILLER_0_4_386 vssd1 vssd1 vccd1 vccd1 sky130_fd_sc_hd__decap_3
XFILLER_0_12_153 vssd1 vssd1 vccd1 vccd1 sky130_ef_sc_hd__decap_12
Xhold522 net355 vssd1 vssd1 vccd1 vccd1 net1737 sky130_fd_sc_hd__dlygate4sd3_1
X_09954_ _04059_ _04060_ vssd1 vssd1 vccd1 vccd1 _04061_ sky130_fd_sc_hd__or2_1
X_08905_ _03011_ _03016_ vssd1 vssd1 vccd1 vccd1 _03018_ sky130_fd_sc_hd__xor2_1
X_09885_ _03855_ _03862_ _03861_ vssd1 vssd1 vccd1 vccd1 _03992_ sky130_fd_sc_hd__a21o_1
XTAP_860 vssd1 vccd1 sky130_fd_sc_hd__tapvpwrvgnd_1
XTAP_871 vssd1 vccd1 sky130_fd_sc_hd__tapvpwrvgnd_1
X_08836_ _02947_ _02948_ _02794_ _02796_ vssd1 vssd1 vccd1 vccd1 _02950_ sky130_fd_sc_hd__a211oi_1
XTAP_882 vssd1 vccd1 sky130_fd_sc_hd__tapvpwrvgnd_1
XTAP_893 vssd1 vccd1 sky130_fd_sc_hd__tapvpwrvgnd_1
X_08767_ _02866_ _02879_ vssd1 vssd1 vccd1 vccd1 _02881_ sky130_fd_sc_hd__and2_2
XFILLER_0_95_613 vssd1 vssd1 vccd1 vccd1 sky130_fd_sc_hd__decap_3
X_08698_ _02399_ _02400_ _02538_ _02537_ vssd1 vssd1 vccd1 vccd1 _02813_ sky130_fd_sc_hd__o31a_1
X_07718_ _01838_ net496 _01738_ _01742_ vssd1 vssd1 vccd1 vccd1 _01841_ sky130_fd_sc_hd__o211ai_2
XFILLER_0_94_134 vssd1 vssd1 vccd1 vccd1 sky130_fd_sc_hd__fill_1
X_07649_ _01766_ _01771_ vssd1 vssd1 vccd1 vccd1 _01772_ sky130_fd_sc_hd__and2_1
X_10660_ net1086 net699 net695 net1078 vssd1 vssd1 vccd1 vccd1 _04762_ sky130_fd_sc_hd__and4b_1
X_09319_ _03427_ _03428_ vssd1 vssd1 vccd1 vccd1 _03429_ sky130_fd_sc_hd__nor2_1
XFILLER_0_91_841 vssd1 vssd1 vccd1 vccd1 sky130_fd_sc_hd__fill_1
XFILLER_0_63_543 vssd1 vssd1 vccd1 vccd1 sky130_fd_sc_hd__fill_2
X_10591_ net836 net942 vssd1 vssd1 vccd1 vccd1 _04693_ sky130_fd_sc_hd__nand2_1
XFILLER_0_106_645 vssd1 vssd1 vccd1 vccd1 sky130_ef_sc_hd__decap_12
XFILLER_0_106_634 vssd1 vssd1 vccd1 vccd1 sky130_fd_sc_hd__decap_8
XFILLER_0_105_111 vssd1 vssd1 vccd1 vccd1 sky130_fd_sc_hd__fill_1
XFILLER_0_90_362 vssd1 vssd1 vccd1 vccd1 sky130_fd_sc_hd__fill_2
X_12330_ net1632 _00897_ net670 vssd1 vssd1 vccd1 vccd1 _00382_ sky130_fd_sc_hd__mux2_1
XFILLER_0_121_615 vssd1 vssd1 vccd1 vccd1 sky130_fd_sc_hd__fill_1
X_12261_ net1563 net57 net689 vssd1 vssd1 vccd1 vccd1 _00315_ sky130_fd_sc_hd__mux2_1
X_11212_ _05307_ _05308_ _05139_ _05186_ vssd1 vssd1 vccd1 vccd1 _05310_ sky130_fd_sc_hd__a211oi_2
X_12192_ x2mx1\[9\] net603 net583 temp1\[9\] vssd1 vssd1 vccd1 vccd1 _06148_ sky130_fd_sc_hd__a22o_1
X_11143_ _05239_ _05240_ vssd1 vssd1 vccd1 vccd1 _05241_ sky130_fd_sc_hd__and2_1
X_11074_ _04995_ _04997_ _05171_ vssd1 vssd1 vccd1 vccd1 _05173_ sky130_fd_sc_hd__a21o_1
Xinput120 v0y[8] vssd1 vssd1 vccd1 vccd1 net120 sky130_fd_sc_hd__buf_1
X_10025_ _04121_ _04130_ vssd1 vssd1 vccd1 vccd1 _04131_ sky130_fd_sc_hd__xnor2_2
Xinput142 v1x[28] vssd1 vssd1 vccd1 vccd1 net142 sky130_fd_sc_hd__clkbuf_1
Xinput153 v1x[9] vssd1 vssd1 vccd1 vccd1 net153 sky130_fd_sc_hd__buf_1
Xinput131 v1x[18] vssd1 vssd1 vccd1 vccd1 net131 sky130_fd_sc_hd__buf_1
Xinput175 v1y[29] vssd1 vssd1 vccd1 vccd1 net175 sky130_fd_sc_hd__clkbuf_1
Xinput164 v1y[19] vssd1 vssd1 vccd1 vccd1 net164 sky130_fd_sc_hd__clkbuf_1
Xinput186 v2x[0] vssd1 vssd1 vccd1 vccd1 net186 sky130_fd_sc_hd__buf_1
XFILLER_0_98_440 vssd1 vssd1 vccd1 vccd1 sky130_fd_sc_hd__decap_6
Xinput197 v2x[1] vssd1 vssd1 vccd1 vccd1 net197 sky130_fd_sc_hd__clkbuf_1
X_11976_ net131 net660 net504 net227 _05986_ vssd1 vssd1 vccd1 vccd1 _05987_ sky130_fd_sc_hd__a221o_1
XFILLER_0_86_668 vssd1 vssd1 vccd1 vccd1 sky130_fd_sc_hd__decap_8
X_10927_ net1055 net703 vssd1 vssd1 vccd1 vccd1 _05027_ sky130_fd_sc_hd__nand2_1
XFILLER_0_58_359 vssd1 vssd1 vccd1 vccd1 sky130_fd_sc_hd__fill_1
XFILLER_0_58_337 vssd1 vssd1 vccd1 vccd1 sky130_ef_sc_hd__decap_12
XFILLER_0_85_167 vssd1 vssd1 vccd1 vccd1 sky130_fd_sc_hd__fill_1
XFILLER_0_73_318 vssd1 vssd1 vccd1 vccd1 sky130_fd_sc_hd__fill_1
XPHY_170 vssd1 vssd1 vccd1 vccd1 sky130_fd_sc_hd__decap_3
X_10858_ net692 _04311_ _04825_ _04954_ vssd1 vssd1 vccd1 vccd1 _04958_ sky130_fd_sc_hd__a31o_4
XFILLER_0_39_573 vssd1 vssd1 vccd1 vccd1 sky130_ef_sc_hd__decap_12
XPHY_192 vssd1 vssd1 vccd1 vccd1 sky130_fd_sc_hd__decap_3
XPHY_181 vssd1 vssd1 vccd1 vccd1 sky130_fd_sc_hd__decap_3
X_10789_ _04737_ _04741_ _04887_ _04888_ vssd1 vssd1 vccd1 vccd1 _04890_ sky130_fd_sc_hd__a211oi_4
X_12528_ net1245 net566 vssd1 vssd1 vccd1 vccd1 _06261_ sky130_fd_sc_hd__nand2_1
XFILLER_0_54_598 vssd1 vssd1 vccd1 vccd1 sky130_fd_sc_hd__fill_1
XFILLER_0_54_587 vssd1 vssd1 vccd1 vccd1 sky130_fd_sc_hd__fill_1
XFILLER_0_41_204 vssd1 vssd1 vccd1 vccd1 sky130_fd_sc_hd__decap_8
XFILLER_0_124_475 vssd1 vssd1 vccd1 vccd1 sky130_fd_sc_hd__fill_1
X_12459_ _04526_ net576 _06224_ vssd1 vssd1 vccd1 vccd1 _06225_ sky130_fd_sc_hd__a21o_1
XFILLER_0_112_637 vssd1 vssd1 vccd1 vccd1 sky130_fd_sc_hd__decap_6
XFILLER_0_111_125 vssd1 vssd1 vccd1 vccd1 sky130_ef_sc_hd__decap_12
XFILLER_0_111_169 vssd1 vssd1 vccd1 vccd1 sky130_ef_sc_hd__decap_12
XFILLER_0_78_79 vssd1 vssd1 vccd1 vccd1 sky130_fd_sc_hd__decap_4
XFILLER_0_22_473 vssd1 vssd1 vccd1 vccd1 sky130_fd_sc_hd__decap_3
XFILLER_0_120_681 vssd1 vssd1 vccd1 vccd1 sky130_ef_sc_hd__decap_12
X_06951_ net905 net1073 vssd1 vssd1 vccd1 vccd1 _01076_ sky130_fd_sc_hd__nand2_1
XFILLER_0_118_41 vssd1 vssd1 vccd1 vccd1 sky130_ef_sc_hd__decap_12
X_09670_ net1078 net1086 net731 net724 vssd1 vssd1 vccd1 vccd1 _03778_ sky130_fd_sc_hd__nand4_2
XFILLER_0_118_85 vssd1 vssd1 vccd1 vccd1 sky130_ef_sc_hd__decap_12
X_08621_ _02608_ _02611_ vssd1 vssd1 vccd1 vccd1 _02736_ sky130_fd_sc_hd__nand2_1
X_06882_ _00782_ _00806_ _01009_ vssd1 vssd1 vccd1 vccd1 _01010_ sky130_fd_sc_hd__o21ai_1
XFILLER_0_77_613 vssd1 vssd1 vccd1 vccd1 sky130_fd_sc_hd__decap_3
X_08552_ _02666_ _02667_ vssd1 vssd1 vccd1 vccd1 _02668_ sky130_fd_sc_hd__nor2_1
X_08483_ net1043 net823 net815 net1051 vssd1 vssd1 vccd1 vccd1 _02599_ sky130_fd_sc_hd__a22o_1
XFILLER_0_49_337 vssd1 vssd1 vccd1 vccd1 sky130_fd_sc_hd__decap_6
X_07503_ _01618_ _01627_ vssd1 vssd1 vccd1 vccd1 _01628_ sky130_fd_sc_hd__and2_1
XFILLER_0_119_225 vssd1 vssd1 vccd1 vccd1 sky130_ef_sc_hd__decap_12
X_07434_ net917 net1105 net1112 net909 vssd1 vssd1 vccd1 vccd1 _01559_ sky130_fd_sc_hd__a22o_1
XFILLER_0_73_841 vssd1 vssd1 vccd1 vccd1 sky130_fd_sc_hd__fill_1
X_07365_ _01487_ _01489_ vssd1 vssd1 vccd1 vccd1 _01490_ sky130_fd_sc_hd__and2b_1
XFILLER_0_72_362 vssd1 vssd1 vccd1 vccd1 sky130_fd_sc_hd__fill_2
X_09104_ _03213_ _03214_ _03210_ vssd1 vssd1 vccd1 vccd1 _03216_ sky130_fd_sc_hd__a21o_1
X_06316_ add1.a_i\[10\] add1.b_i\[10\] vssd1 vssd1 vccd1 vccd1 _00628_ sky130_fd_sc_hd__or2_1
XFILLER_0_45_576 vssd1 vssd1 vccd1 vccd1 sky130_fd_sc_hd__fill_1
X_07296_ _01419_ _01420_ vssd1 vssd1 vccd1 vccd1 _01421_ sky130_fd_sc_hd__xnor2_2
XFILLER_0_103_615 vssd1 vssd1 vccd1 vccd1 sky130_fd_sc_hd__fill_1
X_09035_ _03124_ _03142_ _03144_ vssd1 vssd1 vccd1 vccd1 _03147_ sky130_fd_sc_hd__or3_1
XFILLER_0_72_395 vssd1 vssd1 vccd1 vccd1 sky130_fd_sc_hd__decap_3
XFILLER_0_115_497 vssd1 vssd1 vccd1 vccd1 sky130_fd_sc_hd__decap_6
XFILLER_0_4_194 vssd1 vssd1 vccd1 vccd1 sky130_fd_sc_hd__fill_2
XFILLER_0_130_467 vssd1 vssd1 vccd1 vccd1 sky130_fd_sc_hd__decap_3
Xhold330 net448 vssd1 vssd1 vccd1 vccd1 net1545 sky130_fd_sc_hd__dlygate4sd3_1
Xhold341 l0\[13\] vssd1 vssd1 vccd1 vccd1 net1556 sky130_fd_sc_hd__dlygate4sd3_1
Xhold352 add1.a_i\[17\] vssd1 vssd1 vccd1 vccd1 net1567 sky130_fd_sc_hd__dlygate4sd3_1
Xhold363 l1\[31\] vssd1 vssd1 vccd1 vccd1 net1578 sky130_fd_sc_hd__dlygate4sd3_1
Xhold385 l1\[0\] vssd1 vssd1 vccd1 vccd1 net1600 sky130_fd_sc_hd__dlygate4sd3_1
Xhold374 x0mx2\[16\] vssd1 vssd1 vccd1 vccd1 net1589 sky130_fd_sc_hd__dlygate4sd3_1
Xhold396 x2mx1\[12\] vssd1 vssd1 vccd1 vccd1 net1611 sky130_fd_sc_hd__dlygate4sd3_1
Xfanout821 net822 vssd1 vssd1 vccd1 vccd1 net821 sky130_fd_sc_hd__buf_2
Xfanout810 net811 vssd1 vssd1 vccd1 vccd1 net810 sky130_fd_sc_hd__clkbuf_4
X_09937_ _03854_ _03882_ _03881_ vssd1 vssd1 vccd1 vccd1 _04044_ sky130_fd_sc_hd__a21o_2
Xfanout832 mul1.b\[11\] vssd1 vssd1 vccd1 vccd1 net832 sky130_fd_sc_hd__clkbuf_2
Xfanout843 net844 vssd1 vssd1 vccd1 vccd1 net843 sky130_fd_sc_hd__clkbuf_4
Xfanout865 net866 vssd1 vssd1 vccd1 vccd1 net865 sky130_fd_sc_hd__clkbuf_4
Xfanout876 mul1.b\[6\] vssd1 vssd1 vccd1 vccd1 net876 sky130_fd_sc_hd__clkbuf_2
Xfanout854 net858 vssd1 vssd1 vccd1 vccd1 net854 sky130_fd_sc_hd__buf_2
X_09868_ _03974_ _03973_ _03972_ vssd1 vssd1 vccd1 vccd1 _03975_ sky130_fd_sc_hd__nand3b_1
Xfanout898 net900 vssd1 vssd1 vccd1 vccd1 net898 sky130_fd_sc_hd__buf_2
Xfanout887 net888 vssd1 vssd1 vccd1 vccd1 net887 sky130_fd_sc_hd__buf_2
XTAP_690 vssd1 vccd1 sky130_fd_sc_hd__tapvpwrvgnd_1
XFILLER_0_99_237 vssd1 vssd1 vccd1 vccd1 sky130_fd_sc_hd__fill_2
X_08819_ _02772_ _02780_ _02779_ vssd1 vssd1 vccd1 vccd1 _02933_ sky130_fd_sc_hd__a21bo_1
X_09799_ net1567 _03906_ net524 vssd1 vssd1 vccd1 vccd1 _00140_ sky130_fd_sc_hd__mux2_1
X_11830_ net1374 _05870_ net481 vssd1 vssd1 vccd1 vccd1 _00207_ sky130_fd_sc_hd__mux2_1
XTAP_1834 vssd1 vccd1 sky130_fd_sc_hd__tapvpwrvgnd_1
XTAP_1823 vssd1 vccd1 sky130_fd_sc_hd__tapvpwrvgnd_1
XTAP_1812 vssd1 vccd1 sky130_fd_sc_hd__tapvpwrvgnd_1
XTAP_1801 vssd1 vccd1 sky130_fd_sc_hd__tapvpwrvgnd_1
X_11761_ temp1\[10\] net614 net665 net91 _05811_ vssd1 vssd1 vccd1 vccd1 _05812_ sky130_fd_sc_hd__a221o_1
XTAP_1856 vssd1 vccd1 sky130_fd_sc_hd__tapvpwrvgnd_1
XTAP_1867 vssd1 vccd1 sky130_fd_sc_hd__tapvpwrvgnd_1
XTAP_1845 vssd1 vccd1 sky130_fd_sc_hd__tapvpwrvgnd_1
X_10712_ temp1\[23\] _04813_ net542 vssd1 vssd1 vccd1 vccd1 _04814_ sky130_fd_sc_hd__mux2_1
XTAP_1889 vssd1 vccd1 sky130_fd_sc_hd__tapvpwrvgnd_1
XTAP_1878 vssd1 vccd1 sky130_fd_sc_hd__tapvpwrvgnd_1
XFILLER_0_83_627 vssd1 vssd1 vccd1 vccd1 sky130_fd_sc_hd__decap_8
XFILLER_0_55_329 vssd1 vssd1 vccd1 vccd1 sky130_fd_sc_hd__decap_6
X_11692_ net1385 _05563_ net539 vssd1 vssd1 vccd1 vccd1 _00184_ sky130_fd_sc_hd__mux2_1
XFILLER_0_125_217 vssd1 vssd1 vccd1 vccd1 sky130_fd_sc_hd__fill_1
XFILLER_0_82_137 vssd1 vssd1 vccd1 vccd1 sky130_fd_sc_hd__decap_3
X_10643_ _04594_ _04598_ _04742_ _04743_ vssd1 vssd1 vccd1 vccd1 _04745_ sky130_fd_sc_hd__o211ai_4
X_10574_ _04432_ _04673_ _04674_ vssd1 vssd1 vccd1 vccd1 _04676_ sky130_fd_sc_hd__nand3_2
XFILLER_0_91_693 vssd1 vssd1 vccd1 vccd1 sky130_fd_sc_hd__fill_1
X_12313_ net1636 _00810_ net665 vssd1 vssd1 vccd1 vccd1 _00365_ sky130_fd_sc_hd__mux2_1
X_12244_ _00946_ net511 net468 y1my2\[26\] _06182_ vssd1 vssd1 vccd1 vccd1 _06183_
+ sky130_fd_sc_hd__a221o_1
XFILLER_0_102_670 vssd1 vssd1 vccd1 vccd1 sky130_ef_sc_hd__decap_12
X_12175_ _00823_ net509 net466 y1my2\[3\] _06136_ vssd1 vssd1 vccd1 vccd1 _06137_
+ sky130_fd_sc_hd__a221o_1
X_11126_ _05222_ _05223_ vssd1 vssd1 vccd1 vccd1 _05224_ sky130_fd_sc_hd__xnor2_2
X_11057_ _05150_ _05154_ vssd1 vssd1 vccd1 vccd1 _05156_ sky130_fd_sc_hd__xnor2_1
X_10008_ _04070_ _04113_ vssd1 vssd1 vccd1 vccd1 _04114_ sky130_fd_sc_hd__and2b_1
XFILLER_0_64_37 vssd1 vssd1 vccd1 vccd1 sky130_fd_sc_hd__fill_1
XFILLER_0_86_421 vssd1 vssd1 vccd1 vccd1 sky130_fd_sc_hd__decap_6
XFILLER_0_86_410 vssd1 vssd1 vccd1 vccd1 sky130_fd_sc_hd__fill_1
XFILLER_0_58_123 vssd1 vssd1 vccd1 vccd1 sky130_fd_sc_hd__decap_4
X_11959_ net7 net550 net625 net191 _05973_ vssd1 vssd1 vccd1 vccd1 _05974_ sky130_fd_sc_hd__a221o_1
XFILLER_0_104_65 vssd1 vssd1 vccd1 vccd1 sky130_ef_sc_hd__decap_12
XFILLER_0_55_841 vssd1 vssd1 vccd1 vccd1 sky130_fd_sc_hd__fill_1
XFILLER_0_70_811 vssd1 vssd1 vccd1 vccd1 sky130_fd_sc_hd__fill_1
X_07150_ net919 net910 net1074 net1081 vssd1 vssd1 vccd1 vccd1 _01275_ sky130_fd_sc_hd__nand4_1
XFILLER_0_112_401 vssd1 vssd1 vccd1 vccd1 sky130_ef_sc_hd__decap_12
X_07081_ net922 net914 net1026 net1032 vssd1 vssd1 vccd1 vccd1 _01206_ sky130_fd_sc_hd__nand4_1
XFILLER_0_120_53 vssd1 vssd1 vccd1 vccd1 sky130_ef_sc_hd__decap_12
Xoutput402 net402 vssd1 vssd1 vccd1 vccd1 mstream_o[57] sky130_fd_sc_hd__clkbuf_4
XFILLER_0_120_97 vssd1 vssd1 vccd1 vccd1 sky130_ef_sc_hd__decap_12
Xoutput435 net435 vssd1 vssd1 vccd1 vccd1 mstream_o[87] sky130_fd_sc_hd__clkbuf_4
XFILLER_0_112_445 vssd1 vssd1 vccd1 vccd1 sky130_ef_sc_hd__decap_12
Xoutput424 net424 vssd1 vssd1 vccd1 vccd1 mstream_o[77] sky130_fd_sc_hd__clkbuf_4
Xoutput413 net413 vssd1 vssd1 vccd1 vccd1 mstream_o[67] sky130_fd_sc_hd__buf_2
XFILLER_0_2_643 vssd1 vssd1 vccd1 vccd1 sky130_fd_sc_hd__fill_1
XFILLER_0_23_782 vssd1 vssd1 vccd1 vccd1 sky130_fd_sc_hd__fill_2
XFILLER_0_112_489 vssd1 vssd1 vccd1 vccd1 sky130_ef_sc_hd__decap_12
Xoutput446 net446 vssd1 vssd1 vccd1 vccd1 mstream_o[97] sky130_fd_sc_hd__clkbuf_4
XFILLER_0_10_421 vssd1 vssd1 vccd1 vccd1 sky130_fd_sc_hd__decap_3
X_09722_ _03689_ _03692_ _03828_ _03829_ vssd1 vssd1 vccd1 vccd1 _03830_ sky130_fd_sc_hd__a211o_1
X_07983_ _02100_ _02101_ net1067 net831 vssd1 vssd1 vccd1 vccd1 _02103_ sky130_fd_sc_hd__and4bb_1
X_06934_ net829 net1143 _01057_ _01058_ vssd1 vssd1 vccd1 vccd1 _01059_ sky130_fd_sc_hd__and4_1
X_09653_ _03759_ _03760_ vssd1 vssd1 vccd1 vccd1 _03761_ sky130_fd_sc_hd__and2b_1
X_06865_ net1151 _00608_ net631 _00987_ _00994_ vssd1 vssd1 vccd1 vccd1 _00995_ sky130_fd_sc_hd__a2111o_1
X_08604_ net1076 mul1.b\[17\] vssd1 vssd1 vccd1 vccd1 _02719_ sky130_fd_sc_hd__nand2_1
X_09584_ _03691_ _03692_ vssd1 vssd1 vccd1 vccd1 _03693_ sky130_fd_sc_hd__and2_1
X_08535_ _02649_ _02650_ _02616_ vssd1 vssd1 vccd1 vccd1 _02651_ sky130_fd_sc_hd__o21ai_1
X_06796_ net413 net1230 net644 vssd1 vssd1 vccd1 vccd1 _00070_ sky130_fd_sc_hd__mux2_1
XTAP_1119 vssd1 vccd1 sky130_fd_sc_hd__tapvpwrvgnd_1
XTAP_1108 vssd1 vccd1 sky130_fd_sc_hd__tapvpwrvgnd_1
XFILLER_0_92_424 vssd1 vssd1 vccd1 vccd1 sky130_fd_sc_hd__fill_1
XFILLER_0_92_402 vssd1 vssd1 vccd1 vccd1 sky130_fd_sc_hd__decap_3
X_08466_ _02576_ _02580_ _02581_ vssd1 vssd1 vccd1 vccd1 _02582_ sky130_fd_sc_hd__nand3_1
XFILLER_0_64_104 vssd1 vssd1 vccd1 vccd1 sky130_fd_sc_hd__fill_1
XFILLER_0_37_318 vssd1 vssd1 vccd1 vccd1 sky130_fd_sc_hd__fill_1
X_08397_ _02510_ _02511_ _02512_ vssd1 vssd1 vccd1 vccd1 _02514_ sky130_fd_sc_hd__a21o_1
X_07417_ _01532_ _01536_ _01535_ vssd1 vssd1 vccd1 vccd1 _01542_ sky130_fd_sc_hd__o21a_1
X_07348_ _01413_ _01467_ _01472_ vssd1 vssd1 vccd1 vccd1 _01473_ sky130_fd_sc_hd__nand3_1
XFILLER_0_122_209 vssd1 vssd1 vccd1 vccd1 sky130_ef_sc_hd__decap_12
XFILLER_0_61_833 vssd1 vssd1 vccd1 vccd1 sky130_fd_sc_hd__decap_6
XFILLER_0_60_321 vssd1 vssd1 vccd1 vccd1 sky130_ef_sc_hd__decap_12
XFILLER_0_115_261 vssd1 vssd1 vccd1 vccd1 sky130_ef_sc_hd__decap_12
XFILLER_0_60_365 vssd1 vssd1 vccd1 vccd1 sky130_fd_sc_hd__decap_4
X_07279_ _01269_ _01271_ _01401_ _01402_ vssd1 vssd1 vccd1 vccd1 _01404_ sky130_fd_sc_hd__a211o_1
XFILLER_0_130_253 vssd1 vssd1 vccd1 vccd1 sky130_fd_sc_hd__fill_2
X_09018_ net1124 net720 vssd1 vssd1 vccd1 vccd1 _03130_ sky130_fd_sc_hd__nand2_1
X_10290_ _04393_ vssd1 vssd1 vccd1 vccd1 _04394_ sky130_fd_sc_hd__inv_2
Xhold160 x0mx2\[0\] vssd1 vssd1 vccd1 vccd1 net1375 sky130_fd_sc_hd__dlygate4sd3_1
Xhold171 y2my0\[1\] vssd1 vssd1 vccd1 vccd1 net1386 sky130_fd_sc_hd__dlygate4sd3_1
XFILLER_0_41_590 vssd1 vssd1 vccd1 vccd1 sky130_fd_sc_hd__decap_3
Xhold193 net436 vssd1 vssd1 vccd1 vccd1 net1408 sky130_fd_sc_hd__dlygate4sd3_1
Xhold182 y2my0\[20\] vssd1 vssd1 vccd1 vccd1 net1397 sky130_fd_sc_hd__dlygate4sd3_1
Xfanout651 _00599_ vssd1 vssd1 vccd1 vccd1 net651 sky130_fd_sc_hd__clkbuf_4
Xfanout640 net650 vssd1 vssd1 vccd1 vccd1 net640 sky130_fd_sc_hd__buf_2
Xfanout662 net663 vssd1 vssd1 vccd1 vccd1 net662 sky130_fd_sc_hd__clkbuf_2
Xfanout684 _00805_ vssd1 vssd1 vccd1 vccd1 net684 sky130_fd_sc_hd__clkbuf_4
Xfanout673 _00998_ vssd1 vssd1 vccd1 vccd1 net673 sky130_fd_sc_hd__clkbuf_4
X_12931_ clknet_leaf_8_clk_i _00317_ net1193 vssd1 vssd1 vccd1 vccd1 posx\[2\] sky130_fd_sc_hd__dfrtp_1
Xfanout695 mul1.b\[31\] vssd1 vssd1 vccd1 vccd1 net695 sky130_fd_sc_hd__clkbuf_4
Xclkbuf_leaf_42_clk_i clknet_3_3__leaf_clk_i vssd1 vssd1 vccd1 vccd1 clknet_leaf_42_clk_i
+ sky130_fd_sc_hd__clkbuf_16
X_12862_ clknet_leaf_28_clk_i _00248_ vssd1 vssd1 vccd1 vccd1 sub1.b_i\[29\] sky130_fd_sc_hd__dfxtp_1
XFILLER_0_68_421 vssd1 vssd1 vccd1 vccd1 sky130_fd_sc_hd__fill_1
X_11813_ net99 net669 _05853_ _05855_ vssd1 vssd1 vccd1 vccd1 _05856_ sky130_fd_sc_hd__a211o_1
XTAP_1642 vssd1 vccd1 sky130_fd_sc_hd__tapvpwrvgnd_1
XTAP_1631 vssd1 vccd1 sky130_fd_sc_hd__tapvpwrvgnd_1
XTAP_1620 vssd1 vccd1 sky130_fd_sc_hd__tapvpwrvgnd_1
X_12793_ clknet_leaf_18_clk_i _00179_ vssd1 vssd1 vccd1 vccd1 add1.b_i\[24\] sky130_fd_sc_hd__dfxtp_1
Xclkbuf_leaf_57_clk_i clknet_3_0__leaf_clk_i vssd1 vssd1 vccd1 vccd1 clknet_leaf_57_clk_i
+ sky130_fd_sc_hd__clkbuf_16
XTAP_1664 vssd1 vccd1 sky130_fd_sc_hd__tapvpwrvgnd_1
XTAP_1675 vssd1 vccd1 sky130_fd_sc_hd__tapvpwrvgnd_1
XTAP_1653 vssd1 vccd1 sky130_fd_sc_hd__tapvpwrvgnd_1
X_11744_ net247 net598 net578 net151 _05797_ vssd1 vssd1 vccd1 vccd1 _05798_ sky130_fd_sc_hd__a221o_1
XTAP_1697 vssd1 vccd1 sky130_fd_sc_hd__tapvpwrvgnd_1
XTAP_1686 vssd1 vccd1 sky130_fd_sc_hd__tapvpwrvgnd_1
XFILLER_0_55_159 vssd1 vssd1 vccd1 vccd1 sky130_fd_sc_hd__fill_1
XFILLER_0_55_137 vssd1 vssd1 vccd1 vccd1 sky130_fd_sc_hd__fill_2
X_11675_ net1325 _03111_ net537 vssd1 vssd1 vccd1 vccd1 _00167_ sky130_fd_sc_hd__mux2_1
XFILLER_0_37_841 vssd1 vssd1 vccd1 vccd1 sky130_fd_sc_hd__fill_1
X_10626_ net799 net789 net970 net965 vssd1 vssd1 vccd1 vccd1 _04728_ sky130_fd_sc_hd__and4_1
XFILLER_0_106_250 vssd1 vssd1 vccd1 vccd1 sky130_fd_sc_hd__fill_2
X_10557_ _04658_ _04659_ vssd1 vssd1 vccd1 vccd1 _04660_ sky130_fd_sc_hd__and2b_1
X_10488_ _04589_ _04590_ _04582_ vssd1 vssd1 vccd1 vccd1 _04591_ sky130_fd_sc_hd__a21o_1
XFILLER_0_59_48 vssd1 vssd1 vccd1 vccd1 sky130_fd_sc_hd__fill_2
X_12227_ net757 _06171_ net519 vssd1 vssd1 vccd1 vccd1 _00303_ sky130_fd_sc_hd__mux2_1
X_12158_ _00970_ _06124_ net501 vssd1 vssd1 vccd1 vccd1 _06125_ sky130_fd_sc_hd__mux2_1
XFILLER_0_75_69 vssd1 vssd1 vccd1 vccd1 sky130_fd_sc_hd__fill_1
X_11109_ net836 _04836_ vssd1 vssd1 vccd1 vccd1 _05207_ sky130_fd_sc_hd__nand2_2
X_12089_ y2my0\[13\] net583 net532 x2mx1\[13\] _06072_ vssd1 vssd1 vccd1 vccd1 _06073_
+ sky130_fd_sc_hd__a221o_1
X_06650_ _00873_ _00876_ _00874_ vssd1 vssd1 vccd1 vccd1 _00881_ sky130_fd_sc_hd__a21oi_4
XFILLER_0_91_57 vssd1 vssd1 vccd1 vccd1 sky130_ef_sc_hd__decap_12
X_06581_ _00819_ _00822_ vssd1 vssd1 vccd1 vccd1 _00823_ sky130_fd_sc_hd__xnor2_4
X_08320_ _02433_ _02436_ vssd1 vssd1 vccd1 vccd1 _02437_ sky130_fd_sc_hd__xor2_1
XFILLER_0_74_446 vssd1 vssd1 vccd1 vccd1 sky130_fd_sc_hd__fill_2
XFILLER_0_62_608 vssd1 vssd1 vccd1 vccd1 sky130_fd_sc_hd__decap_4
X_08251_ _02365_ _02366_ _02367_ vssd1 vssd1 vccd1 vccd1 _02369_ sky130_fd_sc_hd__nand3_1
XFILLER_0_28_841 vssd1 vssd1 vccd1 vccd1 sky130_fd_sc_hd__fill_1
XFILLER_0_117_559 vssd1 vssd1 vccd1 vccd1 sky130_fd_sc_hd__fill_1
X_07202_ net1137 net1144 net798 net788 vssd1 vssd1 vccd1 vccd1 _01327_ sky130_fd_sc_hd__and4_1
X_08182_ _02299_ vssd1 vssd1 vccd1 vccd1 _02300_ sky130_fd_sc_hd__inv_2
XFILLER_0_113_721 vssd1 vssd1 vccd1 vccd1 sky130_fd_sc_hd__decap_6
X_07133_ _01254_ _01255_ _01175_ _01195_ vssd1 vssd1 vccd1 vccd1 _01258_ sky130_fd_sc_hd__a211o_1
X_07064_ _01183_ _01188_ vssd1 vssd1 vccd1 vccd1 _01189_ sky130_fd_sc_hd__and2_1
XFILLER_0_112_253 vssd1 vssd1 vccd1 vccd1 sky130_ef_sc_hd__decap_12
XFILLER_0_100_426 vssd1 vssd1 vccd1 vccd1 sky130_fd_sc_hd__fill_2
XFILLER_0_64_3 vssd1 vssd1 vccd1 vccd1 sky130_fd_sc_hd__decap_4
Xoutput276 net276 vssd1 vssd1 vccd1 vccd1 div_mstream_o[31] sky130_fd_sc_hd__clkbuf_4
Xoutput265 net265 vssd1 vssd1 vccd1 vccd1 div_mstream_o[21] sky130_fd_sc_hd__clkbuf_4
Xoutput254 net254 vssd1 vssd1 vccd1 vccd1 div_mstream_o[11] sky130_fd_sc_hd__clkbuf_4
XFILLER_0_11_785 vssd1 vssd1 vccd1 vccd1 sky130_ef_sc_hd__decap_12
Xoutput298 net298 vssd1 vssd1 vccd1 vccd1 div_mstream_o[66] sky130_fd_sc_hd__clkbuf_4
Xoutput287 net287 vssd1 vssd1 vccd1 vccd1 div_mstream_o[41] sky130_fd_sc_hd__clkbuf_4
XFILLER_0_10_273 vssd1 vssd1 vccd1 vccd1 sky130_fd_sc_hd__fill_2
X_07966_ _01966_ _01974_ _01973_ vssd1 vssd1 vccd1 vccd1 _02086_ sky130_fd_sc_hd__a21o_1
X_09705_ _03803_ _03812_ vssd1 vssd1 vccd1 vccd1 _03813_ sky130_fd_sc_hd__xnor2_2
X_06917_ net846 net837 net1118 net1126 vssd1 vssd1 vccd1 vccd1 _01042_ sky130_fd_sc_hd__and4_1
X_09636_ _03743_ _03744_ vssd1 vssd1 vccd1 vccd1 _03745_ sky130_fd_sc_hd__nor2_2
X_07897_ net1015 net898 net889 net1007 vssd1 vssd1 vccd1 vccd1 _02018_ sky130_fd_sc_hd__and4_1
X_06848_ net37 _00617_ _00803_ net35 vssd1 vssd1 vccd1 vccd1 _00979_ sky130_fd_sc_hd__o2bb2a_1
X_09567_ net998 _03675_ _03674_ vssd1 vssd1 vccd1 vccd1 _03676_ sky130_fd_sc_hd__a21bo_1
X_06779_ net1424 l1\[18\] net638 vssd1 vssd1 vccd1 vccd1 _00053_ sky130_fd_sc_hd__mux2_1
X_09498_ _03431_ _03439_ _03605_ vssd1 vssd1 vccd1 vccd1 _03607_ sky130_fd_sc_hd__a21o_1
X_08518_ net913 net961 net955 net921 vssd1 vssd1 vccd1 vccd1 _02634_ sky130_fd_sc_hd__a22o_1
X_08449_ _02563_ _02564_ vssd1 vssd1 vccd1 vccd1 _02565_ sky130_fd_sc_hd__xnor2_1
XFILLER_0_19_841 vssd1 vssd1 vccd1 vccd1 sky130_fd_sc_hd__fill_1
XFILLER_0_80_438 vssd1 vssd1 vccd1 vccd1 sky130_fd_sc_hd__fill_1
XFILLER_0_80_427 vssd1 vssd1 vccd1 vccd1 sky130_fd_sc_hd__fill_1
X_11460_ _05402_ _05405_ _05554_ _05555_ vssd1 vssd1 vccd1 vccd1 _05556_ sky130_fd_sc_hd__a211oi_2
XFILLER_0_46_682 vssd1 vssd1 vccd1 vccd1 sky130_fd_sc_hd__decap_4
XFILLER_0_123_529 vssd1 vssd1 vccd1 vccd1 sky130_ef_sc_hd__decap_12
XFILLER_0_116_581 vssd1 vssd1 vccd1 vccd1 sky130_fd_sc_hd__decap_6
X_10411_ _04512_ _04513_ vssd1 vssd1 vccd1 vccd1 _04515_ sky130_fd_sc_hd__xor2_2
X_11391_ _05485_ _05486_ vssd1 vssd1 vccd1 vccd1 _05487_ sky130_fd_sc_hd__xnor2_1
X_13130_ clknet_leaf_4_clk_i _00516_ vssd1 vssd1 vccd1 vccd1 det_t\[23\] sky130_fd_sc_hd__dfxtp_1
XFILLER_0_103_231 vssd1 vssd1 vccd1 vccd1 sky130_fd_sc_hd__decap_6
X_10342_ _04317_ _04325_ _04324_ vssd1 vssd1 vccd1 vccd1 _04446_ sky130_fd_sc_hd__a21bo_1
XFILLER_0_33_387 vssd1 vssd1 vccd1 vccd1 sky130_fd_sc_hd__decap_4
XFILLER_0_103_275 vssd1 vssd1 vccd1 vccd1 sky130_fd_sc_hd__decap_4
X_13061_ clknet_leaf_36_clk_i _00447_ net1161 vssd1 vssd1 vccd1 vccd1 y2my0\[18\]
+ sky130_fd_sc_hd__dfrtp_1
X_10273_ _04063_ _04376_ _04377_ _04219_ vssd1 vssd1 vccd1 vccd1 _04378_ sky130_fd_sc_hd__o211a_1
X_12012_ net141 net661 net505 net237 _06013_ vssd1 vssd1 vccd1 vccd1 _06014_ sky130_fd_sc_hd__a221o_1
Xfanout481 net484 vssd1 vssd1 vccd1 vccd1 net481 sky130_fd_sc_hd__clkbuf_4
Xfanout470 net472 vssd1 vssd1 vccd1 vccd1 net470 sky130_fd_sc_hd__clkbuf_4
Xmax_cap6 _03247_ vssd1 vssd1 vccd1 vccd1 net1747 sky130_fd_sc_hd__clkbuf_1
X_12914_ clknet_leaf_47_clk_i _00300_ vssd1 vssd1 vccd1 vccd1 mul1.b\[17\] sky130_fd_sc_hd__dfxtp_4
XTAP_2162 vssd1 vccd1 sky130_fd_sc_hd__tapvpwrvgnd_1
XTAP_2151 vssd1 vccd1 sky130_fd_sc_hd__tapvpwrvgnd_1
XTAP_2140 vssd1 vccd1 sky130_fd_sc_hd__tapvpwrvgnd_1
XFILLER_0_69_741 vssd1 vssd1 vccd1 vccd1 sky130_fd_sc_hd__decap_8
X_12845_ clknet_leaf_50_clk_i _00231_ vssd1 vssd1 vccd1 vccd1 sub1.b_i\[12\] sky130_fd_sc_hd__dfxtp_1
XTAP_2195 vssd1 vccd1 sky130_fd_sc_hd__tapvpwrvgnd_1
XTAP_2184 vssd1 vccd1 sky130_fd_sc_hd__tapvpwrvgnd_1
XTAP_2173 vssd1 vccd1 sky130_fd_sc_hd__tapvpwrvgnd_1
XTAP_1450 vssd1 vccd1 sky130_fd_sc_hd__tapvpwrvgnd_1
X_12776_ clknet_leaf_58_clk_i _00162_ vssd1 vssd1 vccd1 vccd1 add1.b_i\[7\] sky130_fd_sc_hd__dfxtp_1
XTAP_1472 vssd1 vccd1 sky130_fd_sc_hd__tapvpwrvgnd_1
XTAP_1483 vssd1 vccd1 sky130_fd_sc_hd__tapvpwrvgnd_1
XTAP_1461 vssd1 vccd1 sky130_fd_sc_hd__tapvpwrvgnd_1
XFILLER_0_68_295 vssd1 vssd1 vccd1 vccd1 sky130_ef_sc_hd__decap_12
X_11727_ net84 net677 net607 net212 vssd1 vssd1 vccd1 vccd1 _05784_ sky130_fd_sc_hd__a22o_1
XFILLER_0_126_323 vssd1 vssd1 vccd1 vccd1 sky130_fd_sc_hd__fill_2
XTAP_1494 vssd1 vccd1 sky130_fd_sc_hd__tapvpwrvgnd_1
XFILLER_0_9_39 vssd1 vssd1 vccd1 vccd1 sky130_ef_sc_hd__decap_12
X_11658_ net1310 _05751_ _01014_ vssd1 vssd1 vccd1 vccd1 _00154_ sky130_fd_sc_hd__mux2_1
X_10609_ net1005 net753 net744 net1013 vssd1 vssd1 vccd1 vccd1 _04711_ sky130_fd_sc_hd__a22o_1
XFILLER_0_4_749 vssd1 vssd1 vccd1 vccd1 sky130_fd_sc_hd__decap_3
XFILLER_0_3_215 vssd1 vssd1 vccd1 vccd1 sky130_fd_sc_hd__fill_2
X_11589_ net983 net718 net694 net1019 vssd1 vssd1 vccd1 vccd1 _05683_ sky130_fd_sc_hd__a211o_1
XFILLER_0_101_55 vssd1 vssd1 vccd1 vccd1 sky130_fd_sc_hd__fill_1
XFILLER_0_52_674 vssd1 vssd1 vccd1 vccd1 sky130_fd_sc_hd__decap_3
XFILLER_0_10_53 vssd1 vssd1 vccd1 vccd1 sky130_ef_sc_hd__decap_12
XFILLER_0_24_365 vssd1 vssd1 vccd1 vccd1 sky130_fd_sc_hd__decap_3
XFILLER_0_110_713 vssd1 vssd1 vccd1 vccd1 sky130_ef_sc_hd__decap_12
XFILLER_0_51_195 vssd1 vssd1 vccd1 vccd1 sky130_fd_sc_hd__fill_2
XFILLER_0_110_757 vssd1 vssd1 vccd1 vccd1 sky130_fd_sc_hd__fill_1
XFILLER_0_86_68 vssd1 vssd1 vccd1 vccd1 sky130_ef_sc_hd__decap_12
X_07820_ _01940_ _01941_ vssd1 vssd1 vccd1 vccd1 _01942_ sky130_fd_sc_hd__and2b_1
XFILLER_0_19_51 vssd1 vssd1 vccd1 vccd1 sky130_fd_sc_hd__decap_4
X_07751_ _01858_ _01871_ vssd1 vssd1 vccd1 vccd1 _01873_ sky130_fd_sc_hd__xor2_1
X_06702_ _00919_ _00922_ _00920_ vssd1 vssd1 vccd1 vccd1 _00924_ sky130_fd_sc_hd__o21a_2
XFILLER_0_126_41 vssd1 vssd1 vccd1 vccd1 sky130_ef_sc_hd__decap_12
X_07682_ _01695_ _01697_ _01801_ _01802_ vssd1 vssd1 vccd1 vccd1 _01805_ sky130_fd_sc_hd__o211ai_2
XFILLER_0_126_85 vssd1 vssd1 vccd1 vccd1 sky130_ef_sc_hd__decap_12
X_09421_ _03373_ _03376_ _03529_ _03530_ vssd1 vssd1 vccd1 vccd1 _03531_ sky130_fd_sc_hd__o211a_1
X_06633_ _00863_ _00866_ vssd1 vssd1 vccd1 vccd1 _00867_ sky130_fd_sc_hd__xor2_4
X_09352_ _03458_ _03460_ _03293_ _03296_ vssd1 vssd1 vccd1 vccd1 _03462_ sky130_fd_sc_hd__a211oi_1
X_06564_ sub1.b_i\[0\] sub1.a_i\[0\] vssd1 vssd1 vccd1 vccd1 _00809_ sky130_fd_sc_hd__nand2b_1
X_08303_ _02306_ _02308_ _02419_ vssd1 vssd1 vccd1 vccd1 _02420_ sky130_fd_sc_hd__a21oi_2
X_06495_ det_t\[5\] net528 vssd1 vssd1 vccd1 vccd1 net295 sky130_fd_sc_hd__and2_1
XFILLER_0_74_276 vssd1 vssd1 vccd1 vccd1 sky130_fd_sc_hd__fill_1
X_09283_ _03235_ _03239_ _03391_ _03392_ vssd1 vssd1 vccd1 vccd1 _03394_ sky130_fd_sc_hd__a211o_1
XFILLER_0_7_532 vssd1 vssd1 vccd1 vccd1 sky130_fd_sc_hd__decap_3
X_08234_ net1015 net865 net1007 net875 vssd1 vssd1 vccd1 vccd1 _02352_ sky130_fd_sc_hd__a22o_1
XFILLER_0_62_449 vssd1 vssd1 vccd1 vccd1 sky130_fd_sc_hd__fill_2
XFILLER_0_28_671 vssd1 vssd1 vccd1 vccd1 sky130_fd_sc_hd__decap_4
X_08165_ _02281_ _02283_ vssd1 vssd1 vccd1 vccd1 _02284_ sky130_fd_sc_hd__xor2_2
XFILLER_0_43_663 vssd1 vssd1 vccd1 vccd1 sky130_fd_sc_hd__fill_1
X_07116_ _01238_ _01239_ vssd1 vssd1 vccd1 vccd1 _01241_ sky130_fd_sc_hd__xnor2_1
XFILLER_0_42_173 vssd1 vssd1 vccd1 vccd1 sky130_fd_sc_hd__decap_6
XFILLER_0_113_573 vssd1 vssd1 vccd1 vccd1 sky130_ef_sc_hd__decap_12
X_08096_ net1043 net849 net839 net1051 vssd1 vssd1 vccd1 vccd1 _02215_ sky130_fd_sc_hd__a22o_1
X_07047_ _01158_ _01159_ _01170_ vssd1 vssd1 vccd1 vccd1 _01172_ sky130_fd_sc_hd__nand3_2
XFILLER_0_11_593 vssd1 vssd1 vccd1 vccd1 sky130_fd_sc_hd__decap_3
X_08998_ _03106_ _03110_ vssd1 vssd1 vccd1 vccd1 _03111_ sky130_fd_sc_hd__xor2_2
X_07949_ net1139 net755 _02065_ _02067_ vssd1 vssd1 vccd1 vccd1 _02069_ sky130_fd_sc_hd__a22oi_1
X_10960_ _04887_ _04890_ _05058_ _05059_ vssd1 vssd1 vccd1 vccd1 _05060_ sky130_fd_sc_hd__o211a_1
X_09619_ _03556_ _03559_ _03726_ _03727_ vssd1 vssd1 vccd1 vccd1 _03728_ sky130_fd_sc_hd__o211ai_2
X_10891_ _04989_ _04990_ vssd1 vssd1 vccd1 vccd1 _04991_ sky130_fd_sc_hd__nand2b_1
X_12630_ clknet_leaf_47_clk_i _00016_ net1160 vssd1 vssd1 vccd1 vccd1 net354 sky130_fd_sc_hd__dfrtp_2
XFILLER_0_38_402 vssd1 vssd1 vccd1 vccd1 sky130_fd_sc_hd__fill_1
XFILLER_0_109_813 vssd1 vssd1 vccd1 vccd1 sky130_fd_sc_hd__fill_1
XFILLER_0_66_744 vssd1 vssd1 vccd1 vccd1 sky130_fd_sc_hd__decap_4
X_12561_ net1449 net5 net559 vssd1 vssd1 vccd1 vccd1 _00537_ sky130_fd_sc_hd__mux2_1
XFILLER_0_53_405 vssd1 vssd1 vccd1 vccd1 sky130_ef_sc_hd__decap_12
XFILLER_0_38_457 vssd1 vssd1 vccd1 vccd1 sky130_fd_sc_hd__decap_8
XFILLER_0_124_805 vssd1 vssd1 vccd1 vccd1 sky130_fd_sc_hd__decap_6
X_12492_ net1248 net568 vssd1 vssd1 vccd1 vccd1 _06243_ sky130_fd_sc_hd__nor2_1
XFILLER_0_81_747 vssd1 vssd1 vccd1 vccd1 sky130_fd_sc_hd__decap_8
XFILLER_0_80_213 vssd1 vssd1 vccd1 vccd1 sky130_fd_sc_hd__decap_3
X_11512_ _05461_ _05462_ _05502_ vssd1 vssd1 vccd1 vccd1 _05607_ sky130_fd_sc_hd__o21ai_1
X_11443_ _05418_ _05421_ _05537_ _05538_ vssd1 vssd1 vccd1 vccd1 _05539_ sky130_fd_sc_hd__a211oi_2
XFILLER_0_34_641 vssd1 vssd1 vccd1 vccd1 sky130_fd_sc_hd__decap_3
XFILLER_0_123_337 vssd1 vssd1 vccd1 vccd1 sky130_ef_sc_hd__decap_12
Xbary_pipe_m_1213 vssd1 vssd1 vccd1 vccd1 bary_pipe_m_1213/HI div_mstream_o[63] sky130_fd_sc_hd__conb_1
Xbary_pipe_m_1202 vssd1 vssd1 vccd1 vccd1 bary_pipe_m_1202/HI div_mstream_o[52] sky130_fd_sc_hd__conb_1
X_13113_ clknet_leaf_2_clk_i _00499_ vssd1 vssd1 vccd1 vccd1 det_t\[6\] sky130_fd_sc_hd__dfxtp_1
XFILLER_0_21_346 vssd1 vssd1 vccd1 vccd1 sky130_fd_sc_hd__decap_4
X_11374_ net765 net952 net946 net775 vssd1 vssd1 vccd1 vccd1 _05470_ sky130_fd_sc_hd__a22o_1
X_10325_ net692 _04311_ _04428_ vssd1 vssd1 vccd1 vccd1 _04429_ sky130_fd_sc_hd__a21oi_4
X_10256_ _04360_ _04359_ vssd1 vssd1 vccd1 vccd1 _04361_ sky130_fd_sc_hd__and2b_1
XTAP_508 vssd1 vccd1 sky130_fd_sc_hd__tapvpwrvgnd_1
XTAP_519 vssd1 vccd1 sky130_fd_sc_hd__tapvpwrvgnd_1
X_13044_ clknet_leaf_48_clk_i _00430_ net1160 vssd1 vssd1 vccd1 vccd1 y2my0\[1\] sky130_fd_sc_hd__dfrtp_1
X_10187_ _04291_ _04290_ _04289_ vssd1 vssd1 vccd1 vccd1 _04292_ sky130_fd_sc_hd__nand3b_1
XFILLER_0_88_357 vssd1 vssd1 vccd1 vccd1 sky130_fd_sc_hd__decap_6
XFILLER_0_72_37 vssd1 vssd1 vccd1 vccd1 sky130_fd_sc_hd__fill_1
XFILLER_0_118_109 vssd1 vssd1 vccd1 vccd1 sky130_ef_sc_hd__decap_12
X_12828_ clknet_leaf_29_clk_i _00214_ vssd1 vssd1 vccd1 vccd1 sub1.a_i\[27\] sky130_fd_sc_hd__dfxtp_1
XTAP_1280 vssd1 vccd1 sky130_fd_sc_hd__tapvpwrvgnd_1
XTAP_1291 vssd1 vccd1 sky130_fd_sc_hd__tapvpwrvgnd_1
XFILLER_0_56_265 vssd1 vssd1 vccd1 vccd1 sky130_fd_sc_hd__fill_1
XFILLER_0_56_243 vssd1 vssd1 vccd1 vccd1 sky130_fd_sc_hd__fill_1
X_12759_ clknet_leaf_17_clk_i _00145_ vssd1 vssd1 vccd1 vccd1 add1.a_i\[22\] sky130_fd_sc_hd__dfxtp_1
XFILLER_0_127_654 vssd1 vssd1 vccd1 vccd1 sky130_fd_sc_hd__fill_2
XFILLER_0_122_3 vssd1 vssd1 vccd1 vccd1 sky130_ef_sc_hd__decap_12
XFILLER_0_98_9 vssd1 vssd1 vccd1 vccd1 sky130_ef_sc_hd__decap_12
XFILLER_0_72_725 vssd1 vssd1 vccd1 vccd1 sky130_ef_sc_hd__decap_12
XFILLER_0_71_213 vssd1 vssd1 vccd1 vccd1 sky130_fd_sc_hd__fill_2
X_06280_ last vssd1 vssd1 vccd1 vccd1 _00596_ sky130_fd_sc_hd__inv_2
XFILLER_0_112_65 vssd1 vssd1 vccd1 vccd1 sky130_ef_sc_hd__decap_12
XFILLER_0_71_279 vssd1 vssd1 vccd1 vccd1 sky130_fd_sc_hd__fill_1
X_09970_ _04074_ _04075_ vssd1 vssd1 vccd1 vccd1 _04076_ sky130_fd_sc_hd__or2_1
XFILLER_0_0_741 vssd1 vssd1 vccd1 vccd1 sky130_fd_sc_hd__fill_2
Xmax_cap489 _03086_ vssd1 vssd1 vccd1 vccd1 net489 sky130_fd_sc_hd__clkbuf_1
X_08921_ net1035 net810 vssd1 vssd1 vccd1 vccd1 _03034_ sky130_fd_sc_hd__nand2_1
XFILLER_0_110_587 vssd1 vssd1 vccd1 vccd1 sky130_fd_sc_hd__fill_1
X_08852_ net1141 net716 net707 net1148 vssd1 vssd1 vccd1 vccd1 _02965_ sky130_fd_sc_hd__a22oi_1
XFILLER_0_0_785 vssd1 vssd1 vccd1 vccd1 sky130_fd_sc_hd__fill_2
X_07803_ _01922_ _01923_ _01924_ vssd1 vssd1 vccd1 vccd1 _01925_ sky130_fd_sc_hd__nand3_4
X_08783_ _02743_ _02745_ vssd1 vssd1 vccd1 vccd1 _02897_ sky130_fd_sc_hd__or2_1
X_07734_ net1142 net774 net771 net1147 vssd1 vssd1 vccd1 vccd1 _01856_ sky130_fd_sc_hd__a22o_1
XFILLER_0_79_368 vssd1 vssd1 vccd1 vccd1 sky130_fd_sc_hd__fill_1
X_07665_ _01787_ vssd1 vssd1 vccd1 vccd1 _01788_ sky130_fd_sc_hd__inv_2
X_09404_ _03511_ _03512_ _03513_ vssd1 vssd1 vccd1 vccd1 _03514_ sky130_fd_sc_hd__nand3_1
X_06616_ net1729 _00852_ net633 vssd1 vssd1 vccd1 vccd1 _00011_ sky130_fd_sc_hd__mux2_1
X_07596_ _01718_ _01719_ vssd1 vssd1 vccd1 vccd1 _01720_ sky130_fd_sc_hd__nor2_1
XFILLER_0_48_755 vssd1 vssd1 vccd1 vccd1 sky130_fd_sc_hd__fill_1
XFILLER_0_47_221 vssd1 vssd1 vccd1 vccd1 sky130_fd_sc_hd__decap_3
X_09335_ net728 _03285_ _03286_ _03287_ vssd1 vssd1 vccd1 vccd1 _03445_ sky130_fd_sc_hd__o2bb2ai_1
XFILLER_0_75_552 vssd1 vssd1 vccd1 vccd1 sky130_fd_sc_hd__decap_8
X_06547_ _00626_ _00627_ _00671_ vssd1 vssd1 vccd1 vccd1 _00797_ sky130_fd_sc_hd__nand3_1
XFILLER_0_118_643 vssd1 vssd1 vccd1 vccd1 sky130_fd_sc_hd__fill_1
XFILLER_0_75_585 vssd1 vssd1 vccd1 vccd1 sky130_fd_sc_hd__decap_6
X_09266_ _03375_ _03376_ vssd1 vssd1 vccd1 vccd1 _03377_ sky130_fd_sc_hd__nor2_1
X_06478_ _00770_ _00773_ vssd1 vssd1 vccd1 vccd1 _00774_ sky130_fd_sc_hd__xor2_4
XFILLER_0_105_315 vssd1 vssd1 vccd1 vccd1 sky130_fd_sc_hd__fill_2
XFILLER_0_90_555 vssd1 vssd1 vccd1 vccd1 sky130_fd_sc_hd__fill_1
X_08217_ _02331_ _02334_ vssd1 vssd1 vccd1 vccd1 _02335_ sky130_fd_sc_hd__xor2_1
XFILLER_0_62_235 vssd1 vssd1 vccd1 vccd1 sky130_fd_sc_hd__fill_1
XFILLER_0_35_449 vssd1 vssd1 vccd1 vccd1 sky130_fd_sc_hd__decap_6
X_09197_ net1094 net738 vssd1 vssd1 vccd1 vccd1 _03308_ sky130_fd_sc_hd__nand2_1
XFILLER_0_62_279 vssd1 vssd1 vccd1 vccd1 sky130_fd_sc_hd__fill_1
XFILLER_0_120_307 vssd1 vssd1 vccd1 vccd1 sky130_fd_sc_hd__fill_1
X_08148_ _02263_ _02265_ _02147_ _02149_ vssd1 vssd1 vccd1 vccd1 _02267_ sky130_fd_sc_hd__a211o_1
X_08079_ _02191_ _02196_ vssd1 vssd1 vccd1 vccd1 _02198_ sky130_fd_sc_hd__xor2_1
XFILLER_0_31_677 vssd1 vssd1 vccd1 vccd1 sky130_fd_sc_hd__fill_1
X_10110_ _04213_ _04214_ vssd1 vssd1 vccd1 vccd1 _04216_ sky130_fd_sc_hd__xor2_4
X_11090_ _05022_ net1745 _05187_ _05188_ vssd1 vssd1 vccd1 vccd1 _05189_ sky130_fd_sc_hd__o211ai_4
X_10041_ _04144_ _04146_ _04131_ vssd1 vssd1 vccd1 vccd1 _04147_ sky130_fd_sc_hd__a21o_1
Xhold20 det_t\[29\] vssd1 vssd1 vccd1 vccd1 net1235 sky130_fd_sc_hd__dlygate4sd3_1
Xhold31 det_t\[17\] vssd1 vssd1 vccd1 vccd1 net1246 sky130_fd_sc_hd__dlygate4sd3_1
Xhold53 det_t\[21\] vssd1 vssd1 vccd1 vccd1 net1268 sky130_fd_sc_hd__dlygate4sd3_1
Xhold42 det_t\[1\] vssd1 vssd1 vccd1 vccd1 net1257 sky130_fd_sc_hd__dlygate4sd3_1
Xhold64 sub1.b_i\[25\] vssd1 vssd1 vccd1 vccd1 net1279 sky130_fd_sc_hd__dlygate4sd3_1
XFILLER_0_98_611 vssd1 vssd1 vccd1 vccd1 sky130_fd_sc_hd__decap_4
Xhold86 add1.b_i\[10\] vssd1 vssd1 vccd1 vccd1 net1301 sky130_fd_sc_hd__dlygate4sd3_1
Xhold75 add1.b_i\[11\] vssd1 vssd1 vccd1 vccd1 net1290 sky130_fd_sc_hd__dlygate4sd3_1
X_11992_ net136 net660 net504 net232 _05998_ vssd1 vssd1 vccd1 vccd1 _05999_ sky130_fd_sc_hd__a221o_1
Xhold97 add1.b_i\[30\] vssd1 vssd1 vccd1 vccd1 net1312 sky130_fd_sc_hd__dlygate4sd3_1
X_10943_ net1020 net1012 net730 net722 vssd1 vssd1 vccd1 vccd1 _05043_ sky130_fd_sc_hd__and4_1
XFILLER_0_98_699 vssd1 vssd1 vccd1 vccd1 sky130_fd_sc_hd__fill_1
XFILLER_0_78_390 vssd1 vssd1 vccd1 vccd1 sky130_fd_sc_hd__decap_4
X_10874_ _04966_ _04973_ vssd1 vssd1 vccd1 vccd1 _04974_ sky130_fd_sc_hd__nor2_1
XFILLER_0_38_210 vssd1 vssd1 vccd1 vccd1 sky130_fd_sc_hd__decap_8
X_12613_ net1578 net26 net556 vssd1 vssd1 vccd1 vccd1 _00588_ sky130_fd_sc_hd__mux2_1
X_12544_ _00779_ net567 vssd1 vssd1 vccd1 vccd1 _06269_ sky130_fd_sc_hd__nor2_1
XFILLER_0_109_665 vssd1 vssd1 vccd1 vccd1 sky130_fd_sc_hd__decap_6
XFILLER_0_93_382 vssd1 vssd1 vccd1 vccd1 sky130_fd_sc_hd__decap_4
XFILLER_0_93_393 vssd1 vssd1 vccd1 vccd1 sky130_fd_sc_hd__fill_1
XFILLER_0_124_613 vssd1 vssd1 vccd1 vccd1 sky130_ef_sc_hd__decap_12
XFILLER_0_108_153 vssd1 vssd1 vccd1 vccd1 sky130_ef_sc_hd__decap_12
XFILLER_0_53_246 vssd1 vssd1 vccd1 vccd1 sky130_fd_sc_hd__decap_8
XFILLER_0_124_657 vssd1 vssd1 vccd1 vccd1 sky130_ef_sc_hd__decap_12
XFILLER_0_108_197 vssd1 vssd1 vccd1 vccd1 sky130_ef_sc_hd__decap_12
X_12475_ temp1\[28\] _06233_ net572 vssd1 vssd1 vccd1 vccd1 _00489_ sky130_fd_sc_hd__mux2_1
XFILLER_0_41_408 vssd1 vssd1 vccd1 vccd1 sky130_fd_sc_hd__fill_1
XANTENNA_6 _00796_ vssd1 vssd1 vccd1 vccd1 sky130_fd_sc_hd__diode_2
XFILLER_0_123_167 vssd1 vssd1 vccd1 vccd1 sky130_fd_sc_hd__fill_1
XFILLER_0_21_121 vssd1 vssd1 vccd1 vccd1 sky130_fd_sc_hd__decap_3
X_11426_ _05521_ vssd1 vssd1 vccd1 vccd1 _05522_ sky130_fd_sc_hd__inv_2
XFILLER_0_111_329 vssd1 vssd1 vccd1 vccd1 sky130_fd_sc_hd__decap_6
XFILLER_0_6_29 vssd1 vssd1 vccd1 vccd1 sky130_ef_sc_hd__decap_12
XFILLER_0_21_154 vssd1 vssd1 vccd1 vccd1 sky130_fd_sc_hd__decap_3
X_11357_ net807 net929 vssd1 vssd1 vccd1 vccd1 _05453_ sky130_fd_sc_hd__nand2_1
X_10308_ _04402_ _04409_ _04410_ vssd1 vssd1 vccd1 vccd1 _04412_ sky130_fd_sc_hd__nand3_2
XFILLER_0_67_15 vssd1 vssd1 vccd1 vccd1 sky130_fd_sc_hd__decap_6
XTAP_305 vssd1 vccd1 sky130_fd_sc_hd__tapvpwrvgnd_1
XFILLER_0_22_699 vssd1 vssd1 vccd1 vccd1 sky130_fd_sc_hd__fill_1
X_11288_ _05382_ _05383_ vssd1 vssd1 vccd1 vccd1 _05385_ sky130_fd_sc_hd__xnor2_1
XTAP_349 vssd1 vccd1 sky130_fd_sc_hd__tapvpwrvgnd_1
XTAP_338 vssd1 vccd1 sky130_fd_sc_hd__tapvpwrvgnd_1
XTAP_327 vssd1 vccd1 sky130_fd_sc_hd__tapvpwrvgnd_1
XTAP_316 vssd1 vccd1 sky130_fd_sc_hd__tapvpwrvgnd_1
X_13027_ clknet_leaf_46_clk_i _00413_ net1163 vssd1 vssd1 vccd1 vccd1 x0mx2\[16\]
+ sky130_fd_sc_hd__dfrtp_1
X_10239_ _04162_ _04163_ _04341_ _04343_ vssd1 vssd1 vccd1 vccd1 _04344_ sky130_fd_sc_hd__a211o_2
Xfanout1040 mul1.a\[14\] vssd1 vssd1 vccd1 vccd1 net1040 sky130_fd_sc_hd__buf_4
Xfanout1062 net1063 vssd1 vssd1 vccd1 vccd1 net1062 sky130_fd_sc_hd__clkbuf_4
Xfanout1051 net1052 vssd1 vssd1 vccd1 vccd1 net1051 sky130_fd_sc_hd__buf_2
Xfanout1073 net1074 vssd1 vssd1 vccd1 vccd1 net1073 sky130_fd_sc_hd__clkbuf_4
XFILLER_0_83_69 vssd1 vssd1 vccd1 vccd1 sky130_fd_sc_hd__decap_6
Xfanout1084 net1085 vssd1 vssd1 vccd1 vccd1 net1084 sky130_fd_sc_hd__clkbuf_4
Xfanout1095 net1096 vssd1 vssd1 vccd1 vccd1 net1095 sky130_fd_sc_hd__buf_2
XFILLER_0_16_41 vssd1 vssd1 vccd1 vccd1 sky130_ef_sc_hd__decap_12
XFILLER_0_16_85 vssd1 vssd1 vccd1 vccd1 sky130_ef_sc_hd__decap_12
XFILLER_0_88_187 vssd1 vssd1 vccd1 vccd1 sky130_fd_sc_hd__fill_1
X_07450_ _01532_ _01572_ _01573_ vssd1 vssd1 vccd1 vccd1 _01575_ sky130_fd_sc_hd__and3_1
X_06401_ net546 _00707_ vssd1 vssd1 vccd1 vccd1 net316 sky130_fd_sc_hd__nor2_1
XFILLER_0_119_429 vssd1 vssd1 vccd1 vccd1 sky130_ef_sc_hd__decap_12
XFILLER_0_91_308 vssd1 vssd1 vccd1 vccd1 sky130_fd_sc_hd__decap_8
X_07381_ _01464_ _01505_ vssd1 vssd1 vccd1 vccd1 _01506_ sky130_fd_sc_hd__and2_1
X_09120_ _03230_ _03231_ _03223_ vssd1 vssd1 vccd1 vccd1 _03232_ sky130_fd_sc_hd__a21o_1
X_06332_ add1.a_i\[3\] add1.b_i\[3\] vssd1 vssd1 vccd1 vccd1 _00644_ sky130_fd_sc_hd__or2_1
XFILLER_0_127_473 vssd1 vssd1 vccd1 vccd1 sky130_ef_sc_hd__decap_12
X_09051_ _03000_ _03001_ vssd1 vssd1 vccd1 vccd1 _03163_ sky130_fd_sc_hd__or2_1
XFILLER_0_84_393 vssd1 vssd1 vccd1 vccd1 sky130_fd_sc_hd__fill_1
XFILLER_0_72_533 vssd1 vssd1 vccd1 vccd1 sky130_fd_sc_hd__decap_3
XFILLER_0_5_822 vssd1 vssd1 vccd1 vccd1 sky130_ef_sc_hd__decap_12
X_08002_ _02116_ _02121_ vssd1 vssd1 vccd1 vccd1 _02122_ sky130_fd_sc_hd__nand2b_1
XFILLER_0_102_307 vssd1 vssd1 vccd1 vccd1 sky130_fd_sc_hd__fill_1
XFILLER_0_4_365 vssd1 vssd1 vccd1 vccd1 sky130_fd_sc_hd__fill_2
Xhold501 net361 vssd1 vssd1 vccd1 vccd1 net1716 sky130_fd_sc_hd__dlygate4sd3_1
XFILLER_0_12_121 vssd1 vssd1 vccd1 vccd1 sky130_ef_sc_hd__decap_12
XFILLER_0_114_189 vssd1 vssd1 vccd1 vccd1 sky130_fd_sc_hd__decap_6
Xhold512 net427 vssd1 vssd1 vccd1 vccd1 net1727 sky130_fd_sc_hd__dlygate4sd3_1
Xhold523 temp1\[31\] vssd1 vssd1 vccd1 vccd1 net1738 sky130_fd_sc_hd__dlygate4sd3_1
XFILLER_0_111_841 vssd1 vssd1 vccd1 vccd1 sky130_fd_sc_hd__fill_1
XFILLER_0_12_165 vssd1 vssd1 vccd1 vccd1 sky130_fd_sc_hd__decap_6
XFILLER_0_40_485 vssd1 vssd1 vccd1 vccd1 sky130_fd_sc_hd__fill_2
X_09953_ _03751_ _03898_ _03897_ vssd1 vssd1 vccd1 vccd1 _04060_ sky130_fd_sc_hd__a21oi_4
X_08904_ _03011_ _03016_ vssd1 vssd1 vccd1 vccd1 _03017_ sky130_fd_sc_hd__nor2_1
X_09884_ _03845_ _03848_ vssd1 vssd1 vccd1 vccd1 _03991_ sky130_fd_sc_hd__nand2_2
XTAP_850 vssd1 vccd1 sky130_fd_sc_hd__tapvpwrvgnd_1
XTAP_861 vssd1 vccd1 sky130_fd_sc_hd__tapvpwrvgnd_1
X_08835_ _02794_ _02796_ _02947_ _02948_ vssd1 vssd1 vccd1 vccd1 _02949_ sky130_fd_sc_hd__o211a_1
XTAP_883 vssd1 vccd1 sky130_fd_sc_hd__tapvpwrvgnd_1
XTAP_872 vssd1 vccd1 sky130_fd_sc_hd__tapvpwrvgnd_1
XTAP_894 vssd1 vccd1 sky130_fd_sc_hd__tapvpwrvgnd_1
X_08766_ _02866_ _02879_ vssd1 vssd1 vccd1 vccd1 _02880_ sky130_fd_sc_hd__nor2_1
X_07717_ _01738_ _01742_ _01838_ net496 vssd1 vssd1 vccd1 vccd1 _01840_ sky130_fd_sc_hd__a211o_1
XFILLER_0_79_165 vssd1 vssd1 vccd1 vccd1 sky130_fd_sc_hd__decap_3
X_08697_ _02669_ _02810_ vssd1 vssd1 vccd1 vccd1 _02812_ sky130_fd_sc_hd__xnor2_1
X_07648_ _01767_ _01770_ vssd1 vssd1 vccd1 vccd1 _01771_ sky130_fd_sc_hd__xor2_1
X_07579_ _01361_ _01362_ vssd1 vssd1 vccd1 vccd1 _01703_ sky130_fd_sc_hd__nor2_1
X_09318_ net1124 net707 _03425_ _03426_ vssd1 vssd1 vccd1 vccd1 _03428_ sky130_fd_sc_hd__o2bb2a_1
XFILLER_0_35_202 vssd1 vssd1 vccd1 vccd1 sky130_fd_sc_hd__fill_1
XFILLER_0_75_393 vssd1 vssd1 vccd1 vccd1 sky130_fd_sc_hd__decap_8
X_10590_ _04690_ _04691_ vssd1 vssd1 vccd1 vccd1 _04692_ sky130_fd_sc_hd__nand2b_1
XFILLER_0_106_657 vssd1 vssd1 vccd1 vccd1 sky130_ef_sc_hd__decap_12
X_09249_ _03201_ _03203_ _03357_ _03358_ vssd1 vssd1 vccd1 vccd1 _03360_ sky130_fd_sc_hd__a211oi_2
XFILLER_0_63_577 vssd1 vssd1 vccd1 vccd1 sky130_fd_sc_hd__decap_8
XFILLER_0_51_739 vssd1 vssd1 vccd1 vccd1 sky130_fd_sc_hd__fill_1
XFILLER_0_50_205 vssd1 vssd1 vccd1 vccd1 sky130_fd_sc_hd__fill_2
XFILLER_0_105_167 vssd1 vssd1 vccd1 vccd1 sky130_fd_sc_hd__fill_1
X_12260_ net696 _06193_ net518 vssd1 vssd1 vccd1 vccd1 _00314_ sky130_fd_sc_hd__mux2_1
X_11211_ _05139_ _05186_ _05307_ _05308_ vssd1 vssd1 vccd1 vccd1 _05309_ sky130_fd_sc_hd__o211a_2
X_12191_ mul1.b\[8\] _06147_ net514 vssd1 vssd1 vccd1 vccd1 _00291_ sky130_fd_sc_hd__mux2_1
X_11142_ _05230_ _05238_ vssd1 vssd1 vccd1 vccd1 _05240_ sky130_fd_sc_hd__nand2_1
XFILLER_0_31_485 vssd1 vssd1 vccd1 vccd1 sky130_fd_sc_hd__decap_8
XFILLER_0_31_496 vssd1 vssd1 vccd1 vccd1 sky130_fd_sc_hd__decap_8
X_11073_ _04995_ _04997_ _05171_ vssd1 vssd1 vccd1 vccd1 _05172_ sky130_fd_sc_hd__a21oi_1
Xinput110 v0y[28] vssd1 vssd1 vccd1 vccd1 net110 sky130_fd_sc_hd__buf_1
X_10024_ _04128_ _04129_ vssd1 vssd1 vccd1 vccd1 _04130_ sky130_fd_sc_hd__nand2b_1
Xinput132 v1x[19] vssd1 vssd1 vccd1 vccd1 net132 sky130_fd_sc_hd__clkbuf_1
Xinput121 v0y[9] vssd1 vssd1 vccd1 vccd1 net121 sky130_fd_sc_hd__buf_1
Xinput143 v1x[29] vssd1 vssd1 vccd1 vccd1 net143 sky130_fd_sc_hd__buf_1
Xinput154 v1y[0] vssd1 vssd1 vccd1 vccd1 net154 sky130_fd_sc_hd__buf_1
Xinput187 v2x[10] vssd1 vssd1 vccd1 vccd1 net187 sky130_fd_sc_hd__buf_1
Xinput176 v1y[2] vssd1 vssd1 vccd1 vccd1 net176 sky130_fd_sc_hd__clkbuf_1
Xinput165 v1y[1] vssd1 vssd1 vccd1 vccd1 net165 sky130_fd_sc_hd__clkbuf_1
XFILLER_0_98_430 vssd1 vssd1 vccd1 vccd1 sky130_fd_sc_hd__fill_1
Xinput198 v2x[20] vssd1 vssd1 vccd1 vccd1 net198 sky130_fd_sc_hd__buf_1
XFILLER_0_59_839 vssd1 vssd1 vccd1 vccd1 sky130_fd_sc_hd__fill_1
XFILLER_0_59_817 vssd1 vssd1 vccd1 vccd1 sky130_fd_sc_hd__fill_2
XFILLER_0_58_305 vssd1 vssd1 vccd1 vccd1 sky130_fd_sc_hd__decap_3
X_11975_ net11 net551 net627 net195 _05985_ vssd1 vssd1 vccd1 vccd1 _05986_ sky130_fd_sc_hd__a221o_1
XFILLER_0_85_113 vssd1 vssd1 vccd1 vccd1 sky130_fd_sc_hd__fill_2
XFILLER_0_85_102 vssd1 vssd1 vccd1 vccd1 sky130_fd_sc_hd__decap_3
X_10926_ _05024_ _05025_ vssd1 vssd1 vccd1 vccd1 _05026_ sky130_fd_sc_hd__nand2b_1
XFILLER_0_58_349 vssd1 vssd1 vccd1 vccd1 sky130_fd_sc_hd__decap_4
XFILLER_0_129_727 vssd1 vssd1 vccd1 vccd1 sky130_fd_sc_hd__fill_1
X_10857_ _04954_ _04956_ vssd1 vssd1 vccd1 vccd1 _04957_ sky130_fd_sc_hd__nor2_1
XFILLER_0_109_440 vssd1 vssd1 vccd1 vccd1 sky130_fd_sc_hd__decap_8
XPHY_160 vssd1 vssd1 vccd1 vccd1 sky130_fd_sc_hd__decap_3
XFILLER_0_39_585 vssd1 vssd1 vccd1 vccd1 sky130_ef_sc_hd__decap_12
XFILLER_0_109_484 vssd1 vssd1 vccd1 vccd1 sky130_fd_sc_hd__decap_4
XFILLER_0_109_462 vssd1 vssd1 vccd1 vccd1 sky130_fd_sc_hd__fill_1
XPHY_193 vssd1 vssd1 vccd1 vccd1 sky130_fd_sc_hd__decap_3
XPHY_182 vssd1 vssd1 vccd1 vccd1 sky130_fd_sc_hd__decap_3
XPHY_171 vssd1 vssd1 vccd1 vccd1 sky130_fd_sc_hd__decap_3
X_10788_ _04887_ _04888_ _04737_ _04741_ vssd1 vssd1 vccd1 vccd1 _04889_ sky130_fd_sc_hd__o211a_1
X_12527_ _00727_ net564 _06260_ vssd1 vssd1 vccd1 vccd1 _00514_ sky130_fd_sc_hd__o21ai_1
XFILLER_0_124_421 vssd1 vssd1 vccd1 vccd1 sky130_ef_sc_hd__decap_12
XFILLER_0_14_419 vssd1 vssd1 vccd1 vccd1 sky130_fd_sc_hd__fill_1
X_12458_ net53 net688 _00918_ net618 vssd1 vssd1 vccd1 vccd1 _06224_ sky130_fd_sc_hd__a22o_1
XFILLER_0_35_791 vssd1 vssd1 vccd1 vccd1 sky130_fd_sc_hd__fill_1
XFILLER_0_41_249 vssd1 vssd1 vccd1 vccd1 sky130_fd_sc_hd__fill_2
X_11409_ _05502_ _05503_ _05341_ _05380_ vssd1 vssd1 vccd1 vccd1 _05505_ sky130_fd_sc_hd__a211oi_1
XFILLER_0_111_137 vssd1 vssd1 vccd1 vccd1 sky130_ef_sc_hd__decap_12
X_12389_ net1407 _00872_ net683 vssd1 vssd1 vccd1 vccd1 _00441_ sky130_fd_sc_hd__mux2_1
XFILLER_0_120_693 vssd1 vssd1 vccd1 vccd1 sky130_fd_sc_hd__decap_6
X_06950_ net919 net911 net1057 net1065 vssd1 vssd1 vccd1 vccd1 _01075_ sky130_fd_sc_hd__and4_1
X_06881_ _00596_ _00802_ net631 _01005_ net688 vssd1 vssd1 vccd1 vccd1 _01009_ sky130_fd_sc_hd__a2111oi_1
XFILLER_0_118_53 vssd1 vssd1 vccd1 vccd1 sky130_ef_sc_hd__decap_12
X_08620_ _02733_ _02734_ vssd1 vssd1 vccd1 vccd1 _02735_ sky130_fd_sc_hd__nand2_1
XFILLER_0_118_97 vssd1 vssd1 vccd1 vccd1 sky130_ef_sc_hd__decap_12
X_08551_ _02664_ _02665_ _02425_ vssd1 vssd1 vccd1 vccd1 _02667_ sky130_fd_sc_hd__a21oi_1
X_08482_ net1060 net812 vssd1 vssd1 vccd1 vccd1 _02598_ sky130_fd_sc_hd__nand2_1
XFILLER_0_77_647 vssd1 vssd1 vccd1 vccd1 sky130_fd_sc_hd__fill_1
XFILLER_0_77_625 vssd1 vssd1 vccd1 vccd1 sky130_fd_sc_hd__fill_2
X_07502_ net896 net1138 net1145 net891 vssd1 vssd1 vccd1 vccd1 _01627_ sky130_fd_sc_hd__a22o_1
X_07433_ net917 net909 net1105 net1112 vssd1 vssd1 vccd1 vccd1 _01558_ sky130_fd_sc_hd__nand4_1
XFILLER_0_119_237 vssd1 vssd1 vccd1 vccd1 sky130_ef_sc_hd__decap_12
XFILLER_0_76_179 vssd1 vssd1 vccd1 vccd1 sky130_fd_sc_hd__fill_1
XFILLER_0_17_213 vssd1 vssd1 vccd1 vccd1 sky130_fd_sc_hd__decap_8
X_09103_ _03210_ _03213_ _03214_ vssd1 vssd1 vccd1 vccd1 _03215_ sky130_fd_sc_hd__and3_1
X_07364_ net871 net1126 net1136 net862 vssd1 vssd1 vccd1 vccd1 _01489_ sky130_fd_sc_hd__a22o_1
XFILLER_0_127_281 vssd1 vssd1 vccd1 vccd1 sky130_fd_sc_hd__fill_1
XFILLER_0_94_3 vssd1 vssd1 vccd1 vccd1 sky130_ef_sc_hd__decap_12
X_06315_ add1.a_i\[10\] add1.b_i\[10\] vssd1 vssd1 vccd1 vccd1 _00627_ sky130_fd_sc_hd__nand2_1
X_07295_ net880 net1111 vssd1 vssd1 vccd1 vccd1 _01420_ sky130_fd_sc_hd__nand2_1
X_09034_ _03124_ _03142_ _03144_ vssd1 vssd1 vccd1 vccd1 _03146_ sky130_fd_sc_hd__nor3_1
XFILLER_0_60_525 vssd1 vssd1 vccd1 vccd1 sky130_fd_sc_hd__decap_6
Xhold320 add1.b_i\[17\] vssd1 vssd1 vccd1 vccd1 net1535 sky130_fd_sc_hd__dlygate4sd3_1
Xhold353 x0mx2\[15\] vssd1 vssd1 vccd1 vccd1 net1568 sky130_fd_sc_hd__dlygate4sd3_1
Xhold342 x0mx2\[28\] vssd1 vssd1 vccd1 vccd1 net1557 sky130_fd_sc_hd__dlygate4sd3_1
Xhold331 net382 vssd1 vssd1 vccd1 vccd1 net1546 sky130_fd_sc_hd__dlygate4sd3_1
XFILLER_0_111_671 vssd1 vssd1 vccd1 vccd1 sky130_fd_sc_hd__fill_1
Xfanout800 net801 vssd1 vssd1 vccd1 vccd1 net800 sky130_fd_sc_hd__clkbuf_2
Xhold364 net385 vssd1 vssd1 vccd1 vccd1 net1579 sky130_fd_sc_hd__dlygate4sd3_1
Xhold386 sub1.b_i\[8\] vssd1 vssd1 vccd1 vccd1 net1601 sky130_fd_sc_hd__dlygate4sd3_1
Xhold375 sub1.b_i\[7\] vssd1 vssd1 vccd1 vccd1 net1590 sky130_fd_sc_hd__dlygate4sd3_1
X_09936_ _04011_ _04042_ vssd1 vssd1 vccd1 vccd1 _04043_ sky130_fd_sc_hd__xor2_4
Xfanout833 net834 vssd1 vssd1 vccd1 vccd1 net833 sky130_fd_sc_hd__clkbuf_4
Xfanout822 net823 vssd1 vssd1 vccd1 vccd1 net822 sky130_fd_sc_hd__buf_2
Xhold397 sub1.b_i\[4\] vssd1 vssd1 vccd1 vccd1 net1612 sky130_fd_sc_hd__dlygate4sd3_1
Xfanout811 net812 vssd1 vssd1 vccd1 vccd1 net811 sky130_fd_sc_hd__buf_2
Xfanout866 net870 vssd1 vssd1 vccd1 vccd1 net866 sky130_fd_sc_hd__clkbuf_4
Xfanout855 net858 vssd1 vssd1 vccd1 vccd1 net855 sky130_fd_sc_hd__dlymetal6s2s_1
Xfanout844 net845 vssd1 vssd1 vccd1 vccd1 net844 sky130_fd_sc_hd__buf_6
X_09867_ net1014 net784 vssd1 vssd1 vccd1 vccd1 _03974_ sky130_fd_sc_hd__nand2_1
Xfanout877 net879 vssd1 vssd1 vccd1 vccd1 net877 sky130_fd_sc_hd__clkbuf_4
Xfanout899 net900 vssd1 vssd1 vccd1 vccd1 net899 sky130_fd_sc_hd__buf_2
Xfanout888 net891 vssd1 vssd1 vccd1 vccd1 net888 sky130_fd_sc_hd__clkbuf_4
XTAP_691 vssd1 vccd1 sky130_fd_sc_hd__tapvpwrvgnd_1
XTAP_680 vssd1 vccd1 sky130_fd_sc_hd__tapvpwrvgnd_1
X_08818_ _02922_ _02929_ _02930_ vssd1 vssd1 vccd1 vccd1 _02932_ sky130_fd_sc_hd__nand3_2
X_09798_ temp1\[17\] _03905_ net541 vssd1 vssd1 vccd1 vccd1 _03906_ sky130_fd_sc_hd__mux2_1
X_08749_ _02861_ _02862_ vssd1 vssd1 vccd1 vccd1 _02863_ sky130_fd_sc_hd__nand2_1
XTAP_1824 vssd1 vccd1 sky130_fd_sc_hd__tapvpwrvgnd_1
XTAP_1813 vssd1 vccd1 sky130_fd_sc_hd__tapvpwrvgnd_1
XTAP_1802 vssd1 vccd1 sky130_fd_sc_hd__tapvpwrvgnd_1
XFILLER_0_95_422 vssd1 vssd1 vccd1 vccd1 sky130_fd_sc_hd__fill_1
XFILLER_0_67_113 vssd1 vssd1 vccd1 vccd1 sky130_fd_sc_hd__decap_3
X_11760_ net59 net674 net608 net187 vssd1 vssd1 vccd1 vccd1 _05811_ sky130_fd_sc_hd__a22o_1
XTAP_1857 vssd1 vccd1 sky130_fd_sc_hd__tapvpwrvgnd_1
XTAP_1846 vssd1 vccd1 sky130_fd_sc_hd__tapvpwrvgnd_1
XTAP_1835 vssd1 vccd1 sky130_fd_sc_hd__tapvpwrvgnd_1
X_10711_ _04811_ _04812_ vssd1 vssd1 vccd1 vccd1 _04813_ sky130_fd_sc_hd__xnor2_4
XFILLER_0_83_617 vssd1 vssd1 vccd1 vccd1 sky130_fd_sc_hd__fill_1
XTAP_1879 vssd1 vccd1 sky130_fd_sc_hd__tapvpwrvgnd_1
XTAP_1868 vssd1 vccd1 sky130_fd_sc_hd__tapvpwrvgnd_1
XFILLER_0_82_116 vssd1 vssd1 vccd1 vccd1 sky130_fd_sc_hd__fill_2
X_11691_ net1366 _05450_ net539 vssd1 vssd1 vccd1 vccd1 _00183_ sky130_fd_sc_hd__mux2_1
XFILLER_0_48_371 vssd1 vssd1 vccd1 vccd1 sky130_fd_sc_hd__fill_1
XFILLER_0_36_500 vssd1 vssd1 vccd1 vccd1 sky130_ef_sc_hd__decap_12
X_10642_ _04742_ _04743_ _04594_ _04598_ vssd1 vssd1 vccd1 vccd1 _04744_ sky130_fd_sc_hd__a211o_1
XFILLER_0_36_533 vssd1 vssd1 vccd1 vccd1 sky130_fd_sc_hd__decap_4
XFILLER_0_119_793 vssd1 vssd1 vccd1 vccd1 sky130_fd_sc_hd__fill_1
X_10573_ _04432_ _04673_ _04674_ vssd1 vssd1 vccd1 vccd1 _04675_ sky130_fd_sc_hd__and3_1
XFILLER_0_51_503 vssd1 vssd1 vccd1 vccd1 sky130_fd_sc_hd__fill_1
XFILLER_0_90_160 vssd1 vssd1 vccd1 vccd1 sky130_fd_sc_hd__decap_8
X_12312_ net1616 _00973_ net680 vssd1 vssd1 vccd1 vccd1 _00364_ sky130_fd_sc_hd__mux2_1
X_12243_ x2mx1\[26\] net605 net587 temp1\[26\] vssd1 vssd1 vccd1 vccd1 _06182_ sky130_fd_sc_hd__a22o_1
XFILLER_0_32_783 vssd1 vssd1 vccd1 vccd1 sky130_fd_sc_hd__fill_1
XFILLER_0_102_682 vssd1 vssd1 vccd1 vccd1 sky130_ef_sc_hd__decap_12
X_12174_ x2mx1\[3\] net602 net584 temp1\[3\] vssd1 vssd1 vccd1 vccd1 _06136_ sky130_fd_sc_hd__a22o_1
X_11125_ _04958_ _05097_ _04955_ vssd1 vssd1 vccd1 vccd1 _05223_ sky130_fd_sc_hd__o21a_1
X_11056_ _05150_ _05154_ vssd1 vssd1 vccd1 vccd1 _05155_ sky130_fd_sc_hd__and2b_1
X_10007_ _04071_ _04112_ vssd1 vssd1 vccd1 vccd1 _04113_ sky130_fd_sc_hd__xor2_4
XFILLER_0_80_15 vssd1 vssd1 vccd1 vccd1 sky130_ef_sc_hd__decap_12
XFILLER_0_59_669 vssd1 vssd1 vccd1 vccd1 sky130_fd_sc_hd__decap_3
X_11958_ net95 net621 net595 net63 vssd1 vssd1 vccd1 vccd1 _05973_ sky130_fd_sc_hd__a22o_1
XFILLER_0_86_477 vssd1 vssd1 vccd1 vccd1 sky130_fd_sc_hd__decap_3
X_10909_ _05000_ _05008_ vssd1 vssd1 vccd1 vccd1 _05009_ sky130_fd_sc_hd__nand2_1
X_11889_ net81 net679 net672 net113 vssd1 vssd1 vccd1 vccd1 _05920_ sky130_fd_sc_hd__a22o_1
XFILLER_0_104_77 vssd1 vssd1 vccd1 vccd1 sky130_fd_sc_hd__decap_6
XFILLER_0_73_138 vssd1 vssd1 vccd1 vccd1 sky130_fd_sc_hd__decap_3
XFILLER_0_66_190 vssd1 vssd1 vccd1 vccd1 sky130_fd_sc_hd__decap_6
XFILLER_0_125_741 vssd1 vssd1 vccd1 vccd1 sky130_ef_sc_hd__decap_12
XFILLER_0_109_281 vssd1 vssd1 vccd1 vccd1 sky130_ef_sc_hd__decap_12
XFILLER_0_54_363 vssd1 vssd1 vccd1 vccd1 sky130_fd_sc_hd__fill_1
XFILLER_0_54_352 vssd1 vssd1 vccd1 vccd1 sky130_fd_sc_hd__fill_2
XFILLER_0_27_555 vssd1 vssd1 vccd1 vccd1 sky130_fd_sc_hd__decap_4
XFILLER_0_42_514 vssd1 vssd1 vccd1 vccd1 sky130_fd_sc_hd__fill_2
XFILLER_0_89_57 vssd1 vssd1 vccd1 vccd1 sky130_ef_sc_hd__decap_12
X_07080_ net922 net1026 net1032 net914 vssd1 vssd1 vccd1 vccd1 _01205_ sky130_fd_sc_hd__a22o_1
XFILLER_0_125_785 vssd1 vssd1 vccd1 vccd1 sky130_ef_sc_hd__decap_12
XFILLER_0_120_65 vssd1 vssd1 vccd1 vccd1 sky130_ef_sc_hd__decap_12
XFILLER_0_112_413 vssd1 vssd1 vccd1 vccd1 sky130_fd_sc_hd__decap_6
XFILLER_0_112_457 vssd1 vssd1 vccd1 vccd1 sky130_ef_sc_hd__decap_12
Xoutput425 net425 vssd1 vssd1 vccd1 vccd1 mstream_o[78] sky130_fd_sc_hd__clkbuf_4
Xoutput414 net414 vssd1 vssd1 vccd1 vccd1 mstream_o[68] sky130_fd_sc_hd__clkbuf_4
Xoutput403 net403 vssd1 vssd1 vccd1 vccd1 mstream_o[58] sky130_fd_sc_hd__clkbuf_4
XFILLER_0_2_655 vssd1 vssd1 vccd1 vccd1 sky130_fd_sc_hd__fill_2
Xoutput447 net447 vssd1 vssd1 vccd1 vccd1 mstream_o[98] sky130_fd_sc_hd__clkbuf_4
XFILLER_0_100_619 vssd1 vssd1 vccd1 vccd1 sky130_fd_sc_hd__decap_6
Xoutput436 net436 vssd1 vssd1 vccd1 vccd1 mstream_o[88] sky130_fd_sc_hd__clkbuf_4
X_07982_ net1067 net831 _02100_ _02101_ vssd1 vssd1 vccd1 vccd1 _02102_ sky130_fd_sc_hd__o2bb2a_1
X_09721_ _03813_ _03826_ _03827_ vssd1 vssd1 vccd1 vccd1 _03829_ sky130_fd_sc_hd__and3_1
X_06933_ net846 net1127 net1135 net837 vssd1 vssd1 vccd1 vccd1 _01058_ sky130_fd_sc_hd__a22o_1
XFILLER_0_38_50 vssd1 vssd1 vccd1 vccd1 sky130_fd_sc_hd__fill_1
XFILLER_0_129_96 vssd1 vssd1 vccd1 vccd1 sky130_fd_sc_hd__decap_4
X_09652_ net1124 net705 _03596_ _03597_ mul1.b\[28\] vssd1 vssd1 vccd1 vccd1 _03760_
+ sky130_fd_sc_hd__a32o_1
X_06864_ _00991_ net616 net609 vssd1 vssd1 vccd1 vccd1 _00994_ sky130_fd_sc_hd__or3_1
X_08603_ net1060 net1068 net797 net787 vssd1 vssd1 vccd1 vccd1 _02718_ sky130_fd_sc_hd__nand4_1
X_09583_ _03672_ _03689_ _03690_ vssd1 vssd1 vccd1 vccd1 _03692_ sky130_fd_sc_hd__nand3_2
X_06795_ net1347 net1337 net641 vssd1 vssd1 vccd1 vccd1 _00069_ sky130_fd_sc_hd__mux2_1
X_08534_ _02646_ _02647_ _02513_ _02517_ vssd1 vssd1 vccd1 vccd1 _02650_ sky130_fd_sc_hd__o211a_1
XTAP_1109 vssd1 vccd1 sky130_fd_sc_hd__tapvpwrvgnd_1
X_08465_ _02577_ _02578_ _02579_ vssd1 vssd1 vccd1 vccd1 _02581_ sky130_fd_sc_hd__a21bo_1
XFILLER_0_58_680 vssd1 vssd1 vccd1 vccd1 sky130_fd_sc_hd__decap_4
X_08396_ _02510_ _02511_ _02512_ vssd1 vssd1 vccd1 vccd1 _02513_ sky130_fd_sc_hd__nand3_4
XFILLER_0_64_149 vssd1 vssd1 vccd1 vccd1 sky130_fd_sc_hd__fill_1
X_07416_ net847 net1144 vssd1 vssd1 vccd1 vccd1 _01541_ sky130_fd_sc_hd__nand2_1
XFILLER_0_18_533 vssd1 vssd1 vccd1 vccd1 sky130_fd_sc_hd__fill_1
X_07347_ _01469_ _01470_ _01468_ vssd1 vssd1 vccd1 vccd1 _01472_ sky130_fd_sc_hd__a21bo_1
XFILLER_0_115_273 vssd1 vssd1 vccd1 vccd1 sky130_fd_sc_hd__decap_6
X_09017_ _03127_ _03128_ vssd1 vssd1 vccd1 vccd1 _03129_ sky130_fd_sc_hd__nor2_1
XFILLER_0_60_333 vssd1 vssd1 vccd1 vccd1 sky130_fd_sc_hd__decap_4
XFILLER_0_5_471 vssd1 vssd1 vccd1 vccd1 sky130_fd_sc_hd__fill_1
X_07278_ _01269_ _01271_ _01401_ _01402_ vssd1 vssd1 vccd1 vccd1 _01403_ sky130_fd_sc_hd__a211oi_2
XFILLER_0_103_446 vssd1 vssd1 vccd1 vccd1 sky130_fd_sc_hd__fill_2
Xhold161 l1\[25\] vssd1 vssd1 vccd1 vccd1 net1376 sky130_fd_sc_hd__dlygate4sd3_1
Xhold150 _00046_ vssd1 vssd1 vccd1 vccd1 net1365 sky130_fd_sc_hd__dlygate4sd3_1
Xhold194 l0\[10\] vssd1 vssd1 vccd1 vccd1 net1409 sky130_fd_sc_hd__dlygate4sd3_1
Xhold183 l1\[4\] vssd1 vssd1 vccd1 vccd1 net1398 sky130_fd_sc_hd__dlygate4sd3_1
Xhold172 y2my0\[11\] vssd1 vssd1 vccd1 vccd1 net1387 sky130_fd_sc_hd__dlygate4sd3_1
Xfanout641 net644 vssd1 vssd1 vccd1 vccd1 net641 sky130_fd_sc_hd__clkbuf_4
Xfanout630 _00977_ vssd1 vssd1 vccd1 vccd1 net630 sky130_fd_sc_hd__buf_2
X_09919_ net893 net931 net927 net902 vssd1 vssd1 vccd1 vccd1 _04026_ sky130_fd_sc_hd__a22o_1
Xfanout652 _00599_ vssd1 vssd1 vccd1 vccd1 net652 sky130_fd_sc_hd__buf_2
Xfanout674 net676 vssd1 vssd1 vccd1 vccd1 net674 sky130_fd_sc_hd__clkbuf_4
Xfanout663 net664 vssd1 vssd1 vccd1 vccd1 net663 sky130_fd_sc_hd__clkbuf_4
Xfanout685 net686 vssd1 vssd1 vccd1 vccd1 net685 sky130_fd_sc_hd__clkbuf_4
X_12930_ clknet_leaf_8_clk_i _00316_ net1193 vssd1 vssd1 vccd1 vccd1 posx\[1\] sky130_fd_sc_hd__dfrtp_1
Xfanout696 mul1.b\[31\] vssd1 vssd1 vccd1 vccd1 net696 sky130_fd_sc_hd__buf_4
X_12861_ clknet_leaf_29_clk_i _00247_ vssd1 vssd1 vccd1 vccd1 sub1.b_i\[28\] sky130_fd_sc_hd__dfxtp_1
X_11812_ net227 net601 net581 net131 _05854_ vssd1 vssd1 vccd1 vccd1 _05855_ sky130_fd_sc_hd__a221o_1
XTAP_1632 vssd1 vccd1 sky130_fd_sc_hd__tapvpwrvgnd_1
XTAP_1621 vssd1 vccd1 sky130_fd_sc_hd__tapvpwrvgnd_1
XTAP_1610 vssd1 vccd1 sky130_fd_sc_hd__tapvpwrvgnd_1
XFILLER_0_68_466 vssd1 vssd1 vccd1 vccd1 sky130_fd_sc_hd__decap_3
X_12792_ clknet_leaf_18_clk_i _00178_ vssd1 vssd1 vccd1 vccd1 add1.b_i\[23\] sky130_fd_sc_hd__dfxtp_1
XTAP_1665 vssd1 vccd1 sky130_fd_sc_hd__tapvpwrvgnd_1
XTAP_1676 vssd1 vccd1 sky130_fd_sc_hd__tapvpwrvgnd_1
XTAP_1654 vssd1 vccd1 sky130_fd_sc_hd__tapvpwrvgnd_1
XTAP_1643 vssd1 vccd1 sky130_fd_sc_hd__tapvpwrvgnd_1
X_11743_ temp1\[7\] net611 net668 net119 _05796_ vssd1 vssd1 vccd1 vccd1 _05797_ sky130_fd_sc_hd__a221o_1
XFILLER_0_28_319 vssd1 vssd1 vccd1 vccd1 sky130_fd_sc_hd__decap_4
XTAP_1698 vssd1 vccd1 sky130_fd_sc_hd__tapvpwrvgnd_1
XTAP_1687 vssd1 vccd1 sky130_fd_sc_hd__tapvpwrvgnd_1
X_11674_ net1290 _02961_ net537 vssd1 vssd1 vccd1 vccd1 _00166_ sky130_fd_sc_hd__mux2_1
XFILLER_0_50_29 vssd1 vssd1 vccd1 vccd1 sky130_fd_sc_hd__decap_3
XFILLER_0_70_108 vssd1 vssd1 vccd1 vccd1 sky130_fd_sc_hd__decap_3
X_10625_ net954 _04547_ _04548_ _04549_ vssd1 vssd1 vccd1 vccd1 _04727_ sky130_fd_sc_hd__o2bb2a_1
XFILLER_0_36_363 vssd1 vssd1 vccd1 vccd1 sky130_fd_sc_hd__fill_1
XFILLER_0_107_763 vssd1 vssd1 vccd1 vccd1 sky130_fd_sc_hd__decap_4
XFILLER_0_107_752 vssd1 vssd1 vccd1 vccd1 sky130_fd_sc_hd__fill_2
XFILLER_0_36_385 vssd1 vssd1 vccd1 vccd1 sky130_fd_sc_hd__decap_4
X_10556_ _04384_ _04515_ _04514_ vssd1 vssd1 vccd1 vccd1 _04659_ sky130_fd_sc_hd__a21o_1
XFILLER_0_24_547 vssd1 vssd1 vccd1 vccd1 sky130_fd_sc_hd__decap_8
XFILLER_0_122_755 vssd1 vssd1 vccd1 vccd1 sky130_fd_sc_hd__fill_1
X_10487_ _04587_ _04588_ _04583_ vssd1 vssd1 vccd1 vccd1 _04590_ sky130_fd_sc_hd__a21o_1
X_12226_ _00913_ net511 net468 y1my2\[20\] _06170_ vssd1 vssd1 vccd1 vccd1 _06171_
+ sky130_fd_sc_hd__a221o_1
X_12157_ net1519 net588 net535 x2mx1\[30\] _06123_ vssd1 vssd1 vccd1 vccd1 _06124_
+ sky130_fd_sc_hd__a221o_1
XFILLER_0_75_15 vssd1 vssd1 vccd1 vccd1 sky130_ef_sc_hd__decap_12
X_11108_ net1626 _05206_ net525 vssd1 vssd1 vccd1 vccd1 _00149_ sky130_fd_sc_hd__mux2_1
X_12088_ x0mx2\[13\] net629 net591 y1my2\[13\] vssd1 vssd1 vccd1 vccd1 _06072_ sky130_fd_sc_hd__a22o_1
X_11039_ _05135_ _05136_ _05101_ vssd1 vssd1 vccd1 vccd1 _05138_ sky130_fd_sc_hd__o21a_2
XFILLER_0_79_709 vssd1 vssd1 vccd1 vccd1 sky130_fd_sc_hd__decap_8
XFILLER_0_91_69 vssd1 vssd1 vccd1 vccd1 sky130_ef_sc_hd__decap_12
X_06580_ _00820_ _00821_ vssd1 vssd1 vccd1 vccd1 _00822_ sky130_fd_sc_hd__nand2_2
XFILLER_0_24_41 vssd1 vssd1 vccd1 vccd1 sky130_ef_sc_hd__decap_12
XFILLER_0_74_403 vssd1 vssd1 vccd1 vccd1 sky130_fd_sc_hd__fill_2
XFILLER_0_47_617 vssd1 vssd1 vccd1 vccd1 sky130_fd_sc_hd__decap_8
XFILLER_0_19_308 vssd1 vssd1 vccd1 vccd1 sky130_fd_sc_hd__decap_3
XFILLER_0_19_319 vssd1 vssd1 vccd1 vccd1 sky130_fd_sc_hd__fill_1
XFILLER_0_24_85 vssd1 vssd1 vccd1 vccd1 sky130_fd_sc_hd__decap_4
XFILLER_0_117_505 vssd1 vssd1 vccd1 vccd1 sky130_ef_sc_hd__decap_12
XFILLER_0_86_285 vssd1 vssd1 vccd1 vccd1 sky130_fd_sc_hd__fill_1
X_08250_ _02366_ _02367_ _02365_ vssd1 vssd1 vccd1 vccd1 _02368_ sky130_fd_sc_hd__a21o_1
XFILLER_0_7_714 vssd1 vssd1 vccd1 vccd1 sky130_fd_sc_hd__fill_1
X_08181_ net1106 net772 net763 net1114 vssd1 vssd1 vccd1 vccd1 _02299_ sky130_fd_sc_hd__a22o_1
XFILLER_0_39_190 vssd1 vssd1 vccd1 vccd1 sky130_fd_sc_hd__fill_1
X_07201_ net1137 net798 net788 net1144 vssd1 vssd1 vccd1 vccd1 _01326_ sky130_fd_sc_hd__a22o_1
XFILLER_0_54_160 vssd1 vssd1 vccd1 vccd1 sky130_fd_sc_hd__decap_4
X_07132_ _01175_ _01195_ _01254_ _01255_ vssd1 vssd1 vccd1 vccd1 _01257_ sky130_fd_sc_hd__o211ai_1
XFILLER_0_40_62 vssd1 vssd1 vccd1 vccd1 sky130_fd_sc_hd__fill_1
XFILLER_0_42_333 vssd1 vssd1 vccd1 vccd1 sky130_fd_sc_hd__fill_1
XFILLER_0_112_221 vssd1 vssd1 vccd1 vccd1 sky130_ef_sc_hd__decap_12
XFILLER_0_30_528 vssd1 vssd1 vccd1 vccd1 sky130_fd_sc_hd__decap_4
X_07063_ _01186_ _01187_ vssd1 vssd1 vccd1 vccd1 _01188_ sky130_fd_sc_hd__nor2_1
XFILLER_0_112_265 vssd1 vssd1 vccd1 vccd1 sky130_ef_sc_hd__decap_12
XFILLER_0_11_742 vssd1 vssd1 vccd1 vccd1 sky130_fd_sc_hd__fill_2
Xoutput277 net277 vssd1 vssd1 vccd1 vccd1 div_mstream_o[32] sky130_fd_sc_hd__clkbuf_4
Xoutput255 net255 vssd1 vssd1 vccd1 vccd1 div_mstream_o[12] sky130_fd_sc_hd__clkbuf_4
Xoutput266 net266 vssd1 vssd1 vccd1 vccd1 div_mstream_o[22] sky130_fd_sc_hd__clkbuf_4
XFILLER_0_57_3 vssd1 vssd1 vccd1 vccd1 sky130_fd_sc_hd__decap_8
Xoutput299 net299 vssd1 vssd1 vccd1 vccd1 div_mstream_o[67] sky130_fd_sc_hd__clkbuf_4
Xoutput288 net288 vssd1 vssd1 vccd1 vccd1 div_mstream_o[42] sky130_fd_sc_hd__clkbuf_4
XFILLER_0_11_797 vssd1 vssd1 vccd1 vccd1 sky130_ef_sc_hd__decap_12
X_07965_ _02076_ _02084_ vssd1 vssd1 vccd1 vccd1 _02085_ sky130_fd_sc_hd__xnor2_1
X_09704_ _03810_ _03811_ vssd1 vssd1 vccd1 vccd1 _03812_ sky130_fd_sc_hd__nand2b_1
X_06916_ _01039_ _01040_ vssd1 vssd1 vccd1 vccd1 _01041_ sky130_fd_sc_hd__nor2_1
X_09635_ _03741_ _03742_ _03442_ vssd1 vssd1 vccd1 vccd1 _03744_ sky130_fd_sc_hd__o21ba_1
X_07896_ net1024 net882 vssd1 vssd1 vccd1 vccd1 _02017_ sky130_fd_sc_hd__nand2_1
X_06847_ _00617_ _00802_ _00975_ net631 vssd1 vssd1 vccd1 vccd1 _00978_ sky130_fd_sc_hd__or4_1
X_09566_ net826 net817 net991 vssd1 vssd1 vccd1 vccd1 _03675_ sky130_fd_sc_hd__and3_1
X_06778_ net1527 net1468 net638 vssd1 vssd1 vccd1 vccd1 _00052_ sky130_fd_sc_hd__mux2_1
X_09497_ _03431_ _03439_ _03605_ vssd1 vssd1 vccd1 vccd1 _03606_ sky130_fd_sc_hd__a21oi_1
XFILLER_0_65_403 vssd1 vssd1 vccd1 vccd1 sky130_ef_sc_hd__decap_12
X_08517_ net908 net967 vssd1 vssd1 vccd1 vccd1 _02633_ sky130_fd_sc_hd__and2_1
X_08448_ net1131 net734 vssd1 vssd1 vccd1 vccd1 _02564_ sky130_fd_sc_hd__nand2_1
XFILLER_0_77_296 vssd1 vssd1 vccd1 vccd1 sky130_fd_sc_hd__fill_1
XFILLER_0_65_425 vssd1 vssd1 vccd1 vccd1 sky130_ef_sc_hd__decap_12
X_10410_ _04512_ _04513_ vssd1 vssd1 vccd1 vccd1 _04514_ sky130_fd_sc_hd__nor2_1
X_08379_ _02494_ _02495_ vssd1 vssd1 vccd1 vccd1 _02496_ sky130_fd_sc_hd__nor2_1
XFILLER_0_61_631 vssd1 vssd1 vccd1 vccd1 sky130_fd_sc_hd__fill_1
XFILLER_0_18_363 vssd1 vssd1 vccd1 vccd1 sky130_fd_sc_hd__fill_1
XFILLER_0_45_182 vssd1 vssd1 vccd1 vccd1 sky130_fd_sc_hd__decap_8
X_11390_ net782 net941 vssd1 vssd1 vccd1 vccd1 _05486_ sky130_fd_sc_hd__nand2_1
XFILLER_0_104_755 vssd1 vssd1 vccd1 vccd1 sky130_fd_sc_hd__fill_1
X_10341_ _04441_ _04442_ _04443_ vssd1 vssd1 vccd1 vccd1 _04445_ sky130_fd_sc_hd__a21oi_1
XFILLER_0_60_152 vssd1 vssd1 vccd1 vccd1 sky130_fd_sc_hd__decap_3
X_10272_ _04067_ _04217_ _04059_ _04060_ vssd1 vssd1 vccd1 vccd1 _04377_ sky130_fd_sc_hd__a211o_1
X_13060_ clknet_leaf_38_clk_i _00446_ net1162 vssd1 vssd1 vccd1 vccd1 y2my0\[17\]
+ sky130_fd_sc_hd__dfrtp_1
X_12011_ net21 net552 net626 net205 _06012_ vssd1 vssd1 vccd1 vccd1 _06013_ sky130_fd_sc_hd__a221o_1
XFILLER_0_45_18 vssd1 vssd1 vccd1 vccd1 sky130_fd_sc_hd__decap_8
Xfanout482 net484 vssd1 vssd1 vccd1 vccd1 net482 sky130_fd_sc_hd__clkbuf_4
Xfanout471 net472 vssd1 vssd1 vccd1 vccd1 net471 sky130_fd_sc_hd__clkbuf_4
X_12913_ clknet_leaf_42_clk_i _00299_ vssd1 vssd1 vccd1 vccd1 mul1.b\[16\] sky130_fd_sc_hd__dfxtp_1
Xmax_cap7 _03090_ vssd1 vssd1 vccd1 vccd1 net1748 sky130_fd_sc_hd__clkbuf_1
XTAP_2152 vssd1 vccd1 sky130_fd_sc_hd__tapvpwrvgnd_1
XTAP_2141 vssd1 vccd1 sky130_fd_sc_hd__tapvpwrvgnd_1
XTAP_2130 vssd1 vccd1 sky130_fd_sc_hd__tapvpwrvgnd_1
X_12844_ clknet_leaf_51_clk_i _00230_ vssd1 vssd1 vccd1 vccd1 sub1.b_i\[11\] sky130_fd_sc_hd__dfxtp_1
XTAP_2185 vssd1 vccd1 sky130_fd_sc_hd__tapvpwrvgnd_1
XTAP_2163 vssd1 vccd1 sky130_fd_sc_hd__tapvpwrvgnd_1
XTAP_2174 vssd1 vccd1 sky130_fd_sc_hd__tapvpwrvgnd_1
XFILLER_0_84_701 vssd1 vssd1 vccd1 vccd1 sky130_fd_sc_hd__fill_2
XTAP_1451 vssd1 vccd1 sky130_fd_sc_hd__tapvpwrvgnd_1
XTAP_1440 vssd1 vccd1 sky130_fd_sc_hd__tapvpwrvgnd_1
XFILLER_0_61_39 vssd1 vssd1 vccd1 vccd1 sky130_fd_sc_hd__decap_6
X_12775_ clknet_leaf_58_clk_i _00161_ vssd1 vssd1 vccd1 vccd1 add1.b_i\[6\] sky130_fd_sc_hd__dfxtp_1
XTAP_2196 vssd1 vccd1 sky130_fd_sc_hd__tapvpwrvgnd_1
XFILLER_0_84_745 vssd1 vssd1 vccd1 vccd1 sky130_fd_sc_hd__decap_3
XTAP_1473 vssd1 vccd1 sky130_fd_sc_hd__tapvpwrvgnd_1
XTAP_1484 vssd1 vccd1 sky130_fd_sc_hd__tapvpwrvgnd_1
XTAP_1462 vssd1 vccd1 sky130_fd_sc_hd__tapvpwrvgnd_1
XFILLER_0_56_425 vssd1 vssd1 vccd1 vccd1 sky130_fd_sc_hd__fill_1
X_11726_ net1322 _05783_ net477 vssd1 vssd1 vccd1 vccd1 _00190_ sky130_fd_sc_hd__mux2_1
XFILLER_0_124_7 vssd1 vssd1 vccd1 vccd1 sky130_ef_sc_hd__decap_12
XTAP_1495 vssd1 vccd1 sky130_fd_sc_hd__tapvpwrvgnd_1
XFILLER_0_28_149 vssd1 vssd1 vccd1 vccd1 sky130_fd_sc_hd__fill_1
X_11657_ temp1\[31\] _05750_ net543 vssd1 vssd1 vccd1 vccd1 _05751_ sky130_fd_sc_hd__mux2_1
X_10608_ net1013 net1005 net753 net744 vssd1 vssd1 vccd1 vccd1 _04710_ sky130_fd_sc_hd__nand4_2
XFILLER_0_3_205 vssd1 vssd1 vccd1 vccd1 sky130_fd_sc_hd__fill_1
X_11588_ net1019 net694 net718 net983 vssd1 vssd1 vccd1 vccd1 _05682_ sky130_fd_sc_hd__o211a_1
X_10539_ _04640_ _04641_ _04409_ _04412_ vssd1 vssd1 vccd1 vccd1 _04642_ sky130_fd_sc_hd__o211ai_1
XFILLER_0_51_163 vssd1 vssd1 vccd1 vccd1 sky130_fd_sc_hd__decap_4
XFILLER_0_10_65 vssd1 vssd1 vccd1 vccd1 sky130_ef_sc_hd__decap_12
XFILLER_0_110_725 vssd1 vssd1 vccd1 vccd1 sky130_ef_sc_hd__decap_12
X_13189_ clknet_leaf_19_clk_i _00575_ net1177 vssd1 vssd1 vccd1 vccd1 l1\[18\] sky130_fd_sc_hd__dfrtp_1
X_12209_ net808 _06159_ net520 vssd1 vssd1 vccd1 vccd1 _00297_ sky130_fd_sc_hd__mux2_1
X_07750_ _01856_ _01857_ _01871_ vssd1 vssd1 vccd1 vccd1 _01872_ sky130_fd_sc_hd__and3_1
X_06701_ net1434 _00923_ net635 vssd1 vssd1 vccd1 vccd1 _00025_ sky130_fd_sc_hd__mux2_1
XFILLER_0_126_53 vssd1 vssd1 vccd1 vccd1 sky130_ef_sc_hd__decap_12
X_07681_ _01695_ _01697_ _01801_ _01802_ vssd1 vssd1 vccd1 vccd1 _01804_ sky130_fd_sc_hd__o211a_1
XFILLER_0_126_97 vssd1 vssd1 vccd1 vccd1 sky130_ef_sc_hd__decap_12
X_09420_ net867 net962 _03527_ _03528_ vssd1 vssd1 vccd1 vccd1 _03530_ sky130_fd_sc_hd__a22o_1
X_06632_ _00864_ _00865_ vssd1 vssd1 vccd1 vccd1 _00866_ sky130_fd_sc_hd__nor2_2
X_09351_ _03293_ _03296_ _03458_ _03460_ vssd1 vssd1 vccd1 vccd1 _03461_ sky130_fd_sc_hd__o211a_1
X_06563_ sub1.a_i\[0\] sub1.b_i\[0\] vssd1 vssd1 vccd1 vccd1 _00808_ sky130_fd_sc_hd__nand2b_4
XFILLER_0_129_140 vssd1 vssd1 vccd1 vccd1 sky130_fd_sc_hd__fill_1
X_08302_ _02417_ _02418_ vssd1 vssd1 vccd1 vccd1 _02419_ sky130_fd_sc_hd__or2_1
XFILLER_0_75_734 vssd1 vssd1 vccd1 vccd1 sky130_ef_sc_hd__decap_12
X_09282_ _03370_ _03389_ _03390_ vssd1 vssd1 vccd1 vccd1 _03393_ sky130_fd_sc_hd__nand3_2
X_06494_ det_t\[4\] net528 vssd1 vssd1 vccd1 vccd1 net294 sky130_fd_sc_hd__and2_1
XFILLER_0_117_335 vssd1 vssd1 vccd1 vccd1 sky130_fd_sc_hd__fill_1
X_08233_ _02231_ _02233_ vssd1 vssd1 vccd1 vccd1 _02351_ sky130_fd_sc_hd__nand2_1
XFILLER_0_62_417 vssd1 vssd1 vccd1 vccd1 sky130_fd_sc_hd__decap_3
XFILLER_0_27_160 vssd1 vssd1 vccd1 vccd1 sky130_fd_sc_hd__fill_2
X_08164_ _02166_ _02282_ vssd1 vssd1 vccd1 vccd1 _02283_ sky130_fd_sc_hd__nor2_1
Xclkbuf_leaf_41_clk_i clknet_3_3__leaf_clk_i vssd1 vssd1 vccd1 vccd1 clknet_leaf_41_clk_i
+ sky130_fd_sc_hd__clkbuf_16
XFILLER_0_113_541 vssd1 vssd1 vccd1 vccd1 sky130_ef_sc_hd__decap_12
X_08095_ net1059 net831 vssd1 vssd1 vccd1 vccd1 _02214_ sky130_fd_sc_hd__nand2_1
XFILLER_0_15_366 vssd1 vssd1 vccd1 vccd1 sky130_fd_sc_hd__fill_1
X_07115_ _01239_ _01238_ vssd1 vssd1 vccd1 vccd1 _01240_ sky130_fd_sc_hd__and2b_1
XFILLER_0_101_714 vssd1 vssd1 vccd1 vccd1 sky130_ef_sc_hd__decap_12
XFILLER_0_30_336 vssd1 vssd1 vccd1 vccd1 sky130_fd_sc_hd__fill_2
X_07046_ _01158_ _01159_ _01170_ vssd1 vssd1 vccd1 vccd1 _01171_ sky130_fd_sc_hd__and3_1
XFILLER_0_113_585 vssd1 vssd1 vccd1 vccd1 sky130_ef_sc_hd__decap_12
XFILLER_0_11_561 vssd1 vssd1 vccd1 vccd1 sky130_fd_sc_hd__decap_4
Xclkbuf_leaf_56_clk_i clknet_3_0__leaf_clk_i vssd1 vssd1 vccd1 vccd1 clknet_leaf_56_clk_i
+ sky130_fd_sc_hd__clkbuf_16
XFILLER_0_2_293 vssd1 vssd1 vccd1 vccd1 sky130_fd_sc_hd__fill_1
X_08997_ _02816_ _03107_ _03108_ _03109_ vssd1 vssd1 vccd1 vccd1 _03110_ sky130_fd_sc_hd__o211a_2
X_07948_ net1139 net755 _02065_ _02067_ vssd1 vssd1 vccd1 vccd1 _02068_ sky130_fd_sc_hd__and4_1
X_07879_ _01990_ _01998_ vssd1 vssd1 vccd1 vccd1 _02000_ sky130_fd_sc_hd__xnor2_1
XFILLER_0_97_358 vssd1 vssd1 vccd1 vccd1 sky130_fd_sc_hd__decap_4
XFILLER_0_92_90 vssd1 vssd1 vccd1 vccd1 sky130_ef_sc_hd__decap_12
X_09618_ _03693_ _03724_ _03725_ vssd1 vssd1 vccd1 vccd1 _03727_ sky130_fd_sc_hd__nand3_1
X_10890_ net765 net975 net969 net775 vssd1 vssd1 vccd1 vccd1 _04990_ sky130_fd_sc_hd__a22o_1
X_09549_ _03652_ _03656_ _03657_ vssd1 vssd1 vccd1 vccd1 _03658_ sky130_fd_sc_hd__nand3_1
XFILLER_0_66_712 vssd1 vssd1 vccd1 vccd1 sky130_fd_sc_hd__fill_1
XFILLER_0_78_583 vssd1 vssd1 vccd1 vccd1 sky130_fd_sc_hd__decap_4
X_12560_ net1548 net4 net559 vssd1 vssd1 vccd1 vccd1 _00536_ sky130_fd_sc_hd__mux2_1
X_12491_ net1255 net568 _06242_ vssd1 vssd1 vccd1 vccd1 _00496_ sky130_fd_sc_hd__o21a_1
XFILLER_0_53_417 vssd1 vssd1 vccd1 vccd1 sky130_fd_sc_hd__decap_4
X_11511_ _05603_ _05604_ _05569_ vssd1 vssd1 vccd1 vccd1 _05606_ sky130_fd_sc_hd__o21ai_1
XFILLER_0_18_193 vssd1 vssd1 vccd1 vccd1 sky130_fd_sc_hd__decap_3
X_11442_ _05414_ _05416_ _05535_ _05536_ vssd1 vssd1 vccd1 vccd1 _05538_ sky130_fd_sc_hd__a211oi_2
XFILLER_0_123_349 vssd1 vssd1 vccd1 vccd1 sky130_ef_sc_hd__decap_12
X_11373_ _05467_ _05468_ vssd1 vssd1 vccd1 vccd1 _05469_ sky130_fd_sc_hd__or2_1
XFILLER_0_34_664 vssd1 vssd1 vccd1 vccd1 sky130_fd_sc_hd__decap_4
Xbary_pipe_m_1214 vssd1 vssd1 vccd1 vccd1 bary_pipe_m_1214/HI div_mstream_o[97] sky130_fd_sc_hd__conb_1
Xbary_pipe_m_1203 vssd1 vssd1 vccd1 vccd1 bary_pipe_m_1203/HI div_mstream_o[53] sky130_fd_sc_hd__conb_1
X_13112_ clknet_leaf_3_clk_i _00498_ vssd1 vssd1 vccd1 vccd1 det_t\[5\] sky130_fd_sc_hd__dfxtp_1
XFILLER_0_61_483 vssd1 vssd1 vccd1 vccd1 sky130_ef_sc_hd__decap_12
X_10324_ _04023_ _04309_ _04310_ vssd1 vssd1 vccd1 vccd1 _04428_ sky130_fd_sc_hd__and3_2
XFILLER_0_33_196 vssd1 vssd1 vccd1 vccd1 sky130_fd_sc_hd__decap_8
XFILLER_0_34_697 vssd1 vssd1 vccd1 vccd1 sky130_fd_sc_hd__decap_3
X_10255_ _04154_ _04204_ _04203_ vssd1 vssd1 vccd1 vccd1 _04360_ sky130_fd_sc_hd__a21oi_4
X_13043_ clknet_leaf_51_clk_i _00429_ net1154 vssd1 vssd1 vccd1 vccd1 y2my0\[0\] sky130_fd_sc_hd__dfrtp_1
XTAP_509 vssd1 vccd1 sky130_fd_sc_hd__tapvpwrvgnd_1
X_10186_ net785 net998 vssd1 vssd1 vccd1 vccd1 _04291_ sky130_fd_sc_hd__nand2_1
XFILLER_0_72_27 vssd1 vssd1 vccd1 vccd1 sky130_fd_sc_hd__fill_1
XFILLER_0_69_561 vssd1 vssd1 vccd1 vccd1 sky130_fd_sc_hd__fill_2
XFILLER_0_9_809 vssd1 vssd1 vccd1 vccd1 sky130_ef_sc_hd__decap_12
X_12827_ clknet_leaf_30_clk_i _00213_ vssd1 vssd1 vccd1 vccd1 sub1.a_i\[26\] sky130_fd_sc_hd__dfxtp_1
XFILLER_0_56_211 vssd1 vssd1 vccd1 vccd1 sky130_fd_sc_hd__decap_4
XTAP_1281 vssd1 vccd1 sky130_fd_sc_hd__tapvpwrvgnd_1
XTAP_1292 vssd1 vccd1 sky130_fd_sc_hd__tapvpwrvgnd_1
XTAP_1270 vssd1 vccd1 sky130_fd_sc_hd__tapvpwrvgnd_1
X_12758_ clknet_leaf_40_clk_i _00144_ vssd1 vssd1 vccd1 vccd1 add1.a_i\[21\] sky130_fd_sc_hd__dfxtp_1
XFILLER_0_126_121 vssd1 vssd1 vccd1 vccd1 sky130_ef_sc_hd__decap_12
X_12689_ clknet_leaf_13_clk_i net1540 net1184 vssd1 vssd1 vccd1 vccd1 net419 sky130_fd_sc_hd__dfrtp_1
XFILLER_0_84_597 vssd1 vssd1 vccd1 vccd1 sky130_fd_sc_hd__fill_1
XFILLER_0_72_737 vssd1 vssd1 vccd1 vccd1 sky130_ef_sc_hd__decap_12
XFILLER_0_71_225 vssd1 vssd1 vccd1 vccd1 sky130_fd_sc_hd__decap_8
XFILLER_0_56_299 vssd1 vssd1 vccd1 vccd1 sky130_fd_sc_hd__decap_3
X_11709_ net197 net607 net668 net101 vssd1 vssd1 vccd1 vccd1 _05769_ sky130_fd_sc_hd__a22o_1
XFILLER_0_127_688 vssd1 vssd1 vccd1 vccd1 sky130_ef_sc_hd__decap_12
XFILLER_0_115_3 vssd1 vssd1 vccd1 vccd1 sky130_ef_sc_hd__decap_12
XFILLER_0_112_77 vssd1 vssd1 vccd1 vccd1 sky130_fd_sc_hd__decap_6
XFILLER_0_130_809 vssd1 vssd1 vccd1 vccd1 sky130_fd_sc_hd__decap_3
XFILLER_0_24_141 vssd1 vssd1 vccd1 vccd1 sky130_ef_sc_hd__decap_12
XFILLER_0_52_494 vssd1 vssd1 vccd1 vccd1 sky130_fd_sc_hd__fill_2
XFILLER_0_4_569 vssd1 vssd1 vccd1 vccd1 sky130_fd_sc_hd__fill_1
XFILLER_0_40_645 vssd1 vssd1 vccd1 vccd1 sky130_fd_sc_hd__fill_2
XFILLER_0_110_533 vssd1 vssd1 vccd1 vccd1 sky130_ef_sc_hd__decap_12
XFILLER_0_97_57 vssd1 vssd1 vccd1 vccd1 sky130_ef_sc_hd__decap_12
Xmax_cap457 _04510_ vssd1 vssd1 vccd1 vccd1 net457 sky130_fd_sc_hd__buf_1
X_08920_ _03030_ _03032_ vssd1 vssd1 vccd1 vccd1 _03033_ sky130_fd_sc_hd__nand2_1
X_08851_ _02847_ _02849_ vssd1 vssd1 vccd1 vccd1 _02964_ sky130_fd_sc_hd__nor2_1
X_07802_ _01819_ _01827_ _01826_ vssd1 vssd1 vccd1 vccd1 _01924_ sky130_fd_sc_hd__a21bo_1
X_08782_ _02892_ _02895_ vssd1 vssd1 vccd1 vccd1 _02896_ sky130_fd_sc_hd__xor2_1
X_07733_ _01781_ _01783_ vssd1 vssd1 vccd1 vccd1 _01855_ sky130_fd_sc_hd__nand2_1
XFILLER_0_46_72 vssd1 vssd1 vccd1 vccd1 sky130_fd_sc_hd__decap_3
X_07664_ net1097 net1105 net822 mul1.b\[13\] vssd1 vssd1 vccd1 vccd1 _01787_ sky130_fd_sc_hd__and4_1
X_09403_ net859 net850 net974 net968 vssd1 vssd1 vccd1 vccd1 _03513_ sky130_fd_sc_hd__nand4_1
X_06615_ _00849_ _00851_ vssd1 vssd1 vccd1 vccd1 _00852_ sky130_fd_sc_hd__xor2_4
X_07595_ _01714_ _01715_ _01717_ vssd1 vssd1 vccd1 vccd1 _01719_ sky130_fd_sc_hd__and3_1
X_06546_ net545 _00796_ vssd1 vssd1 vccd1 vccd1 net307 sky130_fd_sc_hd__nor2_1
X_09334_ _03309_ _03317_ _03316_ vssd1 vssd1 vccd1 vccd1 _03444_ sky130_fd_sc_hd__a21oi_1
XFILLER_0_47_244 vssd1 vssd1 vccd1 vccd1 sky130_fd_sc_hd__fill_1
XFILLER_0_8_831 vssd1 vssd1 vccd1 vccd1 sky130_fd_sc_hd__decap_8
X_09265_ _03371_ _03372_ _03374_ vssd1 vssd1 vccd1 vccd1 _03376_ sky130_fd_sc_hd__and3_1
X_06477_ _00771_ _00772_ vssd1 vssd1 vccd1 vccd1 _00773_ sky130_fd_sc_hd__and2b_1
XFILLER_0_118_699 vssd1 vssd1 vccd1 vccd1 sky130_fd_sc_hd__fill_1
X_09196_ _03305_ _03306_ vssd1 vssd1 vccd1 vccd1 _03307_ sky130_fd_sc_hd__nor2_1
XFILLER_0_105_305 vssd1 vssd1 vccd1 vccd1 sky130_fd_sc_hd__decap_3
X_08216_ net821 _02333_ _02332_ vssd1 vssd1 vccd1 vccd1 _02334_ sky130_fd_sc_hd__a21bo_1
XFILLER_0_16_653 vssd1 vssd1 vccd1 vccd1 sky130_fd_sc_hd__fill_2
XFILLER_0_121_809 vssd1 vssd1 vccd1 vccd1 sky130_fd_sc_hd__fill_1
XFILLER_0_15_152 vssd1 vssd1 vccd1 vccd1 sky130_fd_sc_hd__fill_2
X_08147_ _02147_ net494 _02263_ _02265_ vssd1 vssd1 vccd1 vccd1 _02266_ sky130_fd_sc_hd__o211ai_4
XFILLER_0_15_196 vssd1 vssd1 vccd1 vccd1 sky130_fd_sc_hd__fill_1
X_08078_ _02191_ _02196_ vssd1 vssd1 vccd1 vccd1 _02197_ sky130_fd_sc_hd__nor2_1
XFILLER_0_30_155 vssd1 vssd1 vccd1 vccd1 sky130_fd_sc_hd__decap_4
XFILLER_0_113_393 vssd1 vssd1 vccd1 vccd1 sky130_ef_sc_hd__decap_12
X_07029_ net881 net1073 _01151_ _01152_ vssd1 vssd1 vccd1 vccd1 _01154_ sky130_fd_sc_hd__o2bb2a_1
X_10040_ _04141_ _04142_ _04143_ vssd1 vssd1 vccd1 vccd1 _04146_ sky130_fd_sc_hd__a21o_1
Xhold32 det_t\[5\] vssd1 vssd1 vccd1 vccd1 net1247 sky130_fd_sc_hd__dlygate4sd3_1
Xhold10 _00093_ vssd1 vssd1 vccd1 vccd1 net1225 sky130_fd_sc_hd__dlygate4sd3_1
Xhold21 l0\[7\] vssd1 vssd1 vccd1 vccd1 net1236 sky130_fd_sc_hd__dlygate4sd3_1
Xhold43 det_t\[13\] vssd1 vssd1 vccd1 vccd1 net1258 sky130_fd_sc_hd__dlygate4sd3_1
Xhold54 l0\[14\] vssd1 vssd1 vccd1 vccd1 net1269 sky130_fd_sc_hd__dlygate4sd3_1
Xhold65 sub1.a_i\[11\] vssd1 vssd1 vccd1 vccd1 net1280 sky130_fd_sc_hd__dlygate4sd3_1
Xhold87 sub1.a_i\[27\] vssd1 vssd1 vccd1 vccd1 net1302 sky130_fd_sc_hd__dlygate4sd3_1
Xhold76 sub1.b_i\[27\] vssd1 vssd1 vccd1 vccd1 net1291 sky130_fd_sc_hd__dlygate4sd3_1
Xhold98 sub1.b_i\[15\] vssd1 vssd1 vccd1 vccd1 net1313 sky130_fd_sc_hd__dlygate4sd3_1
X_11991_ net16 net551 net627 net200 _05997_ vssd1 vssd1 vccd1 vccd1 _05998_ sky130_fd_sc_hd__a221o_1
XFILLER_0_98_645 vssd1 vssd1 vccd1 vccd1 sky130_fd_sc_hd__fill_1
X_10942_ _04916_ _04918_ vssd1 vssd1 vccd1 vccd1 _05042_ sky130_fd_sc_hd__or2_1
XFILLER_0_66_531 vssd1 vssd1 vccd1 vccd1 sky130_fd_sc_hd__fill_1
X_10873_ _04967_ _04971_ vssd1 vssd1 vccd1 vccd1 _04973_ sky130_fd_sc_hd__xnor2_1
X_12612_ l1\[30\] net25 net555 vssd1 vssd1 vccd1 vccd1 _00587_ sky130_fd_sc_hd__mux2_1
XFILLER_0_38_233 vssd1 vssd1 vccd1 vccd1 sky130_fd_sc_hd__fill_2
X_12543_ net1235 net565 _06268_ vssd1 vssd1 vccd1 vccd1 _00522_ sky130_fd_sc_hd__a21o_1
XFILLER_0_108_121 vssd1 vssd1 vccd1 vccd1 sky130_ef_sc_hd__decap_12
XFILLER_0_124_625 vssd1 vssd1 vccd1 vccd1 sky130_ef_sc_hd__decap_12
XFILLER_0_108_165 vssd1 vssd1 vccd1 vccd1 sky130_ef_sc_hd__decap_12
XFILLER_0_81_534 vssd1 vssd1 vccd1 vccd1 sky130_fd_sc_hd__decap_3
XFILLER_0_53_225 vssd1 vssd1 vccd1 vccd1 sky130_fd_sc_hd__fill_1
XFILLER_0_38_299 vssd1 vssd1 vccd1 vccd1 sky130_fd_sc_hd__fill_1
XFILLER_0_123_113 vssd1 vssd1 vccd1 vccd1 sky130_ef_sc_hd__decap_12
X_12474_ _00960_ net617 _05450_ net576 vssd1 vssd1 vccd1 vccd1 _06233_ sky130_fd_sc_hd__a22o_1
XANTENNA_7 _00796_ vssd1 vssd1 vccd1 vccd1 sky130_fd_sc_hd__diode_2
XFILLER_0_124_669 vssd1 vssd1 vccd1 vccd1 sky130_ef_sc_hd__decap_12
XFILLER_0_112_809 vssd1 vssd1 vccd1 vccd1 sky130_fd_sc_hd__decap_3
X_11425_ _05519_ _05520_ vssd1 vssd1 vccd1 vccd1 _05521_ sky130_fd_sc_hd__or2_1
XFILLER_0_10_807 vssd1 vssd1 vccd1 vccd1 sky130_fd_sc_hd__decap_4
XFILLER_0_21_144 vssd1 vssd1 vccd1 vccd1 sky130_fd_sc_hd__fill_2
X_11356_ _05209_ _05333_ _05207_ vssd1 vssd1 vccd1 vccd1 _05452_ sky130_fd_sc_hd__o21ai_1
X_10307_ _04409_ _04410_ _04402_ vssd1 vssd1 vccd1 vccd1 _04411_ sky130_fd_sc_hd__a21o_1
XTAP_306 vssd1 vccd1 sky130_fd_sc_hd__tapvpwrvgnd_1
X_11287_ _05382_ _05383_ vssd1 vssd1 vccd1 vccd1 _05384_ sky130_fd_sc_hd__and2b_1
XTAP_339 vssd1 vccd1 sky130_fd_sc_hd__tapvpwrvgnd_1
XTAP_328 vssd1 vccd1 sky130_fd_sc_hd__tapvpwrvgnd_1
XTAP_317 vssd1 vccd1 sky130_fd_sc_hd__tapvpwrvgnd_1
X_13026_ clknet_leaf_45_clk_i _00412_ net1156 vssd1 vssd1 vccd1 vccd1 x0mx2\[15\]
+ sky130_fd_sc_hd__dfrtp_1
X_10238_ net834 net958 _04339_ _04340_ vssd1 vssd1 vccd1 vccd1 _04343_ sky130_fd_sc_hd__a22oi_2
Xfanout1030 net1031 vssd1 vssd1 vccd1 vccd1 net1030 sky130_fd_sc_hd__clkbuf_4
Xfanout1063 net1064 vssd1 vssd1 vccd1 vccd1 net1063 sky130_fd_sc_hd__buf_4
X_10169_ net754 _04273_ _04272_ vssd1 vssd1 vccd1 vccd1 _04274_ sky130_fd_sc_hd__a21bo_1
Xfanout1052 net1056 vssd1 vssd1 vccd1 vccd1 net1052 sky130_fd_sc_hd__buf_2
XFILLER_0_83_15 vssd1 vssd1 vccd1 vccd1 sky130_ef_sc_hd__decap_12
Xfanout1074 net1077 vssd1 vssd1 vccd1 vccd1 net1074 sky130_fd_sc_hd__clkbuf_4
Xfanout1041 net1048 vssd1 vssd1 vccd1 vccd1 net1041 sky130_fd_sc_hd__buf_2
Xfanout1085 mul1.a\[8\] vssd1 vssd1 vccd1 vccd1 net1085 sky130_fd_sc_hd__clkbuf_4
Xfanout1096 net1097 vssd1 vssd1 vccd1 vccd1 net1096 sky130_fd_sc_hd__clkbuf_4
XFILLER_0_107_55 vssd1 vssd1 vccd1 vccd1 sky130_fd_sc_hd__fill_1
XFILLER_0_16_53 vssd1 vssd1 vccd1 vccd1 sky130_ef_sc_hd__decap_12
X_06400_ _00705_ _00706_ vssd1 vssd1 vccd1 vccd1 _00707_ sky130_fd_sc_hd__or2_4
XFILLER_0_9_617 vssd1 vssd1 vccd1 vccd1 sky130_fd_sc_hd__decap_4
XFILLER_0_16_97 vssd1 vssd1 vccd1 vccd1 sky130_ef_sc_hd__decap_12
X_07380_ _01497_ _01504_ vssd1 vssd1 vccd1 vccd1 _01505_ sky130_fd_sc_hd__nand2_1
XFILLER_0_45_726 vssd1 vssd1 vccd1 vccd1 sky130_fd_sc_hd__fill_2
X_06331_ add1.a_i\[3\] add1.b_i\[3\] vssd1 vssd1 vccd1 vccd1 _00643_ sky130_fd_sc_hd__nor2_1
XFILLER_0_32_52 vssd1 vssd1 vccd1 vccd1 sky130_fd_sc_hd__fill_1
XFILLER_0_127_485 vssd1 vssd1 vccd1 vccd1 sky130_ef_sc_hd__decap_12
X_09050_ _03160_ _03161_ vssd1 vssd1 vccd1 vccd1 _03162_ sky130_fd_sc_hd__nor2_1
X_08001_ _02117_ _02120_ vssd1 vssd1 vccd1 vccd1 _02121_ sky130_fd_sc_hd__xor2_2
XFILLER_0_72_589 vssd1 vssd1 vccd1 vccd1 sky130_fd_sc_hd__decap_3
XFILLER_0_5_834 vssd1 vssd1 vccd1 vccd1 sky130_fd_sc_hd__decap_3
Xhold502 add1.a_i\[24\] vssd1 vssd1 vccd1 vccd1 net1717 sky130_fd_sc_hd__dlygate4sd3_1
XFILLER_0_12_133 vssd1 vssd1 vccd1 vccd1 sky130_fd_sc_hd__decap_6
Xhold513 temp1\[3\] vssd1 vssd1 vccd1 vccd1 net1728 sky130_fd_sc_hd__dlygate4sd3_1
Xhold524 temp1\[2\] vssd1 vssd1 vccd1 vccd1 net1739 sky130_fd_sc_hd__dlygate4sd3_1
XFILLER_0_110_341 vssd1 vssd1 vccd1 vccd1 sky130_ef_sc_hd__decap_12
X_09952_ _03907_ _04058_ vssd1 vssd1 vccd1 vccd1 _04059_ sky130_fd_sc_hd__xnor2_4
X_08903_ _03014_ _03015_ vssd1 vssd1 vccd1 vccd1 _03016_ sky130_fd_sc_hd__xnor2_1
X_09883_ _03954_ _03989_ vssd1 vssd1 vccd1 vccd1 _03990_ sky130_fd_sc_hd__xnor2_4
XTAP_840 vssd1 vccd1 sky130_fd_sc_hd__tapvpwrvgnd_1
XTAP_851 vssd1 vccd1 sky130_fd_sc_hd__tapvpwrvgnd_1
XTAP_862 vssd1 vccd1 sky130_fd_sc_hd__tapvpwrvgnd_1
X_08834_ _02884_ _02885_ _02944_ _02945_ vssd1 vssd1 vccd1 vccd1 _02948_ sky130_fd_sc_hd__o22ai_2
XTAP_884 vssd1 vccd1 sky130_fd_sc_hd__tapvpwrvgnd_1
XTAP_873 vssd1 vccd1 sky130_fd_sc_hd__tapvpwrvgnd_1
XTAP_895 vssd1 vccd1 sky130_fd_sc_hd__tapvpwrvgnd_1
X_08765_ _02876_ _02877_ vssd1 vssd1 vccd1 vccd1 _02879_ sky130_fd_sc_hd__xor2_1
XFILLER_0_79_111 vssd1 vssd1 vccd1 vccd1 sky130_fd_sc_hd__fill_1
X_07716_ _01803_ _01804_ _01836_ _01837_ vssd1 vssd1 vccd1 vccd1 _01839_ sky130_fd_sc_hd__nor4_1
X_08696_ _02669_ _02810_ vssd1 vssd1 vccd1 vccd1 _02811_ sky130_fd_sc_hd__and2_1
X_07647_ net798 _01769_ _01768_ vssd1 vssd1 vccd1 vccd1 _01770_ sky130_fd_sc_hd__a21bo_1
XFILLER_0_82_309 vssd1 vssd1 vccd1 vccd1 sky130_fd_sc_hd__decap_4
X_07578_ _01350_ _01353_ _01699_ _01700_ vssd1 vssd1 vccd1 vccd1 _01702_ sky130_fd_sc_hd__a211oi_4
X_09317_ _03425_ _03426_ net1124 net707 vssd1 vssd1 vccd1 vccd1 _03427_ sky130_fd_sc_hd__and4bb_1
X_06529_ _00642_ _00644_ vssd1 vssd1 vccd1 vccd1 _00787_ sky130_fd_sc_hd__nand2_2
XFILLER_0_36_726 vssd1 vssd1 vccd1 vccd1 sky130_fd_sc_hd__fill_2
XFILLER_0_105_113 vssd1 vssd1 vccd1 vccd1 sky130_ef_sc_hd__decap_12
X_09248_ _03357_ _03358_ _03201_ _03203_ vssd1 vssd1 vccd1 vccd1 _03359_ sky130_fd_sc_hd__o211a_1
XFILLER_0_51_729 vssd1 vssd1 vccd1 vccd1 sky130_fd_sc_hd__fill_2
XFILLER_0_121_617 vssd1 vssd1 vccd1 vccd1 sky130_ef_sc_hd__decap_12
X_09179_ _03283_ _03288_ vssd1 vssd1 vccd1 vccd1 _03290_ sky130_fd_sc_hd__xor2_1
XFILLER_0_106_669 vssd1 vssd1 vccd1 vccd1 sky130_ef_sc_hd__decap_12
X_11210_ _05264_ _05266_ _05305_ _05306_ vssd1 vssd1 vccd1 vccd1 _05308_ sky130_fd_sc_hd__o22ai_2
X_12190_ _00852_ net509 net466 y1my2\[8\] _06146_ vssd1 vssd1 vccd1 vccd1 _06147_
+ sky130_fd_sc_hd__a221o_1
X_11141_ _05230_ _05238_ vssd1 vssd1 vccd1 vccd1 _05239_ sky130_fd_sc_hd__or2_1
XFILLER_0_9_3 vssd1 vssd1 vccd1 vccd1 sky130_ef_sc_hd__decap_12
X_11072_ _05162_ _05169_ vssd1 vssd1 vccd1 vccd1 _05171_ sky130_fd_sc_hd__xnor2_2
Xinput111 v0y[29] vssd1 vssd1 vccd1 vccd1 net111 sky130_fd_sc_hd__buf_1
Xinput100 v0y[19] vssd1 vssd1 vccd1 vccd1 net100 sky130_fd_sc_hd__buf_1
X_10023_ _04126_ _04127_ _03961_ _03963_ vssd1 vssd1 vccd1 vccd1 _04129_ sky130_fd_sc_hd__a211o_1
Xinput144 v1x[2] vssd1 vssd1 vccd1 vccd1 net144 sky130_fd_sc_hd__buf_1
Xinput133 v1x[1] vssd1 vssd1 vccd1 vccd1 net133 sky130_fd_sc_hd__buf_1
Xinput122 v1x[0] vssd1 vssd1 vccd1 vccd1 net122 sky130_fd_sc_hd__buf_1
Xinput177 v1y[30] vssd1 vssd1 vccd1 vccd1 net177 sky130_fd_sc_hd__clkbuf_1
Xinput155 v1y[10] vssd1 vssd1 vccd1 vccd1 net155 sky130_fd_sc_hd__clkbuf_1
Xinput166 v1y[20] vssd1 vssd1 vccd1 vccd1 net166 sky130_fd_sc_hd__clkbuf_1
Xinput188 v2x[11] vssd1 vssd1 vccd1 vccd1 net188 sky130_fd_sc_hd__buf_1
Xinput199 v2x[21] vssd1 vssd1 vccd1 vccd1 net199 sky130_fd_sc_hd__buf_1
XFILLER_0_53_29 vssd1 vssd1 vccd1 vccd1 sky130_ef_sc_hd__decap_12
X_11974_ net99 net622 net596 net67 vssd1 vssd1 vccd1 vccd1 _05985_ sky130_fd_sc_hd__a22o_1
X_10925_ net1040 net713 net709 net1048 vssd1 vssd1 vccd1 vccd1 _05025_ sky130_fd_sc_hd__a22o_1
XFILLER_0_85_147 vssd1 vssd1 vccd1 vccd1 sky130_fd_sc_hd__fill_2
X_10856_ net692 _04311_ _04825_ vssd1 vssd1 vccd1 vccd1 _04956_ sky130_fd_sc_hd__and3_1
XFILLER_0_39_531 vssd1 vssd1 vccd1 vccd1 sky130_fd_sc_hd__decap_4
XFILLER_0_39_542 vssd1 vssd1 vccd1 vccd1 sky130_fd_sc_hd__decap_8
XFILLER_0_85_169 vssd1 vssd1 vccd1 vccd1 sky130_fd_sc_hd__fill_1
XPHY_161 vssd1 vssd1 vccd1 vccd1 sky130_fd_sc_hd__decap_3
XPHY_150 vssd1 vssd1 vccd1 vccd1 sky130_fd_sc_hd__decap_3
XFILLER_0_39_597 vssd1 vssd1 vccd1 vccd1 sky130_ef_sc_hd__decap_12
XPHY_194 vssd1 vssd1 vccd1 vccd1 sky130_fd_sc_hd__decap_3
XFILLER_0_93_191 vssd1 vssd1 vccd1 vccd1 sky130_fd_sc_hd__decap_8
XPHY_183 vssd1 vssd1 vccd1 vccd1 sky130_fd_sc_hd__decap_3
XPHY_172 vssd1 vssd1 vccd1 vccd1 sky130_fd_sc_hd__decap_3
X_10787_ _04884_ _04885_ _04700_ _04703_ vssd1 vssd1 vccd1 vccd1 _04888_ sky130_fd_sc_hd__o211a_1
XFILLER_0_26_214 vssd1 vssd1 vccd1 vccd1 sky130_fd_sc_hd__decap_6
X_12526_ net1268 net564 vssd1 vssd1 vccd1 vccd1 _06260_ sky130_fd_sc_hd__nand2_1
XFILLER_0_124_433 vssd1 vssd1 vccd1 vccd1 sky130_ef_sc_hd__decap_12
XFILLER_0_54_567 vssd1 vssd1 vccd1 vccd1 sky130_fd_sc_hd__decap_3
XFILLER_0_78_15 vssd1 vssd1 vccd1 vccd1 sky130_ef_sc_hd__decap_12
X_12457_ net1705 _06223_ net572 vssd1 vssd1 vccd1 vccd1 _00481_ sky130_fd_sc_hd__mux2_1
XFILLER_0_124_477 vssd1 vssd1 vccd1 vccd1 sky130_ef_sc_hd__decap_12
XFILLER_0_111_105 vssd1 vssd1 vccd1 vccd1 sky130_fd_sc_hd__decap_6
X_11408_ _05341_ _05380_ _05502_ _05503_ vssd1 vssd1 vccd1 vccd1 _05504_ sky130_fd_sc_hd__o211a_1
XFILLER_0_111_149 vssd1 vssd1 vccd1 vccd1 sky130_ef_sc_hd__decap_12
X_12388_ net1387 _00867_ net683 vssd1 vssd1 vccd1 vccd1 _00440_ sky130_fd_sc_hd__mux2_1
X_11339_ _05303_ _05305_ _05434_ _05435_ vssd1 vssd1 vccd1 vccd1 _05436_ sky130_fd_sc_hd__o211ai_4
XFILLER_0_118_21 vssd1 vssd1 vccd1 vccd1 sky130_fd_sc_hd__decap_6
X_06880_ state\[2\] _00983_ _01002_ _01008_ vssd1 vssd1 vccd1 vccd1 _00119_ sky130_fd_sc_hd__a22o_1
X_13009_ clknet_leaf_32_clk_i _00395_ net1173 vssd1 vssd1 vccd1 vccd1 x2mx1\[30\]
+ sky130_fd_sc_hd__dfrtp_1
XFILLER_0_118_65 vssd1 vssd1 vccd1 vccd1 sky130_ef_sc_hd__decap_12
X_08550_ _02425_ _02664_ _02665_ vssd1 vssd1 vccd1 vccd1 _02666_ sky130_fd_sc_hd__and3_1
X_08481_ _02486_ _02493_ _02492_ vssd1 vssd1 vccd1 vccd1 _02597_ sky130_fd_sc_hd__a21bo_1
X_07501_ _01621_ _01624_ _01593_ _01620_ vssd1 vssd1 vccd1 vccd1 _01626_ sky130_fd_sc_hd__o211a_1
XFILLER_0_119_205 vssd1 vssd1 vccd1 vccd1 sky130_ef_sc_hd__decap_12
XFILLER_0_58_840 vssd1 vssd1 vccd1 vccd1 sky130_fd_sc_hd__fill_2
XFILLER_0_43_62 vssd1 vssd1 vccd1 vccd1 sky130_ef_sc_hd__decap_12
X_07432_ net917 net909 net1105 net1112 vssd1 vssd1 vccd1 vccd1 _01557_ sky130_fd_sc_hd__and4_1
XFILLER_0_119_249 vssd1 vssd1 vccd1 vccd1 sky130_ef_sc_hd__decap_12
XFILLER_0_64_309 vssd1 vssd1 vccd1 vccd1 sky130_fd_sc_hd__decap_3
X_09102_ net861 net981 _03211_ _03212_ vssd1 vssd1 vccd1 vccd1 _03214_ sky130_fd_sc_hd__a22o_1
X_07363_ net854 net1143 vssd1 vssd1 vccd1 vccd1 _01488_ sky130_fd_sc_hd__nand2_1
X_06314_ _00624_ _00625_ vssd1 vssd1 vccd1 vccd1 _00626_ sky130_fd_sc_hd__nand2_1
X_07294_ _01417_ _01418_ vssd1 vssd1 vccd1 vccd1 _01419_ sky130_fd_sc_hd__nor2_1
X_09033_ _03142_ _03144_ _03124_ vssd1 vssd1 vccd1 vccd1 _03145_ sky130_fd_sc_hd__o21a_1
XFILLER_0_87_3 vssd1 vssd1 vccd1 vccd1 sky130_ef_sc_hd__decap_12
XFILLER_0_72_375 vssd1 vssd1 vccd1 vccd1 sky130_fd_sc_hd__decap_8
XFILLER_0_32_228 vssd1 vssd1 vccd1 vccd1 sky130_fd_sc_hd__fill_2
Xhold310 _00107_ vssd1 vssd1 vccd1 vccd1 net1525 sky130_fd_sc_hd__dlygate4sd3_1
XFILLER_0_103_617 vssd1 vssd1 vccd1 vccd1 sky130_ef_sc_hd__decap_12
Xhold343 net424 vssd1 vssd1 vccd1 vccd1 net1558 sky130_fd_sc_hd__dlygate4sd3_1
Xhold321 x0mx2\[21\] vssd1 vssd1 vccd1 vccd1 net1536 sky130_fd_sc_hd__dlygate4sd3_1
Xhold332 x0mx2\[3\] vssd1 vssd1 vccd1 vccd1 net1547 sky130_fd_sc_hd__dlygate4sd3_1
Xhold354 l0\[9\] vssd1 vssd1 vccd1 vccd1 net1569 sky130_fd_sc_hd__dlygate4sd3_1
Xhold376 l1\[8\] vssd1 vssd1 vccd1 vccd1 net1591 sky130_fd_sc_hd__dlygate4sd3_1
Xhold365 _00044_ vssd1 vssd1 vccd1 vccd1 net1580 sky130_fd_sc_hd__dlygate4sd3_1
Xhold387 add1.b_i\[1\] vssd1 vssd1 vccd1 vccd1 net1602 sky130_fd_sc_hd__dlygate4sd3_1
Xfanout823 mul1.b\[12\] vssd1 vssd1 vccd1 vccd1 net823 sky130_fd_sc_hd__clkbuf_4
Xfanout834 net835 vssd1 vssd1 vccd1 vccd1 net834 sky130_fd_sc_hd__clkbuf_4
X_09935_ _04039_ _04040_ vssd1 vssd1 vccd1 vccd1 _04042_ sky130_fd_sc_hd__xnor2_4
Xfanout801 mul1.b\[15\] vssd1 vssd1 vccd1 vccd1 net801 sky130_fd_sc_hd__clkbuf_2
Xhold398 y1my2\[14\] vssd1 vssd1 vccd1 vccd1 net1613 sky130_fd_sc_hd__dlygate4sd3_1
Xfanout812 mul1.b\[14\] vssd1 vssd1 vccd1 vccd1 net812 sky130_fd_sc_hd__buf_4
X_09866_ net803 net792 net1006 net998 vssd1 vssd1 vccd1 vccd1 _03973_ sky130_fd_sc_hd__nand4_2
Xfanout867 net870 vssd1 vssd1 vccd1 vccd1 net867 sky130_fd_sc_hd__buf_4
Xfanout856 net857 vssd1 vssd1 vccd1 vccd1 net856 sky130_fd_sc_hd__buf_2
XTAP_670 vssd1 vccd1 sky130_fd_sc_hd__tapvpwrvgnd_1
Xfanout845 mul1.b\[10\] vssd1 vssd1 vccd1 vccd1 net845 sky130_fd_sc_hd__clkbuf_4
Xfanout878 net879 vssd1 vssd1 vccd1 vccd1 net878 sky130_fd_sc_hd__buf_4
Xfanout889 net891 vssd1 vssd1 vccd1 vccd1 net889 sky130_fd_sc_hd__buf_2
X_08817_ _02929_ _02930_ _02922_ vssd1 vssd1 vccd1 vccd1 _02931_ sky130_fd_sc_hd__a21o_1
XTAP_692 vssd1 vccd1 sky130_fd_sc_hd__tapvpwrvgnd_1
XTAP_681 vssd1 vccd1 sky130_fd_sc_hd__tapvpwrvgnd_1
X_09797_ _03903_ _03904_ vssd1 vssd1 vccd1 vccd1 _03905_ sky130_fd_sc_hd__xnor2_2
X_08748_ net1099 net756 _02706_ _02707_ net773 vssd1 vssd1 vccd1 vccd1 _02862_ sky130_fd_sc_hd__a32o_1
XTAP_1825 vssd1 vccd1 sky130_fd_sc_hd__tapvpwrvgnd_1
XTAP_1814 vssd1 vccd1 sky130_fd_sc_hd__tapvpwrvgnd_1
XTAP_1803 vssd1 vccd1 sky130_fd_sc_hd__tapvpwrvgnd_1
X_08679_ _02649_ _02652_ _02791_ _02793_ vssd1 vssd1 vccd1 vccd1 _02794_ sky130_fd_sc_hd__o211a_2
XFILLER_0_67_125 vssd1 vssd1 vccd1 vccd1 sky130_fd_sc_hd__decap_4
XTAP_1858 vssd1 vccd1 sky130_fd_sc_hd__tapvpwrvgnd_1
XTAP_1847 vssd1 vccd1 sky130_fd_sc_hd__tapvpwrvgnd_1
XTAP_1836 vssd1 vccd1 sky130_fd_sc_hd__tapvpwrvgnd_1
X_10710_ _04662_ _04663_ _04665_ _04666_ _04670_ vssd1 vssd1 vccd1 vccd1 _04812_ sky130_fd_sc_hd__o32a_2
XFILLER_0_67_136 vssd1 vssd1 vccd1 vccd1 sky130_fd_sc_hd__decap_8
XTAP_1869 vssd1 vccd1 sky130_fd_sc_hd__tapvpwrvgnd_1
X_11690_ net1289 _05321_ net539 vssd1 vssd1 vccd1 vccd1 _00182_ sky130_fd_sc_hd__mux2_1
XFILLER_0_36_512 vssd1 vssd1 vccd1 vccd1 sky130_fd_sc_hd__decap_6
XFILLER_0_119_783 vssd1 vssd1 vccd1 vccd1 sky130_fd_sc_hd__fill_1
XFILLER_0_75_191 vssd1 vssd1 vccd1 vccd1 sky130_fd_sc_hd__fill_2
X_10641_ _04739_ _04740_ _04709_ vssd1 vssd1 vccd1 vccd1 _04743_ sky130_fd_sc_hd__o21ai_2
Xclkbuf_3_3__f_clk_i clknet_0_clk_i vssd1 vssd1 vccd1 vccd1 clknet_3_3__leaf_clk_i
+ sky130_fd_sc_hd__clkbuf_16
X_10572_ net859 net927 _04531_ _04532_ vssd1 vssd1 vccd1 vccd1 _04674_ sky130_fd_sc_hd__a22o_1
XFILLER_0_24_718 vssd1 vssd1 vccd1 vccd1 sky130_fd_sc_hd__fill_2
X_12311_ net1619 _00970_ net680 vssd1 vssd1 vccd1 vccd1 _00363_ sky130_fd_sc_hd__mux2_1
XFILLER_0_90_194 vssd1 vssd1 vccd1 vccd1 sky130_fd_sc_hd__fill_2
XFILLER_0_51_559 vssd1 vssd1 vccd1 vccd1 sky130_fd_sc_hd__fill_1
X_12242_ net722 _06181_ net517 vssd1 vssd1 vccd1 vccd1 _00308_ sky130_fd_sc_hd__mux2_1
XFILLER_0_32_740 vssd1 vssd1 vccd1 vccd1 sky130_fd_sc_hd__decap_4
XFILLER_0_121_447 vssd1 vssd1 vccd1 vccd1 sky130_fd_sc_hd__fill_1
XFILLER_0_31_261 vssd1 vssd1 vccd1 vccd1 sky130_fd_sc_hd__fill_1
XFILLER_0_102_661 vssd1 vssd1 vccd1 vccd1 sky130_fd_sc_hd__fill_1
XFILLER_0_48_29 vssd1 vssd1 vccd1 vccd1 sky130_fd_sc_hd__decap_8
X_12173_ net1698 _06135_ net516 vssd1 vssd1 vccd1 vccd1 _00285_ sky130_fd_sc_hd__mux2_1
XFILLER_0_102_694 vssd1 vssd1 vccd1 vccd1 sky130_fd_sc_hd__decap_6
X_11124_ _05220_ _05221_ vssd1 vssd1 vccd1 vccd1 _05222_ sky130_fd_sc_hd__nand2b_1
X_11055_ _05151_ _05152_ vssd1 vssd1 vccd1 vccd1 _05154_ sky130_fd_sc_hd__nor2_1
X_10006_ _04089_ _04110_ vssd1 vssd1 vccd1 vccd1 _04112_ sky130_fd_sc_hd__xnor2_4
XFILLER_0_99_751 vssd1 vssd1 vccd1 vccd1 sky130_fd_sc_hd__fill_2
XFILLER_0_59_604 vssd1 vssd1 vccd1 vccd1 sky130_fd_sc_hd__fill_2
X_11957_ net1294 _05972_ net480 vssd1 vssd1 vccd1 vccd1 _00232_ sky130_fd_sc_hd__mux2_1
XFILLER_0_129_514 vssd1 vssd1 vccd1 vccd1 sky130_ef_sc_hd__decap_12
XFILLER_0_80_27 vssd1 vssd1 vccd1 vccd1 sky130_fd_sc_hd__fill_1
X_10908_ _05001_ _05006_ vssd1 vssd1 vccd1 vccd1 _05008_ sky130_fd_sc_hd__xor2_1
XFILLER_0_129_558 vssd1 vssd1 vccd1 vccd1 sky130_fd_sc_hd__fill_2
XFILLER_0_117_709 vssd1 vssd1 vccd1 vccd1 sky130_fd_sc_hd__decap_4
XFILLER_0_74_629 vssd1 vssd1 vccd1 vccd1 sky130_fd_sc_hd__fill_1
X_11888_ net1293 _05919_ net482 vssd1 vssd1 vccd1 vccd1 _00216_ sky130_fd_sc_hd__mux2_1
X_10839_ _04748_ net454 _04938_ _04939_ vssd1 vssd1 vccd1 vccd1 _04940_ sky130_fd_sc_hd__o211ai_4
XFILLER_0_27_523 vssd1 vssd1 vccd1 vccd1 sky130_fd_sc_hd__fill_1
X_12509_ _00799_ net562 _06251_ vssd1 vssd1 vccd1 vccd1 _00505_ sky130_fd_sc_hd__o21ai_1
XFILLER_0_125_753 vssd1 vssd1 vccd1 vccd1 sky130_ef_sc_hd__decap_12
XFILLER_0_109_293 vssd1 vssd1 vccd1 vccd1 sky130_fd_sc_hd__decap_4
XFILLER_0_125_797 vssd1 vssd1 vccd1 vccd1 sky130_ef_sc_hd__decap_12
XFILLER_0_89_69 vssd1 vssd1 vccd1 vccd1 sky130_fd_sc_hd__decap_8
XFILLER_0_120_77 vssd1 vssd1 vccd1 vccd1 sky130_fd_sc_hd__decap_6
Xoutput426 net426 vssd1 vssd1 vccd1 vccd1 mstream_o[79] sky130_fd_sc_hd__clkbuf_4
Xoutput415 net415 vssd1 vssd1 vccd1 vccd1 mstream_o[69] sky130_fd_sc_hd__clkbuf_4
Xoutput404 net404 vssd1 vssd1 vccd1 vccd1 mstream_o[59] sky130_fd_sc_hd__clkbuf_4
XFILLER_0_50_570 vssd1 vssd1 vccd1 vccd1 sky130_fd_sc_hd__fill_2
Xoutput448 net448 vssd1 vssd1 vccd1 vccd1 mstream_o[99] sky130_fd_sc_hd__clkbuf_4
XFILLER_0_112_469 vssd1 vssd1 vccd1 vccd1 sky130_fd_sc_hd__decap_6
Xoutput437 net437 vssd1 vssd1 vccd1 vccd1 mstream_o[89] sky130_fd_sc_hd__clkbuf_4
X_07981_ net1051 net1059 net849 net839 vssd1 vssd1 vccd1 vccd1 _02101_ sky130_fd_sc_hd__and4_1
X_09720_ _03826_ _03827_ _03813_ vssd1 vssd1 vccd1 vccd1 _03828_ sky130_fd_sc_hd__a21oi_1
X_06932_ _01056_ vssd1 vssd1 vccd1 vccd1 _01057_ sky130_fd_sc_hd__inv_2
XFILLER_0_38_73 vssd1 vssd1 vccd1 vccd1 sky130_fd_sc_hd__decap_8
X_09651_ _03757_ _03758_ vssd1 vssd1 vccd1 vccd1 _03759_ sky130_fd_sc_hd__xnor2_1
X_06863_ state\[3\] _00976_ vssd1 vssd1 vccd1 vccd1 _00993_ sky130_fd_sc_hd__nor2_4
X_08602_ net1060 net797 net787 net1068 vssd1 vssd1 vccd1 vccd1 _02717_ sky130_fd_sc_hd__a22o_1
X_09582_ _03689_ _03690_ _03672_ vssd1 vssd1 vccd1 vccd1 _03691_ sky130_fd_sc_hd__a21o_1
X_06794_ net1450 l0\[1\] net644 vssd1 vssd1 vccd1 vccd1 _00068_ sky130_fd_sc_hd__mux2_1
X_08533_ _02513_ _02517_ _02646_ _02647_ vssd1 vssd1 vccd1 vccd1 _02649_ sky130_fd_sc_hd__a211oi_4
XFILLER_0_77_412 vssd1 vssd1 vccd1 vccd1 sky130_fd_sc_hd__decap_8
XFILLER_0_54_83 vssd1 vssd1 vccd1 vccd1 sky130_fd_sc_hd__fill_1
XFILLER_0_77_456 vssd1 vssd1 vccd1 vccd1 sky130_fd_sc_hd__fill_1
X_08464_ _02579_ _02578_ _02577_ vssd1 vssd1 vccd1 vccd1 _02580_ sky130_fd_sc_hd__nand3b_1
XFILLER_0_49_169 vssd1 vssd1 vccd1 vccd1 sky130_fd_sc_hd__fill_1
XFILLER_0_46_810 vssd1 vssd1 vccd1 vccd1 sky130_fd_sc_hd__fill_2
XFILLER_0_70_71 vssd1 vssd1 vccd1 vccd1 sky130_fd_sc_hd__fill_1
X_08395_ _02364_ _02372_ _02371_ vssd1 vssd1 vccd1 vccd1 _02512_ sky130_fd_sc_hd__a21bo_1
XFILLER_0_64_128 vssd1 vssd1 vccd1 vccd1 sky130_ef_sc_hd__decap_12
X_07415_ _01530_ _01539_ _01496_ _01513_ vssd1 vssd1 vccd1 vccd1 _01540_ sky130_fd_sc_hd__o211a_1
XFILLER_0_45_331 vssd1 vssd1 vccd1 vccd1 sky130_fd_sc_hd__decap_4
X_07346_ _01468_ _01469_ _01470_ vssd1 vssd1 vccd1 vccd1 _01471_ sky130_fd_sc_hd__nand3_1
XFILLER_0_45_397 vssd1 vssd1 vccd1 vccd1 sky130_fd_sc_hd__fill_1
X_09016_ net1108 net1116 net728 net723 vssd1 vssd1 vccd1 vccd1 _03128_ sky130_fd_sc_hd__and4_1
XFILLER_0_103_403 vssd1 vssd1 vccd1 vccd1 sky130_fd_sc_hd__fill_2
X_07277_ _01399_ _01400_ _01263_ vssd1 vssd1 vccd1 vccd1 _01402_ sky130_fd_sc_hd__a21oi_2
Xhold140 _00063_ vssd1 vssd1 vccd1 vccd1 net1355 sky130_fd_sc_hd__dlygate4sd3_1
Xhold151 add1.b_i\[28\] vssd1 vssd1 vccd1 vccd1 net1366 sky130_fd_sc_hd__dlygate4sd3_1
Xhold162 net376 vssd1 vssd1 vccd1 vccd1 net1377 sky130_fd_sc_hd__dlygate4sd3_1
Xhold173 l0\[5\] vssd1 vssd1 vccd1 vccd1 net1388 sky130_fd_sc_hd__dlygate4sd3_1
Xhold184 net410 vssd1 vssd1 vccd1 vccd1 net1399 sky130_fd_sc_hd__dlygate4sd3_1
Xhold195 sub1.a_i\[22\] vssd1 vssd1 vccd1 vccd1 net1410 sky130_fd_sc_hd__dlygate4sd3_1
Xfanout642 net643 vssd1 vssd1 vccd1 vccd1 net642 sky130_fd_sc_hd__clkbuf_4
X_09918_ _03869_ _04023_ vssd1 vssd1 vccd1 vccd1 _04025_ sky130_fd_sc_hd__nor2_2
Xfanout620 _00990_ vssd1 vssd1 vccd1 vccd1 net620 sky130_fd_sc_hd__clkbuf_4
Xfanout631 net632 vssd1 vssd1 vccd1 vccd1 net631 sky130_fd_sc_hd__clkbuf_4
Xfanout664 _01006_ vssd1 vssd1 vccd1 vccd1 net664 sky130_fd_sc_hd__clkbuf_4
Xfanout675 net676 vssd1 vssd1 vccd1 vccd1 net675 sky130_fd_sc_hd__buf_4
Xfanout653 net654 vssd1 vssd1 vccd1 vccd1 net653 sky130_fd_sc_hd__clkbuf_4
X_09849_ net1046 net1053 net752 net745 vssd1 vssd1 vccd1 vccd1 _03956_ sky130_fd_sc_hd__and4_1
Xfanout686 _00805_ vssd1 vssd1 vccd1 vccd1 net686 sky130_fd_sc_hd__clkbuf_4
Xfanout697 net698 vssd1 vssd1 vccd1 vccd1 net697 sky130_fd_sc_hd__clkbuf_4
X_12860_ clknet_leaf_29_clk_i _00246_ vssd1 vssd1 vccd1 vccd1 sub1.b_i\[27\] sky130_fd_sc_hd__dfxtp_1
XTAP_1600 vssd1 vccd1 sky130_fd_sc_hd__tapvpwrvgnd_1
X_11811_ net40 net687 net678 net67 vssd1 vssd1 vccd1 vccd1 _05854_ sky130_fd_sc_hd__a22o_1
XTAP_1633 vssd1 vccd1 sky130_fd_sc_hd__tapvpwrvgnd_1
XTAP_1622 vssd1 vccd1 sky130_fd_sc_hd__tapvpwrvgnd_1
XTAP_1611 vssd1 vccd1 sky130_fd_sc_hd__tapvpwrvgnd_1
X_12791_ clknet_leaf_17_clk_i _00177_ vssd1 vssd1 vccd1 vccd1 add1.b_i\[22\] sky130_fd_sc_hd__dfxtp_1
XFILLER_0_95_253 vssd1 vssd1 vccd1 vccd1 sky130_ef_sc_hd__decap_12
XTAP_1666 vssd1 vccd1 sky130_fd_sc_hd__tapvpwrvgnd_1
XTAP_1655 vssd1 vccd1 sky130_fd_sc_hd__tapvpwrvgnd_1
XTAP_1644 vssd1 vccd1 sky130_fd_sc_hd__tapvpwrvgnd_1
XFILLER_0_56_618 vssd1 vssd1 vccd1 vccd1 sky130_fd_sc_hd__decap_3
X_11742_ net87 net677 net607 net215 vssd1 vssd1 vccd1 vccd1 _05796_ sky130_fd_sc_hd__a22o_1
XFILLER_0_28_309 vssd1 vssd1 vccd1 vccd1 sky130_fd_sc_hd__fill_1
XTAP_1699 vssd1 vccd1 sky130_fd_sc_hd__tapvpwrvgnd_1
XTAP_1688 vssd1 vccd1 sky130_fd_sc_hd__tapvpwrvgnd_1
XTAP_1677 vssd1 vccd1 sky130_fd_sc_hd__tapvpwrvgnd_1
X_11673_ net1301 _02819_ net537 vssd1 vssd1 vccd1 vccd1 _00165_ sky130_fd_sc_hd__mux2_1
X_10624_ _04585_ _04587_ vssd1 vssd1 vccd1 vccd1 _04726_ sky130_fd_sc_hd__nand2_1
XFILLER_0_64_640 vssd1 vssd1 vccd1 vccd1 sky130_fd_sc_hd__decap_4
XFILLER_0_122_701 vssd1 vssd1 vccd1 vccd1 sky130_ef_sc_hd__decap_12
XFILLER_0_107_775 vssd1 vssd1 vccd1 vccd1 sky130_fd_sc_hd__decap_3
X_10555_ _04529_ _04657_ vssd1 vssd1 vccd1 vccd1 _04658_ sky130_fd_sc_hd__xnor2_1
X_10486_ _04583_ _04587_ _04588_ vssd1 vssd1 vccd1 vccd1 _04589_ sky130_fd_sc_hd__nand3_2
X_12225_ x2mx1\[20\] net606 net589 temp1\[20\] vssd1 vssd1 vccd1 vccd1 _06170_ sky130_fd_sc_hd__a22o_1
XFILLER_0_20_765 vssd1 vssd1 vccd1 vccd1 sky130_fd_sc_hd__decap_3
X_12156_ x0mx2\[30\] net632 net593 y1my2\[30\] vssd1 vssd1 vccd1 vccd1 _06123_ sky130_fd_sc_hd__a22o_1
XFILLER_0_75_27 vssd1 vssd1 vccd1 vccd1 sky130_ef_sc_hd__decap_12
X_11107_ temp1\[26\] _05205_ net542 vssd1 vssd1 vccd1 vccd1 _05206_ sky130_fd_sc_hd__mux2_1
X_12087_ net1056 _06071_ net514 vssd1 vssd1 vccd1 vccd1 _00263_ sky130_fd_sc_hd__mux2_1
X_11038_ _05101_ _05135_ _05136_ vssd1 vssd1 vccd1 vccd1 _05137_ sky130_fd_sc_hd__nor3_2
XFILLER_0_91_15 vssd1 vssd1 vccd1 vccd1 sky130_ef_sc_hd__decap_12
XFILLER_0_115_55 vssd1 vssd1 vccd1 vccd1 sky130_fd_sc_hd__fill_1
X_12989_ clknet_leaf_0_clk_i _00375_ net1155 vssd1 vssd1 vccd1 vccd1 x2mx1\[10\] sky130_fd_sc_hd__dfrtp_1
XFILLER_0_24_53 vssd1 vssd1 vccd1 vccd1 sky130_ef_sc_hd__decap_12
XFILLER_0_117_517 vssd1 vssd1 vccd1 vccd1 sky130_ef_sc_hd__decap_12
XFILLER_0_46_128 vssd1 vssd1 vccd1 vccd1 sky130_ef_sc_hd__decap_12
X_08180_ _02296_ _02297_ vssd1 vssd1 vccd1 vccd1 _02298_ sky130_fd_sc_hd__or2_1
XFILLER_0_61_109 vssd1 vssd1 vccd1 vccd1 sky130_fd_sc_hd__decap_3
X_07200_ _01271_ _01272_ _01324_ vssd1 vssd1 vccd1 vccd1 _01325_ sky130_fd_sc_hd__and3_1
X_07131_ _01175_ _01195_ _01254_ _01255_ vssd1 vssd1 vccd1 vccd1 _01256_ sky130_fd_sc_hd__o211a_1
XFILLER_0_40_41 vssd1 vssd1 vccd1 vccd1 sky130_fd_sc_hd__decap_8
XFILLER_0_125_561 vssd1 vssd1 vccd1 vccd1 sky130_ef_sc_hd__decap_12
XFILLER_0_27_397 vssd1 vssd1 vccd1 vccd1 sky130_fd_sc_hd__fill_1
XFILLER_0_112_233 vssd1 vssd1 vccd1 vccd1 sky130_ef_sc_hd__decap_12
X_07062_ net806 net1143 _01184_ _01185_ vssd1 vssd1 vccd1 vccd1 _01187_ sky130_fd_sc_hd__a22oi_1
XFILLER_0_100_406 vssd1 vssd1 vccd1 vccd1 sky130_fd_sc_hd__fill_1
Xoutput267 net267 vssd1 vssd1 vccd1 vccd1 div_mstream_o[23] sky130_fd_sc_hd__clkbuf_4
Xoutput256 net256 vssd1 vssd1 vccd1 vccd1 div_mstream_o[13] sky130_fd_sc_hd__clkbuf_4
XFILLER_0_112_277 vssd1 vssd1 vccd1 vccd1 sky130_ef_sc_hd__decap_12
XFILLER_0_49_61 vssd1 vssd1 vccd1 vccd1 sky130_fd_sc_hd__fill_2
Xoutput289 net289 vssd1 vssd1 vccd1 vccd1 div_mstream_o[43] sky130_fd_sc_hd__clkbuf_4
Xoutput278 net278 vssd1 vssd1 vccd1 vccd1 div_mstream_o[33] sky130_fd_sc_hd__clkbuf_4
X_07964_ _02077_ _02082_ vssd1 vssd1 vccd1 vccd1 _02084_ sky130_fd_sc_hd__xor2_1
XFILLER_0_4_41 vssd1 vssd1 vccd1 vccd1 sky130_ef_sc_hd__decap_12
X_09703_ _03808_ _03809_ _03642_ _03644_ vssd1 vssd1 vccd1 vccd1 _03811_ sky130_fd_sc_hd__a211o_1
X_07895_ _02006_ _02014_ vssd1 vssd1 vccd1 vccd1 _02016_ sky130_fd_sc_hd__xor2_2
XFILLER_0_4_85 vssd1 vssd1 vccd1 vccd1 sky130_fd_sc_hd__fill_1
X_06915_ net829 net1126 _01037_ _01038_ vssd1 vssd1 vccd1 vccd1 _01040_ sky130_fd_sc_hd__o2bb2a_1
X_09634_ _03741_ _03742_ _03442_ vssd1 vssd1 vccd1 vccd1 _03743_ sky130_fd_sc_hd__nor3b_2
XFILLER_0_69_209 vssd1 vssd1 vccd1 vccd1 sky130_fd_sc_hd__decap_8
XFILLER_0_65_82 vssd1 vssd1 vccd1 vccd1 sky130_fd_sc_hd__decap_3
X_06846_ _00606_ _00976_ vssd1 vssd1 vccd1 vccd1 _00977_ sky130_fd_sc_hd__nor2_1
X_09565_ net817 net998 net991 net826 vssd1 vssd1 vccd1 vccd1 _03674_ sky130_fd_sc_hd__a22o_1
X_06777_ net1411 net1370 net639 vssd1 vssd1 vccd1 vccd1 _00051_ sky130_fd_sc_hd__mux2_1
X_09496_ _03595_ _03603_ vssd1 vssd1 vccd1 vccd1 _03605_ sky130_fd_sc_hd__xnor2_1
X_08516_ _02628_ _02631_ vssd1 vssd1 vccd1 vccd1 _02632_ sky130_fd_sc_hd__xnor2_2
XFILLER_0_65_415 vssd1 vssd1 vccd1 vccd1 sky130_fd_sc_hd__fill_2
XFILLER_0_37_106 vssd1 vssd1 vccd1 vccd1 sky130_fd_sc_hd__decap_6
XFILLER_0_108_517 vssd1 vssd1 vccd1 vccd1 sky130_fd_sc_hd__fill_2
X_08447_ _02561_ _02562_ vssd1 vssd1 vccd1 vccd1 _02563_ sky130_fd_sc_hd__nor2_1
XFILLER_0_65_437 vssd1 vssd1 vccd1 vccd1 sky130_fd_sc_hd__decap_8
XFILLER_0_18_342 vssd1 vssd1 vccd1 vccd1 sky130_fd_sc_hd__fill_1
XFILLER_0_92_278 vssd1 vssd1 vccd1 vccd1 sky130_fd_sc_hd__fill_1
XFILLER_0_80_418 vssd1 vssd1 vccd1 vccd1 sky130_fd_sc_hd__fill_2
X_08378_ _02486_ _02492_ _02493_ vssd1 vssd1 vccd1 vccd1 _02495_ sky130_fd_sc_hd__and3_1
XFILLER_0_45_172 vssd1 vssd1 vccd1 vccd1 sky130_fd_sc_hd__fill_2
XFILLER_0_104_701 vssd1 vssd1 vccd1 vccd1 sky130_fd_sc_hd__decap_8
X_07329_ _01442_ _01451_ _01452_ vssd1 vssd1 vccd1 vccd1 _01454_ sky130_fd_sc_hd__nand3_1
XFILLER_0_33_345 vssd1 vssd1 vccd1 vccd1 sky130_fd_sc_hd__decap_3
X_10340_ _04441_ _04442_ _04443_ vssd1 vssd1 vccd1 vccd1 _04444_ sky130_fd_sc_hd__and3_2
XFILLER_0_61_687 vssd1 vssd1 vccd1 vccd1 sky130_fd_sc_hd__decap_6
XFILLER_0_103_255 vssd1 vssd1 vccd1 vccd1 sky130_fd_sc_hd__decap_4
X_10271_ _04062_ _04220_ vssd1 vssd1 vccd1 vccd1 _04376_ sky130_fd_sc_hd__or2_1
X_12010_ net109 net623 net597 net77 vssd1 vssd1 vccd1 vccd1 _06012_ sky130_fd_sc_hd__a22o_1
Xfanout483 net484 vssd1 vssd1 vccd1 vccd1 net483 sky130_fd_sc_hd__buf_2
Xfanout472 _05766_ vssd1 vssd1 vccd1 vccd1 net472 sky130_fd_sc_hd__clkbuf_4
X_12912_ clknet_leaf_46_clk_i _00298_ vssd1 vssd1 vccd1 vccd1 mul1.b\[15\] sky130_fd_sc_hd__dfxtp_4
Xmax_cap8 _02946_ vssd1 vssd1 vccd1 vccd1 net1749 sky130_fd_sc_hd__clkbuf_1
XTAP_2153 vssd1 vccd1 sky130_fd_sc_hd__tapvpwrvgnd_1
XTAP_2142 vssd1 vccd1 sky130_fd_sc_hd__tapvpwrvgnd_1
XTAP_2131 vssd1 vccd1 sky130_fd_sc_hd__tapvpwrvgnd_1
XTAP_2120 vssd1 vccd1 sky130_fd_sc_hd__tapvpwrvgnd_1
X_12843_ clknet_leaf_51_clk_i _00229_ vssd1 vssd1 vccd1 vccd1 sub1.b_i\[10\] sky130_fd_sc_hd__dfxtp_1
XTAP_2186 vssd1 vccd1 sky130_fd_sc_hd__tapvpwrvgnd_1
XTAP_2164 vssd1 vccd1 sky130_fd_sc_hd__tapvpwrvgnd_1
XTAP_2175 vssd1 vccd1 sky130_fd_sc_hd__tapvpwrvgnd_1
XFILLER_0_84_713 vssd1 vssd1 vccd1 vccd1 sky130_ef_sc_hd__decap_12
XTAP_1441 vssd1 vccd1 sky130_fd_sc_hd__tapvpwrvgnd_1
XTAP_1430 vssd1 vccd1 sky130_fd_sc_hd__tapvpwrvgnd_1
X_12774_ clknet_leaf_58_clk_i _00160_ vssd1 vssd1 vccd1 vccd1 add1.b_i\[5\] sky130_fd_sc_hd__dfxtp_1
XFILLER_0_29_607 vssd1 vssd1 vccd1 vccd1 sky130_fd_sc_hd__decap_6
XTAP_2197 vssd1 vccd1 sky130_fd_sc_hd__tapvpwrvgnd_1
XFILLER_0_84_757 vssd1 vssd1 vccd1 vccd1 sky130_fd_sc_hd__fill_2
XTAP_1474 vssd1 vccd1 sky130_fd_sc_hd__tapvpwrvgnd_1
XTAP_1463 vssd1 vccd1 sky130_fd_sc_hd__tapvpwrvgnd_1
XTAP_1452 vssd1 vccd1 sky130_fd_sc_hd__tapvpwrvgnd_1
X_11725_ net179 net470 _05782_ vssd1 vssd1 vccd1 vccd1 _05783_ sky130_fd_sc_hd__o21a_1
XFILLER_0_83_245 vssd1 vssd1 vccd1 vccd1 sky130_fd_sc_hd__decap_4
XTAP_1496 vssd1 vccd1 sky130_fd_sc_hd__tapvpwrvgnd_1
XTAP_1485 vssd1 vccd1 sky130_fd_sc_hd__tapvpwrvgnd_1
XFILLER_0_71_418 vssd1 vssd1 vccd1 vccd1 sky130_fd_sc_hd__fill_2
XFILLER_0_64_481 vssd1 vssd1 vccd1 vccd1 sky130_fd_sc_hd__fill_1
X_11656_ _05673_ _05749_ vssd1 vssd1 vccd1 vccd1 _05750_ sky130_fd_sc_hd__xnor2_2
XFILLER_0_37_684 vssd1 vssd1 vccd1 vccd1 sky130_fd_sc_hd__fill_2
X_10607_ _04559_ _04562_ vssd1 vssd1 vccd1 vccd1 _04709_ sky130_fd_sc_hd__nor2_1
XFILLER_0_52_654 vssd1 vssd1 vccd1 vccd1 sky130_ef_sc_hd__decap_12
X_11587_ _05677_ _05680_ vssd1 vssd1 vccd1 vccd1 _05681_ sky130_fd_sc_hd__xnor2_1
XFILLER_0_36_183 vssd1 vssd1 vccd1 vccd1 sky130_fd_sc_hd__decap_6
XFILLER_0_36_194 vssd1 vssd1 vccd1 vccd1 sky130_fd_sc_hd__fill_2
XFILLER_0_122_531 vssd1 vssd1 vccd1 vccd1 sky130_fd_sc_hd__fill_1
XFILLER_0_101_57 vssd1 vssd1 vccd1 vccd1 sky130_ef_sc_hd__decap_12
X_10538_ _04638_ _04639_ _04628_ vssd1 vssd1 vccd1 vccd1 _04641_ sky130_fd_sc_hd__a21oi_1
XFILLER_0_51_153 vssd1 vssd1 vccd1 vccd1 sky130_fd_sc_hd__fill_1
XFILLER_0_12_529 vssd1 vssd1 vccd1 vccd1 sky130_fd_sc_hd__decap_3
XFILLER_0_10_77 vssd1 vssd1 vccd1 vccd1 sky130_fd_sc_hd__decap_6
XFILLER_0_110_737 vssd1 vssd1 vccd1 vccd1 sky130_ef_sc_hd__decap_12
XFILLER_0_86_15 vssd1 vssd1 vccd1 vccd1 sky130_ef_sc_hd__decap_12
X_10469_ net999 net769 net992 net779 vssd1 vssd1 vccd1 vccd1 _04572_ sky130_fd_sc_hd__a22o_1
X_12208_ _00882_ net510 net467 y1my2\[14\] _06158_ vssd1 vssd1 vccd1 vccd1 _06159_
+ sky130_fd_sc_hd__a221o_1
X_13188_ clknet_leaf_20_clk_i _00574_ net1180 vssd1 vssd1 vccd1 vccd1 l1\[17\] sky130_fd_sc_hd__dfrtp_1
X_12139_ net960 _06110_ net517 vssd1 vssd1 vccd1 vccd1 _00276_ sky130_fd_sc_hd__mux2_1
X_06700_ _00921_ _00922_ vssd1 vssd1 vccd1 vccd1 _00923_ sky130_fd_sc_hd__xnor2_4
XFILLER_0_126_65 vssd1 vssd1 vccd1 vccd1 sky130_ef_sc_hd__decap_12
X_07680_ _01801_ _01802_ _01695_ _01697_ vssd1 vssd1 vccd1 vccd1 _01803_ sky130_fd_sc_hd__a211oi_1
XFILLER_0_35_52 vssd1 vssd1 vccd1 vccd1 sky130_fd_sc_hd__decap_4
X_06631_ sub1.a_i\[11\] sub1.b_i\[11\] vssd1 vssd1 vccd1 vccd1 _00865_ sky130_fd_sc_hd__and2b_1
XFILLER_0_35_85 vssd1 vssd1 vccd1 vccd1 sky130_fd_sc_hd__fill_1
X_09350_ _03459_ vssd1 vssd1 vccd1 vccd1 _03460_ sky130_fd_sc_hd__inv_2
X_06562_ _00614_ _00807_ vssd1 vssd1 vccd1 vccd1 _00002_ sky130_fd_sc_hd__nor2_1
X_08301_ net1148 net727 _02295_ _02296_ vssd1 vssd1 vccd1 vccd1 _02418_ sky130_fd_sc_hd__a211oi_1
XFILLER_0_87_584 vssd1 vssd1 vccd1 vccd1 sky130_fd_sc_hd__decap_4
XFILLER_0_75_746 vssd1 vssd1 vccd1 vccd1 sky130_fd_sc_hd__fill_1
X_09281_ _03370_ _03389_ _03390_ vssd1 vssd1 vccd1 vccd1 _03392_ sky130_fd_sc_hd__and3_1
X_06493_ det_t\[3\] net528 vssd1 vssd1 vccd1 vccd1 net285 sky130_fd_sc_hd__and2_1
X_08232_ _02348_ _02349_ vssd1 vssd1 vccd1 vccd1 _02350_ sky130_fd_sc_hd__nand2_1
XFILLER_0_16_802 vssd1 vssd1 vccd1 vccd1 sky130_fd_sc_hd__decap_3
XFILLER_0_51_73 vssd1 vssd1 vccd1 vccd1 sky130_fd_sc_hd__fill_2
XFILLER_0_16_813 vssd1 vssd1 vccd1 vccd1 sky130_ef_sc_hd__decap_12
X_08163_ _01945_ _02052_ _02054_ _02162_ vssd1 vssd1 vccd1 vccd1 _02282_ sky130_fd_sc_hd__nor4_1
X_08094_ _02209_ _02212_ vssd1 vssd1 vccd1 vccd1 _02213_ sky130_fd_sc_hd__xor2_1
XFILLER_0_70_473 vssd1 vssd1 vccd1 vccd1 sky130_fd_sc_hd__decap_3
X_07114_ _01177_ _01178_ vssd1 vssd1 vccd1 vccd1 _01239_ sky130_fd_sc_hd__nor2_1
XFILLER_0_113_553 vssd1 vssd1 vccd1 vccd1 sky130_fd_sc_hd__decap_6
X_07045_ _01160_ _01168_ vssd1 vssd1 vccd1 vccd1 _01170_ sky130_fd_sc_hd__xor2_2
XFILLER_0_113_597 vssd1 vssd1 vccd1 vccd1 sky130_ef_sc_hd__decap_12
XFILLER_0_101_726 vssd1 vssd1 vccd1 vccd1 sky130_fd_sc_hd__fill_2
XFILLER_0_76_70 vssd1 vssd1 vccd1 vccd1 sky130_fd_sc_hd__fill_2
X_08996_ _02808_ _02811_ _02959_ vssd1 vssd1 vccd1 vccd1 _03109_ sky130_fd_sc_hd__o21ai_1
X_07947_ _02066_ vssd1 vssd1 vccd1 vccd1 _02067_ sky130_fd_sc_hd__inv_2
X_07878_ _01990_ _01998_ vssd1 vssd1 vccd1 vccd1 _01999_ sky130_fd_sc_hd__and2_1
X_06829_ net1551 posy\[4\] net646 vssd1 vssd1 vccd1 vccd1 _00103_ sky130_fd_sc_hd__mux2_1
X_09617_ _03724_ _03725_ _03693_ vssd1 vssd1 vccd1 vccd1 _03726_ sky130_fd_sc_hd__a21o_1
X_09548_ _03653_ _03654_ _03655_ vssd1 vssd1 vccd1 vccd1 _03657_ sky130_fd_sc_hd__a21bo_1
XFILLER_0_78_573 vssd1 vssd1 vccd1 vccd1 sky130_fd_sc_hd__fill_2
X_09479_ _03584_ _03585_ _03587_ vssd1 vssd1 vccd1 vccd1 _03588_ sky130_fd_sc_hd__and3_2
X_11510_ _05569_ _05603_ _05604_ vssd1 vssd1 vccd1 vccd1 _05605_ sky130_fd_sc_hd__or3_1
X_12490_ _00788_ net568 vssd1 vssd1 vccd1 vccd1 _06242_ sky130_fd_sc_hd__nand2_1
XFILLER_0_93_598 vssd1 vssd1 vccd1 vccd1 sky130_fd_sc_hd__decap_4
XFILLER_0_81_727 vssd1 vssd1 vccd1 vccd1 sky130_fd_sc_hd__fill_1
XFILLER_0_65_278 vssd1 vssd1 vccd1 vccd1 sky130_fd_sc_hd__fill_2
XFILLER_0_53_429 vssd1 vssd1 vccd1 vccd1 sky130_fd_sc_hd__decap_4
X_11441_ _05535_ _05536_ _05414_ _05416_ vssd1 vssd1 vccd1 vccd1 _05537_ sky130_fd_sc_hd__o211a_1
XFILLER_0_61_440 vssd1 vssd1 vccd1 vccd1 sky130_fd_sc_hd__decap_8
X_11372_ net975 net736 _05464_ _05466_ vssd1 vssd1 vccd1 vccd1 _05468_ sky130_fd_sc_hd__a22oi_1
Xbary_pipe_m_1204 vssd1 vssd1 vccd1 vccd1 bary_pipe_m_1204/HI div_mstream_o[54] sky130_fd_sc_hd__conb_1
X_13111_ clknet_leaf_3_clk_i _00497_ vssd1 vssd1 vccd1 vccd1 det_t\[4\] sky130_fd_sc_hd__dfxtp_1
Xbary_pipe_m_1215 vssd1 vssd1 vccd1 vccd1 bary_pipe_m_1215/HI mstream_o[115] sky130_fd_sc_hd__conb_1
X_10323_ _04424_ _04425_ _04263_ _04267_ vssd1 vssd1 vccd1 vccd1 _04427_ sky130_fd_sc_hd__o211a_1
XFILLER_0_61_495 vssd1 vssd1 vccd1 vccd1 sky130_fd_sc_hd__decap_8
X_10254_ _04357_ _04358_ vssd1 vssd1 vccd1 vccd1 _04359_ sky130_fd_sc_hd__and2_2
X_13042_ clknet_leaf_30_clk_i _00428_ net1168 vssd1 vssd1 vccd1 vccd1 x0mx2\[31\]
+ sky130_fd_sc_hd__dfrtp_1
X_10185_ net803 net792 net991 net984 vssd1 vssd1 vccd1 vccd1 _04290_ sky130_fd_sc_hd__nand4_1
XFILLER_0_56_29 vssd1 vssd1 vccd1 vccd1 sky130_ef_sc_hd__decap_12
XFILLER_0_88_337 vssd1 vssd1 vccd1 vccd1 sky130_ef_sc_hd__decap_12
X_12826_ clknet_leaf_30_clk_i _00212_ vssd1 vssd1 vccd1 vccd1 sub1.a_i\[25\] sky130_fd_sc_hd__dfxtp_1
XFILLER_0_84_510 vssd1 vssd1 vccd1 vccd1 sky130_fd_sc_hd__fill_1
XFILLER_0_127_623 vssd1 vssd1 vccd1 vccd1 sky130_fd_sc_hd__decap_8
XTAP_1293 vssd1 vccd1 sky130_fd_sc_hd__tapvpwrvgnd_1
XTAP_1271 vssd1 vccd1 sky130_fd_sc_hd__tapvpwrvgnd_1
XTAP_1282 vssd1 vccd1 sky130_fd_sc_hd__tapvpwrvgnd_1
XTAP_1260 vssd1 vccd1 sky130_fd_sc_hd__tapvpwrvgnd_1
X_12757_ clknet_leaf_46_clk_i _00143_ vssd1 vssd1 vccd1 vccd1 add1.a_i\[20\] sky130_fd_sc_hd__dfxtp_1
XFILLER_0_127_645 vssd1 vssd1 vccd1 vccd1 sky130_fd_sc_hd__fill_2
XFILLER_0_126_133 vssd1 vssd1 vccd1 vccd1 sky130_fd_sc_hd__decap_6
XFILLER_0_84_587 vssd1 vssd1 vccd1 vccd1 sky130_fd_sc_hd__fill_1
X_12688_ clknet_leaf_14_clk_i net1237 net1184 vssd1 vssd1 vccd1 vccd1 net418 sky130_fd_sc_hd__dfrtp_1
XFILLER_0_72_749 vssd1 vssd1 vccd1 vccd1 sky130_fd_sc_hd__decap_6
X_11708_ net69 net677 net611 temp1\[1\] vssd1 vssd1 vccd1 vccd1 _05768_ sky130_fd_sc_hd__a22o_1
XFILLER_0_16_109 vssd1 vssd1 vccd1 vccd1 sky130_fd_sc_hd__decap_6
XFILLER_0_24_120 vssd1 vssd1 vccd1 vccd1 sky130_ef_sc_hd__decap_12
X_11639_ net997 net709 vssd1 vssd1 vccd1 vccd1 _05733_ sky130_fd_sc_hd__nand2_1
XFILLER_0_108_3 vssd1 vssd1 vccd1 vccd1 sky130_ef_sc_hd__decap_12
XFILLER_0_21_87 vssd1 vssd1 vccd1 vccd1 sky130_ef_sc_hd__decap_12
XFILLER_0_24_153 vssd1 vssd1 vccd1 vccd1 sky130_fd_sc_hd__fill_1
XFILLER_0_12_304 vssd1 vssd1 vccd1 vccd1 sky130_fd_sc_hd__decap_4
XFILLER_0_24_186 vssd1 vssd1 vccd1 vccd1 sky130_fd_sc_hd__decap_8
XFILLER_0_24_197 vssd1 vssd1 vccd1 vccd1 sky130_fd_sc_hd__decap_6
XFILLER_0_110_501 vssd1 vssd1 vccd1 vccd1 sky130_ef_sc_hd__decap_12
XFILLER_0_97_69 vssd1 vssd1 vccd1 vccd1 sky130_ef_sc_hd__decap_12
Xmax_cap458 _04891_ vssd1 vssd1 vccd1 vccd1 net458 sky130_fd_sc_hd__clkbuf_2
XFILLER_0_0_721 vssd1 vssd1 vccd1 vccd1 sky130_fd_sc_hd__fill_2
XFILLER_0_110_545 vssd1 vssd1 vccd1 vccd1 sky130_ef_sc_hd__decap_12
XFILLER_0_110_589 vssd1 vssd1 vccd1 vccd1 sky130_ef_sc_hd__decap_12
X_08850_ _02822_ _02955_ _02953_ vssd1 vssd1 vccd1 vccd1 _02963_ sky130_fd_sc_hd__a21oi_4
XFILLER_0_0_798 vssd1 vssd1 vccd1 vccd1 sky130_fd_sc_hd__fill_2
X_07801_ _01913_ _01920_ _01921_ vssd1 vssd1 vccd1 vccd1 _01923_ sky130_fd_sc_hd__nand3_2
X_08781_ _02893_ _02894_ vssd1 vssd1 vccd1 vccd1 _02895_ sky130_fd_sc_hd__nand2_1
X_07732_ net1609 _01854_ net522 vssd1 vssd1 vccd1 vccd1 _00125_ sky130_fd_sc_hd__mux2_1
XFILLER_0_79_348 vssd1 vssd1 vccd1 vccd1 sky130_fd_sc_hd__decap_4
X_07663_ net1097 mul1.b\[12\] net813 net1105 vssd1 vssd1 vccd1 vccd1 _01786_ sky130_fd_sc_hd__a22o_1
X_09402_ net850 net974 net968 net859 vssd1 vssd1 vccd1 vccd1 _03512_ sky130_fd_sc_hd__a22o_1
X_06614_ _00836_ _00839_ _00844_ _00850_ vssd1 vssd1 vccd1 vccd1 _00851_ sky130_fd_sc_hd__a31o_2
X_09333_ _03274_ _03277_ _03441_ vssd1 vssd1 vccd1 vccd1 _03443_ sky130_fd_sc_hd__and3_1
XFILLER_0_94_329 vssd1 vssd1 vccd1 vccd1 sky130_fd_sc_hd__fill_1
X_07594_ _01715_ _01717_ _01714_ vssd1 vssd1 vccd1 vccd1 _01718_ sky130_fd_sc_hd__a21oi_1
XFILLER_0_118_601 vssd1 vssd1 vccd1 vccd1 sky130_ef_sc_hd__decap_12
X_06545_ _00629_ _00670_ vssd1 vssd1 vccd1 vccd1 _00796_ sky130_fd_sc_hd__xor2_4
XFILLER_0_118_645 vssd1 vssd1 vccd1 vccd1 sky130_ef_sc_hd__decap_12
XFILLER_0_117_111 vssd1 vssd1 vccd1 vccd1 sky130_fd_sc_hd__fill_1
XFILLER_0_75_598 vssd1 vssd1 vccd1 vccd1 sky130_fd_sc_hd__decap_3
XFILLER_0_63_716 vssd1 vssd1 vccd1 vccd1 sky130_fd_sc_hd__decap_8
X_09264_ _03372_ _03374_ _03371_ vssd1 vssd1 vccd1 vccd1 _03375_ sky130_fd_sc_hd__a21oi_1
X_06476_ add1.a_i\[29\] add1.b_i\[29\] vssd1 vssd1 vccd1 vccd1 _00772_ sky130_fd_sc_hd__nand2_1
X_09195_ net1080 net1087 net754 net746 vssd1 vssd1 vccd1 vccd1 _03306_ sky130_fd_sc_hd__and4_1
X_08215_ net1059 net1067 net814 vssd1 vssd1 vccd1 vccd1 _02333_ sky130_fd_sc_hd__and3_1
X_08146_ _02226_ _02227_ _02261_ _02262_ vssd1 vssd1 vccd1 vccd1 _02265_ sky130_fd_sc_hd__or4_2
XFILLER_0_43_440 vssd1 vssd1 vccd1 vccd1 sky130_fd_sc_hd__decap_8
XFILLER_0_120_309 vssd1 vssd1 vccd1 vccd1 sky130_ef_sc_hd__decap_12
XFILLER_0_113_361 vssd1 vssd1 vccd1 vccd1 sky130_ef_sc_hd__decap_12
X_08077_ _02194_ _02195_ vssd1 vssd1 vccd1 vccd1 _02196_ sky130_fd_sc_hd__xnor2_1
X_07028_ _01151_ _01152_ net880 net1073 vssd1 vssd1 vccd1 vccd1 _01153_ sky130_fd_sc_hd__and4bb_1
XFILLER_0_3_592 vssd1 vssd1 vccd1 vccd1 sky130_fd_sc_hd__fill_2
Xhold11 det_t\[30\] vssd1 vssd1 vccd1 vccd1 net1226 sky130_fd_sc_hd__dlygate4sd3_1
Xhold22 _00074_ vssd1 vssd1 vccd1 vccd1 net1237 sky130_fd_sc_hd__dlygate4sd3_1
Xhold44 det_t\[7\] vssd1 vssd1 vccd1 vccd1 net1259 sky130_fd_sc_hd__dlygate4sd3_1
Xhold33 det_t\[4\] vssd1 vssd1 vccd1 vccd1 net1248 sky130_fd_sc_hd__dlygate4sd3_1
X_08979_ _03027_ _03028_ _03088_ _03089_ vssd1 vssd1 vccd1 vccd1 _03092_ sky130_fd_sc_hd__o22ai_2
Xhold55 _00081_ vssd1 vssd1 vccd1 vccd1 net1270 sky130_fd_sc_hd__dlygate4sd3_1
Xhold66 add1.b_i\[20\] vssd1 vssd1 vccd1 vccd1 net1281 sky130_fd_sc_hd__dlygate4sd3_1
Xhold99 add1.b_i\[18\] vssd1 vssd1 vccd1 vccd1 net1314 sky130_fd_sc_hd__dlygate4sd3_1
Xhold77 sub1.a_i\[25\] vssd1 vssd1 vccd1 vccd1 net1292 sky130_fd_sc_hd__dlygate4sd3_1
Xhold88 sub1.b_i\[17\] vssd1 vssd1 vccd1 vccd1 net1303 sky130_fd_sc_hd__dlygate4sd3_1
X_11990_ net104 net622 net596 net72 vssd1 vssd1 vccd1 vccd1 _05997_ sky130_fd_sc_hd__a22o_1
X_10941_ _04906_ _05039_ vssd1 vssd1 vccd1 vccd1 _05041_ sky130_fd_sc_hd__xnor2_1
X_12611_ net1381 net23 net555 vssd1 vssd1 vccd1 vccd1 _00586_ sky130_fd_sc_hd__mux2_1
X_10872_ _04967_ _04971_ vssd1 vssd1 vccd1 vccd1 _04972_ sky130_fd_sc_hd__and2_1
XFILLER_0_38_223 vssd1 vssd1 vccd1 vccd1 sky130_fd_sc_hd__fill_2
XFILLER_0_39_768 vssd1 vssd1 vccd1 vccd1 sky130_fd_sc_hd__decap_3
X_12542_ _00774_ net565 vssd1 vssd1 vccd1 vccd1 _06268_ sky130_fd_sc_hd__nor2_1
XFILLER_0_108_133 vssd1 vssd1 vccd1 vccd1 sky130_fd_sc_hd__decap_6
XFILLER_0_38_278 vssd1 vssd1 vccd1 vccd1 sky130_fd_sc_hd__decap_4
X_12473_ temp1\[27\] _06232_ net572 vssd1 vssd1 vccd1 vccd1 _00488_ sky130_fd_sc_hd__mux2_1
XFILLER_0_124_637 vssd1 vssd1 vccd1 vccd1 sky130_fd_sc_hd__decap_6
XFILLER_0_123_125 vssd1 vssd1 vccd1 vccd1 sky130_ef_sc_hd__decap_12
XFILLER_0_108_177 vssd1 vssd1 vccd1 vccd1 sky130_ef_sc_hd__decap_12
XFILLER_0_81_579 vssd1 vssd1 vccd1 vccd1 sky130_fd_sc_hd__fill_1
X_11424_ _05394_ _05399_ _05518_ vssd1 vssd1 vccd1 vccd1 _05520_ sky130_fd_sc_hd__nor3_1
XANTENNA_8 _00799_ vssd1 vssd1 vccd1 vccd1 sky130_fd_sc_hd__diode_2
XFILLER_0_123_169 vssd1 vssd1 vccd1 vccd1 sky130_ef_sc_hd__decap_12
XFILLER_0_61_281 vssd1 vssd1 vccd1 vccd1 sky130_fd_sc_hd__fill_1
XFILLER_0_34_484 vssd1 vssd1 vccd1 vccd1 sky130_ef_sc_hd__decap_12
XFILLER_0_120_821 vssd1 vssd1 vccd1 vccd1 sky130_fd_sc_hd__decap_4
X_11355_ net1396 _05451_ net525 vssd1 vssd1 vccd1 vccd1 _00151_ sky130_fd_sc_hd__mux2_1
X_10306_ _04407_ _04408_ _04403_ vssd1 vssd1 vccd1 vccd1 _04410_ sky130_fd_sc_hd__a21o_1
X_11286_ _05222_ _05223_ _05262_ vssd1 vssd1 vccd1 vccd1 _05383_ sky130_fd_sc_hd__o21ai_1
X_10237_ net834 net958 _04339_ _04340_ vssd1 vssd1 vccd1 vccd1 _04342_ sky130_fd_sc_hd__nand4_2
XTAP_329 vssd1 vccd1 sky130_fd_sc_hd__tapvpwrvgnd_1
XTAP_318 vssd1 vccd1 sky130_fd_sc_hd__tapvpwrvgnd_1
XTAP_307 vssd1 vccd1 sky130_fd_sc_hd__tapvpwrvgnd_1
X_13025_ clknet_leaf_45_clk_i _00411_ net1163 vssd1 vssd1 vccd1 vccd1 x0mx2\[14\]
+ sky130_fd_sc_hd__dfrtp_1
Xfanout1031 mul1.a\[15\] vssd1 vssd1 vccd1 vccd1 net1031 sky130_fd_sc_hd__clkbuf_4
Xfanout1020 net1023 vssd1 vssd1 vccd1 vccd1 net1020 sky130_fd_sc_hd__clkbuf_2
X_10168_ net1029 net1038 net745 vssd1 vssd1 vccd1 vccd1 _04273_ sky130_fd_sc_hd__and3_1
Xfanout1053 net1054 vssd1 vssd1 vccd1 vccd1 net1053 sky130_fd_sc_hd__clkbuf_4
Xfanout1042 net1048 vssd1 vssd1 vccd1 vccd1 net1042 sky130_fd_sc_hd__dlymetal6s2s_1
Xfanout1064 mul1.a\[11\] vssd1 vssd1 vccd1 vccd1 net1064 sky130_fd_sc_hd__buf_4
XFILLER_0_89_624 vssd1 vssd1 vccd1 vccd1 sky130_fd_sc_hd__decap_8
X_10099_ _04154_ _04204_ vssd1 vssd1 vccd1 vccd1 _04205_ sky130_fd_sc_hd__xnor2_4
XFILLER_0_83_27 vssd1 vssd1 vccd1 vccd1 sky130_ef_sc_hd__decap_12
Xfanout1086 net1087 vssd1 vssd1 vccd1 vccd1 net1086 sky130_fd_sc_hd__clkbuf_4
Xfanout1075 net1076 vssd1 vssd1 vccd1 vccd1 net1075 sky130_fd_sc_hd__clkbuf_4
Xfanout1097 net1102 vssd1 vssd1 vccd1 vccd1 net1097 sky130_fd_sc_hd__clkbuf_4
Xclkbuf_leaf_40_clk_i clknet_3_3__leaf_clk_i vssd1 vssd1 vccd1 vccd1 clknet_leaf_40_clk_i
+ sky130_fd_sc_hd__clkbuf_16
XFILLER_0_16_65 vssd1 vssd1 vccd1 vccd1 sky130_ef_sc_hd__decap_12
XFILLER_0_9_607 vssd1 vssd1 vccd1 vccd1 sky130_fd_sc_hd__fill_2
XFILLER_0_29_212 vssd1 vssd1 vccd1 vccd1 sky130_fd_sc_hd__decap_4
XFILLER_0_85_841 vssd1 vssd1 vccd1 vccd1 sky130_fd_sc_hd__fill_1
XFILLER_0_57_532 vssd1 vssd1 vccd1 vccd1 sky130_fd_sc_hd__decap_4
X_12809_ clknet_leaf_54_clk_i _00195_ vssd1 vssd1 vccd1 vccd1 sub1.a_i\[8\] sky130_fd_sc_hd__dfxtp_1
Xclkbuf_leaf_55_clk_i clknet_3_0__leaf_clk_i vssd1 vssd1 vccd1 vccd1 clknet_leaf_55_clk_i
+ sky130_fd_sc_hd__clkbuf_16
XFILLER_0_123_55 vssd1 vssd1 vccd1 vccd1 sky130_fd_sc_hd__fill_1
XFILLER_0_84_362 vssd1 vssd1 vccd1 vccd1 sky130_fd_sc_hd__fill_2
XTAP_1090 vssd1 vccd1 sky130_fd_sc_hd__tapvpwrvgnd_1
X_06330_ add1.a_i\[3\] add1.b_i\[3\] vssd1 vssd1 vccd1 vccd1 _00642_ sky130_fd_sc_hd__nand2_1
XFILLER_0_32_64 vssd1 vssd1 vccd1 vccd1 sky130_fd_sc_hd__fill_1
XFILLER_0_115_615 vssd1 vssd1 vccd1 vccd1 sky130_fd_sc_hd__fill_1
XFILLER_0_72_557 vssd1 vssd1 vccd1 vccd1 sky130_fd_sc_hd__fill_2
XFILLER_0_72_546 vssd1 vssd1 vccd1 vccd1 sky130_fd_sc_hd__fill_1
XFILLER_0_127_497 vssd1 vssd1 vccd1 vccd1 sky130_fd_sc_hd__fill_2
X_08000_ net874 _02119_ _02118_ vssd1 vssd1 vccd1 vccd1 _02120_ sky130_fd_sc_hd__a21bo_1
XFILLER_0_102_309 vssd1 vssd1 vccd1 vccd1 sky130_fd_sc_hd__decap_8
Xhold514 net438 vssd1 vssd1 vccd1 vccd1 net1729 sky130_fd_sc_hd__dlygate4sd3_1
Xhold525 temp1\[7\] vssd1 vssd1 vccd1 vccd1 net1740 sky130_fd_sc_hd__dlygate4sd3_1
Xhold503 temp1\[9\] vssd1 vssd1 vccd1 vccd1 net1718 sky130_fd_sc_hd__dlygate4sd3_1
XFILLER_0_40_432 vssd1 vssd1 vccd1 vccd1 sky130_fd_sc_hd__fill_1
X_09951_ _04055_ _04056_ vssd1 vssd1 vccd1 vccd1 _04058_ sky130_fd_sc_hd__xor2_4
XFILLER_0_110_353 vssd1 vssd1 vccd1 vccd1 sky130_fd_sc_hd__fill_1
X_08902_ net1061 net784 vssd1 vssd1 vccd1 vccd1 _03015_ sky130_fd_sc_hd__and2_1
XFILLER_0_110_397 vssd1 vssd1 vccd1 vccd1 sky130_fd_sc_hd__decap_3
X_09882_ _03986_ _03987_ vssd1 vssd1 vccd1 vccd1 _03989_ sky130_fd_sc_hd__or2_2
XTAP_830 vssd1 vccd1 sky130_fd_sc_hd__tapvpwrvgnd_1
XTAP_841 vssd1 vccd1 sky130_fd_sc_hd__tapvpwrvgnd_1
XTAP_852 vssd1 vccd1 sky130_fd_sc_hd__tapvpwrvgnd_1
X_08833_ _02884_ _02885_ _02944_ _02945_ vssd1 vssd1 vccd1 vccd1 _02947_ sky130_fd_sc_hd__or4_1
XTAP_863 vssd1 vccd1 sky130_fd_sc_hd__tapvpwrvgnd_1
XTAP_885 vssd1 vccd1 sky130_fd_sc_hd__tapvpwrvgnd_1
XTAP_874 vssd1 vccd1 sky130_fd_sc_hd__tapvpwrvgnd_1
X_08764_ _02876_ _02877_ vssd1 vssd1 vccd1 vccd1 _02878_ sky130_fd_sc_hd__nor2_1
XFILLER_0_32_3 vssd1 vssd1 vccd1 vccd1 sky130_ef_sc_hd__decap_12
XTAP_896 vssd1 vccd1 sky130_fd_sc_hd__tapvpwrvgnd_1
X_07715_ _01803_ _01804_ _01836_ _01837_ vssd1 vssd1 vccd1 vccd1 _01838_ sky130_fd_sc_hd__o22a_1
X_08695_ _02807_ _02809_ vssd1 vssd1 vccd1 vccd1 _02810_ sky130_fd_sc_hd__and2_1
X_07646_ net1121 net1129 net788 vssd1 vssd1 vccd1 vccd1 _01769_ sky130_fd_sc_hd__and3_1
XFILLER_0_76_841 vssd1 vssd1 vccd1 vccd1 sky130_fd_sc_hd__fill_1
XFILLER_0_48_543 vssd1 vssd1 vccd1 vccd1 sky130_fd_sc_hd__decap_3
X_07577_ _01699_ _01700_ _01350_ _01353_ vssd1 vssd1 vccd1 vccd1 _01701_ sky130_fd_sc_hd__o211a_1
X_06528_ net544 _00786_ vssd1 vssd1 vccd1 vccd1 net298 sky130_fd_sc_hd__nor2_1
X_09316_ net1108 net1116 net720 net716 vssd1 vssd1 vccd1 vccd1 _03426_ sky130_fd_sc_hd__and4_1
XFILLER_0_75_362 vssd1 vssd1 vccd1 vccd1 sky130_ef_sc_hd__decap_12
XFILLER_0_118_475 vssd1 vssd1 vccd1 vccd1 sky130_fd_sc_hd__fill_1
XFILLER_0_90_321 vssd1 vssd1 vccd1 vccd1 sky130_fd_sc_hd__decap_8
X_09247_ _03355_ _03356_ _03342_ vssd1 vssd1 vccd1 vccd1 _03358_ sky130_fd_sc_hd__a21oi_1
XFILLER_0_63_557 vssd1 vssd1 vccd1 vccd1 sky130_fd_sc_hd__decap_3
XFILLER_0_105_125 vssd1 vssd1 vccd1 vccd1 sky130_ef_sc_hd__decap_12
XFILLER_0_90_343 vssd1 vssd1 vccd1 vccd1 sky130_fd_sc_hd__fill_2
X_06459_ _00755_ _00756_ vssd1 vssd1 vccd1 vccd1 _00757_ sky130_fd_sc_hd__nand2_2
XFILLER_0_51_708 vssd1 vssd1 vccd1 vccd1 sky130_fd_sc_hd__fill_1
X_09178_ _03283_ _03288_ vssd1 vssd1 vccd1 vccd1 _03289_ sky130_fd_sc_hd__nand2_1
XFILLER_0_121_629 vssd1 vssd1 vccd1 vccd1 sky130_ef_sc_hd__decap_12
XFILLER_0_114_681 vssd1 vssd1 vccd1 vccd1 sky130_ef_sc_hd__decap_12
XFILLER_0_105_169 vssd1 vssd1 vccd1 vccd1 sky130_ef_sc_hd__decap_12
X_08129_ _02246_ _02247_ _02245_ vssd1 vssd1 vccd1 vccd1 _02248_ sky130_fd_sc_hd__a21o_1
XFILLER_0_120_139 vssd1 vssd1 vccd1 vccd1 sky130_fd_sc_hd__fill_1
X_11140_ _05235_ _05236_ vssd1 vssd1 vccd1 vccd1 _05238_ sky130_fd_sc_hd__xor2_1
XFILLER_0_101_364 vssd1 vssd1 vccd1 vccd1 sky130_fd_sc_hd__fill_2
X_11071_ _05162_ _05169_ vssd1 vssd1 vccd1 vccd1 _05170_ sky130_fd_sc_hd__nand2_1
Xinput101 v0y[1] vssd1 vssd1 vccd1 vccd1 net101 sky130_fd_sc_hd__buf_1
X_10022_ _03961_ _03963_ _04126_ _04127_ vssd1 vssd1 vccd1 vccd1 _04128_ sky130_fd_sc_hd__o211a_1
Xinput123 v1x[10] vssd1 vssd1 vccd1 vccd1 net123 sky130_fd_sc_hd__buf_1
Xinput145 v1x[30] vssd1 vssd1 vccd1 vccd1 net145 sky130_fd_sc_hd__buf_1
Xinput112 v0y[2] vssd1 vssd1 vccd1 vccd1 net112 sky130_fd_sc_hd__buf_1
Xinput134 v1x[20] vssd1 vssd1 vccd1 vccd1 net134 sky130_fd_sc_hd__buf_1
Xinput178 v1y[31] vssd1 vssd1 vccd1 vccd1 net178 sky130_fd_sc_hd__clkbuf_1
Xinput156 v1y[11] vssd1 vssd1 vccd1 vccd1 net156 sky130_fd_sc_hd__clkbuf_1
Xinput167 v1y[21] vssd1 vssd1 vccd1 vccd1 net167 sky130_fd_sc_hd__clkbuf_1
Xinput189 v2x[12] vssd1 vssd1 vccd1 vccd1 net189 sky130_fd_sc_hd__buf_1
X_11973_ net1303 _05984_ net481 vssd1 vssd1 vccd1 vccd1 _00236_ sky130_fd_sc_hd__mux2_1
X_10924_ net1040 net1048 net712 net709 vssd1 vssd1 vccd1 vccd1 _05024_ sky130_fd_sc_hd__and4_1
XFILLER_0_85_159 vssd1 vssd1 vccd1 vccd1 sky130_fd_sc_hd__decap_8
XFILLER_0_67_841 vssd1 vssd1 vccd1 vccd1 sky130_fd_sc_hd__fill_1
X_10855_ _04954_ vssd1 vssd1 vccd1 vccd1 _04955_ sky130_fd_sc_hd__inv_2
XPHY_151 vssd1 vssd1 vccd1 vccd1 sky130_fd_sc_hd__decap_3
XPHY_140 vssd1 vssd1 vccd1 vccd1 sky130_fd_sc_hd__decap_3
XFILLER_0_54_513 vssd1 vssd1 vccd1 vccd1 sky130_fd_sc_hd__fill_1
X_12525_ _00720_ net564 _06259_ vssd1 vssd1 vccd1 vccd1 _00513_ sky130_fd_sc_hd__o21ai_1
XPHY_184 vssd1 vssd1 vccd1 vccd1 sky130_fd_sc_hd__decap_3
XPHY_173 vssd1 vssd1 vccd1 vccd1 sky130_fd_sc_hd__decap_3
XPHY_162 vssd1 vssd1 vccd1 vccd1 sky130_fd_sc_hd__decap_3
XFILLER_0_66_395 vssd1 vssd1 vccd1 vccd1 sky130_fd_sc_hd__fill_2
X_10786_ _04700_ _04703_ _04884_ _04885_ vssd1 vssd1 vccd1 vccd1 _04887_ sky130_fd_sc_hd__a211oi_4
XFILLER_0_124_401 vssd1 vssd1 vccd1 vccd1 sky130_ef_sc_hd__decap_12
XPHY_195 vssd1 vssd1 vccd1 vccd1 sky130_fd_sc_hd__decap_3
XFILLER_0_81_343 vssd1 vssd1 vccd1 vccd1 sky130_fd_sc_hd__fill_1
XFILLER_0_124_445 vssd1 vssd1 vccd1 vccd1 sky130_ef_sc_hd__decap_12
X_12456_ _04381_ net576 _06222_ vssd1 vssd1 vccd1 vccd1 _06223_ sky130_fd_sc_hd__a21o_1
XFILLER_0_124_489 vssd1 vssd1 vccd1 vccd1 sky130_ef_sc_hd__decap_12
XFILLER_0_78_27 vssd1 vssd1 vccd1 vccd1 sky130_fd_sc_hd__fill_1
XFILLER_0_2_827 vssd1 vssd1 vccd1 vccd1 sky130_fd_sc_hd__fill_1
XFILLER_0_22_421 vssd1 vssd1 vccd1 vccd1 sky130_fd_sc_hd__decap_3
X_12387_ net1534 _00862_ net682 vssd1 vssd1 vccd1 vccd1 _00439_ sky130_fd_sc_hd__mux2_1
X_11407_ _05499_ _05500_ _05463_ vssd1 vssd1 vccd1 vccd1 _05503_ sky130_fd_sc_hd__o21ai_1
X_11338_ _05432_ _05433_ _05265_ _05307_ vssd1 vssd1 vccd1 vccd1 _05435_ sky130_fd_sc_hd__o211ai_4
XFILLER_0_94_15 vssd1 vssd1 vccd1 vccd1 sky130_ef_sc_hd__decap_12
X_11269_ net785 net946 vssd1 vssd1 vccd1 vccd1 _05366_ sky130_fd_sc_hd__nand2_1
X_13008_ clknet_leaf_25_clk_i _00394_ net1172 vssd1 vssd1 vccd1 vccd1 x2mx1\[29\]
+ sky130_fd_sc_hd__dfrtp_1
XFILLER_0_118_77 vssd1 vssd1 vccd1 vccd1 sky130_fd_sc_hd__decap_6
XFILLER_0_77_605 vssd1 vssd1 vccd1 vccd1 sky130_fd_sc_hd__decap_8
X_07500_ net904 net1138 _01622_ _01623_ vssd1 vssd1 vccd1 vccd1 _01625_ sky130_fd_sc_hd__nand4_1
X_08480_ _02477_ _02480_ vssd1 vssd1 vccd1 vccd1 _02596_ sky130_fd_sc_hd__nand2_1
XFILLER_0_119_217 vssd1 vssd1 vccd1 vccd1 sky130_fd_sc_hd__decap_6
XFILLER_0_43_74 vssd1 vssd1 vccd1 vccd1 sky130_fd_sc_hd__fill_1
X_07431_ _01516_ _01518_ _01517_ vssd1 vssd1 vccd1 vccd1 _01556_ sky130_fd_sc_hd__a21o_1
XFILLER_0_85_671 vssd1 vssd1 vccd1 vccd1 sky130_fd_sc_hd__fill_1
XFILLER_0_45_502 vssd1 vssd1 vccd1 vccd1 sky130_fd_sc_hd__fill_2
XFILLER_0_9_459 vssd1 vssd1 vccd1 vccd1 sky130_fd_sc_hd__decap_3
X_07362_ net871 net862 net1126 net1136 vssd1 vssd1 vccd1 vccd1 _01487_ sky130_fd_sc_hd__and4_1
XFILLER_0_17_204 vssd1 vssd1 vccd1 vccd1 sky130_fd_sc_hd__decap_4
XFILLER_0_128_773 vssd1 vssd1 vccd1 vccd1 sky130_ef_sc_hd__decap_12
XFILLER_0_128_751 vssd1 vssd1 vccd1 vccd1 sky130_fd_sc_hd__decap_4
XFILLER_0_72_332 vssd1 vssd1 vccd1 vccd1 sky130_fd_sc_hd__fill_1
X_09101_ net861 net981 _03211_ _03212_ vssd1 vssd1 vccd1 vccd1 _03213_ sky130_fd_sc_hd__nand4_1
XFILLER_0_57_384 vssd1 vssd1 vccd1 vccd1 sky130_fd_sc_hd__decap_8
X_06313_ add1.a_i\[11\] add1.b_i\[11\] vssd1 vssd1 vccd1 vccd1 _00625_ sky130_fd_sc_hd__or2_1
XFILLER_0_45_568 vssd1 vssd1 vccd1 vccd1 sky130_fd_sc_hd__decap_8
X_07293_ net895 net887 net1095 net1104 vssd1 vssd1 vccd1 vccd1 _01418_ sky130_fd_sc_hd__and4_1
X_09032_ _03139_ _03140_ _02980_ _02984_ vssd1 vssd1 vccd1 vccd1 _03144_ sky130_fd_sc_hd__o211a_1
XFILLER_0_72_387 vssd1 vssd1 vccd1 vccd1 sky130_fd_sc_hd__decap_8
XFILLER_0_60_538 vssd1 vssd1 vccd1 vccd1 sky130_fd_sc_hd__decap_6
XFILLER_0_5_654 vssd1 vssd1 vccd1 vccd1 sky130_fd_sc_hd__fill_1
XFILLER_0_13_410 vssd1 vssd1 vccd1 vccd1 sky130_fd_sc_hd__fill_1
XFILLER_0_103_629 vssd1 vssd1 vccd1 vccd1 sky130_ef_sc_hd__decap_12
XFILLER_0_102_117 vssd1 vssd1 vccd1 vccd1 sky130_fd_sc_hd__fill_1
Xhold311 net405 vssd1 vssd1 vccd1 vccd1 net1526 sky130_fd_sc_hd__dlygate4sd3_1
Xhold300 x0mx2\[6\] vssd1 vssd1 vccd1 vccd1 net1515 sky130_fd_sc_hd__dlygate4sd3_1
XFILLER_0_102_139 vssd1 vssd1 vccd1 vccd1 sky130_fd_sc_hd__fill_1
Xhold333 l0\[11\] vssd1 vssd1 vccd1 vccd1 net1548 sky130_fd_sc_hd__dlygate4sd3_1
Xhold344 l0\[6\] vssd1 vssd1 vccd1 vccd1 net1559 sky130_fd_sc_hd__dlygate4sd3_1
Xhold322 x0mx2\[22\] vssd1 vssd1 vccd1 vccd1 net1537 sky130_fd_sc_hd__dlygate4sd3_1
XFILLER_0_40_251 vssd1 vssd1 vccd1 vccd1 sky130_fd_sc_hd__fill_1
XFILLER_0_111_673 vssd1 vssd1 vccd1 vccd1 sky130_ef_sc_hd__decap_12
Xhold377 _00043_ vssd1 vssd1 vccd1 vccd1 net1592 sky130_fd_sc_hd__dlygate4sd3_1
Xhold355 x0mx2\[9\] vssd1 vssd1 vccd1 vccd1 net1570 sky130_fd_sc_hd__dlygate4sd3_1
Xhold366 add1.a_i\[27\] vssd1 vssd1 vccd1 vccd1 net1581 sky130_fd_sc_hd__dlygate4sd3_1
Xfanout802 net804 vssd1 vssd1 vccd1 vccd1 net802 sky130_fd_sc_hd__buf_2
X_09934_ _04039_ _04040_ vssd1 vssd1 vccd1 vccd1 _04041_ sky130_fd_sc_hd__and2b_1
Xhold388 sub1.a_i\[6\] vssd1 vssd1 vccd1 vccd1 net1603 sky130_fd_sc_hd__dlygate4sd3_1
Xhold399 x2mx1\[31\] vssd1 vssd1 vccd1 vccd1 net1614 sky130_fd_sc_hd__dlygate4sd3_1
Xfanout813 mul1.b\[13\] vssd1 vssd1 vccd1 vccd1 net813 sky130_fd_sc_hd__buf_2
Xfanout824 net828 vssd1 vssd1 vccd1 vccd1 net824 sky130_fd_sc_hd__clkbuf_4
X_09865_ net792 net1006 net998 net803 vssd1 vssd1 vccd1 vccd1 _03972_ sky130_fd_sc_hd__a22o_1
Xfanout835 net836 vssd1 vssd1 vccd1 vccd1 net835 sky130_fd_sc_hd__buf_2
Xfanout857 net858 vssd1 vssd1 vccd1 vccd1 net857 sky130_fd_sc_hd__clkbuf_4
XTAP_660 vssd1 vccd1 sky130_fd_sc_hd__tapvpwrvgnd_1
Xfanout846 net847 vssd1 vssd1 vccd1 vccd1 net846 sky130_fd_sc_hd__buf_2
Xfanout868 net870 vssd1 vssd1 vccd1 vccd1 net868 sky130_fd_sc_hd__buf_2
Xfanout879 mul1.b\[6\] vssd1 vssd1 vccd1 vccd1 net879 sky130_fd_sc_hd__buf_2
X_08816_ _02926_ _02927_ _02928_ vssd1 vssd1 vccd1 vccd1 _02930_ sky130_fd_sc_hd__a21o_1
XTAP_682 vssd1 vccd1 sky130_fd_sc_hd__tapvpwrvgnd_1
XTAP_671 vssd1 vccd1 sky130_fd_sc_hd__tapvpwrvgnd_1
XTAP_693 vssd1 vccd1 sky130_fd_sc_hd__tapvpwrvgnd_1
X_09796_ _03588_ _03748_ _03747_ vssd1 vssd1 vccd1 vccd1 _03904_ sky130_fd_sc_hd__o21ai_1
XFILLER_0_84_70 vssd1 vssd1 vccd1 vccd1 sky130_ef_sc_hd__decap_12
X_08747_ _02857_ _02860_ vssd1 vssd1 vccd1 vccd1 _02861_ sky130_fd_sc_hd__xor2_1
XTAP_1815 vssd1 vccd1 sky130_fd_sc_hd__tapvpwrvgnd_1
XTAP_1804 vssd1 vccd1 sky130_fd_sc_hd__tapvpwrvgnd_1
X_08678_ _02754_ _02755_ _02789_ _02790_ vssd1 vssd1 vccd1 vccd1 _02793_ sky130_fd_sc_hd__or4_1
XFILLER_0_68_627 vssd1 vssd1 vccd1 vccd1 sky130_fd_sc_hd__decap_3
XTAP_1848 vssd1 vccd1 sky130_fd_sc_hd__tapvpwrvgnd_1
XTAP_1837 vssd1 vccd1 sky130_fd_sc_hd__tapvpwrvgnd_1
XTAP_1826 vssd1 vccd1 sky130_fd_sc_hd__tapvpwrvgnd_1
XFILLER_0_49_841 vssd1 vssd1 vccd1 vccd1 sky130_fd_sc_hd__fill_1
X_07629_ _01750_ _01751_ _01398_ _01401_ vssd1 vssd1 vccd1 vccd1 _01753_ sky130_fd_sc_hd__a211o_1
XTAP_1859 vssd1 vccd1 sky130_fd_sc_hd__tapvpwrvgnd_1
X_10640_ _04709_ _04739_ _04740_ vssd1 vssd1 vccd1 vccd1 _04742_ sky130_fd_sc_hd__or3_4
XFILLER_0_63_365 vssd1 vssd1 vccd1 vccd1 sky130_fd_sc_hd__fill_1
X_10571_ net859 _04531_ _04532_ vssd1 vssd1 vccd1 vccd1 _04673_ sky130_fd_sc_hd__nand3_2
XFILLER_0_51_505 vssd1 vssd1 vccd1 vccd1 sky130_fd_sc_hd__decap_4
XFILLER_0_16_270 vssd1 vssd1 vccd1 vccd1 sky130_fd_sc_hd__fill_2
X_12310_ net1682 _00965_ net680 vssd1 vssd1 vccd1 vccd1 _00362_ sky130_fd_sc_hd__mux2_1
X_12241_ _00940_ net511 net468 y1my2\[25\] _06180_ vssd1 vssd1 vccd1 vccd1 _06181_
+ sky130_fd_sc_hd__a221o_1
XFILLER_0_102_651 vssd1 vssd1 vccd1 vccd1 sky130_fd_sc_hd__fill_1
X_12172_ _00818_ net510 net467 net1674 _06134_ vssd1 vssd1 vccd1 vccd1 _06135_ sky130_fd_sc_hd__a221o_1
X_11123_ _04958_ _05219_ vssd1 vssd1 vccd1 vccd1 _05221_ sky130_fd_sc_hd__nand2_1
X_11054_ _05152_ vssd1 vssd1 vccd1 vccd1 _05153_ sky130_fd_sc_hd__inv_2
X_10005_ _04089_ _04110_ vssd1 vssd1 vccd1 vccd1 _04111_ sky130_fd_sc_hd__and2b_1
XFILLER_0_64_29 vssd1 vssd1 vccd1 vccd1 sky130_fd_sc_hd__decap_8
XFILLER_0_99_774 vssd1 vssd1 vccd1 vccd1 sky130_fd_sc_hd__fill_1
X_11956_ net126 net656 net503 net222 _05971_ vssd1 vssd1 vccd1 vccd1 _05972_ sky130_fd_sc_hd__a221o_1
XFILLER_0_129_526 vssd1 vssd1 vccd1 vccd1 sky130_ef_sc_hd__decap_12
X_10907_ _05001_ _05006_ vssd1 vssd1 vccd1 vccd1 _05007_ sky130_fd_sc_hd__or2_1
X_11887_ net175 net472 _05918_ vssd1 vssd1 vccd1 vccd1 _05919_ sky130_fd_sc_hd__o21a_1
XFILLER_0_116_209 vssd1 vssd1 vccd1 vccd1 sky130_ef_sc_hd__decap_12
X_10838_ _04893_ _04894_ _04936_ _04937_ vssd1 vssd1 vccd1 vccd1 _04939_ sky130_fd_sc_hd__a22o_1
XFILLER_0_13_55 vssd1 vssd1 vccd1 vccd1 sky130_fd_sc_hd__fill_1
XFILLER_0_125_721 vssd1 vssd1 vccd1 vccd1 sky130_fd_sc_hd__decap_6
XFILLER_0_109_261 vssd1 vssd1 vccd1 vccd1 sky130_fd_sc_hd__decap_8
XFILLER_0_89_15 vssd1 vssd1 vccd1 vccd1 sky130_ef_sc_hd__decap_12
XFILLER_0_81_140 vssd1 vssd1 vccd1 vccd1 sky130_ef_sc_hd__decap_12
X_10769_ _04860_ _04868_ vssd1 vssd1 vccd1 vccd1 _04870_ sky130_fd_sc_hd__nand2_1
XFILLER_0_125_765 vssd1 vssd1 vccd1 vccd1 sky130_ef_sc_hd__decap_12
X_12508_ net1243 net562 vssd1 vssd1 vccd1 vccd1 _06251_ sky130_fd_sc_hd__nand2_1
XFILLER_0_54_387 vssd1 vssd1 vccd1 vccd1 sky130_fd_sc_hd__fill_2
XFILLER_0_54_365 vssd1 vssd1 vccd1 vccd1 sky130_fd_sc_hd__decap_4
XFILLER_0_42_538 vssd1 vssd1 vccd1 vccd1 sky130_fd_sc_hd__decap_4
X_12439_ _00882_ net613 _03420_ net575 vssd1 vssd1 vccd1 vccd1 _06212_ sky130_fd_sc_hd__a22o_1
Xoutput405 net405 vssd1 vssd1 vccd1 vccd1 mstream_o[5] sky130_fd_sc_hd__clkbuf_4
Xoutput416 net416 vssd1 vssd1 vccd1 vccd1 mstream_o[6] sky130_fd_sc_hd__buf_2
XFILLER_0_66_9 vssd1 vssd1 vccd1 vccd1 sky130_fd_sc_hd__decap_8
Xoutput427 net427 vssd1 vssd1 vccd1 vccd1 mstream_o[7] sky130_fd_sc_hd__clkbuf_4
Xoutput438 net438 vssd1 vssd1 vccd1 vccd1 mstream_o[8] sky130_fd_sc_hd__buf_2
Xoutput449 net449 vssd1 vssd1 vccd1 vccd1 mstream_o[9] sky130_fd_sc_hd__buf_2
XFILLER_0_22_273 vssd1 vssd1 vccd1 vccd1 sky130_fd_sc_hd__fill_1
X_07980_ net1051 net848 net839 net1059 vssd1 vssd1 vccd1 vccd1 _02100_ sky130_fd_sc_hd__a22oi_1
XFILLER_0_129_76 vssd1 vssd1 vccd1 vccd1 sky130_fd_sc_hd__decap_3
X_06931_ net846 net837 net1127 net1135 vssd1 vssd1 vccd1 vccd1 _01056_ sky130_fd_sc_hd__and4_1
X_09650_ net1116 net705 vssd1 vssd1 vccd1 vccd1 _03758_ sky130_fd_sc_hd__nand2_1
X_08601_ net1060 net812 _02599_ _02600_ net823 vssd1 vssd1 vccd1 vccd1 _02716_ sky130_fd_sc_hd__a32o_1
X_06862_ _00976_ state\[2\] state\[3\] vssd1 vssd1 vccd1 vccd1 _00992_ sky130_fd_sc_hd__nor3b_1
X_09581_ _03687_ _03688_ _03673_ vssd1 vssd1 vccd1 vccd1 _03690_ sky130_fd_sc_hd__a21o_1
X_06793_ net1399 l0\[0\] net641 vssd1 vssd1 vccd1 vccd1 _00067_ sky130_fd_sc_hd__mux2_1
X_08532_ _02627_ _02644_ _02645_ vssd1 vssd1 vccd1 vccd1 _02648_ sky130_fd_sc_hd__nand3_2
X_08463_ net1085 net781 vssd1 vssd1 vccd1 vccd1 _02579_ sky130_fd_sc_hd__nand2_1
XFILLER_0_49_126 vssd1 vssd1 vccd1 vccd1 sky130_fd_sc_hd__fill_1
X_07414_ _01530_ _01537_ _01538_ vssd1 vssd1 vccd1 vccd1 _01539_ sky130_fd_sc_hd__nor3_1
X_08394_ _02501_ _02508_ _02509_ vssd1 vssd1 vccd1 vccd1 _02511_ sky130_fd_sc_hd__nand3_2
XFILLER_0_128_581 vssd1 vssd1 vccd1 vccd1 sky130_fd_sc_hd__decap_6
XFILLER_0_70_83 vssd1 vssd1 vccd1 vccd1 sky130_fd_sc_hd__fill_1
X_07345_ net917 net1090 net1097 net909 vssd1 vssd1 vccd1 vccd1 _01470_ sky130_fd_sc_hd__a22o_1
XFILLER_0_73_696 vssd1 vssd1 vccd1 vccd1 sky130_fd_sc_hd__decap_3
X_07276_ _01263_ _01399_ _01400_ vssd1 vssd1 vccd1 vccd1 _01401_ sky130_fd_sc_hd__and3_2
X_09015_ net1108 net728 net723 net1116 vssd1 vssd1 vccd1 vccd1 _03127_ sky130_fd_sc_hd__a22oi_1
Xhold141 det_t\[18\] vssd1 vssd1 vccd1 vccd1 net1356 sky130_fd_sc_hd__dlygate4sd3_1
XFILLER_0_103_459 vssd1 vssd1 vccd1 vccd1 sky130_fd_sc_hd__decap_4
Xhold130 _00062_ vssd1 vssd1 vccd1 vccd1 net1345 sky130_fd_sc_hd__dlygate4sd3_1
Xhold152 l1\[1\] vssd1 vssd1 vccd1 vccd1 net1367 sky130_fd_sc_hd__dlygate4sd3_1
XFILLER_0_41_582 vssd1 vssd1 vccd1 vccd1 sky130_fd_sc_hd__decap_8
Xhold163 net414 vssd1 vssd1 vccd1 vccd1 net1378 sky130_fd_sc_hd__dlygate4sd3_1
Xhold185 _00067_ vssd1 vssd1 vccd1 vccd1 net1400 sky130_fd_sc_hd__dlygate4sd3_1
Xhold174 net375 vssd1 vssd1 vccd1 vccd1 net1389 sky130_fd_sc_hd__dlygate4sd3_1
X_09917_ net908 _03710_ vssd1 vssd1 vccd1 vccd1 _04024_ sky130_fd_sc_hd__nand2_1
Xhold196 net392 vssd1 vssd1 vccd1 vccd1 net1411 sky130_fd_sc_hd__dlygate4sd3_1
Xfanout621 _00990_ vssd1 vssd1 vccd1 vccd1 net621 sky130_fd_sc_hd__clkbuf_2
Xfanout610 _00993_ vssd1 vssd1 vccd1 vccd1 net610 sky130_fd_sc_hd__clkbuf_4
Xfanout632 _00977_ vssd1 vssd1 vccd1 vccd1 net632 sky130_fd_sc_hd__clkbuf_4
Xfanout643 net644 vssd1 vssd1 vccd1 vccd1 net643 sky130_fd_sc_hd__clkbuf_2
Xfanout665 net667 vssd1 vssd1 vccd1 vccd1 net665 sky130_fd_sc_hd__clkbuf_4
Xfanout654 _00599_ vssd1 vssd1 vccd1 vccd1 net654 sky130_fd_sc_hd__clkbuf_4
Xfanout676 _00985_ vssd1 vssd1 vccd1 vccd1 net676 sky130_fd_sc_hd__clkbuf_4
X_09848_ net1046 net752 net745 net1053 vssd1 vssd1 vccd1 vccd1 _03955_ sky130_fd_sc_hd__a22oi_2
XTAP_490 vssd1 vccd1 sky130_fd_sc_hd__tapvpwrvgnd_1
Xfanout687 net688 vssd1 vssd1 vccd1 vccd1 net687 sky130_fd_sc_hd__clkbuf_4
Xfanout698 net701 vssd1 vssd1 vccd1 vccd1 net698 sky130_fd_sc_hd__clkbuf_2
X_09779_ _03834_ _03886_ vssd1 vssd1 vccd1 vccd1 _03887_ sky130_fd_sc_hd__xnor2_4
X_12790_ clknet_leaf_40_clk_i _00176_ vssd1 vssd1 vccd1 vccd1 add1.b_i\[21\] sky130_fd_sc_hd__dfxtp_1
X_11810_ temp1\[18\] net615 net610 net195 vssd1 vssd1 vccd1 vccd1 _05853_ sky130_fd_sc_hd__a22o_1
XTAP_1623 vssd1 vccd1 sky130_fd_sc_hd__tapvpwrvgnd_1
XTAP_1612 vssd1 vccd1 sky130_fd_sc_hd__tapvpwrvgnd_1
XTAP_1601 vssd1 vccd1 sky130_fd_sc_hd__tapvpwrvgnd_1
X_11741_ net1603 _05795_ net478 vssd1 vssd1 vccd1 vccd1 _00193_ sky130_fd_sc_hd__mux2_1
XTAP_1667 vssd1 vccd1 sky130_fd_sc_hd__tapvpwrvgnd_1
XTAP_1656 vssd1 vccd1 sky130_fd_sc_hd__tapvpwrvgnd_1
XTAP_1645 vssd1 vccd1 sky130_fd_sc_hd__tapvpwrvgnd_1
XTAP_1634 vssd1 vccd1 sky130_fd_sc_hd__tapvpwrvgnd_1
XFILLER_0_55_107 vssd1 vssd1 vccd1 vccd1 sky130_fd_sc_hd__decap_4
XTAP_1689 vssd1 vccd1 sky130_fd_sc_hd__tapvpwrvgnd_1
XTAP_1678 vssd1 vccd1 sky130_fd_sc_hd__tapvpwrvgnd_1
XFILLER_0_55_129 vssd1 vssd1 vccd1 vccd1 sky130_fd_sc_hd__decap_8
X_11672_ net1283 _02672_ net536 vssd1 vssd1 vccd1 vccd1 _00164_ sky130_fd_sc_hd__mux2_1
X_10623_ _04723_ _04724_ vssd1 vssd1 vccd1 vccd1 _04725_ sky130_fd_sc_hd__and2_1
X_10554_ _04655_ _04656_ vssd1 vssd1 vccd1 vccd1 _04657_ sky130_fd_sc_hd__and2b_1
XFILLER_0_64_696 vssd1 vssd1 vccd1 vccd1 sky130_fd_sc_hd__decap_4
XFILLER_0_63_162 vssd1 vssd1 vccd1 vccd1 sky130_fd_sc_hd__fill_1
XFILLER_0_63_151 vssd1 vssd1 vccd1 vccd1 sky130_fd_sc_hd__fill_1
XFILLER_0_122_713 vssd1 vssd1 vccd1 vccd1 sky130_ef_sc_hd__decap_12
XFILLER_0_106_264 vssd1 vssd1 vccd1 vccd1 sky130_ef_sc_hd__decap_12
XFILLER_0_91_493 vssd1 vssd1 vccd1 vccd1 sky130_fd_sc_hd__fill_1
XFILLER_0_51_324 vssd1 vssd1 vccd1 vccd1 sky130_fd_sc_hd__decap_3
XFILLER_0_122_757 vssd1 vssd1 vccd1 vccd1 sky130_ef_sc_hd__decap_12
XFILLER_0_121_223 vssd1 vssd1 vccd1 vccd1 sky130_fd_sc_hd__fill_1
X_10485_ _04584_ _04585_ _04586_ vssd1 vssd1 vccd1 vccd1 _04588_ sky130_fd_sc_hd__a21bo_1
X_12224_ net765 _06169_ net519 vssd1 vssd1 vccd1 vccd1 _00302_ sky130_fd_sc_hd__mux2_1
XFILLER_0_20_755 vssd1 vssd1 vccd1 vccd1 sky130_fd_sc_hd__fill_1
X_12155_ net1710 _06122_ net518 vssd1 vssd1 vccd1 vccd1 _00280_ sky130_fd_sc_hd__mux2_1
XFILLER_0_102_492 vssd1 vssd1 vccd1 vccd1 sky130_fd_sc_hd__decap_4
X_11106_ _05200_ _05204_ vssd1 vssd1 vccd1 vccd1 _05205_ sky130_fd_sc_hd__xor2_2
XFILLER_0_75_39 vssd1 vssd1 vccd1 vccd1 sky130_fd_sc_hd__fill_1
X_12086_ _00872_ _06070_ net499 vssd1 vssd1 vccd1 vccd1 _06071_ sky130_fd_sc_hd__mux2_1
X_11037_ _05011_ _05014_ _05133_ _05134_ vssd1 vssd1 vccd1 vccd1 _05136_ sky130_fd_sc_hd__a211oi_4
XFILLER_0_91_27 vssd1 vssd1 vccd1 vccd1 sky130_ef_sc_hd__decap_12
XFILLER_0_59_413 vssd1 vssd1 vccd1 vccd1 sky130_fd_sc_hd__decap_3
X_12988_ clknet_leaf_53_clk_i _00374_ net1155 vssd1 vssd1 vccd1 vccd1 x2mx1\[9\] sky130_fd_sc_hd__dfrtp_1
X_11939_ net34 net549 net624 net217 _05958_ vssd1 vssd1 vccd1 vccd1 _05959_ sky130_fd_sc_hd__a221o_1
XFILLER_0_24_65 vssd1 vssd1 vccd1 vccd1 sky130_fd_sc_hd__fill_1
XFILLER_0_74_427 vssd1 vssd1 vccd1 vccd1 sky130_fd_sc_hd__fill_1
XFILLER_0_28_822 vssd1 vssd1 vccd1 vccd1 sky130_fd_sc_hd__decap_4
XFILLER_0_117_529 vssd1 vssd1 vccd1 vccd1 sky130_ef_sc_hd__decap_12
X_07130_ _01232_ _01233_ _01251_ _01252_ vssd1 vssd1 vccd1 vccd1 _01255_ sky130_fd_sc_hd__a2bb2o_1
XFILLER_0_125_573 vssd1 vssd1 vccd1 vccd1 sky130_ef_sc_hd__decap_12
XFILLER_0_54_195 vssd1 vssd1 vccd1 vccd1 sky130_fd_sc_hd__fill_1
XFILLER_0_70_677 vssd1 vssd1 vccd1 vccd1 sky130_fd_sc_hd__fill_1
XFILLER_0_30_519 vssd1 vssd1 vccd1 vccd1 sky130_fd_sc_hd__decap_4
X_07061_ net806 net1143 _01184_ _01185_ vssd1 vssd1 vccd1 vccd1 _01186_ sky130_fd_sc_hd__and4_1
XFILLER_0_40_97 vssd1 vssd1 vccd1 vccd1 sky130_fd_sc_hd__fill_1
XFILLER_0_112_245 vssd1 vssd1 vccd1 vccd1 sky130_fd_sc_hd__decap_6
Xoutput268 net268 vssd1 vssd1 vccd1 vccd1 div_mstream_o[24] sky130_fd_sc_hd__clkbuf_4
Xoutput257 net257 vssd1 vssd1 vccd1 vccd1 div_mstream_o[14] sky130_fd_sc_hd__clkbuf_4
XFILLER_0_112_289 vssd1 vssd1 vccd1 vccd1 sky130_ef_sc_hd__decap_12
Xoutput279 net279 vssd1 vssd1 vccd1 vccd1 div_mstream_o[34] sky130_fd_sc_hd__clkbuf_4
X_07963_ _02077_ _02082_ vssd1 vssd1 vccd1 vccd1 _02083_ sky130_fd_sc_hd__nor2_1
X_09702_ _03642_ _03644_ _03808_ _03809_ vssd1 vssd1 vccd1 vccd1 _03810_ sky130_fd_sc_hd__o211a_1
X_07894_ _02006_ _02014_ vssd1 vssd1 vccd1 vccd1 _02015_ sky130_fd_sc_hd__nand2_1
XFILLER_0_4_53 vssd1 vssd1 vccd1 vccd1 sky130_ef_sc_hd__decap_12
X_06914_ _01037_ _01038_ net829 net1126 vssd1 vssd1 vccd1 vccd1 _01039_ sky130_fd_sc_hd__and4bb_1
X_09633_ _03739_ _03740_ _03568_ _03570_ vssd1 vssd1 vccd1 vccd1 _03742_ sky130_fd_sc_hd__a211oi_2
X_06845_ state\[4\] _00598_ vssd1 vssd1 vccd1 vccd1 _00976_ sky130_fd_sc_hd__or2_4
X_09564_ _03526_ _03532_ _03531_ vssd1 vssd1 vccd1 vccd1 _03673_ sky130_fd_sc_hd__a21o_1
X_08515_ _02629_ _02630_ vssd1 vssd1 vccd1 vccd1 _02631_ sky130_fd_sc_hd__nor2_1
X_06776_ net1513 l1\[15\] net638 vssd1 vssd1 vccd1 vccd1 _00050_ sky130_fd_sc_hd__mux2_1
X_09495_ _03595_ _03603_ vssd1 vssd1 vccd1 vccd1 _03604_ sky130_fd_sc_hd__nor2_1
X_08446_ net1114 net1122 net748 net740 vssd1 vssd1 vccd1 vccd1 _02562_ sky130_fd_sc_hd__and4_1
XFILLER_0_93_747 vssd1 vssd1 vccd1 vccd1 sky130_fd_sc_hd__fill_1
XFILLER_0_65_449 vssd1 vssd1 vccd1 vccd1 sky130_fd_sc_hd__decap_6
XFILLER_0_80_408 vssd1 vssd1 vccd1 vccd1 sky130_fd_sc_hd__decap_3
X_08377_ _02492_ _02493_ _02486_ vssd1 vssd1 vccd1 vccd1 _02494_ sky130_fd_sc_hd__a21oi_1
XFILLER_0_18_365 vssd1 vssd1 vccd1 vccd1 sky130_fd_sc_hd__fill_1
X_07328_ _01442_ _01451_ _01452_ vssd1 vssd1 vccd1 vccd1 _01453_ sky130_fd_sc_hd__a21o_1
XFILLER_0_61_644 vssd1 vssd1 vccd1 vccd1 sky130_ef_sc_hd__decap_12
XFILLER_0_104_757 vssd1 vssd1 vccd1 vccd1 sky130_fd_sc_hd__decap_4
XFILLER_0_60_165 vssd1 vssd1 vccd1 vccd1 sky130_fd_sc_hd__decap_4
X_07259_ _01209_ _01215_ _01210_ vssd1 vssd1 vccd1 vccd1 _01384_ sky130_fd_sc_hd__a21bo_1
X_10270_ _04372_ _04373_ vssd1 vssd1 vccd1 vccd1 _04375_ sky130_fd_sc_hd__xnor2_4
Xfanout484 net485 vssd1 vssd1 vccd1 vccd1 net484 sky130_fd_sc_hd__clkbuf_4
Xfanout473 _05765_ vssd1 vssd1 vccd1 vccd1 net473 sky130_fd_sc_hd__clkbuf_4
X_12911_ clknet_leaf_42_clk_i _00297_ vssd1 vssd1 vccd1 vccd1 mul1.b\[14\] sky130_fd_sc_hd__dfxtp_1
XTAP_2110 vssd1 vccd1 sky130_fd_sc_hd__tapvpwrvgnd_1
XFILLER_0_69_700 vssd1 vssd1 vccd1 vccd1 sky130_fd_sc_hd__fill_2
Xmax_cap9 _05137_ vssd1 vssd1 vccd1 vccd1 net1750 sky130_fd_sc_hd__clkbuf_2
XTAP_2143 vssd1 vccd1 sky130_fd_sc_hd__tapvpwrvgnd_1
XTAP_2132 vssd1 vccd1 sky130_fd_sc_hd__tapvpwrvgnd_1
XTAP_2121 vssd1 vccd1 sky130_fd_sc_hd__tapvpwrvgnd_1
XFILLER_0_96_530 vssd1 vssd1 vccd1 vccd1 sky130_fd_sc_hd__fill_2
X_12842_ clknet_leaf_51_clk_i _00228_ vssd1 vssd1 vccd1 vccd1 sub1.b_i\[9\] sky130_fd_sc_hd__dfxtp_2
XTAP_2165 vssd1 vccd1 sky130_fd_sc_hd__tapvpwrvgnd_1
XTAP_2176 vssd1 vccd1 sky130_fd_sc_hd__tapvpwrvgnd_1
XTAP_2154 vssd1 vccd1 sky130_fd_sc_hd__tapvpwrvgnd_1
XTAP_1442 vssd1 vccd1 sky130_fd_sc_hd__tapvpwrvgnd_1
XTAP_1431 vssd1 vccd1 sky130_fd_sc_hd__tapvpwrvgnd_1
XTAP_1420 vssd1 vccd1 sky130_fd_sc_hd__tapvpwrvgnd_1
X_12773_ clknet_leaf_58_clk_i _00159_ vssd1 vssd1 vccd1 vccd1 add1.b_i\[4\] sky130_fd_sc_hd__dfxtp_1
XTAP_2198 vssd1 vccd1 sky130_fd_sc_hd__tapvpwrvgnd_1
XTAP_2187 vssd1 vccd1 sky130_fd_sc_hd__tapvpwrvgnd_1
XFILLER_0_84_725 vssd1 vssd1 vccd1 vccd1 sky130_ef_sc_hd__decap_12
XTAP_1475 vssd1 vccd1 sky130_fd_sc_hd__tapvpwrvgnd_1
XTAP_1464 vssd1 vccd1 sky130_fd_sc_hd__tapvpwrvgnd_1
XTAP_1453 vssd1 vccd1 sky130_fd_sc_hd__tapvpwrvgnd_1
X_11724_ net651 _00823_ net473 _05781_ vssd1 vssd1 vccd1 vccd1 _05782_ sky130_fd_sc_hd__a211o_1
XTAP_1497 vssd1 vccd1 sky130_fd_sc_hd__tapvpwrvgnd_1
XTAP_1486 vssd1 vccd1 sky130_fd_sc_hd__tapvpwrvgnd_1
X_11655_ _05696_ _05748_ vssd1 vssd1 vccd1 vccd1 _05749_ sky130_fd_sc_hd__xnor2_2
XFILLER_0_36_151 vssd1 vssd1 vccd1 vccd1 sky130_fd_sc_hd__fill_2
X_10606_ _04704_ _04705_ _04706_ vssd1 vssd1 vccd1 vccd1 _04708_ sky130_fd_sc_hd__a21o_1
X_11586_ _05678_ _05679_ vssd1 vssd1 vccd1 vccd1 _05680_ sky130_fd_sc_hd__xnor2_1
X_10537_ _04628_ _04638_ _04639_ vssd1 vssd1 vccd1 vccd1 _04640_ sky130_fd_sc_hd__and3_1
XFILLER_0_52_666 vssd1 vssd1 vccd1 vccd1 sky130_fd_sc_hd__decap_8
XFILLER_0_101_69 vssd1 vssd1 vccd1 vccd1 sky130_ef_sc_hd__decap_12
X_10468_ _04569_ _04570_ vssd1 vssd1 vccd1 vccd1 _04571_ sky130_fd_sc_hd__xnor2_1
XFILLER_0_51_187 vssd1 vssd1 vccd1 vccd1 sky130_fd_sc_hd__decap_8
XFILLER_0_122_587 vssd1 vssd1 vccd1 vccd1 sky130_fd_sc_hd__fill_1
XFILLER_0_110_749 vssd1 vssd1 vccd1 vccd1 sky130_fd_sc_hd__fill_1
XFILLER_0_86_27 vssd1 vssd1 vccd1 vccd1 sky130_fd_sc_hd__fill_1
X_12207_ x2mx1\[14\] net603 net586 temp1\[14\] vssd1 vssd1 vccd1 vccd1 _06158_ sky130_fd_sc_hd__a22o_1
X_10399_ _04499_ _04501_ _04348_ _04351_ vssd1 vssd1 vccd1 vccd1 _04503_ sky130_fd_sc_hd__a211o_1
X_13187_ clknet_leaf_19_clk_i _00573_ net1177 vssd1 vssd1 vccd1 vccd1 l1\[16\] sky130_fd_sc_hd__dfrtp_1
XFILLER_0_20_585 vssd1 vssd1 vccd1 vccd1 sky130_fd_sc_hd__decap_3
X_12138_ _00940_ _06109_ net500 vssd1 vssd1 vccd1 vccd1 _06110_ sky130_fd_sc_hd__mux2_1
X_12069_ y2my0\[8\] net583 net531 x2mx1\[8\] _06057_ vssd1 vssd1 vccd1 vccd1 _06058_
+ sky130_fd_sc_hd__a221o_1
X_06630_ sub1.b_i\[11\] sub1.a_i\[11\] vssd1 vssd1 vccd1 vccd1 _00864_ sky130_fd_sc_hd__and2b_1
XFILLER_0_126_77 vssd1 vssd1 vccd1 vccd1 sky130_fd_sc_hd__decap_6
X_06561_ _00782_ net685 net251 vssd1 vssd1 vccd1 vccd1 _00807_ sky130_fd_sc_hd__a21oi_1
X_06492_ det_t\[2\] net529 vssd1 vssd1 vccd1 vccd1 net274 sky130_fd_sc_hd__and2_1
X_08300_ _02295_ _02296_ net1147 net727 vssd1 vssd1 vccd1 vccd1 _02417_ sky130_fd_sc_hd__o211a_1
X_09280_ _03389_ _03390_ _03370_ vssd1 vssd1 vccd1 vccd1 _03391_ sky130_fd_sc_hd__a21oi_1
X_08231_ _02220_ _02222_ _02346_ _02347_ vssd1 vssd1 vccd1 vccd1 _02349_ sky130_fd_sc_hd__o211ai_4
XFILLER_0_51_41 vssd1 vssd1 vccd1 vccd1 sky130_ef_sc_hd__decap_12
XFILLER_0_28_641 vssd1 vssd1 vccd1 vccd1 sky130_fd_sc_hd__decap_3
XFILLER_0_117_337 vssd1 vssd1 vccd1 vccd1 sky130_ef_sc_hd__decap_12
XFILLER_0_55_460 vssd1 vssd1 vccd1 vccd1 sky130_fd_sc_hd__decap_8
XFILLER_0_7_557 vssd1 vssd1 vccd1 vccd1 sky130_fd_sc_hd__decap_3
XFILLER_0_16_825 vssd1 vssd1 vccd1 vccd1 sky130_fd_sc_hd__decap_4
XFILLER_0_27_140 vssd1 vssd1 vccd1 vccd1 sky130_fd_sc_hd__fill_2
X_08162_ _02278_ _02280_ vssd1 vssd1 vccd1 vccd1 _02281_ sky130_fd_sc_hd__xnor2_2
X_08093_ net821 _02211_ _02210_ vssd1 vssd1 vccd1 vccd1 _02212_ sky130_fd_sc_hd__a21bo_1
X_07113_ _01236_ _01237_ vssd1 vssd1 vccd1 vccd1 _01238_ sky130_fd_sc_hd__and2_1
XFILLER_0_70_485 vssd1 vssd1 vccd1 vccd1 sky130_fd_sc_hd__fill_1
X_07044_ _01160_ _01168_ vssd1 vssd1 vccd1 vccd1 _01169_ sky130_fd_sc_hd__nand2_1
XFILLER_0_101_749 vssd1 vssd1 vccd1 vccd1 sky130_fd_sc_hd__fill_1
XFILLER_0_62_3 vssd1 vssd1 vccd1 vccd1 sky130_ef_sc_hd__decap_12
X_08995_ _02812_ _02814_ _02960_ vssd1 vssd1 vccd1 vccd1 _03108_ sky130_fd_sc_hd__or3_1
X_07946_ net1123 net1132 net772 net763 vssd1 vssd1 vccd1 vccd1 _02066_ sky130_fd_sc_hd__and4_1
X_07877_ _01995_ _01996_ vssd1 vssd1 vccd1 vccd1 _01998_ sky130_fd_sc_hd__xor2_1
X_06828_ net1545 net1507 net646 vssd1 vssd1 vccd1 vccd1 _00102_ sky130_fd_sc_hd__mux2_1
X_09616_ _03722_ _03723_ _03551_ _03555_ vssd1 vssd1 vccd1 vccd1 _03725_ sky130_fd_sc_hd__o211ai_2
X_09547_ _03655_ _03654_ _03653_ vssd1 vssd1 vccd1 vccd1 _03656_ sky130_fd_sc_hd__nand3b_1
X_06759_ _00971_ _00972_ vssd1 vssd1 vccd1 vccd1 _00973_ sky130_fd_sc_hd__xnor2_4
XFILLER_0_65_213 vssd1 vssd1 vccd1 vccd1 sky130_fd_sc_hd__decap_3
X_09478_ _03417_ _03418_ _03580_ _03586_ _03577_ vssd1 vssd1 vccd1 vccd1 _03587_ sky130_fd_sc_hd__o32a_1
X_08429_ _02532_ _02534_ vssd1 vssd1 vccd1 vccd1 _02545_ sky130_fd_sc_hd__nor2_1
XFILLER_0_46_493 vssd1 vssd1 vccd1 vccd1 sky130_fd_sc_hd__fill_2
XFILLER_0_18_173 vssd1 vssd1 vccd1 vccd1 sky130_fd_sc_hd__fill_1
X_11440_ _05356_ _05359_ _05534_ vssd1 vssd1 vccd1 vccd1 _05536_ sky130_fd_sc_hd__and3_1
X_11371_ _05465_ net736 net975 _05464_ vssd1 vssd1 vccd1 vccd1 _05467_ sky130_fd_sc_hd__and4b_1
XFILLER_0_22_817 vssd1 vssd1 vccd1 vccd1 sky130_fd_sc_hd__fill_1
Xbary_pipe_m_1205 vssd1 vssd1 vccd1 vccd1 bary_pipe_m_1205/HI div_mstream_o[55] sky130_fd_sc_hd__conb_1
X_13110_ clknet_leaf_3_clk_i _00496_ vssd1 vssd1 vccd1 vccd1 det_t\[3\] sky130_fd_sc_hd__dfxtp_1
X_10322_ _04263_ _04267_ _04424_ _04425_ vssd1 vssd1 vccd1 vccd1 _04426_ sky130_fd_sc_hd__a211oi_1
XFILLER_0_34_688 vssd1 vssd1 vccd1 vccd1 sky130_fd_sc_hd__fill_1
XFILLER_0_14_390 vssd1 vssd1 vccd1 vccd1 sky130_fd_sc_hd__fill_1
X_13041_ clknet_leaf_32_clk_i _00427_ net1166 vssd1 vssd1 vccd1 vccd1 x0mx2\[30\]
+ sky130_fd_sc_hd__dfrtp_1
X_10253_ _04307_ _04308_ _04355_ _04356_ vssd1 vssd1 vccd1 vccd1 _04358_ sky130_fd_sc_hd__a22o_1
X_10184_ net792 net991 net984 net804 vssd1 vssd1 vccd1 vccd1 _04289_ sky130_fd_sc_hd__a22o_1
XFILLER_0_88_349 vssd1 vssd1 vccd1 vccd1 sky130_fd_sc_hd__decap_4
XFILLER_0_88_327 vssd1 vssd1 vccd1 vccd1 sky130_fd_sc_hd__decap_3
XFILLER_0_72_29 vssd1 vssd1 vccd1 vccd1 sky130_fd_sc_hd__decap_8
X_12825_ clknet_leaf_34_clk_i _00211_ vssd1 vssd1 vccd1 vccd1 sub1.a_i\[24\] sky130_fd_sc_hd__dfxtp_1
XTAP_1250 vssd1 vccd1 sky130_fd_sc_hd__tapvpwrvgnd_1
XTAP_1272 vssd1 vccd1 sky130_fd_sc_hd__tapvpwrvgnd_1
XTAP_1283 vssd1 vccd1 sky130_fd_sc_hd__tapvpwrvgnd_1
XTAP_1261 vssd1 vccd1 sky130_fd_sc_hd__tapvpwrvgnd_1
X_12756_ clknet_leaf_41_clk_i _00142_ vssd1 vssd1 vccd1 vccd1 add1.a_i\[19\] sky130_fd_sc_hd__dfxtp_1
X_12687_ clknet_leaf_14_clk_i _00073_ net1184 vssd1 vssd1 vccd1 vccd1 net417 sky130_fd_sc_hd__dfrtp_1
XTAP_1294 vssd1 vccd1 sky130_fd_sc_hd__tapvpwrvgnd_1
X_11707_ net1456 _05767_ net477 vssd1 vssd1 vccd1 vccd1 _00187_ sky130_fd_sc_hd__mux2_1
XFILLER_0_25_600 vssd1 vssd1 vccd1 vccd1 sky130_fd_sc_hd__fill_2
XFILLER_0_126_167 vssd1 vssd1 vccd1 vccd1 sky130_fd_sc_hd__fill_2
XFILLER_0_115_819 vssd1 vssd1 vccd1 vccd1 sky130_fd_sc_hd__fill_1
XFILLER_0_114_307 vssd1 vssd1 vccd1 vccd1 sky130_fd_sc_hd__fill_1
XFILLER_0_71_238 vssd1 vssd1 vccd1 vccd1 sky130_ef_sc_hd__decap_12
XFILLER_0_21_55 vssd1 vssd1 vccd1 vccd1 sky130_fd_sc_hd__fill_1
X_11638_ net1004 net702 vssd1 vssd1 vccd1 vccd1 _05732_ sky130_fd_sc_hd__nand2_1
XFILLER_0_13_806 vssd1 vssd1 vccd1 vccd1 sky130_ef_sc_hd__decap_12
XFILLER_0_123_841 vssd1 vssd1 vccd1 vccd1 sky130_fd_sc_hd__fill_1
XFILLER_0_97_15 vssd1 vssd1 vccd1 vccd1 sky130_ef_sc_hd__decap_12
XFILLER_0_21_99 vssd1 vssd1 vccd1 vccd1 sky130_fd_sc_hd__fill_2
XFILLER_0_40_625 vssd1 vssd1 vccd1 vccd1 sky130_fd_sc_hd__fill_2
X_11569_ _05660_ _05661_ _05662_ vssd1 vssd1 vccd1 vccd1 _05664_ sky130_fd_sc_hd__o21ai_1
XFILLER_0_110_513 vssd1 vssd1 vccd1 vccd1 sky130_ef_sc_hd__decap_12
Xmax_cap459 _03400_ vssd1 vssd1 vccd1 vccd1 net459 sky130_fd_sc_hd__buf_1
XFILLER_0_40_658 vssd1 vssd1 vccd1 vccd1 sky130_fd_sc_hd__fill_1
XFILLER_0_110_557 vssd1 vssd1 vccd1 vccd1 sky130_ef_sc_hd__decap_12
X_08780_ net852 net843 net1008 net1001 vssd1 vssd1 vccd1 vccd1 _02894_ sky130_fd_sc_hd__nand4_1
X_07800_ _01920_ _01921_ _01913_ vssd1 vssd1 vccd1 vccd1 _01922_ sky130_fd_sc_hd__a21o_1
XFILLER_0_46_52 vssd1 vssd1 vccd1 vccd1 sky130_ef_sc_hd__decap_12
X_07731_ temp1\[2\] _01853_ net541 vssd1 vssd1 vccd1 vccd1 _01854_ sky130_fd_sc_hd__mux2_1
X_07662_ net1113 net806 vssd1 vssd1 vccd1 vccd1 _01785_ sky130_fd_sc_hd__nand2_1
XFILLER_0_1_21 vssd1 vssd1 vccd1 vccd1 sky130_fd_sc_hd__decap_8
X_09401_ net841 net981 vssd1 vssd1 vccd1 vccd1 _03511_ sky130_fd_sc_hd__and2_1
X_07593_ net1032 net1041 net899 net890 vssd1 vssd1 vccd1 vccd1 _01717_ sky130_fd_sc_hd__nand4_1
X_06613_ sub1.a_i\[6\] _00592_ _00842_ _00843_ vssd1 vssd1 vccd1 vccd1 _00850_ sky130_fd_sc_hd__a31o_1
X_06544_ net544 _00795_ vssd1 vssd1 vccd1 vccd1 net306 sky130_fd_sc_hd__nor2_1
X_09332_ _03274_ _03277_ _03441_ vssd1 vssd1 vccd1 vccd1 _03442_ sky130_fd_sc_hd__a21oi_2
XFILLER_0_87_371 vssd1 vssd1 vccd1 vccd1 sky130_fd_sc_hd__decap_6
XFILLER_0_87_360 vssd1 vssd1 vccd1 vccd1 sky130_fd_sc_hd__fill_1
XFILLER_0_75_511 vssd1 vssd1 vccd1 vccd1 sky130_fd_sc_hd__fill_1
XFILLER_0_62_73 vssd1 vssd1 vccd1 vccd1 sky130_fd_sc_hd__fill_2
XFILLER_0_118_613 vssd1 vssd1 vccd1 vccd1 sky130_ef_sc_hd__decap_12
XFILLER_0_87_393 vssd1 vssd1 vccd1 vccd1 sky130_fd_sc_hd__fill_2
XFILLER_0_75_544 vssd1 vssd1 vccd1 vccd1 sky130_fd_sc_hd__fill_1
XFILLER_0_8_811 vssd1 vssd1 vccd1 vccd1 sky130_fd_sc_hd__fill_1
XFILLER_0_118_657 vssd1 vssd1 vccd1 vccd1 sky130_ef_sc_hd__decap_12
XFILLER_0_62_205 vssd1 vssd1 vccd1 vccd1 sky130_fd_sc_hd__fill_2
X_09263_ net901 net892 net949 net944 vssd1 vssd1 vccd1 vccd1 _03374_ sky130_fd_sc_hd__nand4_1
X_06475_ add1.a_i\[29\] add1.b_i\[29\] vssd1 vssd1 vccd1 vccd1 _00771_ sky130_fd_sc_hd__nor2_1
XFILLER_0_7_321 vssd1 vssd1 vccd1 vccd1 sky130_fd_sc_hd__fill_2
XFILLER_0_117_167 vssd1 vssd1 vccd1 vccd1 sky130_fd_sc_hd__fill_1
X_09194_ net1080 net754 net746 net1087 vssd1 vssd1 vccd1 vccd1 _03305_ sky130_fd_sc_hd__a22oi_2
X_08214_ net1059 net821 net814 net1067 vssd1 vssd1 vccd1 vccd1 _02332_ sky130_fd_sc_hd__a22o_1
XFILLER_0_62_227 vssd1 vssd1 vccd1 vccd1 sky130_fd_sc_hd__decap_8
X_08145_ _02226_ _02227_ _02261_ _02262_ vssd1 vssd1 vccd1 vccd1 _02264_ sky130_fd_sc_hd__nor4_1
XFILLER_0_71_794 vssd1 vssd1 vccd1 vccd1 sky130_fd_sc_hd__fill_1
XFILLER_0_71_783 vssd1 vssd1 vccd1 vccd1 sky130_fd_sc_hd__fill_1
XFILLER_0_43_496 vssd1 vssd1 vccd1 vccd1 sky130_fd_sc_hd__fill_1
XFILLER_0_30_113 vssd1 vssd1 vccd1 vccd1 sky130_fd_sc_hd__decap_4
XFILLER_0_31_614 vssd1 vssd1 vccd1 vccd1 sky130_fd_sc_hd__fill_2
XFILLER_0_113_373 vssd1 vssd1 vccd1 vccd1 sky130_ef_sc_hd__decap_12
XFILLER_0_101_502 vssd1 vssd1 vccd1 vccd1 sky130_fd_sc_hd__fill_2
X_08076_ net1106 net781 vssd1 vssd1 vccd1 vccd1 _02195_ sky130_fd_sc_hd__and2_1
XFILLER_0_70_293 vssd1 vssd1 vccd1 vccd1 sky130_fd_sc_hd__decap_4
X_07027_ net899 net888 net1057 net1065 vssd1 vssd1 vccd1 vccd1 _01152_ sky130_fd_sc_hd__and4_1
XFILLER_0_11_360 vssd1 vssd1 vccd1 vccd1 sky130_fd_sc_hd__fill_1
XFILLER_0_101_568 vssd1 vssd1 vccd1 vccd1 sky130_fd_sc_hd__fill_1
XFILLER_0_11_393 vssd1 vssd1 vccd1 vccd1 sky130_fd_sc_hd__fill_2
Xhold12 det_t\[28\] vssd1 vssd1 vccd1 vccd1 net1227 sky130_fd_sc_hd__dlygate4sd3_1
Xhold23 det_t\[20\] vssd1 vssd1 vccd1 vccd1 net1238 sky130_fd_sc_hd__dlygate4sd3_1
X_08978_ _03027_ _03028_ _03088_ _03089_ vssd1 vssd1 vccd1 vccd1 _03091_ sky130_fd_sc_hd__or4_1
Xhold34 l1\[24\] vssd1 vssd1 vccd1 vccd1 net1249 sky130_fd_sc_hd__dlygate4sd3_1
Xhold45 l1\[26\] vssd1 vssd1 vccd1 vccd1 net1260 sky130_fd_sc_hd__dlygate4sd3_1
Xhold56 sub1.b_i\[23\] vssd1 vssd1 vccd1 vccd1 net1271 sky130_fd_sc_hd__dlygate4sd3_1
X_07929_ _02047_ _02048_ _01875_ _01878_ vssd1 vssd1 vccd1 vccd1 _02050_ sky130_fd_sc_hd__o211ai_4
Xhold67 add1.b_i\[15\] vssd1 vssd1 vccd1 vccd1 net1282 sky130_fd_sc_hd__dlygate4sd3_1
Xhold78 sub1.a_i\[29\] vssd1 vssd1 vccd1 vccd1 net1293 sky130_fd_sc_hd__dlygate4sd3_1
Xhold89 net362 vssd1 vssd1 vccd1 vccd1 net1304 sky130_fd_sc_hd__dlygate4sd3_1
XFILLER_0_97_113 vssd1 vssd1 vccd1 vccd1 sky130_fd_sc_hd__fill_2
X_10940_ _04906_ _05039_ vssd1 vssd1 vccd1 vccd1 _05040_ sky130_fd_sc_hd__nor2_1
X_12610_ net1354 net22 net555 vssd1 vssd1 vccd1 vccd1 _00585_ sky130_fd_sc_hd__mux2_1
X_10871_ _04968_ _04970_ vssd1 vssd1 vccd1 vccd1 _04971_ sky130_fd_sc_hd__xnor2_1
XFILLER_0_66_533 vssd1 vssd1 vccd1 vccd1 sky130_fd_sc_hd__decap_3
X_12541_ net1227 net565 _06267_ vssd1 vssd1 vccd1 vccd1 _00521_ sky130_fd_sc_hd__a21o_1
XFILLER_0_81_503 vssd1 vssd1 vccd1 vccd1 sky130_fd_sc_hd__fill_1
X_12472_ _00951_ net617 _05321_ net576 vssd1 vssd1 vccd1 vccd1 _06232_ sky130_fd_sc_hd__a22o_1
XFILLER_0_108_189 vssd1 vssd1 vccd1 vccd1 sky130_fd_sc_hd__decap_6
X_11423_ _05394_ _05399_ _05518_ vssd1 vssd1 vccd1 vccd1 _05519_ sky130_fd_sc_hd__o21a_1
XANTENNA_9 _00799_ vssd1 vssd1 vccd1 vccd1 sky130_fd_sc_hd__diode_2
XFILLER_0_123_137 vssd1 vssd1 vccd1 vccd1 sky130_ef_sc_hd__decap_12
XFILLER_0_105_841 vssd1 vssd1 vccd1 vccd1 sky130_fd_sc_hd__fill_1
XFILLER_0_34_463 vssd1 vssd1 vccd1 vccd1 sky130_fd_sc_hd__fill_1
XFILLER_0_34_496 vssd1 vssd1 vccd1 vccd1 sky130_fd_sc_hd__fill_1
XFILLER_0_104_373 vssd1 vssd1 vccd1 vccd1 sky130_fd_sc_hd__decap_3
X_11354_ temp1\[28\] _05450_ net542 vssd1 vssd1 vccd1 vccd1 _05451_ sky130_fd_sc_hd__mux2_1
XFILLER_0_21_113 vssd1 vssd1 vccd1 vccd1 sky130_fd_sc_hd__decap_8
X_10305_ _04403_ _04407_ _04408_ vssd1 vssd1 vccd1 vccd1 _04409_ sky130_fd_sc_hd__nand3_2
X_11285_ _05380_ _05381_ vssd1 vssd1 vccd1 vccd1 _05382_ sky130_fd_sc_hd__or2_1
X_10236_ net833 net958 _04339_ _04340_ vssd1 vssd1 vccd1 vccd1 _04341_ sky130_fd_sc_hd__and4_1
XTAP_319 vssd1 vccd1 sky130_fd_sc_hd__tapvpwrvgnd_1
XTAP_308 vssd1 vccd1 sky130_fd_sc_hd__tapvpwrvgnd_1
XFILLER_0_30_691 vssd1 vssd1 vccd1 vccd1 sky130_fd_sc_hd__decap_8
X_13024_ clknet_leaf_45_clk_i _00410_ net1156 vssd1 vssd1 vccd1 vccd1 x0mx2\[13\]
+ sky130_fd_sc_hd__dfrtp_1
Xfanout1021 net1022 vssd1 vssd1 vccd1 vccd1 net1021 sky130_fd_sc_hd__buf_2
Xfanout1010 mul1.a\[17\] vssd1 vssd1 vccd1 vccd1 net1010 sky130_fd_sc_hd__clkbuf_4
Xfanout1054 net1055 vssd1 vssd1 vccd1 vccd1 net1054 sky130_fd_sc_hd__clkbuf_4
X_10167_ net1028 net752 net745 net1038 vssd1 vssd1 vccd1 vccd1 _04272_ sky130_fd_sc_hd__a22o_1
Xfanout1043 net1044 vssd1 vssd1 vccd1 vccd1 net1043 sky130_fd_sc_hd__buf_2
Xfanout1032 net1040 vssd1 vssd1 vccd1 vccd1 net1032 sky130_fd_sc_hd__buf_2
Xfanout1065 net1066 vssd1 vssd1 vccd1 vccd1 net1065 sky130_fd_sc_hd__clkbuf_4
Xfanout1087 mul1.a\[8\] vssd1 vssd1 vccd1 vccd1 net1087 sky130_fd_sc_hd__buf_4
Xfanout1076 net1077 vssd1 vssd1 vccd1 vccd1 net1076 sky130_fd_sc_hd__clkbuf_4
X_10098_ _04201_ _04202_ vssd1 vssd1 vccd1 vccd1 _04204_ sky130_fd_sc_hd__xor2_4
XFILLER_0_83_39 vssd1 vssd1 vccd1 vccd1 sky130_ef_sc_hd__decap_12
Xfanout1098 net1099 vssd1 vssd1 vccd1 vccd1 net1098 sky130_fd_sc_hd__clkbuf_4
XFILLER_0_107_57 vssd1 vssd1 vccd1 vccd1 sky130_ef_sc_hd__decap_12
XFILLER_0_89_658 vssd1 vssd1 vccd1 vccd1 sky130_fd_sc_hd__fill_1
XFILLER_0_88_102 vssd1 vssd1 vccd1 vccd1 sky130_ef_sc_hd__decap_12
XFILLER_0_16_77 vssd1 vssd1 vccd1 vccd1 sky130_fd_sc_hd__decap_6
XFILLER_0_29_202 vssd1 vssd1 vccd1 vccd1 sky130_fd_sc_hd__fill_2
X_12808_ clknet_leaf_54_clk_i _00194_ vssd1 vssd1 vccd1 vccd1 sub1.a_i\[7\] sky130_fd_sc_hd__dfxtp_1
XTAP_1091 vssd1 vccd1 sky130_fd_sc_hd__tapvpwrvgnd_1
XTAP_1080 vssd1 vccd1 sky130_fd_sc_hd__tapvpwrvgnd_1
X_12739_ clknet_leaf_0_clk_i _00125_ vssd1 vssd1 vccd1 vccd1 add1.a_i\[2\] sky130_fd_sc_hd__dfxtp_1
XFILLER_0_127_443 vssd1 vssd1 vccd1 vccd1 sky130_fd_sc_hd__decap_4
XFILLER_0_120_3 vssd1 vssd1 vccd1 vccd1 sky130_ef_sc_hd__decap_12
XFILLER_0_5_814 vssd1 vssd1 vccd1 vccd1 sky130_fd_sc_hd__fill_2
XFILLER_0_130_608 vssd1 vssd1 vccd1 vccd1 sky130_fd_sc_hd__fill_2
XFILLER_0_13_614 vssd1 vssd1 vccd1 vccd1 sky130_fd_sc_hd__fill_2
XFILLER_0_123_671 vssd1 vssd1 vccd1 vccd1 sky130_fd_sc_hd__fill_1
Xhold504 add1.b_i\[5\] vssd1 vssd1 vccd1 vccd1 net1719 sky130_fd_sc_hd__dlygate4sd3_1
Xhold515 net383 vssd1 vssd1 vccd1 vccd1 net1730 sky130_fd_sc_hd__dlygate4sd3_1
XFILLER_0_25_496 vssd1 vssd1 vccd1 vccd1 sky130_fd_sc_hd__decap_4
Xhold526 add1.a_i\[5\] vssd1 vssd1 vccd1 vccd1 net1741 sky130_fd_sc_hd__dlygate4sd3_1
XFILLER_0_110_321 vssd1 vssd1 vccd1 vccd1 sky130_fd_sc_hd__fill_2
X_09950_ _04055_ _04056_ vssd1 vssd1 vccd1 vccd1 _04057_ sky130_fd_sc_hd__nor2_1
XFILLER_0_40_477 vssd1 vssd1 vccd1 vccd1 sky130_fd_sc_hd__decap_8
XFILLER_0_110_365 vssd1 vssd1 vccd1 vccd1 sky130_ef_sc_hd__decap_12
X_08901_ net802 _03013_ _03012_ vssd1 vssd1 vccd1 vccd1 _03014_ sky130_fd_sc_hd__a21oi_1
X_09881_ _03987_ vssd1 vssd1 vccd1 vccd1 _03988_ sky130_fd_sc_hd__inv_2
XFILLER_0_57_62 vssd1 vssd1 vccd1 vccd1 sky130_fd_sc_hd__fill_1
XTAP_820 vssd1 vccd1 sky130_fd_sc_hd__tapvpwrvgnd_1
XTAP_831 vssd1 vccd1 sky130_fd_sc_hd__tapvpwrvgnd_1
XTAP_842 vssd1 vccd1 sky130_fd_sc_hd__tapvpwrvgnd_1
XTAP_853 vssd1 vccd1 sky130_fd_sc_hd__tapvpwrvgnd_1
X_08832_ _02884_ _02885_ _02944_ _02945_ vssd1 vssd1 vccd1 vccd1 _02946_ sky130_fd_sc_hd__nor4_1
XTAP_864 vssd1 vccd1 sky130_fd_sc_hd__tapvpwrvgnd_1
XTAP_886 vssd1 vccd1 sky130_fd_sc_hd__tapvpwrvgnd_1
XTAP_875 vssd1 vccd1 sky130_fd_sc_hd__tapvpwrvgnd_1
X_08763_ _02722_ _02725_ vssd1 vssd1 vccd1 vccd1 _02877_ sky130_fd_sc_hd__and2_1
XTAP_897 vssd1 vccd1 sky130_fd_sc_hd__tapvpwrvgnd_1
XFILLER_0_79_113 vssd1 vssd1 vccd1 vccd1 sky130_fd_sc_hd__decap_6
X_07714_ _01833_ _01834_ _01732_ _01736_ vssd1 vssd1 vccd1 vccd1 _01837_ sky130_fd_sc_hd__o211a_1
XFILLER_0_25_3 vssd1 vssd1 vccd1 vccd1 sky130_ef_sc_hd__decap_12
X_08694_ _02805_ _02806_ _02674_ vssd1 vssd1 vccd1 vccd1 _02809_ sky130_fd_sc_hd__o21ai_1
XFILLER_0_79_135 vssd1 vssd1 vccd1 vccd1 sky130_ef_sc_hd__decap_12
XFILLER_0_95_617 vssd1 vssd1 vccd1 vccd1 sky130_ef_sc_hd__decap_12
X_07645_ net1121 net798 net788 net1129 vssd1 vssd1 vccd1 vccd1 _01768_ sky130_fd_sc_hd__a22o_1
XFILLER_0_94_138 vssd1 vssd1 vccd1 vccd1 sky130_fd_sc_hd__fill_2
X_07576_ _01365_ _01367_ _01698_ vssd1 vssd1 vccd1 vccd1 _01700_ sky130_fd_sc_hd__and3_1
XFILLER_0_118_421 vssd1 vssd1 vccd1 vccd1 sky130_ef_sc_hd__decap_12
X_09315_ net1108 net720 net716 net1116 vssd1 vssd1 vccd1 vccd1 _03425_ sky130_fd_sc_hd__a22oi_1
XFILLER_0_75_374 vssd1 vssd1 vccd1 vccd1 sky130_fd_sc_hd__decap_6
XFILLER_0_63_503 vssd1 vssd1 vccd1 vccd1 sky130_fd_sc_hd__fill_1
X_06527_ _00653_ _00785_ vssd1 vssd1 vccd1 vccd1 _00786_ sky130_fd_sc_hd__xnor2_4
XFILLER_0_90_300 vssd1 vssd1 vccd1 vccd1 sky130_fd_sc_hd__fill_1
X_09246_ _03342_ _03355_ _03356_ vssd1 vssd1 vccd1 vccd1 _03357_ sky130_fd_sc_hd__and3_2
X_06458_ add1.a_i\[27\] add1.b_i\[27\] vssd1 vssd1 vccd1 vccd1 _00756_ sky130_fd_sc_hd__nand2_1
XFILLER_0_16_430 vssd1 vssd1 vccd1 vccd1 sky130_fd_sc_hd__fill_1
X_09177_ _03286_ _03287_ vssd1 vssd1 vccd1 vccd1 _03288_ sky130_fd_sc_hd__xor2_1
XFILLER_0_105_137 vssd1 vssd1 vccd1 vccd1 sky130_ef_sc_hd__decap_12
X_06389_ _00694_ _00696_ vssd1 vssd1 vccd1 vccd1 _00697_ sky130_fd_sc_hd__nand2_2
X_08128_ net921 net913 net979 net973 vssd1 vssd1 vccd1 vccd1 _02247_ sky130_fd_sc_hd__nand4_1
XFILLER_0_114_693 vssd1 vssd1 vccd1 vccd1 sky130_fd_sc_hd__decap_6
XFILLER_0_113_181 vssd1 vssd1 vccd1 vccd1 sky130_ef_sc_hd__decap_12
X_08059_ net1139 net1147 net748 net740 vssd1 vssd1 vccd1 vccd1 _02178_ sky130_fd_sc_hd__and4_1
X_11070_ _05167_ _05168_ vssd1 vssd1 vccd1 vccd1 _05169_ sky130_fd_sc_hd__and2_1
X_10021_ net1028 net760 _04122_ _04124_ vssd1 vssd1 vccd1 vccd1 _04127_ sky130_fd_sc_hd__a22o_1
Xinput102 v0y[20] vssd1 vssd1 vccd1 vccd1 net102 sky130_fd_sc_hd__buf_1
Xinput124 v1x[11] vssd1 vssd1 vccd1 vccd1 net124 sky130_fd_sc_hd__buf_1
Xinput113 v0y[30] vssd1 vssd1 vccd1 vccd1 net113 sky130_fd_sc_hd__buf_1
Xinput135 v1x[21] vssd1 vssd1 vccd1 vccd1 net135 sky130_fd_sc_hd__buf_1
Xinput157 v1y[12] vssd1 vssd1 vccd1 vccd1 net157 sky130_fd_sc_hd__clkbuf_1
Xinput168 v1y[22] vssd1 vssd1 vccd1 vccd1 net168 sky130_fd_sc_hd__buf_1
Xinput146 v1x[31] vssd1 vssd1 vccd1 vccd1 net146 sky130_fd_sc_hd__buf_1
Xinput179 v1y[3] vssd1 vssd1 vccd1 vccd1 net179 sky130_fd_sc_hd__clkbuf_1
X_11972_ net130 net660 net504 net226 _05983_ vssd1 vssd1 vccd1 vccd1 _05984_ sky130_fd_sc_hd__a221o_1
X_10923_ _05020_ _05021_ _04854_ net1751 vssd1 vssd1 vccd1 vccd1 _05023_ sky130_fd_sc_hd__a211oi_1
XFILLER_0_66_330 vssd1 vssd1 vccd1 vccd1 sky130_fd_sc_hd__decap_8
X_10854_ _04428_ _04823_ _04824_ vssd1 vssd1 vccd1 vccd1 _04954_ sky130_fd_sc_hd__and3_2
XFILLER_0_94_672 vssd1 vssd1 vccd1 vccd1 sky130_fd_sc_hd__decap_4
XPHY_152 vssd1 vssd1 vccd1 vccd1 sky130_fd_sc_hd__decap_3
XPHY_141 vssd1 vssd1 vccd1 vccd1 sky130_fd_sc_hd__decap_3
XPHY_130 vssd1 vssd1 vccd1 vccd1 sky130_fd_sc_hd__decap_3
X_12524_ net1238 net564 vssd1 vssd1 vccd1 vccd1 _06259_ sky130_fd_sc_hd__nand2_1
XPHY_185 vssd1 vssd1 vccd1 vccd1 sky130_fd_sc_hd__decap_3
XPHY_174 vssd1 vssd1 vccd1 vccd1 sky130_fd_sc_hd__decap_3
XPHY_163 vssd1 vssd1 vccd1 vccd1 sky130_fd_sc_hd__decap_3
X_10785_ _04885_ vssd1 vssd1 vccd1 vccd1 _04886_ sky130_fd_sc_hd__inv_2
XFILLER_0_26_205 vssd1 vssd1 vccd1 vccd1 sky130_fd_sc_hd__fill_2
XFILLER_0_27_739 vssd1 vssd1 vccd1 vccd1 sky130_fd_sc_hd__fill_1
XFILLER_0_124_413 vssd1 vssd1 vccd1 vccd1 sky130_fd_sc_hd__decap_6
XPHY_196 vssd1 vssd1 vccd1 vccd1 sky130_fd_sc_hd__decap_3
XFILLER_0_124_457 vssd1 vssd1 vccd1 vccd1 sky130_ef_sc_hd__decap_12
X_12455_ net52 net688 _00913_ net615 vssd1 vssd1 vccd1 vccd1 _06222_ sky130_fd_sc_hd__a22o_1
XFILLER_0_105_671 vssd1 vssd1 vccd1 vccd1 sky130_fd_sc_hd__fill_1
X_12386_ net1505 _00855_ net682 vssd1 vssd1 vccd1 vccd1 _00438_ sky130_fd_sc_hd__mux2_1
X_11406_ _05463_ _05499_ _05500_ vssd1 vssd1 vccd1 vccd1 _05502_ sky130_fd_sc_hd__or3_1
XFILLER_0_105_693 vssd1 vssd1 vccd1 vccd1 sky130_fd_sc_hd__decap_8
XFILLER_0_104_170 vssd1 vssd1 vccd1 vccd1 sky130_ef_sc_hd__decap_12
X_11337_ _05265_ _05307_ _05432_ _05433_ vssd1 vssd1 vccd1 vccd1 _05434_ sky130_fd_sc_hd__a211o_2
XFILLER_0_22_477 vssd1 vssd1 vccd1 vccd1 sky130_fd_sc_hd__fill_2
XFILLER_0_94_27 vssd1 vssd1 vccd1 vccd1 sky130_fd_sc_hd__fill_1
X_11268_ _05363_ _05364_ vssd1 vssd1 vccd1 vccd1 _05365_ sky130_fd_sc_hd__and2b_1
X_10219_ _04318_ _04322_ _04323_ vssd1 vssd1 vccd1 vccd1 _04324_ sky130_fd_sc_hd__nand3_1
X_13007_ clknet_leaf_25_clk_i _00393_ net1172 vssd1 vssd1 vccd1 vccd1 x2mx1\[28\]
+ sky130_fd_sc_hd__dfrtp_1
X_11199_ _05294_ _05295_ _05167_ _05170_ vssd1 vssd1 vccd1 vccd1 _05297_ sky130_fd_sc_hd__o211a_1
XFILLER_0_27_21 vssd1 vssd1 vccd1 vccd1 sky130_ef_sc_hd__decap_12
XFILLER_0_89_444 vssd1 vssd1 vccd1 vccd1 sky130_fd_sc_hd__decap_4
XFILLER_0_77_617 vssd1 vssd1 vccd1 vccd1 sky130_fd_sc_hd__decap_8
XFILLER_0_43_31 vssd1 vssd1 vccd1 vccd1 sky130_fd_sc_hd__decap_3
X_07430_ _01521_ _01527_ _01526_ vssd1 vssd1 vccd1 vccd1 _01555_ sky130_fd_sc_hd__a21o_1
XFILLER_0_9_449 vssd1 vssd1 vccd1 vccd1 sky130_fd_sc_hd__fill_1
X_07361_ _01483_ _01484_ vssd1 vssd1 vccd1 vccd1 _01486_ sky130_fd_sc_hd__xor2_1
XFILLER_0_128_763 vssd1 vssd1 vccd1 vccd1 sky130_fd_sc_hd__decap_3
X_09100_ net877 net869 net974 net968 vssd1 vssd1 vccd1 vccd1 _03212_ sky130_fd_sc_hd__nand4_1
X_06312_ add1.a_i\[11\] add1.b_i\[11\] vssd1 vssd1 vccd1 vccd1 _00624_ sky130_fd_sc_hd__nand2_1
XFILLER_0_128_785 vssd1 vssd1 vccd1 vccd1 sky130_ef_sc_hd__decap_12
X_09031_ _03142_ vssd1 vssd1 vccd1 vccd1 _03143_ sky130_fd_sc_hd__inv_2
X_07292_ net895 net1095 net1104 net887 vssd1 vssd1 vccd1 vccd1 _01417_ sky130_fd_sc_hd__a22oi_1
Xhold301 net430 vssd1 vssd1 vccd1 vccd1 net1516 sky130_fd_sc_hd__dlygate4sd3_1
Xhold312 net393 vssd1 vssd1 vccd1 vccd1 net1527 sky130_fd_sc_hd__dlygate4sd3_1
XFILLER_0_7_53 vssd1 vssd1 vccd1 vccd1 sky130_fd_sc_hd__decap_3
Xhold334 y2my0\[15\] vssd1 vssd1 vccd1 vccd1 net1549 sky130_fd_sc_hd__dlygate4sd3_1
Xhold323 net380 vssd1 vssd1 vccd1 vccd1 net1538 sky130_fd_sc_hd__dlygate4sd3_1
XFILLER_0_111_641 vssd1 vssd1 vccd1 vccd1 sky130_ef_sc_hd__decap_12
Xhold356 net339 vssd1 vssd1 vccd1 vccd1 net1571 sky130_fd_sc_hd__dlygate4sd3_1
Xhold367 l0\[8\] vssd1 vssd1 vccd1 vccd1 net1582 sky130_fd_sc_hd__dlygate4sd3_1
Xhold345 net417 vssd1 vssd1 vccd1 vccd1 net1560 sky130_fd_sc_hd__dlygate4sd3_1
XFILLER_0_13_499 vssd1 vssd1 vccd1 vccd1 sky130_fd_sc_hd__decap_4
Xhold378 y2my0\[24\] vssd1 vssd1 vccd1 vccd1 net1593 sky130_fd_sc_hd__dlygate4sd3_1
XFILLER_0_111_685 vssd1 vssd1 vccd1 vccd1 sky130_ef_sc_hd__decap_12
Xfanout803 net804 vssd1 vssd1 vccd1 vccd1 net803 sky130_fd_sc_hd__clkbuf_4
Xfanout825 net827 vssd1 vssd1 vccd1 vccd1 net825 sky130_fd_sc_hd__buf_2
X_09933_ _03864_ _03878_ _03877_ vssd1 vssd1 vccd1 vccd1 _04040_ sky130_fd_sc_hd__o21ai_4
XFILLER_0_68_83 vssd1 vssd1 vccd1 vccd1 sky130_fd_sc_hd__fill_1
Xfanout814 net815 vssd1 vssd1 vccd1 vccd1 net814 sky130_fd_sc_hd__buf_2
Xhold389 add1.a_i\[3\] vssd1 vssd1 vccd1 vccd1 net1604 sky130_fd_sc_hd__dlygate4sd3_1
XFILLER_0_110_195 vssd1 vssd1 vccd1 vccd1 sky130_fd_sc_hd__fill_1
X_09864_ net809 net998 _03836_ _03675_ net985 vssd1 vssd1 vccd1 vccd1 _03971_ sky130_fd_sc_hd__a32o_1
XTAP_650 vssd1 vccd1 sky130_fd_sc_hd__tapvpwrvgnd_1
XTAP_661 vssd1 vccd1 sky130_fd_sc_hd__tapvpwrvgnd_1
Xfanout847 mul1.b\[9\] vssd1 vssd1 vccd1 vccd1 net847 sky130_fd_sc_hd__buf_2
Xfanout858 mul1.b\[8\] vssd1 vssd1 vccd1 vccd1 net858 sky130_fd_sc_hd__buf_2
Xfanout836 mul1.b\[11\] vssd1 vssd1 vccd1 vccd1 net836 sky130_fd_sc_hd__clkbuf_4
Xfanout869 net870 vssd1 vssd1 vccd1 vccd1 net869 sky130_fd_sc_hd__buf_2
X_08815_ _02926_ _02927_ _02928_ vssd1 vssd1 vccd1 vccd1 _02929_ sky130_fd_sc_hd__nand3_1
XTAP_683 vssd1 vccd1 sky130_fd_sc_hd__tapvpwrvgnd_1
XTAP_672 vssd1 vccd1 sky130_fd_sc_hd__tapvpwrvgnd_1
XTAP_694 vssd1 vccd1 sky130_fd_sc_hd__tapvpwrvgnd_1
X_09795_ _03900_ _03902_ vssd1 vssd1 vccd1 vccd1 _03903_ sky130_fd_sc_hd__nand2_1
XFILLER_0_84_82 vssd1 vssd1 vccd1 vccd1 sky130_fd_sc_hd__fill_2
X_08746_ _02858_ _02859_ vssd1 vssd1 vccd1 vccd1 _02860_ sky130_fd_sc_hd__nand2_1
XTAP_1816 vssd1 vccd1 sky130_fd_sc_hd__tapvpwrvgnd_1
XTAP_1805 vssd1 vccd1 sky130_fd_sc_hd__tapvpwrvgnd_1
X_08677_ _02754_ _02755_ _02789_ _02790_ vssd1 vssd1 vccd1 vccd1 _02792_ sky130_fd_sc_hd__nor4_1
XTAP_1849 vssd1 vccd1 sky130_fd_sc_hd__tapvpwrvgnd_1
XTAP_1838 vssd1 vccd1 sky130_fd_sc_hd__tapvpwrvgnd_1
XTAP_1827 vssd1 vccd1 sky130_fd_sc_hd__tapvpwrvgnd_1
X_07628_ _01398_ _01401_ _01750_ _01751_ vssd1 vssd1 vccd1 vccd1 _01752_ sky130_fd_sc_hd__o211a_1
XFILLER_0_82_108 vssd1 vssd1 vccd1 vccd1 sky130_fd_sc_hd__decap_8
XFILLER_0_76_661 vssd1 vssd1 vccd1 vccd1 sky130_fd_sc_hd__decap_6
XFILLER_0_48_363 vssd1 vssd1 vccd1 vccd1 sky130_fd_sc_hd__fill_1
XFILLER_0_119_741 vssd1 vssd1 vccd1 vccd1 sky130_ef_sc_hd__decap_12
XFILLER_0_75_160 vssd1 vssd1 vccd1 vccd1 sky130_fd_sc_hd__fill_1
X_07559_ net1121 net806 vssd1 vssd1 vccd1 vccd1 _01683_ sky130_fd_sc_hd__nand2_1
XFILLER_0_48_396 vssd1 vssd1 vccd1 vccd1 sky130_fd_sc_hd__decap_3
XFILLER_0_119_785 vssd1 vssd1 vccd1 vccd1 sky130_fd_sc_hd__decap_8
XFILLER_0_118_251 vssd1 vssd1 vccd1 vccd1 sky130_fd_sc_hd__fill_1
XFILLER_0_90_141 vssd1 vssd1 vccd1 vccd1 sky130_ef_sc_hd__decap_12
X_10570_ net1692 _04672_ net525 vssd1 vssd1 vccd1 vccd1 _00145_ sky130_fd_sc_hd__mux2_1
XFILLER_0_36_558 vssd1 vssd1 vccd1 vccd1 sky130_fd_sc_hd__decap_8
X_09229_ _03180_ _03183_ _03337_ _03338_ vssd1 vssd1 vccd1 vccd1 _03340_ sky130_fd_sc_hd__o211a_1
XFILLER_0_16_260 vssd1 vssd1 vccd1 vccd1 sky130_fd_sc_hd__fill_1
XFILLER_0_17_783 vssd1 vssd1 vccd1 vccd1 sky130_fd_sc_hd__fill_1
XFILLER_0_121_405 vssd1 vssd1 vccd1 vccd1 sky130_ef_sc_hd__decap_12
X_12240_ x2mx1\[25\] net605 net587 temp1\[25\] vssd1 vssd1 vccd1 vccd1 _06180_ sky130_fd_sc_hd__a22o_1
XFILLER_0_121_449 vssd1 vssd1 vccd1 vccd1 sky130_ef_sc_hd__decap_12
X_12171_ x2mx1\[2\] net602 net585 temp1\[2\] vssd1 vssd1 vccd1 vccd1 _06134_ sky130_fd_sc_hd__a22o_1
XFILLER_0_101_173 vssd1 vssd1 vccd1 vccd1 sky130_ef_sc_hd__decap_12
X_11122_ _04958_ _05219_ vssd1 vssd1 vccd1 vccd1 _05220_ sky130_fd_sc_hd__nor2_1
X_11053_ net1064 net698 net696 net1055 vssd1 vssd1 vccd1 vccd1 _05152_ sky130_fd_sc_hd__and4b_1
Xclkbuf_leaf_54_clk_i clknet_3_0__leaf_clk_i vssd1 vssd1 vccd1 vccd1 clknet_leaf_54_clk_i
+ sky130_fd_sc_hd__clkbuf_16
X_10004_ _04107_ _04108_ vssd1 vssd1 vccd1 vccd1 _04110_ sky130_fd_sc_hd__xnor2_4
X_11955_ net6 net550 net625 net190 _05970_ vssd1 vssd1 vccd1 vccd1 _05971_ sky130_fd_sc_hd__a221o_1
XFILLER_0_129_505 vssd1 vssd1 vccd1 vccd1 sky130_fd_sc_hd__fill_2
XFILLER_0_80_29 vssd1 vssd1 vccd1 vccd1 sky130_ef_sc_hd__decap_12
XFILLER_0_58_127 vssd1 vssd1 vccd1 vccd1 sky130_fd_sc_hd__fill_1
X_10906_ _05004_ _05005_ vssd1 vssd1 vccd1 vccd1 _05006_ sky130_fd_sc_hd__or2_1
XFILLER_0_129_538 vssd1 vssd1 vccd1 vccd1 sky130_ef_sc_hd__decap_12
X_11886_ net653 _00965_ net476 _05917_ vssd1 vssd1 vccd1 vccd1 _05918_ sky130_fd_sc_hd__a211o_1
X_10837_ _04893_ _04894_ _04936_ _04937_ vssd1 vssd1 vccd1 vccd1 _04938_ sky130_fd_sc_hd__nand4_4
X_10768_ _04860_ _04868_ vssd1 vssd1 vccd1 vccd1 _04869_ sky130_fd_sc_hd__or2_1
XFILLER_0_6_419 vssd1 vssd1 vccd1 vccd1 sky130_fd_sc_hd__fill_1
XFILLER_0_13_89 vssd1 vssd1 vccd1 vccd1 sky130_fd_sc_hd__fill_1
X_12507_ net1234 net566 _06250_ vssd1 vssd1 vccd1 vccd1 _00504_ sky130_fd_sc_hd__a21o_1
XFILLER_0_124_221 vssd1 vssd1 vccd1 vccd1 sky130_fd_sc_hd__fill_2
XFILLER_0_89_27 vssd1 vssd1 vccd1 vccd1 sky130_ef_sc_hd__decap_12
XFILLER_0_81_152 vssd1 vssd1 vccd1 vccd1 sky130_fd_sc_hd__decap_8
XFILLER_0_42_506 vssd1 vssd1 vccd1 vccd1 sky130_fd_sc_hd__decap_8
XFILLER_0_125_777 vssd1 vssd1 vccd1 vccd1 sky130_fd_sc_hd__decap_6
X_10699_ _04798_ _04799_ _04800_ vssd1 vssd1 vccd1 vccd1 _04801_ sky130_fd_sc_hd__nor3b_1
X_12438_ temp1\[13\] _06211_ net571 vssd1 vssd1 vccd1 vccd1 _00474_ sky130_fd_sc_hd__mux2_1
XFILLER_0_124_287 vssd1 vssd1 vccd1 vccd1 sky130_fd_sc_hd__fill_2
Xoutput417 net417 vssd1 vssd1 vccd1 vccd1 mstream_o[70] sky130_fd_sc_hd__clkbuf_4
Xoutput406 net406 vssd1 vssd1 vccd1 vccd1 mstream_o[60] sky130_fd_sc_hd__clkbuf_4
Xoutput439 net439 vssd1 vssd1 vccd1 vccd1 mstream_o[90] sky130_fd_sc_hd__clkbuf_4
Xoutput428 net428 vssd1 vssd1 vccd1 vccd1 mstream_o[80] sky130_fd_sc_hd__clkbuf_4
X_12369_ net1417 _00935_ net663 vssd1 vssd1 vccd1 vccd1 _00421_ sky130_fd_sc_hd__mux2_1
XFILLER_0_129_44 vssd1 vssd1 vccd1 vccd1 sky130_fd_sc_hd__decap_6
X_06930_ _01045_ _01054_ vssd1 vssd1 vccd1 vccd1 _01055_ sky130_fd_sc_hd__nor2_1
X_08600_ _02578_ _02580_ vssd1 vssd1 vccd1 vccd1 _02715_ sky130_fd_sc_hd__nand2_1
X_06861_ net1150 net622 vssd1 vssd1 vccd1 vccd1 _00991_ sky130_fd_sc_hd__and2b_1
X_09580_ _03673_ _03687_ _03688_ vssd1 vssd1 vccd1 vccd1 _03689_ sky130_fd_sc_hd__nand3_2
X_06792_ net1391 l1\[31\] net641 vssd1 vssd1 vccd1 vccd1 _00066_ sky130_fd_sc_hd__mux2_1
X_08531_ _02627_ _02644_ _02645_ vssd1 vssd1 vccd1 vccd1 _02647_ sky130_fd_sc_hd__and3_1
X_08462_ net1068 net1076 net797 net787 vssd1 vssd1 vccd1 vccd1 _02578_ sky130_fd_sc_hd__nand4_2
XFILLER_0_54_85 vssd1 vssd1 vccd1 vccd1 sky130_fd_sc_hd__decap_4
XFILLER_0_65_609 vssd1 vssd1 vccd1 vccd1 sky130_fd_sc_hd__decap_3
X_07413_ _01480_ _01514_ _01529_ vssd1 vssd1 vccd1 vccd1 _01538_ sky130_fd_sc_hd__a21oi_1
XFILLER_0_70_40 vssd1 vssd1 vccd1 vccd1 sky130_ef_sc_hd__decap_12
X_08393_ _02508_ _02509_ _02501_ vssd1 vssd1 vccd1 vccd1 _02510_ sky130_fd_sc_hd__a21o_1
XFILLER_0_85_491 vssd1 vssd1 vccd1 vccd1 sky130_fd_sc_hd__decap_4
X_07344_ net904 net1105 vssd1 vssd1 vccd1 vccd1 _01469_ sky130_fd_sc_hd__and2_1
XFILLER_0_72_141 vssd1 vssd1 vccd1 vccd1 sky130_fd_sc_hd__decap_8
X_07275_ _01396_ _01397_ _01256_ _01266_ vssd1 vssd1 vccd1 vccd1 _01400_ sky130_fd_sc_hd__a211o_1
XFILLER_0_116_777 vssd1 vssd1 vccd1 vccd1 sky130_fd_sc_hd__decap_3
X_09014_ _02994_ _02996_ vssd1 vssd1 vccd1 vccd1 _03126_ sky130_fd_sc_hd__or2_1
XFILLER_0_33_539 vssd1 vssd1 vccd1 vccd1 sky130_fd_sc_hd__decap_6
XFILLER_0_103_449 vssd1 vssd1 vccd1 vccd1 sky130_fd_sc_hd__decap_6
XFILLER_0_103_438 vssd1 vssd1 vccd1 vccd1 sky130_fd_sc_hd__decap_8
Xhold142 posx\[8\] vssd1 vssd1 vccd1 vccd1 net1357 sky130_fd_sc_hd__dlygate4sd3_1
Xhold120 net445 vssd1 vssd1 vccd1 vccd1 net1335 sky130_fd_sc_hd__dlygate4sd3_1
Xhold131 add1.b_i\[8\] vssd1 vssd1 vccd1 vccd1 net1346 sky130_fd_sc_hd__dlygate4sd3_1
Xhold153 add1.a_i\[12\] vssd1 vssd1 vccd1 vccd1 net1368 sky130_fd_sc_hd__dlygate4sd3_1
Xhold186 net432 vssd1 vssd1 vccd1 vccd1 net1401 sky130_fd_sc_hd__dlygate4sd3_1
Xhold164 _00071_ vssd1 vssd1 vccd1 vccd1 net1379 sky130_fd_sc_hd__dlygate4sd3_1
Xhold175 _00035_ vssd1 vssd1 vccd1 vccd1 net1390 sky130_fd_sc_hd__dlygate4sd3_1
Xhold197 net440 vssd1 vssd1 vccd1 vccd1 net1412 sky130_fd_sc_hd__dlygate4sd3_1
X_09916_ net924 net916 net907 net927 vssd1 vssd1 vccd1 vccd1 _04023_ sky130_fd_sc_hd__and4_1
Xfanout600 net601 vssd1 vssd1 vccd1 vccd1 net600 sky130_fd_sc_hd__clkbuf_4
Xfanout622 _00990_ vssd1 vssd1 vccd1 vccd1 net622 sky130_fd_sc_hd__clkbuf_4
Xfanout633 net634 vssd1 vssd1 vccd1 vccd1 net633 sky130_fd_sc_hd__clkbuf_4
Xfanout611 net619 vssd1 vssd1 vccd1 vccd1 net611 sky130_fd_sc_hd__clkbuf_4
XFILLER_0_95_81 vssd1 vssd1 vccd1 vccd1 sky130_fd_sc_hd__decap_4
Xfanout644 net650 vssd1 vssd1 vccd1 vccd1 net644 sky130_fd_sc_hd__clkbuf_2
Xfanout666 net667 vssd1 vssd1 vccd1 vccd1 net666 sky130_fd_sc_hd__buf_4
X_09847_ _03823_ _03824_ _03825_ _03829_ vssd1 vssd1 vccd1 vccd1 _03954_ sky130_fd_sc_hd__a31o_2
Xfanout699 net701 vssd1 vssd1 vccd1 vccd1 net699 sky130_fd_sc_hd__buf_2
Xfanout677 _00985_ vssd1 vssd1 vccd1 vccd1 net677 sky130_fd_sc_hd__clkbuf_4
XTAP_491 vssd1 vccd1 sky130_fd_sc_hd__tapvpwrvgnd_1
XTAP_480 vssd1 vccd1 sky130_fd_sc_hd__tapvpwrvgnd_1
Xfanout688 net691 vssd1 vssd1 vccd1 vccd1 net688 sky130_fd_sc_hd__buf_4
X_09778_ _03883_ _03884_ vssd1 vssd1 vccd1 vccd1 _03886_ sky130_fd_sc_hd__xnor2_4
X_08729_ _02840_ _02841_ vssd1 vssd1 vccd1 vccd1 _02843_ sky130_fd_sc_hd__xnor2_1
XFILLER_0_96_701 vssd1 vssd1 vccd1 vccd1 sky130_ef_sc_hd__decap_12
XTAP_1624 vssd1 vccd1 sky130_fd_sc_hd__tapvpwrvgnd_1
XTAP_1613 vssd1 vccd1 sky130_fd_sc_hd__tapvpwrvgnd_1
XTAP_1602 vssd1 vccd1 sky130_fd_sc_hd__tapvpwrvgnd_1
X_11740_ net651 _00840_ net473 net182 _05794_ vssd1 vssd1 vccd1 vccd1 _05795_ sky130_fd_sc_hd__a221o_1
XTAP_1657 vssd1 vccd1 sky130_fd_sc_hd__tapvpwrvgnd_1
XTAP_1646 vssd1 vccd1 sky130_fd_sc_hd__tapvpwrvgnd_1
XTAP_1635 vssd1 vccd1 sky130_fd_sc_hd__tapvpwrvgnd_1
XFILLER_0_83_406 vssd1 vssd1 vccd1 vccd1 sky130_fd_sc_hd__decap_6
XFILLER_0_56_609 vssd1 vssd1 vccd1 vccd1 sky130_fd_sc_hd__fill_2
XTAP_1668 vssd1 vccd1 sky130_fd_sc_hd__tapvpwrvgnd_1
XTAP_1679 vssd1 vccd1 sky130_fd_sc_hd__tapvpwrvgnd_1
X_11671_ net1346 _02542_ net536 vssd1 vssd1 vccd1 vccd1 _00163_ sky130_fd_sc_hd__mux2_1
XFILLER_0_49_694 vssd1 vssd1 vccd1 vccd1 sky130_fd_sc_hd__fill_1
X_10622_ _04714_ _04722_ vssd1 vssd1 vccd1 vccd1 _04724_ sky130_fd_sc_hd__or2_1
XFILLER_0_107_744 vssd1 vssd1 vccd1 vccd1 sky130_fd_sc_hd__decap_8
XFILLER_0_106_221 vssd1 vssd1 vccd1 vccd1 sky130_ef_sc_hd__decap_12
X_10553_ _04653_ _04654_ _04508_ net457 vssd1 vssd1 vccd1 vccd1 _04656_ sky130_fd_sc_hd__a211o_1
XFILLER_0_64_664 vssd1 vssd1 vccd1 vccd1 sky130_ef_sc_hd__decap_12
XFILLER_0_51_314 vssd1 vssd1 vccd1 vccd1 sky130_fd_sc_hd__fill_1
XFILLER_0_122_725 vssd1 vssd1 vccd1 vccd1 sky130_ef_sc_hd__decap_12
XFILLER_0_106_276 vssd1 vssd1 vccd1 vccd1 sky130_ef_sc_hd__decap_12
X_10484_ _04586_ _04585_ _04584_ vssd1 vssd1 vccd1 vccd1 _04587_ sky130_fd_sc_hd__nand3b_2
XFILLER_0_122_769 vssd1 vssd1 vccd1 vccd1 sky130_ef_sc_hd__decap_12
X_12223_ _00908_ net511 net468 y1my2\[19\] _06168_ vssd1 vssd1 vccd1 vccd1 _06169_
+ sky130_fd_sc_hd__a221o_1
XFILLER_0_121_279 vssd1 vssd1 vccd1 vccd1 sky130_fd_sc_hd__fill_1
X_12154_ _00965_ _06121_ net500 vssd1 vssd1 vccd1 vccd1 _06122_ sky130_fd_sc_hd__mux2_1
X_11105_ _05201_ _05203_ vssd1 vssd1 vccd1 vccd1 _05204_ sky130_fd_sc_hd__nand2_1
X_12085_ y2my0\[12\] net583 net532 x2mx1\[12\] _06069_ vssd1 vssd1 vccd1 vccd1 _06070_
+ sky130_fd_sc_hd__a221o_1
X_11036_ _05133_ _05134_ _05011_ _05014_ vssd1 vssd1 vccd1 vccd1 _05135_ sky130_fd_sc_hd__o211a_1
XFILLER_0_91_39 vssd1 vssd1 vccd1 vccd1 sky130_ef_sc_hd__decap_12
XFILLER_0_86_211 vssd1 vssd1 vccd1 vccd1 sky130_ef_sc_hd__decap_12
X_12987_ clknet_leaf_44_clk_i _00373_ net1156 vssd1 vssd1 vccd1 vccd1 x2mx1\[8\] sky130_fd_sc_hd__dfrtp_1
XFILLER_0_115_57 vssd1 vssd1 vccd1 vccd1 sky130_ef_sc_hd__decap_12
X_11938_ net121 net620 net594 net89 vssd1 vssd1 vccd1 vccd1 _05958_ sky130_fd_sc_hd__a22o_1
XFILLER_0_74_417 vssd1 vssd1 vccd1 vccd1 sky130_fd_sc_hd__decap_3
X_11869_ net172 net471 _05903_ vssd1 vssd1 vccd1 vccd1 _05904_ sky130_fd_sc_hd__o21a_1
XFILLER_0_55_653 vssd1 vssd1 vccd1 vccd1 sky130_fd_sc_hd__fill_1
XFILLER_0_55_631 vssd1 vssd1 vccd1 vccd1 sky130_fd_sc_hd__decap_4
XFILLER_0_125_541 vssd1 vssd1 vccd1 vccd1 sky130_ef_sc_hd__decap_12
XFILLER_0_43_837 vssd1 vssd1 vccd1 vccd1 sky130_fd_sc_hd__decap_3
XFILLER_0_27_366 vssd1 vssd1 vccd1 vccd1 sky130_fd_sc_hd__decap_4
X_07060_ net1127 _01016_ vssd1 vssd1 vccd1 vccd1 _01185_ sky130_fd_sc_hd__nand2_1
XFILLER_0_125_585 vssd1 vssd1 vccd1 vccd1 sky130_ef_sc_hd__decap_12
XFILLER_0_23_561 vssd1 vssd1 vccd1 vccd1 sky130_ef_sc_hd__decap_12
Xoutput258 net258 vssd1 vssd1 vccd1 vccd1 div_mstream_o[15] sky130_fd_sc_hd__clkbuf_4
XFILLER_0_64_7 vssd1 vssd1 vccd1 vccd1 sky130_fd_sc_hd__fill_1
Xoutput269 net269 vssd1 vssd1 vccd1 vccd1 div_mstream_o[25] sky130_fd_sc_hd__clkbuf_4
X_09701_ net1046 net759 _03804_ _03806_ vssd1 vssd1 vccd1 vccd1 _03809_ sky130_fd_sc_hd__a22o_1
X_07962_ _02080_ _02081_ vssd1 vssd1 vccd1 vccd1 _02082_ sky130_fd_sc_hd__xnor2_1
X_07893_ _02007_ _02012_ vssd1 vssd1 vccd1 vccd1 _02014_ sky130_fd_sc_hd__xnor2_2
XFILLER_0_65_51 vssd1 vssd1 vccd1 vccd1 sky130_fd_sc_hd__fill_2
XFILLER_0_4_65 vssd1 vssd1 vccd1 vccd1 sky130_fd_sc_hd__decap_6
X_06913_ net846 net837 net1112 net1118 vssd1 vssd1 vccd1 vccd1 _01038_ sky130_fd_sc_hd__and4_1
X_09632_ _03568_ _03570_ _03739_ _03740_ vssd1 vssd1 vccd1 vccd1 _03741_ sky130_fd_sc_hd__o211a_1
X_06844_ _00607_ _00800_ _00597_ vssd1 vssd1 vccd1 vccd1 _00975_ sky130_fd_sc_hd__o21ai_1
X_09563_ _03517_ _03520_ vssd1 vssd1 vccd1 vccd1 _03672_ sky130_fd_sc_hd__nand2_1
XFILLER_0_77_222 vssd1 vssd1 vccd1 vccd1 sky130_fd_sc_hd__fill_2
X_08514_ net903 net894 net979 net973 vssd1 vssd1 vccd1 vccd1 _02630_ sky130_fd_sc_hd__and4_1
X_06775_ net390 net1218 net638 vssd1 vssd1 vccd1 vccd1 _00049_ sky130_fd_sc_hd__mux2_1
X_09494_ _03600_ _03601_ vssd1 vssd1 vccd1 vccd1 _03603_ sky130_fd_sc_hd__xor2_1
XFILLER_0_77_255 vssd1 vssd1 vccd1 vccd1 sky130_fd_sc_hd__fill_2
XFILLER_0_38_609 vssd1 vssd1 vccd1 vccd1 sky130_fd_sc_hd__decap_4
X_08445_ net1114 net748 net740 net1122 vssd1 vssd1 vccd1 vccd1 _02561_ sky130_fd_sc_hd__a22oi_2
XFILLER_0_77_288 vssd1 vssd1 vccd1 vccd1 sky130_fd_sc_hd__decap_8
X_08376_ _02490_ _02491_ _02487_ vssd1 vssd1 vccd1 vccd1 _02493_ sky130_fd_sc_hd__a21o_1
XFILLER_0_46_653 vssd1 vssd1 vccd1 vccd1 sky130_fd_sc_hd__decap_4
XFILLER_0_45_130 vssd1 vssd1 vccd1 vccd1 sky130_fd_sc_hd__fill_1
XFILLER_0_46_686 vssd1 vssd1 vccd1 vccd1 sky130_fd_sc_hd__fill_1
X_07327_ _01316_ _01318_ vssd1 vssd1 vccd1 vccd1 _01452_ sky130_fd_sc_hd__xor2_1
XFILLER_0_61_656 vssd1 vssd1 vccd1 vccd1 sky130_fd_sc_hd__decap_8
XFILLER_0_60_144 vssd1 vssd1 vccd1 vccd1 sky130_fd_sc_hd__decap_8
X_07258_ _01373_ _01380_ _01381_ vssd1 vssd1 vccd1 vccd1 _01383_ sky130_fd_sc_hd__nand3_1
XFILLER_0_5_271 vssd1 vssd1 vccd1 vccd1 sky130_fd_sc_hd__fill_2
X_07189_ _01312_ _01313_ vssd1 vssd1 vccd1 vccd1 _01314_ sky130_fd_sc_hd__and2_1
XFILLER_0_103_279 vssd1 vssd1 vccd1 vccd1 sky130_fd_sc_hd__fill_1
Xfanout474 _05765_ vssd1 vssd1 vccd1 vccd1 net474 sky130_fd_sc_hd__clkbuf_2
Xfanout485 _05758_ vssd1 vssd1 vccd1 vccd1 net485 sky130_fd_sc_hd__clkbuf_4
X_12910_ clknet_leaf_42_clk_i _00296_ vssd1 vssd1 vccd1 vccd1 mul1.b\[13\] sky130_fd_sc_hd__dfxtp_4
XTAP_2100 vssd1 vccd1 sky130_fd_sc_hd__tapvpwrvgnd_1
XFILLER_0_88_509 vssd1 vssd1 vccd1 vccd1 sky130_fd_sc_hd__fill_1
X_12841_ clknet_leaf_54_clk_i _00227_ vssd1 vssd1 vccd1 vccd1 sub1.b_i\[8\] sky130_fd_sc_hd__dfxtp_1
XTAP_2144 vssd1 vccd1 sky130_fd_sc_hd__tapvpwrvgnd_1
XTAP_2133 vssd1 vccd1 sky130_fd_sc_hd__tapvpwrvgnd_1
XTAP_2122 vssd1 vccd1 sky130_fd_sc_hd__tapvpwrvgnd_1
XTAP_2111 vssd1 vccd1 sky130_fd_sc_hd__tapvpwrvgnd_1
XTAP_2166 vssd1 vccd1 sky130_fd_sc_hd__tapvpwrvgnd_1
XTAP_2177 vssd1 vccd1 sky130_fd_sc_hd__tapvpwrvgnd_1
XTAP_2155 vssd1 vccd1 sky130_fd_sc_hd__tapvpwrvgnd_1
XTAP_1432 vssd1 vccd1 sky130_fd_sc_hd__tapvpwrvgnd_1
XTAP_1421 vssd1 vccd1 sky130_fd_sc_hd__tapvpwrvgnd_1
XTAP_1410 vssd1 vccd1 sky130_fd_sc_hd__tapvpwrvgnd_1
X_12772_ clknet_leaf_0_clk_i _00158_ vssd1 vssd1 vccd1 vccd1 add1.b_i\[3\] sky130_fd_sc_hd__dfxtp_1
XTAP_2199 vssd1 vccd1 sky130_fd_sc_hd__tapvpwrvgnd_1
XTAP_2188 vssd1 vccd1 sky130_fd_sc_hd__tapvpwrvgnd_1
XFILLER_0_84_737 vssd1 vssd1 vccd1 vccd1 sky130_fd_sc_hd__decap_8
XTAP_1465 vssd1 vccd1 sky130_fd_sc_hd__tapvpwrvgnd_1
XTAP_1454 vssd1 vccd1 sky130_fd_sc_hd__tapvpwrvgnd_1
XTAP_1443 vssd1 vccd1 sky130_fd_sc_hd__tapvpwrvgnd_1
X_11723_ net243 net598 net578 net147 _05780_ vssd1 vssd1 vccd1 vccd1 _05781_ sky130_fd_sc_hd__a221o_1
XFILLER_0_127_839 vssd1 vssd1 vccd1 vccd1 sky130_fd_sc_hd__fill_1
XFILLER_0_83_236 vssd1 vssd1 vccd1 vccd1 sky130_fd_sc_hd__fill_1
XTAP_1498 vssd1 vccd1 sky130_fd_sc_hd__tapvpwrvgnd_1
XTAP_1476 vssd1 vccd1 sky130_fd_sc_hd__tapvpwrvgnd_1
XTAP_1487 vssd1 vccd1 sky130_fd_sc_hd__tapvpwrvgnd_1
X_11654_ _05724_ _05747_ vssd1 vssd1 vccd1 vccd1 _05748_ sky130_fd_sc_hd__xnor2_1
X_10605_ _04704_ _04705_ _04706_ vssd1 vssd1 vccd1 vccd1 _04707_ sky130_fd_sc_hd__nand3_4
XFILLER_0_64_472 vssd1 vssd1 vccd1 vccd1 sky130_fd_sc_hd__decap_4
XFILLER_0_101_15 vssd1 vssd1 vccd1 vccd1 sky130_ef_sc_hd__decap_12
XFILLER_0_52_645 vssd1 vssd1 vccd1 vccd1 sky130_fd_sc_hd__decap_3
XFILLER_0_52_634 vssd1 vssd1 vccd1 vccd1 sky130_fd_sc_hd__fill_1
XFILLER_0_51_100 vssd1 vssd1 vccd1 vccd1 sky130_fd_sc_hd__decap_3
X_11585_ net978 net722 vssd1 vssd1 vccd1 vccd1 _05679_ sky130_fd_sc_hd__nand2_1
XFILLER_0_122_533 vssd1 vssd1 vccd1 vccd1 sky130_ef_sc_hd__decap_12
XFILLER_0_107_574 vssd1 vssd1 vccd1 vccd1 sky130_ef_sc_hd__decap_12
X_10536_ _04629_ _04636_ _04637_ vssd1 vssd1 vccd1 vccd1 _04639_ sky130_fd_sc_hd__nand3_2
X_10467_ net1029 net737 vssd1 vssd1 vccd1 vccd1 _04570_ sky130_fd_sc_hd__nand2_1
X_12206_ net819 _06157_ net515 vssd1 vssd1 vccd1 vccd1 _00296_ sky130_fd_sc_hd__mux2_1
X_10398_ _04348_ _04351_ _04499_ _04501_ vssd1 vssd1 vccd1 vccd1 _04502_ sky130_fd_sc_hd__o211ai_4
X_13186_ clknet_leaf_21_clk_i _00572_ net1180 vssd1 vssd1 vccd1 vccd1 l1\[15\] sky130_fd_sc_hd__dfrtp_1
X_12137_ y2my0\[25\] net587 net534 x2mx1\[25\] _06108_ vssd1 vssd1 vccd1 vccd1 _06109_
+ sky130_fd_sc_hd__a221o_1
XFILLER_0_19_55 vssd1 vssd1 vccd1 vccd1 sky130_fd_sc_hd__fill_1
XFILLER_0_20_597 vssd1 vssd1 vccd1 vccd1 sky130_fd_sc_hd__fill_1
X_12068_ x0mx2\[8\] net628 net590 y1my2\[8\] vssd1 vssd1 vccd1 vccd1 _06057_ sky130_fd_sc_hd__a22o_1
X_11019_ _05002_ _05004_ vssd1 vssd1 vccd1 vccd1 _05118_ sky130_fd_sc_hd__or2_1
XFILLER_0_59_211 vssd1 vssd1 vccd1 vccd1 sky130_fd_sc_hd__fill_2
X_06560_ net334 net685 _00615_ vssd1 vssd1 vccd1 vccd1 _00001_ sky130_fd_sc_hd__o21a_1
X_06491_ det_t\[1\] net528 vssd1 vssd1 vccd1 vccd1 net263 sky130_fd_sc_hd__and2_1
XFILLER_0_87_575 vssd1 vssd1 vccd1 vccd1 sky130_fd_sc_hd__fill_1
XFILLER_0_75_726 vssd1 vssd1 vccd1 vccd1 sky130_fd_sc_hd__fill_2
XFILLER_0_59_266 vssd1 vssd1 vccd1 vccd1 sky130_fd_sc_hd__fill_1
XFILLER_0_117_305 vssd1 vssd1 vccd1 vccd1 sky130_ef_sc_hd__decap_12
X_08230_ _02346_ _02347_ _02220_ _02222_ vssd1 vssd1 vccd1 vccd1 _02348_ sky130_fd_sc_hd__a211o_1
XFILLER_0_51_53 vssd1 vssd1 vccd1 vccd1 sky130_fd_sc_hd__decap_3
XFILLER_0_117_349 vssd1 vssd1 vccd1 vccd1 sky130_ef_sc_hd__decap_12
XFILLER_0_27_152 vssd1 vssd1 vccd1 vccd1 sky130_fd_sc_hd__decap_8
XFILLER_0_28_675 vssd1 vssd1 vccd1 vccd1 sky130_fd_sc_hd__fill_1
X_08161_ _02053_ _02162_ _02161_ vssd1 vssd1 vccd1 vccd1 _02280_ sky130_fd_sc_hd__o21a_1
XFILLER_0_43_623 vssd1 vssd1 vccd1 vccd1 sky130_fd_sc_hd__fill_1
X_08092_ net1067 net1075 net814 vssd1 vssd1 vccd1 vccd1 _02211_ sky130_fd_sc_hd__and3_1
X_07112_ net829 net1113 _01234_ _01235_ vssd1 vssd1 vccd1 vccd1 _01237_ sky130_fd_sc_hd__a22o_1
XFILLER_0_31_818 vssd1 vssd1 vccd1 vccd1 sky130_fd_sc_hd__fill_2
XFILLER_0_42_155 vssd1 vssd1 vccd1 vccd1 sky130_fd_sc_hd__decap_4
XFILLER_0_125_393 vssd1 vssd1 vccd1 vccd1 sky130_ef_sc_hd__decap_12
X_07043_ _01161_ _01166_ vssd1 vssd1 vccd1 vccd1 _01168_ sky130_fd_sc_hd__xnor2_2
XFILLER_0_3_797 vssd1 vssd1 vccd1 vccd1 sky130_fd_sc_hd__fill_2
XFILLER_0_2_263 vssd1 vssd1 vccd1 vccd1 sky130_fd_sc_hd__fill_2
XFILLER_0_23_391 vssd1 vssd1 vccd1 vccd1 sky130_fd_sc_hd__fill_1
XFILLER_0_100_238 vssd1 vssd1 vccd1 vccd1 sky130_fd_sc_hd__fill_1
X_08994_ _02812_ _02960_ vssd1 vssd1 vccd1 vccd1 _03107_ sky130_fd_sc_hd__or2_1
XFILLER_0_55_3 vssd1 vssd1 vccd1 vccd1 sky130_ef_sc_hd__decap_12
XFILLER_0_76_83 vssd1 vssd1 vccd1 vccd1 sky130_fd_sc_hd__fill_1
X_07945_ net1123 net772 net763 net1132 vssd1 vssd1 vccd1 vccd1 _02065_ sky130_fd_sc_hd__a22o_1
X_09615_ _03551_ _03555_ _03722_ _03723_ vssd1 vssd1 vccd1 vccd1 _03724_ sky130_fd_sc_hd__a211o_1
X_07876_ _01995_ _01996_ vssd1 vssd1 vccd1 vccd1 _01997_ sky130_fd_sc_hd__and2_1
X_06827_ net1384 net1351 net649 vssd1 vssd1 vccd1 vccd1 _00101_ sky130_fd_sc_hd__mux2_1
X_09546_ net1030 net784 vssd1 vssd1 vccd1 vccd1 _03655_ sky130_fd_sc_hd__nand2_1
X_06758_ sub1.a_i\[31\] sub1.b_i\[31\] vssd1 vssd1 vccd1 vccd1 _00972_ sky130_fd_sc_hd__xor2_2
X_09477_ _03413_ _03416_ vssd1 vssd1 vccd1 vccd1 _03586_ sky130_fd_sc_hd__nor2_1
XFILLER_0_109_839 vssd1 vssd1 vccd1 vccd1 sky130_fd_sc_hd__fill_1
X_08428_ _02415_ _02541_ _02540_ vssd1 vssd1 vccd1 vccd1 _02544_ sky130_fd_sc_hd__o21ai_2
XFILLER_0_19_631 vssd1 vssd1 vccd1 vccd1 sky130_fd_sc_hd__fill_2
X_06689_ net1304 _00913_ net635 vssd1 vssd1 vccd1 vccd1 _00023_ sky130_fd_sc_hd__mux2_1
XFILLER_0_46_450 vssd1 vssd1 vccd1 vccd1 sky130_fd_sc_hd__decap_8
XFILLER_0_18_141 vssd1 vssd1 vccd1 vccd1 sky130_fd_sc_hd__fill_2
XFILLER_0_34_601 vssd1 vssd1 vccd1 vccd1 sky130_ef_sc_hd__decap_12
X_08359_ _02336_ _02337_ _02338_ vssd1 vssd1 vccd1 vccd1 _02476_ sky130_fd_sc_hd__a21bo_1
XFILLER_0_18_185 vssd1 vssd1 vccd1 vccd1 sky130_fd_sc_hd__decap_8
XFILLER_0_34_634 vssd1 vssd1 vccd1 vccd1 sky130_fd_sc_hd__fill_2
XFILLER_0_34_645 vssd1 vssd1 vccd1 vccd1 sky130_fd_sc_hd__decap_4
X_11370_ _05465_ vssd1 vssd1 vccd1 vccd1 _05466_ sky130_fd_sc_hd__inv_2
Xbary_pipe_m_1206 vssd1 vssd1 vccd1 vccd1 bary_pipe_m_1206/HI div_mstream_o[56] sky130_fd_sc_hd__conb_1
X_10321_ _04421_ _04422_ _04305_ _04308_ vssd1 vssd1 vccd1 vccd1 _04425_ sky130_fd_sc_hd__o211a_1
X_13040_ clknet_leaf_25_clk_i _00426_ net1172 vssd1 vssd1 vccd1 vccd1 x0mx2\[29\]
+ sky130_fd_sc_hd__dfrtp_1
X_10252_ _04307_ _04308_ _04355_ _04356_ vssd1 vssd1 vccd1 vccd1 _04357_ sky130_fd_sc_hd__nand4_2
X_10183_ net811 net984 _04156_ _04157_ net970 vssd1 vssd1 vccd1 vccd1 _04288_ sky130_fd_sc_hd__a32o_1
X_12824_ clknet_leaf_34_clk_i _00210_ vssd1 vssd1 vccd1 vccd1 sub1.a_i\[23\] sky130_fd_sc_hd__dfxtp_1
XTAP_1240 vssd1 vccd1 sky130_fd_sc_hd__tapvpwrvgnd_1
X_12755_ clknet_leaf_41_clk_i _00141_ vssd1 vssd1 vccd1 vccd1 add1.a_i\[18\] sky130_fd_sc_hd__dfxtp_1
XTAP_1273 vssd1 vccd1 sky130_fd_sc_hd__tapvpwrvgnd_1
XTAP_1284 vssd1 vccd1 sky130_fd_sc_hd__tapvpwrvgnd_1
XTAP_1262 vssd1 vccd1 sky130_fd_sc_hd__tapvpwrvgnd_1
XTAP_1251 vssd1 vccd1 sky130_fd_sc_hd__tapvpwrvgnd_1
XFILLER_0_56_225 vssd1 vssd1 vccd1 vccd1 sky130_ef_sc_hd__decap_12
X_11706_ net154 net473 _05764_ _05762_ vssd1 vssd1 vccd1 vccd1 _05767_ sky130_fd_sc_hd__a211o_1
XFILLER_0_127_658 vssd1 vssd1 vccd1 vccd1 sky130_ef_sc_hd__decap_12
X_12686_ clknet_leaf_14_clk_i _00072_ net1184 vssd1 vssd1 vccd1 vccd1 net415 sky130_fd_sc_hd__dfrtp_1
XTAP_1295 vssd1 vccd1 sky130_fd_sc_hd__tapvpwrvgnd_1
X_11637_ _05727_ _05730_ vssd1 vssd1 vccd1 vccd1 _05731_ sky130_fd_sc_hd__xnor2_1
XFILLER_0_37_494 vssd1 vssd1 vccd1 vccd1 sky130_fd_sc_hd__decap_8
XFILLER_0_13_818 vssd1 vssd1 vccd1 vccd1 sky130_ef_sc_hd__decap_12
X_11568_ _05660_ _05661_ _05662_ vssd1 vssd1 vccd1 vccd1 _05663_ sky130_fd_sc_hd__or3_1
XFILLER_0_107_393 vssd1 vssd1 vccd1 vccd1 sky130_fd_sc_hd__decap_3
XFILLER_0_97_27 vssd1 vssd1 vccd1 vccd1 sky130_ef_sc_hd__decap_12
X_10519_ _04616_ _04620_ vssd1 vssd1 vccd1 vccd1 _04622_ sky130_fd_sc_hd__xnor2_1
XFILLER_0_122_363 vssd1 vssd1 vccd1 vccd1 sky130_fd_sc_hd__fill_1
XFILLER_0_0_701 vssd1 vssd1 vccd1 vccd1 sky130_fd_sc_hd__decap_3
X_11499_ _05592_ _05593_ vssd1 vssd1 vccd1 vccd1 _05594_ sky130_fd_sc_hd__nor2_1
XFILLER_0_110_525 vssd1 vssd1 vccd1 vccd1 sky130_fd_sc_hd__decap_6
XFILLER_0_0_745 vssd1 vssd1 vccd1 vccd1 sky130_fd_sc_hd__fill_1
XFILLER_0_110_569 vssd1 vssd1 vccd1 vccd1 sky130_ef_sc_hd__decap_12
X_13169_ clknet_leaf_9_clk_i _00555_ net1190 vssd1 vssd1 vccd1 vccd1 l0\[30\] sky130_fd_sc_hd__dfstp_1
X_07730_ _01763_ _01852_ vssd1 vssd1 vccd1 vccd1 _01853_ sky130_fd_sc_hd__xor2_2
XFILLER_0_46_64 vssd1 vssd1 vccd1 vccd1 sky130_fd_sc_hd__decap_8
X_07661_ _01329_ _01677_ _01781_ _01782_ vssd1 vssd1 vccd1 vccd1 _01784_ sky130_fd_sc_hd__a22o_1
XFILLER_0_94_309 vssd1 vssd1 vccd1 vccd1 sky130_fd_sc_hd__fill_2
X_09400_ _03506_ _03509_ vssd1 vssd1 vccd1 vccd1 _03510_ sky130_fd_sc_hd__xor2_1
X_07592_ net1032 net1041 net899 net890 vssd1 vssd1 vccd1 vccd1 _01716_ sky130_fd_sc_hd__and4_1
X_06612_ _00847_ _00848_ vssd1 vssd1 vccd1 vccd1 _00849_ sky130_fd_sc_hd__nor2_2
X_09331_ _03439_ _03440_ vssd1 vssd1 vccd1 vccd1 _03441_ sky130_fd_sc_hd__nand2_1
X_06543_ _00632_ _00668_ vssd1 vssd1 vccd1 vccd1 _00795_ sky130_fd_sc_hd__xor2_4
XFILLER_0_62_85 vssd1 vssd1 vccd1 vccd1 sky130_fd_sc_hd__decap_6
XFILLER_0_47_225 vssd1 vssd1 vccd1 vccd1 sky130_fd_sc_hd__fill_2
XFILLER_0_118_625 vssd1 vssd1 vccd1 vccd1 sky130_ef_sc_hd__decap_12
XFILLER_0_117_113 vssd1 vssd1 vccd1 vccd1 sky130_ef_sc_hd__decap_12
XFILLER_0_63_729 vssd1 vssd1 vccd1 vccd1 sky130_fd_sc_hd__fill_1
X_09262_ net901 net892 net949 net944 vssd1 vssd1 vccd1 vccd1 _03373_ sky130_fd_sc_hd__and4_1
X_06474_ _00765_ _00766_ _00767_ vssd1 vssd1 vccd1 vccd1 _00770_ sky130_fd_sc_hd__o21a_2
XFILLER_0_118_669 vssd1 vssd1 vccd1 vccd1 sky130_ef_sc_hd__decap_12
X_09193_ _03301_ _03302_ _03143_ _03147_ vssd1 vssd1 vccd1 vccd1 _03304_ sky130_fd_sc_hd__o211a_1
X_08213_ net1075 net805 vssd1 vssd1 vccd1 vccd1 _02331_ sky130_fd_sc_hd__nand2_1
XFILLER_0_15_111 vssd1 vssd1 vccd1 vccd1 sky130_fd_sc_hd__fill_1
X_08144_ _02226_ _02227_ _02261_ _02262_ vssd1 vssd1 vccd1 vccd1 _02263_ sky130_fd_sc_hd__o22ai_4
XFILLER_0_70_272 vssd1 vssd1 vccd1 vccd1 sky130_fd_sc_hd__decap_3
X_08075_ net796 _02193_ _02192_ vssd1 vssd1 vccd1 vccd1 _02194_ sky130_fd_sc_hd__a21oi_1
XFILLER_0_113_385 vssd1 vssd1 vccd1 vccd1 sky130_fd_sc_hd__decap_6
XFILLER_0_30_147 vssd1 vssd1 vccd1 vccd1 sky130_fd_sc_hd__fill_1
X_07026_ net897 net1057 net1065 net888 vssd1 vssd1 vccd1 vccd1 _01151_ sky130_fd_sc_hd__a22oi_1
Xhold13 det_t\[24\] vssd1 vssd1 vccd1 vccd1 net1228 sky130_fd_sc_hd__dlygate4sd3_1
Xhold24 det_t\[26\] vssd1 vssd1 vccd1 vccd1 net1239 sky130_fd_sc_hd__dlygate4sd3_1
X_08977_ _03027_ _03028_ _03088_ _03089_ vssd1 vssd1 vccd1 vccd1 _03090_ sky130_fd_sc_hd__nor4_1
Xhold46 _00061_ vssd1 vssd1 vccd1 vccd1 net1261 sky130_fd_sc_hd__dlygate4sd3_1
Xhold35 _00059_ vssd1 vssd1 vccd1 vccd1 net1250 sky130_fd_sc_hd__dlygate4sd3_1
Xhold68 add1.b_i\[9\] vssd1 vssd1 vccd1 vccd1 net1283 sky130_fd_sc_hd__dlygate4sd3_1
X_07928_ _01875_ _01878_ _02047_ _02048_ vssd1 vssd1 vccd1 vccd1 _02049_ sky130_fd_sc_hd__a211o_2
Xhold57 sub1.a_i\[18\] vssd1 vssd1 vccd1 vccd1 net1272 sky130_fd_sc_hd__dlygate4sd3_1
Xhold79 sub1.b_i\[13\] vssd1 vssd1 vccd1 vccd1 net1294 sky130_fd_sc_hd__dlygate4sd3_1
XFILLER_0_97_125 vssd1 vssd1 vccd1 vccd1 sky130_fd_sc_hd__decap_8
X_07859_ _01965_ _01978_ vssd1 vssd1 vccd1 vccd1 _01980_ sky130_fd_sc_hd__xnor2_1
X_10870_ _04836_ _04969_ vssd1 vssd1 vccd1 vccd1 _04970_ sky130_fd_sc_hd__and2b_1
X_09529_ _03636_ _03637_ vssd1 vssd1 vccd1 vccd1 _03638_ sky130_fd_sc_hd__nor2_1
XFILLER_0_97_169 vssd1 vssd1 vccd1 vccd1 sky130_ef_sc_hd__decap_12
XFILLER_0_78_394 vssd1 vssd1 vccd1 vccd1 sky130_fd_sc_hd__fill_1
XFILLER_0_66_545 vssd1 vssd1 vccd1 vccd1 sky130_ef_sc_hd__decap_12
X_12540_ _00769_ net565 vssd1 vssd1 vccd1 vccd1 _06267_ sky130_fd_sc_hd__nor2_1
XFILLER_0_93_386 vssd1 vssd1 vccd1 vccd1 sky130_fd_sc_hd__fill_1
X_12471_ temp1\[26\] _06231_ net572 vssd1 vssd1 vccd1 vccd1 _00487_ sky130_fd_sc_hd__mux2_1
XFILLER_0_123_105 vssd1 vssd1 vccd1 vccd1 sky130_fd_sc_hd__decap_6
XFILLER_0_81_559 vssd1 vssd1 vccd1 vccd1 sky130_fd_sc_hd__fill_1
X_11422_ _05514_ _05517_ vssd1 vssd1 vccd1 vccd1 _05518_ sky130_fd_sc_hd__xnor2_1
XFILLER_0_123_149 vssd1 vssd1 vccd1 vccd1 sky130_ef_sc_hd__decap_12
XFILLER_0_104_330 vssd1 vssd1 vccd1 vccd1 sky130_fd_sc_hd__fill_2
XFILLER_0_120_801 vssd1 vssd1 vccd1 vccd1 sky130_fd_sc_hd__decap_3
X_11353_ _05448_ _05449_ vssd1 vssd1 vccd1 vccd1 _05450_ sky130_fd_sc_hd__and2_1
X_10304_ _04404_ _04405_ _04406_ vssd1 vssd1 vccd1 vccd1 _04408_ sky130_fd_sc_hd__a21bo_1
X_11284_ _05378_ _05379_ _05343_ vssd1 vssd1 vccd1 vccd1 _05381_ sky130_fd_sc_hd__o21a_1
XFILLER_0_21_169 vssd1 vssd1 vccd1 vccd1 sky130_fd_sc_hd__decap_4
X_10235_ net851 net841 net953 net947 vssd1 vssd1 vccd1 vccd1 _04340_ sky130_fd_sc_hd__nand4_4
XTAP_309 vssd1 vccd1 sky130_fd_sc_hd__tapvpwrvgnd_1
X_13023_ clknet_leaf_44_clk_i _00409_ net1156 vssd1 vssd1 vccd1 vccd1 x0mx2\[12\]
+ sky130_fd_sc_hd__dfrtp_1
Xfanout1000 net1001 vssd1 vssd1 vccd1 vccd1 net1000 sky130_fd_sc_hd__buf_2
Xfanout1022 net1023 vssd1 vssd1 vccd1 vccd1 net1022 sky130_fd_sc_hd__buf_2
Xfanout1011 net1012 vssd1 vssd1 vccd1 vccd1 net1011 sky130_fd_sc_hd__buf_2
X_10166_ _04226_ _04269_ vssd1 vssd1 vccd1 vccd1 _04271_ sky130_fd_sc_hd__xnor2_4
Xfanout1044 net1048 vssd1 vssd1 vccd1 vccd1 net1044 sky130_fd_sc_hd__buf_2
Xfanout1033 net1034 vssd1 vssd1 vccd1 vccd1 net1033 sky130_fd_sc_hd__buf_2
Xfanout1055 net1056 vssd1 vssd1 vccd1 vccd1 net1055 sky130_fd_sc_hd__buf_4
XFILLER_0_89_615 vssd1 vssd1 vccd1 vccd1 sky130_fd_sc_hd__fill_1
X_10097_ _04201_ _04202_ vssd1 vssd1 vccd1 vccd1 _04203_ sky130_fd_sc_hd__nor2_1
Xfanout1077 mul1.a\[9\] vssd1 vssd1 vccd1 vccd1 net1077 sky130_fd_sc_hd__buf_4
Xfanout1088 net1090 vssd1 vssd1 vccd1 vccd1 net1088 sky130_fd_sc_hd__buf_2
Xfanout1066 net1069 vssd1 vssd1 vccd1 vccd1 net1066 sky130_fd_sc_hd__clkbuf_4
Xfanout1099 net1102 vssd1 vssd1 vccd1 vccd1 net1099 sky130_fd_sc_hd__clkbuf_4
XFILLER_0_88_114 vssd1 vssd1 vccd1 vccd1 sky130_fd_sc_hd__decap_4
XFILLER_0_107_69 vssd1 vssd1 vccd1 vccd1 sky130_ef_sc_hd__decap_12
XFILLER_0_85_810 vssd1 vssd1 vccd1 vccd1 sky130_fd_sc_hd__fill_1
XFILLER_0_69_361 vssd1 vssd1 vccd1 vccd1 sky130_fd_sc_hd__fill_1
X_12807_ clknet_leaf_55_clk_i _00193_ vssd1 vssd1 vccd1 vccd1 sub1.a_i\[6\] sky130_fd_sc_hd__dfxtp_1
XFILLER_0_57_523 vssd1 vssd1 vccd1 vccd1 sky130_fd_sc_hd__decap_4
X_10999_ _04957_ _05097_ vssd1 vssd1 vccd1 vccd1 _05098_ sky130_fd_sc_hd__xnor2_1
XFILLER_0_8_108 vssd1 vssd1 vccd1 vccd1 sky130_fd_sc_hd__fill_2
XFILLER_0_123_57 vssd1 vssd1 vccd1 vccd1 sky130_ef_sc_hd__decap_12
XFILLER_0_57_578 vssd1 vssd1 vccd1 vccd1 sky130_fd_sc_hd__fill_1
XFILLER_0_57_556 vssd1 vssd1 vccd1 vccd1 sky130_fd_sc_hd__decap_4
XTAP_1092 vssd1 vccd1 sky130_fd_sc_hd__tapvpwrvgnd_1
XTAP_1070 vssd1 vccd1 sky130_fd_sc_hd__tapvpwrvgnd_1
XTAP_1081 vssd1 vccd1 sky130_fd_sc_hd__tapvpwrvgnd_1
X_12738_ clknet_leaf_57_clk_i _00124_ vssd1 vssd1 vccd1 vccd1 add1.a_i\[1\] sky130_fd_sc_hd__dfxtp_1
X_12669_ clknet_leaf_19_clk_i _00055_ net1178 vssd1 vssd1 vccd1 vccd1 net397 sky130_fd_sc_hd__dfrtp_1
XFILLER_0_115_617 vssd1 vssd1 vccd1 vccd1 sky130_ef_sc_hd__decap_12
XFILLER_0_113_3 vssd1 vssd1 vccd1 vccd1 sky130_ef_sc_hd__decap_12
Xhold505 net416 vssd1 vssd1 vccd1 vccd1 net1720 sky130_fd_sc_hd__dlygate4sd3_1
Xhold516 net353 vssd1 vssd1 vccd1 vccd1 net1731 sky130_fd_sc_hd__dlygate4sd3_1
X_08900_ net1044 net1052 net793 vssd1 vssd1 vccd1 vccd1 _03013_ sky130_fd_sc_hd__and3_1
X_09880_ _03984_ _03985_ _03850_ _03853_ vssd1 vssd1 vccd1 vccd1 _03987_ sky130_fd_sc_hd__o211a_1
XTAP_810 vssd1 vccd1 sky130_fd_sc_hd__tapvpwrvgnd_1
XFILLER_0_110_377 vssd1 vssd1 vccd1 vccd1 sky130_ef_sc_hd__decap_12
X_08831_ _02941_ _02943_ _02789_ net491 vssd1 vssd1 vccd1 vccd1 _02945_ sky130_fd_sc_hd__a211oi_2
XFILLER_0_20_180 vssd1 vssd1 vccd1 vccd1 sky130_ef_sc_hd__decap_12
XTAP_821 vssd1 vccd1 sky130_fd_sc_hd__tapvpwrvgnd_1
XTAP_832 vssd1 vccd1 sky130_fd_sc_hd__tapvpwrvgnd_1
XTAP_843 vssd1 vccd1 sky130_fd_sc_hd__tapvpwrvgnd_1
XTAP_854 vssd1 vccd1 sky130_fd_sc_hd__tapvpwrvgnd_1
XTAP_865 vssd1 vccd1 sky130_fd_sc_hd__tapvpwrvgnd_1
XTAP_876 vssd1 vccd1 sky130_fd_sc_hd__tapvpwrvgnd_1
X_08762_ _02867_ _02875_ vssd1 vssd1 vccd1 vccd1 _02876_ sky130_fd_sc_hd__xnor2_1
XTAP_887 vssd1 vccd1 sky130_fd_sc_hd__tapvpwrvgnd_1
XTAP_898 vssd1 vccd1 sky130_fd_sc_hd__tapvpwrvgnd_1
X_08693_ _02807_ vssd1 vssd1 vccd1 vccd1 _02808_ sky130_fd_sc_hd__inv_2
X_07713_ _01732_ _01736_ _01833_ _01834_ vssd1 vssd1 vccd1 vccd1 _01836_ sky130_fd_sc_hd__a211oi_4
XFILLER_0_79_147 vssd1 vssd1 vccd1 vccd1 sky130_fd_sc_hd__fill_2
XFILLER_0_73_73 vssd1 vssd1 vccd1 vccd1 sky130_fd_sc_hd__fill_1
X_07644_ net1137 net781 vssd1 vssd1 vccd1 vccd1 _01767_ sky130_fd_sc_hd__nand2_1
XFILLER_0_18_3 vssd1 vssd1 vccd1 vccd1 sky130_ef_sc_hd__decap_12
XFILLER_0_95_629 vssd1 vssd1 vccd1 vccd1 sky130_fd_sc_hd__fill_1
X_07575_ _01365_ _01367_ _01698_ vssd1 vssd1 vccd1 vccd1 _01699_ sky130_fd_sc_hd__a21oi_4
X_09314_ _03297_ _03300_ vssd1 vssd1 vccd1 vccd1 _03424_ sky130_fd_sc_hd__or2_1
X_06526_ _00645_ _00647_ vssd1 vssd1 vccd1 vccd1 _00785_ sky130_fd_sc_hd__nand2_2
XFILLER_0_118_433 vssd1 vssd1 vccd1 vccd1 sky130_ef_sc_hd__decap_12
X_09245_ _03347_ _03353_ _03354_ vssd1 vssd1 vccd1 vccd1 _03356_ sky130_fd_sc_hd__nand3_1
XFILLER_0_63_515 vssd1 vssd1 vccd1 vccd1 sky130_fd_sc_hd__fill_1
X_06457_ add1.a_i\[27\] add1.b_i\[27\] vssd1 vssd1 vccd1 vccd1 _00755_ sky130_fd_sc_hd__or2_1
XFILLER_0_118_477 vssd1 vssd1 vccd1 vccd1 sky130_ef_sc_hd__decap_12
XFILLER_0_105_105 vssd1 vssd1 vccd1 vccd1 sky130_fd_sc_hd__decap_6
X_09176_ net1116 net720 vssd1 vssd1 vccd1 vccd1 _03287_ sky130_fd_sc_hd__nand2_1
XFILLER_0_105_149 vssd1 vssd1 vccd1 vccd1 sky130_ef_sc_hd__decap_12
X_06388_ add1.a_i\[17\] add1.b_i\[17\] vssd1 vssd1 vccd1 vccd1 _00696_ sky130_fd_sc_hd__nand2_1
XFILLER_0_121_609 vssd1 vssd1 vccd1 vccd1 sky130_fd_sc_hd__decap_6
X_08127_ net913 net979 net973 net921 vssd1 vssd1 vccd1 vccd1 _02246_ sky130_fd_sc_hd__a22o_1
X_08058_ _02176_ vssd1 vssd1 vccd1 vccd1 _02177_ sky130_fd_sc_hd__inv_2
XFILLER_0_113_193 vssd1 vssd1 vccd1 vccd1 sky130_ef_sc_hd__decap_12
X_07009_ _01120_ _01121_ _01132_ vssd1 vssd1 vccd1 vccd1 _01134_ sky130_fd_sc_hd__nand3_2
X_10020_ net1028 net761 _04122_ _04124_ vssd1 vssd1 vccd1 vccd1 _04126_ sky130_fd_sc_hd__nand4_1
Xinput125 v1x[12] vssd1 vssd1 vccd1 vccd1 net125 sky130_fd_sc_hd__buf_1
Xinput114 v0y[31] vssd1 vssd1 vccd1 vccd1 net114 sky130_fd_sc_hd__buf_1
Xinput103 v0y[21] vssd1 vssd1 vccd1 vccd1 net103 sky130_fd_sc_hd__buf_1
Xinput136 v1x[22] vssd1 vssd1 vccd1 vccd1 net136 sky130_fd_sc_hd__buf_1
Xinput158 v1y[13] vssd1 vssd1 vccd1 vccd1 net158 sky130_fd_sc_hd__buf_1
Xinput169 v1y[23] vssd1 vssd1 vccd1 vccd1 net169 sky130_fd_sc_hd__clkbuf_1
Xinput147 v1x[3] vssd1 vssd1 vccd1 vccd1 net147 sky130_fd_sc_hd__buf_1
XFILLER_0_98_401 vssd1 vssd1 vccd1 vccd1 sky130_fd_sc_hd__decap_8
X_11971_ net10 net551 net627 net194 _05982_ vssd1 vssd1 vccd1 vccd1 _05983_ sky130_fd_sc_hd__a221o_1
X_10922_ _04854_ net1751 _05020_ _05021_ vssd1 vssd1 vccd1 vccd1 _05022_ sky130_fd_sc_hd__o211a_2
XFILLER_0_58_309 vssd1 vssd1 vccd1 vccd1 sky130_fd_sc_hd__decap_4
XFILLER_0_79_681 vssd1 vssd1 vccd1 vccd1 sky130_ef_sc_hd__decap_12
X_10853_ net1717 _04953_ net525 vssd1 vssd1 vccd1 vccd1 _00147_ sky130_fd_sc_hd__mux2_1
XPHY_142 vssd1 vssd1 vccd1 vccd1 sky130_fd_sc_hd__decap_3
XPHY_131 vssd1 vssd1 vccd1 vccd1 sky130_fd_sc_hd__decap_3
X_10784_ _04871_ _04882_ _04883_ vssd1 vssd1 vccd1 vccd1 _04885_ sky130_fd_sc_hd__and3_2
XPHY_120 vssd1 vssd1 vccd1 vccd1 sky130_fd_sc_hd__decap_3
X_12523_ _00713_ net564 _06258_ vssd1 vssd1 vccd1 vccd1 _00512_ sky130_fd_sc_hd__o21ai_1
XFILLER_0_94_684 vssd1 vssd1 vccd1 vccd1 sky130_ef_sc_hd__decap_12
XFILLER_0_93_183 vssd1 vssd1 vccd1 vccd1 sky130_fd_sc_hd__fill_1
XPHY_175 vssd1 vssd1 vccd1 vccd1 sky130_fd_sc_hd__decap_3
XPHY_164 vssd1 vssd1 vccd1 vccd1 sky130_fd_sc_hd__decap_3
XPHY_153 vssd1 vssd1 vccd1 vccd1 sky130_fd_sc_hd__decap_3
XFILLER_0_27_729 vssd1 vssd1 vccd1 vccd1 sky130_fd_sc_hd__fill_1
XFILLER_0_109_488 vssd1 vssd1 vccd1 vccd1 sky130_fd_sc_hd__fill_1
XPHY_197 vssd1 vssd1 vccd1 vccd1 sky130_fd_sc_hd__decap_3
XPHY_186 vssd1 vssd1 vccd1 vccd1 sky130_fd_sc_hd__decap_3
XFILLER_0_81_389 vssd1 vssd1 vccd1 vccd1 sky130_fd_sc_hd__decap_3
X_12454_ temp1\[19\] _06221_ net573 vssd1 vssd1 vccd1 vccd1 _00480_ sky130_fd_sc_hd__mux2_1
XFILLER_0_124_469 vssd1 vssd1 vccd1 vccd1 sky130_fd_sc_hd__decap_6
XFILLER_0_78_29 vssd1 vssd1 vccd1 vccd1 sky130_ef_sc_hd__decap_12
X_12385_ net1506 _00852_ net682 vssd1 vssd1 vccd1 vccd1 _00437_ sky130_fd_sc_hd__mux2_1
X_11405_ _05500_ vssd1 vssd1 vccd1 vccd1 _05501_ sky130_fd_sc_hd__inv_2
XFILLER_0_104_182 vssd1 vssd1 vccd1 vccd1 sky130_fd_sc_hd__fill_2
XFILLER_0_50_754 vssd1 vssd1 vccd1 vccd1 sky130_fd_sc_hd__fill_2
X_11336_ _05430_ _05431_ _05385_ vssd1 vssd1 vccd1 vccd1 _05433_ sky130_fd_sc_hd__a21oi_2
X_13006_ clknet_leaf_31_clk_i _00392_ net1168 vssd1 vssd1 vccd1 vccd1 x2mx1\[27\]
+ sky130_fd_sc_hd__dfrtp_1
X_11267_ net791 net941 net935 net801 vssd1 vssd1 vccd1 vccd1 _05364_ sky130_fd_sc_hd__a22o_1
X_10218_ _04319_ _04320_ _04321_ vssd1 vssd1 vccd1 vccd1 _04323_ sky130_fd_sc_hd__a21bo_1
X_11198_ _05167_ _05170_ _05294_ _05295_ vssd1 vssd1 vccd1 vccd1 _05296_ sky130_fd_sc_hd__a211oi_4
X_10149_ _04251_ _04252_ _04247_ vssd1 vssd1 vccd1 vccd1 _04254_ sky130_fd_sc_hd__a21o_1
XFILLER_0_27_33 vssd1 vssd1 vccd1 vccd1 sky130_ef_sc_hd__decap_12
XFILLER_0_27_55 vssd1 vssd1 vccd1 vccd1 sky130_fd_sc_hd__fill_1
XFILLER_0_89_434 vssd1 vssd1 vccd1 vccd1 sky130_fd_sc_hd__decap_4
XFILLER_0_27_99 vssd1 vssd1 vccd1 vccd1 sky130_fd_sc_hd__decap_8
XFILLER_0_76_139 vssd1 vssd1 vccd1 vccd1 sky130_fd_sc_hd__fill_1
XPHY_0 vssd1 vssd1 vccd1 vccd1 sky130_fd_sc_hd__decap_3
XFILLER_0_85_673 vssd1 vssd1 vccd1 vccd1 sky130_ef_sc_hd__decap_12
X_07360_ _01483_ _01484_ vssd1 vssd1 vccd1 vccd1 _01485_ sky130_fd_sc_hd__and2_1
XFILLER_0_84_161 vssd1 vssd1 vccd1 vccd1 sky130_fd_sc_hd__decap_8
X_06311_ _00621_ _00622_ vssd1 vssd1 vccd1 vccd1 _00623_ sky130_fd_sc_hd__nand2_2
XFILLER_0_128_797 vssd1 vssd1 vccd1 vccd1 sky130_ef_sc_hd__decap_12
X_09030_ _02980_ _02984_ _03139_ _03140_ vssd1 vssd1 vccd1 vccd1 _03142_ sky130_fd_sc_hd__a211oi_2
XFILLER_0_45_559 vssd1 vssd1 vccd1 vccd1 sky130_fd_sc_hd__fill_1
X_07291_ _01278_ _01414_ _01415_ vssd1 vssd1 vccd1 vccd1 _01416_ sky130_fd_sc_hd__nand3_1
XFILLER_0_115_447 vssd1 vssd1 vccd1 vccd1 sky130_fd_sc_hd__fill_1
XFILLER_0_53_592 vssd1 vssd1 vccd1 vccd1 sky130_fd_sc_hd__decap_4
Xhold302 net386 vssd1 vssd1 vccd1 vccd1 net1517 sky130_fd_sc_hd__dlygate4sd3_1
Xhold324 net419 vssd1 vssd1 vccd1 vccd1 net1539 sky130_fd_sc_hd__dlygate4sd3_1
Xhold335 l0\[4\] vssd1 vssd1 vccd1 vccd1 net1550 sky130_fd_sc_hd__dlygate4sd3_1
Xhold313 l1\[18\] vssd1 vssd1 vccd1 vccd1 net1528 sky130_fd_sc_hd__dlygate4sd3_1
XFILLER_0_7_21 vssd1 vssd1 vccd1 vccd1 sky130_ef_sc_hd__decap_12
XFILLER_0_4_177 vssd1 vssd1 vccd1 vccd1 sky130_fd_sc_hd__fill_1
XFILLER_0_40_242 vssd1 vssd1 vccd1 vccd1 sky130_fd_sc_hd__fill_2
XFILLER_0_111_653 vssd1 vssd1 vccd1 vccd1 sky130_ef_sc_hd__decap_12
XFILLER_0_110_141 vssd1 vssd1 vccd1 vccd1 sky130_ef_sc_hd__decap_12
Xhold357 l0\[15\] vssd1 vssd1 vccd1 vccd1 net1572 sky130_fd_sc_hd__dlygate4sd3_1
X_09932_ _04037_ _04038_ vssd1 vssd1 vccd1 vccd1 _04039_ sky130_fd_sc_hd__nand2b_2
Xhold368 net381 vssd1 vssd1 vccd1 vccd1 net1583 sky130_fd_sc_hd__dlygate4sd3_1
Xhold346 y2my0\[5\] vssd1 vssd1 vccd1 vccd1 net1561 sky130_fd_sc_hd__dlygate4sd3_1
XFILLER_0_111_697 vssd1 vssd1 vccd1 vccd1 sky130_ef_sc_hd__decap_12
Xfanout815 mul1.b\[13\] vssd1 vssd1 vccd1 vccd1 net815 sky130_fd_sc_hd__buf_2
Xfanout804 mul1.b\[15\] vssd1 vssd1 vccd1 vccd1 net804 sky130_fd_sc_hd__buf_2
Xhold379 l1\[9\] vssd1 vssd1 vccd1 vccd1 net1594 sky130_fd_sc_hd__dlygate4sd3_1
X_09863_ _03817_ _03819_ vssd1 vssd1 vccd1 vccd1 _03970_ sky130_fd_sc_hd__nand2_1
Xfanout826 net827 vssd1 vssd1 vccd1 vccd1 net826 sky130_fd_sc_hd__buf_2
Xfanout848 net849 vssd1 vssd1 vccd1 vccd1 net848 sky130_fd_sc_hd__clkbuf_4
XTAP_640 vssd1 vccd1 sky130_fd_sc_hd__tapvpwrvgnd_1
XTAP_651 vssd1 vccd1 sky130_fd_sc_hd__tapvpwrvgnd_1
Xfanout837 net845 vssd1 vssd1 vccd1 vccd1 net837 sky130_fd_sc_hd__buf_2
X_09794_ _03741_ _03743_ _03899_ vssd1 vssd1 vccd1 vccd1 _03902_ sky130_fd_sc_hd__or3_1
Xfanout859 mul1.b\[8\] vssd1 vssd1 vccd1 vccd1 net859 sky130_fd_sc_hd__clkbuf_4
X_08814_ _02773_ _02774_ _02775_ vssd1 vssd1 vccd1 vccd1 _02928_ sky130_fd_sc_hd__a21bo_1
XTAP_662 vssd1 vccd1 sky130_fd_sc_hd__tapvpwrvgnd_1
XTAP_684 vssd1 vccd1 sky130_fd_sc_hd__tapvpwrvgnd_1
XTAP_673 vssd1 vccd1 sky130_fd_sc_hd__tapvpwrvgnd_1
XTAP_695 vssd1 vccd1 sky130_fd_sc_hd__tapvpwrvgnd_1
X_08745_ net1076 net1085 net773 net764 vssd1 vssd1 vccd1 vccd1 _02859_ sky130_fd_sc_hd__nand4_1
XTAP_1806 vssd1 vccd1 sky130_fd_sc_hd__tapvpwrvgnd_1
X_08676_ _02754_ _02755_ _02789_ _02790_ vssd1 vssd1 vccd1 vccd1 _02791_ sky130_fd_sc_hd__o22ai_2
XTAP_1839 vssd1 vccd1 sky130_fd_sc_hd__tapvpwrvgnd_1
XTAP_1828 vssd1 vccd1 sky130_fd_sc_hd__tapvpwrvgnd_1
XTAP_1817 vssd1 vccd1 sky130_fd_sc_hd__tapvpwrvgnd_1
X_07627_ _01747_ _01748_ _01335_ vssd1 vssd1 vccd1 vccd1 _01751_ sky130_fd_sc_hd__o21bai_1
X_07558_ _01332_ _01680_ vssd1 vssd1 vccd1 vccd1 _01682_ sky130_fd_sc_hd__xor2_1
X_06509_ det_t\[19\] net528 vssd1 vssd1 vccd1 vccd1 net262 sky130_fd_sc_hd__and2_1
XFILLER_0_119_753 vssd1 vssd1 vccd1 vccd1 sky130_ef_sc_hd__decap_12
X_07489_ _01613_ vssd1 vssd1 vccd1 vccd1 _01614_ sky130_fd_sc_hd__inv_2
XFILLER_0_106_447 vssd1 vssd1 vccd1 vccd1 sky130_ef_sc_hd__decap_12
X_09228_ _03337_ _03338_ _03180_ _03183_ vssd1 vssd1 vccd1 vccd1 _03339_ sky130_fd_sc_hd__a211oi_2
XFILLER_0_90_153 vssd1 vssd1 vccd1 vccd1 sky130_fd_sc_hd__fill_2
XFILLER_0_121_417 vssd1 vssd1 vccd1 vccd1 sky130_ef_sc_hd__decap_12
X_09159_ _03269_ net705 net1141 _03267_ vssd1 vssd1 vccd1 vccd1 _03270_ sky130_fd_sc_hd__and4b_1
X_12170_ net1735 _06133_ net515 vssd1 vssd1 vccd1 vccd1 _00284_ sky130_fd_sc_hd__mux2_1
XFILLER_0_101_130 vssd1 vssd1 vccd1 vccd1 sky130_fd_sc_hd__decap_8
X_11121_ _05208_ _05217_ vssd1 vssd1 vccd1 vccd1 _05219_ sky130_fd_sc_hd__xor2_1
XFILLER_0_101_185 vssd1 vssd1 vccd1 vccd1 sky130_ef_sc_hd__decap_12
X_11052_ net1055 net698 net694 net1064 vssd1 vssd1 vccd1 vccd1 _05151_ sky130_fd_sc_hd__o2bb2a_1
X_10003_ _04108_ _04107_ vssd1 vssd1 vccd1 vccd1 _04109_ sky130_fd_sc_hd__and2b_1
XFILLER_0_86_415 vssd1 vssd1 vccd1 vccd1 sky130_fd_sc_hd__decap_4
XFILLER_0_86_404 vssd1 vssd1 vccd1 vccd1 sky130_fd_sc_hd__fill_2
X_11954_ net94 net621 net595 net62 vssd1 vssd1 vccd1 vccd1 _05970_ sky130_fd_sc_hd__a22o_1
X_10905_ net783 net964 _05002_ _05003_ vssd1 vssd1 vccd1 vccd1 _05005_ sky130_fd_sc_hd__o2bb2a_1
X_11885_ net239 net600 net580 net143 _05916_ vssd1 vssd1 vccd1 vccd1 _05917_ sky130_fd_sc_hd__a221o_1
XFILLER_0_104_15 vssd1 vssd1 vccd1 vccd1 sky130_ef_sc_hd__decap_12
X_10836_ _04934_ _04935_ _04895_ vssd1 vssd1 vccd1 vccd1 _04937_ sky130_fd_sc_hd__a21o_1
XFILLER_0_67_662 vssd1 vssd1 vccd1 vccd1 sky130_fd_sc_hd__decap_3
XFILLER_0_82_610 vssd1 vssd1 vccd1 vccd1 sky130_ef_sc_hd__decap_12
XFILLER_0_73_109 vssd1 vssd1 vccd1 vccd1 sky130_fd_sc_hd__decap_3
XFILLER_0_67_673 vssd1 vssd1 vccd1 vccd1 sky130_fd_sc_hd__fill_1
XFILLER_0_13_57 vssd1 vssd1 vccd1 vccd1 sky130_ef_sc_hd__decap_12
XFILLER_0_27_515 vssd1 vssd1 vccd1 vccd1 sky130_fd_sc_hd__decap_8
X_10767_ _04865_ _04866_ vssd1 vssd1 vccd1 vccd1 _04868_ sky130_fd_sc_hd__xor2_1
XFILLER_0_27_559 vssd1 vssd1 vccd1 vccd1 sky130_fd_sc_hd__fill_1
X_12506_ _00798_ net566 vssd1 vssd1 vccd1 vccd1 _06250_ sky130_fd_sc_hd__nor2_1
XFILLER_0_89_39 vssd1 vssd1 vccd1 vccd1 sky130_ef_sc_hd__decap_12
X_10698_ _04648_ _04650_ vssd1 vssd1 vccd1 vccd1 _04800_ sky130_fd_sc_hd__or2_1
XFILLER_0_81_164 vssd1 vssd1 vccd1 vccd1 sky130_fd_sc_hd__decap_4
XFILLER_0_14_209 vssd1 vssd1 vccd1 vccd1 sky130_ef_sc_hd__decap_12
X_12437_ _00877_ net613 _03263_ net575 vssd1 vssd1 vccd1 vccd1 _06211_ sky130_fd_sc_hd__a22o_1
XFILLER_0_105_480 vssd1 vssd1 vccd1 vccd1 sky130_fd_sc_hd__fill_2
Xoutput407 net407 vssd1 vssd1 vccd1 vccd1 mstream_o[61] sky130_fd_sc_hd__clkbuf_4
XFILLER_0_50_562 vssd1 vssd1 vccd1 vccd1 sky130_fd_sc_hd__fill_1
Xoutput429 net429 vssd1 vssd1 vccd1 vccd1 mstream_o[81] sky130_fd_sc_hd__clkbuf_4
Xoutput418 net418 vssd1 vssd1 vccd1 vccd1 mstream_o[71] sky130_fd_sc_hd__clkbuf_4
XFILLER_0_1_136 vssd1 vssd1 vccd1 vccd1 sky130_fd_sc_hd__fill_1
X_12368_ net1447 _00928_ net661 vssd1 vssd1 vccd1 vccd1 _00420_ sky130_fd_sc_hd__mux2_1
X_12299_ net1627 _00903_ net678 vssd1 vssd1 vccd1 vccd1 _00351_ sky130_fd_sc_hd__mux2_1
X_11319_ _05407_ _05415_ vssd1 vssd1 vccd1 vccd1 _05416_ sky130_fd_sc_hd__nand2_1
X_06860_ net1151 _00988_ vssd1 vssd1 vccd1 vccd1 _00990_ sky130_fd_sc_hd__and2_2
XFILLER_0_38_98 vssd1 vssd1 vccd1 vccd1 sky130_fd_sc_hd__fill_2
X_06791_ net1562 l1\[30\] net641 vssd1 vssd1 vccd1 vccd1 _00065_ sky130_fd_sc_hd__mux2_1
X_08530_ _02644_ _02645_ _02627_ vssd1 vssd1 vccd1 vccd1 _02646_ sky130_fd_sc_hd__a21oi_2
X_08461_ net1068 net797 net787 net1076 vssd1 vssd1 vccd1 vccd1 _02577_ sky130_fd_sc_hd__a22o_1
X_07412_ _01532_ _01536_ vssd1 vssd1 vccd1 vccd1 _01537_ sky130_fd_sc_hd__xnor2_1
XFILLER_0_73_610 vssd1 vssd1 vccd1 vccd1 sky130_fd_sc_hd__decap_6
XFILLER_0_70_52 vssd1 vssd1 vccd1 vccd1 sky130_fd_sc_hd__decap_6
X_08392_ _02505_ _02506_ _02507_ vssd1 vssd1 vccd1 vccd1 _02509_ sky130_fd_sc_hd__a21o_1
XFILLER_0_58_684 vssd1 vssd1 vccd1 vccd1 sky130_fd_sc_hd__fill_1
XFILLER_0_116_701 vssd1 vssd1 vccd1 vccd1 sky130_fd_sc_hd__decap_8
XFILLER_0_72_120 vssd1 vssd1 vccd1 vccd1 sky130_fd_sc_hd__decap_6
X_07343_ net917 net909 net1090 net1097 vssd1 vssd1 vccd1 vccd1 _01468_ sky130_fd_sc_hd__nand4_1
XFILLER_0_73_687 vssd1 vssd1 vccd1 vccd1 sky130_fd_sc_hd__fill_1
X_07274_ _01256_ _01266_ _01396_ _01397_ vssd1 vssd1 vccd1 vccd1 _01399_ sky130_fd_sc_hd__o211ai_2
X_09013_ net1133 net720 _02972_ _02971_ vssd1 vssd1 vccd1 vccd1 _03125_ sky130_fd_sc_hd__a31o_1
XFILLER_0_60_337 vssd1 vssd1 vccd1 vccd1 sky130_fd_sc_hd__fill_1
Xhold110 add1.b_i\[12\] vssd1 vssd1 vccd1 vccd1 net1325 sky130_fd_sc_hd__dlygate4sd3_1
XFILLER_0_13_220 vssd1 vssd1 vccd1 vccd1 sky130_fd_sc_hd__fill_1
XFILLER_0_14_776 vssd1 vssd1 vccd1 vccd1 sky130_fd_sc_hd__fill_2
Xhold132 net412 vssd1 vssd1 vccd1 vccd1 net1347 sky130_fd_sc_hd__dlygate4sd3_1
Xhold143 l1\[21\] vssd1 vssd1 vccd1 vccd1 net1358 sky130_fd_sc_hd__dlygate4sd3_1
Xhold121 add1.a_i\[13\] vssd1 vssd1 vccd1 vccd1 net1336 sky130_fd_sc_hd__dlygate4sd3_1
Xhold154 net350 vssd1 vssd1 vccd1 vccd1 net1369 sky130_fd_sc_hd__dlygate4sd3_1
XFILLER_0_111_461 vssd1 vssd1 vccd1 vccd1 sky130_ef_sc_hd__decap_12
Xhold165 l0\[24\] vssd1 vssd1 vccd1 vccd1 net1380 sky130_fd_sc_hd__dlygate4sd3_1
Xhold176 net409 vssd1 vssd1 vccd1 vccd1 net1391 sky130_fd_sc_hd__dlygate4sd3_1
Xhold198 _00094_ vssd1 vssd1 vccd1 vccd1 net1413 sky130_fd_sc_hd__dlygate4sd3_1
Xhold187 _00087_ vssd1 vssd1 vccd1 vccd1 net1402 sky130_fd_sc_hd__dlygate4sd3_1
X_09915_ _04012_ _04019_ _04020_ vssd1 vssd1 vccd1 vccd1 _04022_ sky130_fd_sc_hd__and3_1
Xfanout623 _00990_ vssd1 vssd1 vccd1 vccd1 net623 sky130_fd_sc_hd__clkbuf_2
Xfanout601 _01003_ vssd1 vssd1 vccd1 vccd1 net601 sky130_fd_sc_hd__clkbuf_4
Xfanout612 net619 vssd1 vssd1 vccd1 vccd1 net612 sky130_fd_sc_hd__buf_2
X_09846_ _03909_ _03951_ vssd1 vssd1 vccd1 vccd1 _03953_ sky130_fd_sc_hd__xnor2_4
Xfanout645 net648 vssd1 vssd1 vccd1 vccd1 net645 sky130_fd_sc_hd__clkbuf_4
Xfanout656 net658 vssd1 vssd1 vccd1 vccd1 net656 sky130_fd_sc_hd__clkbuf_4
Xfanout634 net650 vssd1 vssd1 vccd1 vccd1 net634 sky130_fd_sc_hd__buf_2
Xfanout667 _00998_ vssd1 vssd1 vccd1 vccd1 net667 sky130_fd_sc_hd__clkbuf_2
Xfanout689 net691 vssd1 vssd1 vccd1 vccd1 net689 sky130_fd_sc_hd__clkbuf_4
Xfanout678 net681 vssd1 vssd1 vccd1 vccd1 net678 sky130_fd_sc_hd__clkbuf_4
XTAP_470 vssd1 vccd1 sky130_fd_sc_hd__tapvpwrvgnd_1
XTAP_492 vssd1 vccd1 sky130_fd_sc_hd__tapvpwrvgnd_1
XTAP_481 vssd1 vccd1 sky130_fd_sc_hd__tapvpwrvgnd_1
X_09777_ _03883_ _03884_ vssd1 vssd1 vccd1 vccd1 _03885_ sky130_fd_sc_hd__and2b_1
X_06989_ net897 net1065 net1073 net888 vssd1 vssd1 vccd1 vccd1 _01114_ sky130_fd_sc_hd__a22oi_2
X_08728_ _02840_ _02841_ vssd1 vssd1 vccd1 vccd1 _02842_ sky130_fd_sc_hd__or2_1
XFILLER_0_96_713 vssd1 vssd1 vccd1 vccd1 sky130_ef_sc_hd__decap_12
XFILLER_0_96_757 vssd1 vssd1 vccd1 vccd1 sky130_fd_sc_hd__fill_2
XTAP_1614 vssd1 vccd1 sky130_fd_sc_hd__tapvpwrvgnd_1
XTAP_1603 vssd1 vccd1 sky130_fd_sc_hd__tapvpwrvgnd_1
X_08659_ net916 net955 net949 net924 vssd1 vssd1 vccd1 vccd1 _02774_ sky130_fd_sc_hd__a22o_1
XFILLER_0_95_245 vssd1 vssd1 vccd1 vccd1 sky130_fd_sc_hd__fill_2
XTAP_1658 vssd1 vccd1 sky130_fd_sc_hd__tapvpwrvgnd_1
XTAP_1647 vssd1 vccd1 sky130_fd_sc_hd__tapvpwrvgnd_1
XTAP_1636 vssd1 vccd1 sky130_fd_sc_hd__tapvpwrvgnd_1
XTAP_1625 vssd1 vccd1 sky130_fd_sc_hd__tapvpwrvgnd_1
XTAP_1669 vssd1 vccd1 sky130_fd_sc_hd__tapvpwrvgnd_1
XFILLER_0_64_610 vssd1 vssd1 vccd1 vccd1 sky130_fd_sc_hd__fill_1
X_11670_ net1288 _02407_ net536 vssd1 vssd1 vccd1 vccd1 _00162_ sky130_fd_sc_hd__mux2_1
XFILLER_0_119_561 vssd1 vssd1 vccd1 vccd1 sky130_ef_sc_hd__decap_12
X_10621_ _04714_ _04722_ vssd1 vssd1 vccd1 vccd1 _04723_ sky130_fd_sc_hd__nand2_1
X_10552_ _04508_ net457 _04653_ _04654_ vssd1 vssd1 vccd1 vccd1 _04655_ sky130_fd_sc_hd__o211a_1
XFILLER_0_64_676 vssd1 vssd1 vccd1 vccd1 sky130_fd_sc_hd__decap_3
XFILLER_0_24_507 vssd1 vssd1 vccd1 vccd1 sky130_ef_sc_hd__decap_12
XFILLER_0_106_233 vssd1 vssd1 vccd1 vccd1 sky130_fd_sc_hd__decap_4
XFILLER_0_122_737 vssd1 vssd1 vccd1 vccd1 sky130_ef_sc_hd__decap_12
XFILLER_0_121_225 vssd1 vssd1 vccd1 vccd1 sky130_ef_sc_hd__decap_12
XFILLER_0_106_299 vssd1 vssd1 vccd1 vccd1 sky130_fd_sc_hd__fill_1
XFILLER_0_106_288 vssd1 vssd1 vccd1 vccd1 sky130_fd_sc_hd__decap_6
X_10483_ net785 net984 vssd1 vssd1 vccd1 vccd1 _04586_ sky130_fd_sc_hd__nand2_1
X_12222_ x2mx1\[19\] net604 net585 temp1\[19\] vssd1 vssd1 vccd1 vccd1 _06168_ sky130_fd_sc_hd__a22o_1
XFILLER_0_20_757 vssd1 vssd1 vccd1 vccd1 sky130_fd_sc_hd__fill_2
X_12153_ y2my0\[29\] net588 net534 x2mx1\[29\] _06120_ vssd1 vssd1 vccd1 vccd1 _06121_
+ sky130_fd_sc_hd__a221o_1
X_11104_ _04818_ _04819_ _05202_ vssd1 vssd1 vccd1 vccd1 _05203_ sky130_fd_sc_hd__a21o_1
X_12084_ x0mx2\[12\] net629 net591 y1my2\[12\] vssd1 vssd1 vccd1 vccd1 _06069_ sky130_fd_sc_hd__a22o_1
X_11035_ _05131_ _05132_ _04976_ _04978_ vssd1 vssd1 vccd1 vccd1 _05134_ sky130_fd_sc_hd__a211oi_2
X_12986_ clknet_leaf_53_clk_i _00372_ net1155 vssd1 vssd1 vccd1 vccd1 x2mx1\[7\] sky130_fd_sc_hd__dfrtp_1
XFILLER_0_86_223 vssd1 vssd1 vccd1 vccd1 sky130_fd_sc_hd__fill_1
XFILLER_0_59_426 vssd1 vssd1 vccd1 vccd1 sky130_fd_sc_hd__fill_2
XFILLER_0_115_69 vssd1 vssd1 vccd1 vccd1 sky130_ef_sc_hd__decap_12
XFILLER_0_86_256 vssd1 vssd1 vccd1 vccd1 sky130_fd_sc_hd__decap_4
X_11937_ net1601 _05957_ net478 vssd1 vssd1 vccd1 vccd1 _00227_ sky130_fd_sc_hd__mux2_1
X_11868_ net653 _00946_ net476 _05902_ vssd1 vssd1 vccd1 vccd1 _05903_ sky130_fd_sc_hd__a211o_1
X_10819_ _04710_ _04712_ _04918_ _04919_ vssd1 vssd1 vccd1 vccd1 _04920_ sky130_fd_sc_hd__a211o_1
XFILLER_0_7_718 vssd1 vssd1 vccd1 vccd1 sky130_fd_sc_hd__fill_1
X_11799_ net129 net581 _05842_ _05843_ vssd1 vssd1 vccd1 vccd1 _05844_ sky130_fd_sc_hd__a211o_1
XFILLER_0_27_323 vssd1 vssd1 vccd1 vccd1 sky130_fd_sc_hd__decap_4
XFILLER_0_39_183 vssd1 vssd1 vccd1 vccd1 sky130_fd_sc_hd__fill_1
XFILLER_0_43_827 vssd1 vssd1 vccd1 vccd1 sky130_fd_sc_hd__fill_1
XFILLER_0_43_805 vssd1 vssd1 vccd1 vccd1 sky130_fd_sc_hd__fill_2
XFILLER_0_40_22 vssd1 vssd1 vccd1 vccd1 sky130_fd_sc_hd__decap_6
XFILLER_0_125_553 vssd1 vssd1 vccd1 vccd1 sky130_fd_sc_hd__decap_6
XFILLER_0_54_197 vssd1 vssd1 vccd1 vccd1 sky130_fd_sc_hd__decap_4
XFILLER_0_125_597 vssd1 vssd1 vccd1 vccd1 sky130_ef_sc_hd__decap_12
XFILLER_0_11_702 vssd1 vssd1 vccd1 vccd1 sky130_fd_sc_hd__fill_1
XFILLER_0_23_573 vssd1 vssd1 vccd1 vccd1 sky130_ef_sc_hd__decap_12
Xoutput259 net259 vssd1 vssd1 vccd1 vccd1 div_mstream_o[16] sky130_fd_sc_hd__clkbuf_4
X_07961_ net1115 net781 vssd1 vssd1 vccd1 vccd1 _02081_ sky130_fd_sc_hd__and2_1
XFILLER_0_10_245 vssd1 vssd1 vccd1 vccd1 sky130_fd_sc_hd__fill_2
X_09700_ net1046 net759 _03804_ _03806_ vssd1 vssd1 vccd1 vccd1 _03808_ sky130_fd_sc_hd__nand4_1
X_06912_ net846 net1112 net1118 net837 vssd1 vssd1 vccd1 vccd1 _01037_ sky130_fd_sc_hd__a22oi_1
X_07892_ _02007_ _02010_ _02011_ vssd1 vssd1 vccd1 vccd1 _02013_ sky130_fd_sc_hd__or3_1
X_09631_ _03737_ _03738_ _03589_ vssd1 vssd1 vccd1 vccd1 _03740_ sky130_fd_sc_hd__a21o_1
X_06843_ _00607_ _00800_ vssd1 vssd1 vccd1 vccd1 _00974_ sky130_fd_sc_hd__nor2_1
X_09562_ _03669_ _03670_ vssd1 vssd1 vccd1 vccd1 _03671_ sky130_fd_sc_hd__nor2_1
X_06774_ net1393 l1\[13\] net638 vssd1 vssd1 vccd1 vccd1 _00048_ sky130_fd_sc_hd__mux2_1
X_08513_ net894 net979 net973 net903 vssd1 vssd1 vccd1 vccd1 _02629_ sky130_fd_sc_hd__a22oi_2
X_09493_ _03600_ _03601_ vssd1 vssd1 vccd1 vccd1 _03602_ sky130_fd_sc_hd__and2b_1
XFILLER_0_81_51 vssd1 vssd1 vccd1 vccd1 sky130_fd_sc_hd__decap_4
XFILLER_0_78_757 vssd1 vssd1 vccd1 vccd1 sky130_fd_sc_hd__decap_3
XFILLER_0_77_245 vssd1 vssd1 vccd1 vccd1 sky130_fd_sc_hd__decap_3
XFILLER_0_93_727 vssd1 vssd1 vccd1 vccd1 sky130_fd_sc_hd__fill_1
X_08444_ _02423_ _02559_ vssd1 vssd1 vccd1 vccd1 _02560_ sky130_fd_sc_hd__xnor2_1
XFILLER_0_108_509 vssd1 vssd1 vccd1 vccd1 sky130_fd_sc_hd__decap_8
XFILLER_0_92_226 vssd1 vssd1 vccd1 vccd1 sky130_ef_sc_hd__decap_12
X_08375_ _02487_ _02490_ _02491_ vssd1 vssd1 vccd1 vccd1 _02492_ sky130_fd_sc_hd__nand3_1
Xclkbuf_leaf_53_clk_i clknet_3_0__leaf_clk_i vssd1 vssd1 vccd1 vccd1 clknet_leaf_53_clk_i
+ sky130_fd_sc_hd__clkbuf_16
XFILLER_0_116_531 vssd1 vssd1 vccd1 vccd1 sky130_fd_sc_hd__fill_1
X_07326_ _01450_ vssd1 vssd1 vccd1 vccd1 _01451_ sky130_fd_sc_hd__inv_2
XFILLER_0_61_624 vssd1 vssd1 vccd1 vccd1 sky130_fd_sc_hd__fill_2
XFILLER_0_60_123 vssd1 vssd1 vccd1 vccd1 sky130_fd_sc_hd__fill_2
XFILLER_0_104_737 vssd1 vssd1 vccd1 vccd1 sky130_ef_sc_hd__decap_12
X_07257_ _01380_ _01381_ _01373_ vssd1 vssd1 vccd1 vccd1 _01382_ sky130_fd_sc_hd__a21o_1
X_07188_ net846 net837 net1135 net1143 vssd1 vssd1 vccd1 vccd1 _01313_ sky130_fd_sc_hd__and4_1
Xfanout475 _05765_ vssd1 vssd1 vccd1 vccd1 net475 sky130_fd_sc_hd__clkbuf_4
X_09829_ _03935_ _03934_ _03933_ vssd1 vssd1 vccd1 vccd1 _03936_ sky130_fd_sc_hd__nand3b_2
XTAP_2101 vssd1 vccd1 sky130_fd_sc_hd__tapvpwrvgnd_1
X_12840_ clknet_leaf_54_clk_i _00226_ vssd1 vssd1 vccd1 vccd1 sub1.b_i\[7\] sky130_fd_sc_hd__dfxtp_1
XTAP_2134 vssd1 vccd1 sky130_fd_sc_hd__tapvpwrvgnd_1
XTAP_2123 vssd1 vccd1 sky130_fd_sc_hd__tapvpwrvgnd_1
XTAP_2112 vssd1 vccd1 sky130_fd_sc_hd__tapvpwrvgnd_1
XTAP_2156 vssd1 vccd1 sky130_fd_sc_hd__tapvpwrvgnd_1
XTAP_2167 vssd1 vccd1 sky130_fd_sc_hd__tapvpwrvgnd_1
XTAP_2145 vssd1 vccd1 sky130_fd_sc_hd__tapvpwrvgnd_1
XTAP_1433 vssd1 vccd1 sky130_fd_sc_hd__tapvpwrvgnd_1
XTAP_1422 vssd1 vccd1 sky130_fd_sc_hd__tapvpwrvgnd_1
XTAP_1411 vssd1 vccd1 sky130_fd_sc_hd__tapvpwrvgnd_1
XTAP_1400 vssd1 vccd1 sky130_fd_sc_hd__tapvpwrvgnd_1
X_12771_ clknet_leaf_0_clk_i _00157_ vssd1 vssd1 vccd1 vccd1 add1.b_i\[2\] sky130_fd_sc_hd__dfxtp_1
XTAP_2189 vssd1 vccd1 sky130_fd_sc_hd__tapvpwrvgnd_1
XTAP_2178 vssd1 vccd1 sky130_fd_sc_hd__tapvpwrvgnd_1
XFILLER_0_96_598 vssd1 vssd1 vccd1 vccd1 sky130_fd_sc_hd__decap_6
XTAP_1466 vssd1 vccd1 sky130_fd_sc_hd__tapvpwrvgnd_1
XTAP_1455 vssd1 vccd1 sky130_fd_sc_hd__tapvpwrvgnd_1
XTAP_1444 vssd1 vccd1 sky130_fd_sc_hd__tapvpwrvgnd_1
X_11722_ temp1\[3\] net611 net668 net115 _05779_ vssd1 vssd1 vccd1 vccd1 _05780_ sky130_fd_sc_hd__a221o_1
XFILLER_0_28_109 vssd1 vssd1 vccd1 vccd1 sky130_fd_sc_hd__decap_4
XFILLER_0_126_317 vssd1 vssd1 vccd1 vccd1 sky130_fd_sc_hd__decap_4
XTAP_1499 vssd1 vccd1 sky130_fd_sc_hd__tapvpwrvgnd_1
XTAP_1488 vssd1 vccd1 sky130_fd_sc_hd__tapvpwrvgnd_1
XTAP_1477 vssd1 vccd1 sky130_fd_sc_hd__tapvpwrvgnd_1
X_11653_ _05743_ _05746_ vssd1 vssd1 vccd1 vccd1 _05747_ sky130_fd_sc_hd__xnor2_1
X_10604_ _04543_ _04563_ vssd1 vssd1 vccd1 vccd1 _04706_ sky130_fd_sc_hd__nand2b_1
XFILLER_0_37_676 vssd1 vssd1 vccd1 vccd1 sky130_fd_sc_hd__fill_1
XFILLER_0_119_391 vssd1 vssd1 vccd1 vccd1 sky130_fd_sc_hd__fill_1
XFILLER_0_24_326 vssd1 vssd1 vccd1 vccd1 sky130_fd_sc_hd__decap_4
X_11584_ _05642_ _05645_ vssd1 vssd1 vccd1 vccd1 _05678_ sky130_fd_sc_hd__nand2_1
XFILLER_0_122_501 vssd1 vssd1 vccd1 vccd1 sky130_ef_sc_hd__decap_12
XFILLER_0_107_586 vssd1 vssd1 vccd1 vccd1 sky130_ef_sc_hd__decap_12
XFILLER_0_101_27 vssd1 vssd1 vccd1 vccd1 sky130_ef_sc_hd__decap_12
X_10535_ _04636_ _04637_ _04629_ vssd1 vssd1 vccd1 vccd1 _04638_ sky130_fd_sc_hd__a21o_1
XFILLER_0_36_197 vssd1 vssd1 vccd1 vccd1 sky130_fd_sc_hd__decap_4
XFILLER_0_122_545 vssd1 vssd1 vccd1 vccd1 sky130_ef_sc_hd__decap_12
X_10466_ net753 _04568_ _04567_ vssd1 vssd1 vccd1 vccd1 _04569_ sky130_fd_sc_hd__a21bo_1
XFILLER_0_51_167 vssd1 vssd1 vccd1 vccd1 sky130_fd_sc_hd__fill_1
XFILLER_0_122_589 vssd1 vssd1 vccd1 vccd1 sky130_ef_sc_hd__decap_12
XFILLER_0_86_29 vssd1 vssd1 vccd1 vccd1 sky130_ef_sc_hd__decap_12
X_13185_ clknet_leaf_19_clk_i _00571_ net1177 vssd1 vssd1 vccd1 vccd1 l1\[14\] sky130_fd_sc_hd__dfrtp_1
X_12205_ _00877_ net510 net467 y1my2\[13\] _06156_ vssd1 vssd1 vccd1 vccd1 _06157_
+ sky130_fd_sc_hd__a221o_1
X_10397_ _04483_ _04496_ _04498_ vssd1 vssd1 vccd1 vccd1 _04501_ sky130_fd_sc_hd__nand3_2
X_12136_ x0mx2\[25\] net631 net592 y1my2\[25\] vssd1 vssd1 vccd1 vccd1 _06108_ sky130_fd_sc_hd__a22o_1
X_12067_ net1090 _06056_ net513 vssd1 vssd1 vccd1 vccd1 _00258_ sky130_fd_sc_hd__mux2_1
X_11018_ _05115_ _05116_ vssd1 vssd1 vccd1 vccd1 _05117_ sky130_fd_sc_hd__and2_1
XFILLER_0_99_370 vssd1 vssd1 vccd1 vccd1 sky130_ef_sc_hd__decap_12
X_12969_ clknet_leaf_33_clk_i _00355_ net1167 vssd1 vssd1 vccd1 vccd1 y1my2\[22\]
+ sky130_fd_sc_hd__dfrtp_1
X_06490_ det_t\[0\] net527 vssd1 vssd1 vccd1 vccd1 net252 sky130_fd_sc_hd__and2_1
XFILLER_0_118_807 vssd1 vssd1 vccd1 vccd1 sky130_fd_sc_hd__decap_4
XFILLER_0_117_317 vssd1 vssd1 vccd1 vccd1 sky130_ef_sc_hd__decap_12
XFILLER_0_90_708 vssd1 vssd1 vccd1 vccd1 sky130_ef_sc_hd__decap_12
XFILLER_0_55_440 vssd1 vssd1 vccd1 vccd1 sky130_fd_sc_hd__fill_1
X_08160_ _02053_ _02162_ vssd1 vssd1 vccd1 vccd1 _02279_ sky130_fd_sc_hd__or2_1
XFILLER_0_126_840 vssd1 vssd1 vccd1 vccd1 sky130_fd_sc_hd__fill_2
XFILLER_0_70_410 vssd1 vssd1 vccd1 vccd1 sky130_fd_sc_hd__decap_4
X_07111_ net829 net1113 _01234_ _01235_ vssd1 vssd1 vccd1 vccd1 _01236_ sky130_fd_sc_hd__nand4_2
XFILLER_0_43_635 vssd1 vssd1 vccd1 vccd1 sky130_ef_sc_hd__decap_12
X_08091_ net1067 net821 net814 net1075 vssd1 vssd1 vccd1 vccd1 _02210_ sky130_fd_sc_hd__a22o_1
X_07042_ _01161_ _01166_ vssd1 vssd1 vccd1 vccd1 _01167_ sky130_fd_sc_hd__nand2b_1
XFILLER_0_101_729 vssd1 vssd1 vccd1 vccd1 sky130_ef_sc_hd__decap_12
X_08993_ _02958_ _03104_ vssd1 vssd1 vccd1 vccd1 _03106_ sky130_fd_sc_hd__xnor2_4
X_07944_ _02062_ _02063_ vssd1 vssd1 vccd1 vccd1 _02064_ sky130_fd_sc_hd__and2_1
XFILLER_0_48_3 vssd1 vssd1 vccd1 vccd1 sky130_ef_sc_hd__decap_12
X_07875_ _01886_ _01888_ vssd1 vssd1 vccd1 vccd1 _01996_ sky130_fd_sc_hd__nand2_1
X_06826_ net1363 net1341 net649 vssd1 vssd1 vccd1 vccd1 _00100_ sky130_fd_sc_hd__mux2_1
X_09614_ _03703_ _03720_ _03721_ vssd1 vssd1 vccd1 vccd1 _03723_ sky130_fd_sc_hd__and3_1
XFILLER_0_92_83 vssd1 vssd1 vccd1 vccd1 sky130_fd_sc_hd__fill_1
X_09545_ net1023 net804 net793 net1010 vssd1 vssd1 vccd1 vccd1 _03654_ sky130_fd_sc_hd__nand4_2
X_06757_ _00967_ _00969_ _00966_ vssd1 vssd1 vccd1 vccd1 _00971_ sky130_fd_sc_hd__o21bai_4
XFILLER_0_78_587 vssd1 vssd1 vccd1 vccd1 sky130_fd_sc_hd__fill_1
X_09476_ _02411_ _02414_ _02815_ _03107_ _03583_ vssd1 vssd1 vccd1 vccd1 _03585_ sky130_fd_sc_hd__a2111o_2
X_06688_ _00911_ _00912_ vssd1 vssd1 vccd1 vccd1 _00913_ sky130_fd_sc_hd__xor2_4
XFILLER_0_38_407 vssd1 vssd1 vccd1 vccd1 sky130_fd_sc_hd__fill_2
XFILLER_0_38_418 vssd1 vssd1 vccd1 vccd1 sky130_fd_sc_hd__fill_2
X_08427_ net1501 _02543_ net522 vssd1 vssd1 vccd1 vccd1 _00131_ sky130_fd_sc_hd__mux2_1
XFILLER_0_19_621 vssd1 vssd1 vccd1 vccd1 sky130_fd_sc_hd__fill_1
XFILLER_0_108_328 vssd1 vssd1 vccd1 vccd1 sky130_fd_sc_hd__decap_3
X_08358_ _02471_ _02472_ _02473_ vssd1 vssd1 vccd1 vccd1 _02475_ sky130_fd_sc_hd__nand3_1
XFILLER_0_34_613 vssd1 vssd1 vccd1 vccd1 sky130_fd_sc_hd__decap_4
X_08289_ _02405_ _02406_ vssd1 vssd1 vccd1 vccd1 _02407_ sky130_fd_sc_hd__xnor2_2
XFILLER_0_6_570 vssd1 vssd1 vccd1 vccd1 sky130_fd_sc_hd__decap_4
X_07309_ _01431_ _01433_ vssd1 vssd1 vccd1 vccd1 _01434_ sky130_fd_sc_hd__and2b_1
XFILLER_0_33_134 vssd1 vssd1 vccd1 vccd1 sky130_fd_sc_hd__fill_2
XFILLER_0_34_668 vssd1 vssd1 vccd1 vccd1 sky130_fd_sc_hd__fill_1
Xbary_pipe_m_1207 vssd1 vssd1 vccd1 vccd1 bary_pipe_m_1207/HI div_mstream_o[57] sky130_fd_sc_hd__conb_1
X_10320_ _04305_ _04308_ _04421_ _04422_ vssd1 vssd1 vccd1 vccd1 _04424_ sky130_fd_sc_hd__a211oi_1
XFILLER_0_33_167 vssd1 vssd1 vccd1 vccd1 sky130_fd_sc_hd__fill_1
X_10251_ _04353_ _04354_ _04197_ net1757 vssd1 vssd1 vccd1 vccd1 _04356_ sky130_fd_sc_hd__a211o_1
XFILLER_0_30_841 vssd1 vssd1 vccd1 vccd1 sky130_fd_sc_hd__fill_1
X_10182_ _04135_ _04137_ vssd1 vssd1 vccd1 vccd1 _04287_ sky130_fd_sc_hd__nand2_1
XFILLER_0_88_307 vssd1 vssd1 vccd1 vccd1 sky130_fd_sc_hd__fill_1
XFILLER_0_97_841 vssd1 vssd1 vccd1 vccd1 sky130_fd_sc_hd__fill_1
XFILLER_0_96_340 vssd1 vssd1 vccd1 vccd1 sky130_fd_sc_hd__fill_2
XFILLER_0_69_543 vssd1 vssd1 vccd1 vccd1 sky130_fd_sc_hd__fill_2
X_12823_ clknet_leaf_35_clk_i _00209_ vssd1 vssd1 vccd1 vccd1 sub1.a_i\[22\] sky130_fd_sc_hd__dfxtp_1
XTAP_1241 vssd1 vccd1 sky130_fd_sc_hd__tapvpwrvgnd_1
XTAP_1230 vssd1 vccd1 sky130_fd_sc_hd__tapvpwrvgnd_1
XFILLER_0_57_727 vssd1 vssd1 vccd1 vccd1 sky130_fd_sc_hd__fill_1
X_12754_ clknet_leaf_41_clk_i _00140_ vssd1 vssd1 vccd1 vccd1 add1.a_i\[17\] sky130_fd_sc_hd__dfxtp_1
XFILLER_0_127_615 vssd1 vssd1 vccd1 vccd1 sky130_fd_sc_hd__fill_1
XTAP_1274 vssd1 vccd1 sky130_fd_sc_hd__tapvpwrvgnd_1
XTAP_1263 vssd1 vccd1 sky130_fd_sc_hd__tapvpwrvgnd_1
XTAP_1252 vssd1 vccd1 sky130_fd_sc_hd__tapvpwrvgnd_1
XFILLER_0_56_237 vssd1 vssd1 vccd1 vccd1 sky130_fd_sc_hd__decap_6
X_11705_ net671 _05756_ net580 vssd1 vssd1 vccd1 vccd1 _05766_ sky130_fd_sc_hd__or3_1
XFILLER_0_127_637 vssd1 vssd1 vccd1 vccd1 sky130_fd_sc_hd__decap_8
XFILLER_0_112_15 vssd1 vssd1 vccd1 vccd1 sky130_ef_sc_hd__decap_12
X_12685_ clknet_leaf_15_clk_i net1379 net1184 vssd1 vssd1 vccd1 vccd1 net414 sky130_fd_sc_hd__dfrtp_1
XTAP_1296 vssd1 vccd1 sky130_fd_sc_hd__tapvpwrvgnd_1
XTAP_1285 vssd1 vccd1 sky130_fd_sc_hd__tapvpwrvgnd_1
XFILLER_0_65_782 vssd1 vssd1 vccd1 vccd1 sky130_fd_sc_hd__fill_2
XFILLER_0_52_421 vssd1 vssd1 vccd1 vccd1 sky130_fd_sc_hd__fill_1
X_11636_ _05728_ _05729_ vssd1 vssd1 vccd1 vccd1 _05730_ sky130_fd_sc_hd__xnor2_1
XFILLER_0_37_473 vssd1 vssd1 vccd1 vccd1 sky130_fd_sc_hd__decap_4
XFILLER_0_114_309 vssd1 vssd1 vccd1 vccd1 sky130_ef_sc_hd__decap_12
XFILLER_0_21_57 vssd1 vssd1 vccd1 vccd1 sky130_ef_sc_hd__decap_12
X_11567_ _05397_ _05522_ _05519_ vssd1 vssd1 vccd1 vccd1 _05662_ sky130_fd_sc_hd__a21oi_1
X_10518_ _04616_ _04620_ vssd1 vssd1 vccd1 vccd1 _04621_ sky130_fd_sc_hd__and2b_1
XFILLER_0_24_167 vssd1 vssd1 vccd1 vccd1 sky130_fd_sc_hd__decap_4
XFILLER_0_97_39 vssd1 vssd1 vccd1 vccd1 sky130_ef_sc_hd__decap_12
XFILLER_0_21_841 vssd1 vssd1 vccd1 vccd1 sky130_fd_sc_hd__fill_1
X_11498_ _05590_ _05591_ _05586_ vssd1 vssd1 vccd1 vccd1 _05593_ sky130_fd_sc_hd__a21oi_1
X_10449_ net851 net841 net942 net938 vssd1 vssd1 vccd1 vccd1 _04552_ sky130_fd_sc_hd__nand4_4
X_13168_ clknet_leaf_9_clk_i _00554_ net1191 vssd1 vssd1 vccd1 vccd1 l0\[29\] sky130_fd_sc_hd__dfrtp_1
X_13099_ clknet_leaf_18_clk_i _00485_ vssd1 vssd1 vccd1 vccd1 temp1\[24\] sky130_fd_sc_hd__dfxtp_2
X_12119_ net989 _06095_ net519 vssd1 vssd1 vccd1 vccd1 _00271_ sky130_fd_sc_hd__mux2_1
X_07660_ _01329_ _01677_ _01781_ _01782_ vssd1 vssd1 vccd1 vccd1 _01783_ sky130_fd_sc_hd__nand4_2
XFILLER_0_88_841 vssd1 vssd1 vccd1 vccd1 sky130_fd_sc_hd__fill_1
X_07591_ net1032 net899 net890 net1041 vssd1 vssd1 vccd1 vccd1 _01715_ sky130_fd_sc_hd__a22o_1
X_06611_ sub1.b_i\[8\] sub1.a_i\[8\] vssd1 vssd1 vccd1 vccd1 _00848_ sky130_fd_sc_hd__and2b_1
X_06542_ net544 _00794_ vssd1 vssd1 vccd1 vccd1 net305 sky130_fd_sc_hd__nor2_1
X_09330_ _03432_ _03438_ vssd1 vssd1 vccd1 vccd1 _03440_ sky130_fd_sc_hd__or2_1
XFILLER_0_62_97 vssd1 vssd1 vccd1 vccd1 sky130_fd_sc_hd__fill_1
X_09261_ net892 net949 net944 net901 vssd1 vssd1 vccd1 vccd1 _03372_ sky130_fd_sc_hd__a22o_1
X_06473_ net547 _00769_ vssd1 vssd1 vccd1 vccd1 net327 sky130_fd_sc_hd__nor2_1
XFILLER_0_118_637 vssd1 vssd1 vccd1 vccd1 sky130_fd_sc_hd__decap_6
XFILLER_0_117_125 vssd1 vssd1 vccd1 vccd1 sky130_ef_sc_hd__decap_12
X_08212_ _02229_ _02235_ _02234_ vssd1 vssd1 vccd1 vccd1 _02330_ sky130_fd_sc_hd__a21o_1
X_09192_ _03143_ _03147_ _03301_ _03302_ vssd1 vssd1 vccd1 vccd1 _03303_ sky130_fd_sc_hd__a211oi_2
XFILLER_0_126_681 vssd1 vssd1 vccd1 vccd1 sky130_ef_sc_hd__decap_12
XFILLER_0_117_169 vssd1 vssd1 vccd1 vccd1 sky130_ef_sc_hd__decap_12
XFILLER_0_114_821 vssd1 vssd1 vccd1 vccd1 sky130_fd_sc_hd__fill_1
X_08143_ _02258_ _02259_ _02142_ _02145_ vssd1 vssd1 vccd1 vccd1 _02262_ sky130_fd_sc_hd__o211a_1
XFILLER_0_71_741 vssd1 vssd1 vccd1 vccd1 sky130_ef_sc_hd__decap_12
XFILLER_0_15_134 vssd1 vssd1 vccd1 vccd1 sky130_fd_sc_hd__fill_1
X_08074_ net1091 net1098 net786 vssd1 vssd1 vccd1 vccd1 _02193_ sky130_fd_sc_hd__and3_1
X_07025_ _01143_ _01147_ _01148_ vssd1 vssd1 vccd1 vccd1 _01150_ sky130_fd_sc_hd__nand3_1
XFILLER_0_101_537 vssd1 vssd1 vccd1 vccd1 sky130_ef_sc_hd__decap_12
Xhold14 det_t\[23\] vssd1 vssd1 vccd1 vccd1 net1229 sky130_fd_sc_hd__dlygate4sd3_1
Xhold36 det_t\[19\] vssd1 vssd1 vccd1 vccd1 net1251 sky130_fd_sc_hd__dlygate4sd3_1
Xhold25 det_t\[6\] vssd1 vssd1 vccd1 vccd1 net1240 sky130_fd_sc_hd__dlygate4sd3_1
X_08976_ _03085_ _03087_ _02939_ net490 vssd1 vssd1 vccd1 vccd1 _03089_ sky130_fd_sc_hd__a211oi_2
Xhold47 l1\[2\] vssd1 vssd1 vccd1 vccd1 net1262 sky130_fd_sc_hd__dlygate4sd3_1
X_07927_ _02045_ _02046_ _01935_ _01938_ vssd1 vssd1 vccd1 vccd1 _02048_ sky130_fd_sc_hd__a211oi_2
Xhold69 sub1.a_i\[13\] vssd1 vssd1 vccd1 vccd1 net1284 sky130_fd_sc_hd__dlygate4sd3_1
Xhold58 sub1.a_i\[24\] vssd1 vssd1 vccd1 vccd1 net1273 sky130_fd_sc_hd__dlygate4sd3_1
X_07858_ _01965_ _01978_ vssd1 vssd1 vccd1 vccd1 _01979_ sky130_fd_sc_hd__or2_1
XFILLER_0_97_148 vssd1 vssd1 vccd1 vccd1 sky130_ef_sc_hd__decap_12
X_06809_ net1533 net1471 net642 vssd1 vssd1 vccd1 vccd1 _00083_ sky130_fd_sc_hd__mux2_1
XFILLER_0_79_841 vssd1 vssd1 vccd1 vccd1 sky130_fd_sc_hd__fill_1
X_07789_ net1018 net1026 net898 net889 vssd1 vssd1 vccd1 vccd1 _01911_ sky130_fd_sc_hd__and4_1
X_09528_ net1063 net1071 net752 net744 vssd1 vssd1 vccd1 vccd1 _03637_ sky130_fd_sc_hd__and4_1
XFILLER_0_66_502 vssd1 vssd1 vccd1 vccd1 sky130_fd_sc_hd__decap_4
XFILLER_0_109_615 vssd1 vssd1 vccd1 vccd1 sky130_fd_sc_hd__fill_1
XFILLER_0_39_749 vssd1 vssd1 vccd1 vccd1 sky130_fd_sc_hd__decap_3
X_09459_ _03566_ _03567_ _03403_ net1742 vssd1 vssd1 vccd1 vccd1 _03569_ sky130_fd_sc_hd__a211oi_2
XFILLER_0_81_505 vssd1 vssd1 vccd1 vccd1 sky130_fd_sc_hd__decap_4
XFILLER_0_66_557 vssd1 vssd1 vccd1 vccd1 sky130_fd_sc_hd__decap_3
X_12470_ _00946_ net617 _05205_ net576 vssd1 vssd1 vccd1 vccd1 _06231_ sky130_fd_sc_hd__a22o_1
Xclkbuf_3_6__f_clk_i clknet_0_clk_i vssd1 vssd1 vccd1 vccd1 clknet_3_6__leaf_clk_i
+ sky130_fd_sc_hd__clkbuf_16
XFILLER_0_34_421 vssd1 vssd1 vccd1 vccd1 sky130_fd_sc_hd__fill_2
XFILLER_0_34_443 vssd1 vssd1 vccd1 vccd1 sky130_fd_sc_hd__fill_1
X_11421_ _05515_ _05516_ vssd1 vssd1 vccd1 vccd1 _05517_ sky130_fd_sc_hd__nor2_1
X_11352_ _05327_ _05447_ vssd1 vssd1 vccd1 vccd1 _05449_ sky130_fd_sc_hd__nand2_1
XFILLER_0_22_627 vssd1 vssd1 vccd1 vccd1 sky130_fd_sc_hd__fill_2
XFILLER_0_104_342 vssd1 vssd1 vccd1 vccd1 sky130_fd_sc_hd__decap_3
X_10303_ _04406_ _04405_ _04404_ vssd1 vssd1 vccd1 vccd1 _04407_ sky130_fd_sc_hd__nand3b_2
XFILLER_0_61_273 vssd1 vssd1 vccd1 vccd1 sky130_fd_sc_hd__fill_1
X_11283_ _05343_ _05378_ _05379_ vssd1 vssd1 vccd1 vccd1 _05380_ sky130_fd_sc_hd__nor3_1
X_10234_ net841 net953 net947 net851 vssd1 vssd1 vccd1 vccd1 _04339_ sky130_fd_sc_hd__a22o_1
X_13022_ clknet_leaf_44_clk_i _00408_ net1157 vssd1 vssd1 vccd1 vccd1 x0mx2\[11\]
+ sky130_fd_sc_hd__dfrtp_1
X_10165_ _04226_ _04269_ vssd1 vssd1 vccd1 vccd1 _04270_ sky130_fd_sc_hd__and2b_1
Xfanout1001 net1002 vssd1 vssd1 vccd1 vccd1 net1001 sky130_fd_sc_hd__buf_2
Xfanout1012 mul1.a\[17\] vssd1 vssd1 vccd1 vccd1 net1012 sky130_fd_sc_hd__buf_2
XFILLER_0_100_581 vssd1 vssd1 vccd1 vccd1 sky130_fd_sc_hd__fill_2
Xfanout1034 net1035 vssd1 vssd1 vccd1 vccd1 net1034 sky130_fd_sc_hd__dlymetal6s2s_1
Xfanout1023 mul1.a\[16\] vssd1 vssd1 vccd1 vccd1 net1023 sky130_fd_sc_hd__clkbuf_4
Xfanout1056 mul1.a\[12\] vssd1 vssd1 vccd1 vccd1 net1056 sky130_fd_sc_hd__clkbuf_8
Xfanout1045 net1048 vssd1 vssd1 vccd1 vccd1 net1045 sky130_fd_sc_hd__buf_2
XFILLER_0_107_15 vssd1 vssd1 vccd1 vccd1 sky130_ef_sc_hd__decap_12
X_10096_ _04011_ _04042_ _04041_ vssd1 vssd1 vccd1 vccd1 _04202_ sky130_fd_sc_hd__a21oi_4
Xfanout1067 net1069 vssd1 vssd1 vccd1 vccd1 net1067 sky130_fd_sc_hd__buf_2
Xfanout1078 net1080 vssd1 vssd1 vccd1 vccd1 net1078 sky130_fd_sc_hd__clkbuf_4
Xfanout1089 net1090 vssd1 vssd1 vccd1 vccd1 net1089 sky130_fd_sc_hd__clkbuf_2
XFILLER_0_89_649 vssd1 vssd1 vccd1 vccd1 sky130_fd_sc_hd__decap_3
XFILLER_0_69_351 vssd1 vssd1 vccd1 vccd1 sky130_fd_sc_hd__fill_1
X_12806_ clknet_leaf_55_clk_i _00192_ vssd1 vssd1 vccd1 vccd1 sub1.a_i\[5\] sky130_fd_sc_hd__dfxtp_1
XFILLER_0_97_693 vssd1 vssd1 vccd1 vccd1 sky130_ef_sc_hd__decap_12
X_10998_ _05095_ _05096_ vssd1 vssd1 vccd1 vccd1 _05097_ sky130_fd_sc_hd__nand2_1
XFILLER_0_123_69 vssd1 vssd1 vccd1 vccd1 sky130_ef_sc_hd__decap_12
XFILLER_0_72_505 vssd1 vssd1 vccd1 vccd1 sky130_fd_sc_hd__fill_1
XTAP_1071 vssd1 vccd1 sky130_fd_sc_hd__tapvpwrvgnd_1
XTAP_1082 vssd1 vccd1 sky130_fd_sc_hd__tapvpwrvgnd_1
XTAP_1060 vssd1 vccd1 sky130_fd_sc_hd__tapvpwrvgnd_1
X_12737_ clknet_leaf_57_clk_i _00123_ vssd1 vssd1 vccd1 vccd1 add1.a_i\[0\] sky130_fd_sc_hd__dfxtp_1
X_12668_ clknet_leaf_20_clk_i _00054_ net1178 vssd1 vssd1 vccd1 vccd1 net396 sky130_fd_sc_hd__dfrtp_1
XTAP_1093 vssd1 vccd1 sky130_fd_sc_hd__tapvpwrvgnd_1
XFILLER_0_44_207 vssd1 vssd1 vccd1 vccd1 sky130_ef_sc_hd__decap_12
XFILLER_0_115_629 vssd1 vssd1 vccd1 vccd1 sky130_ef_sc_hd__decap_12
X_11619_ _05631_ _05639_ _05638_ vssd1 vssd1 vccd1 vccd1 _05713_ sky130_fd_sc_hd__a21oi_1
XFILLER_0_114_139 vssd1 vssd1 vccd1 vccd1 sky130_fd_sc_hd__fill_1
XFILLER_0_108_681 vssd1 vssd1 vccd1 vccd1 sky130_ef_sc_hd__decap_12
XFILLER_0_106_3 vssd1 vssd1 vccd1 vccd1 sky130_ef_sc_hd__decap_12
X_12599_ net1468 net10 net556 vssd1 vssd1 vccd1 vccd1 _00574_ sky130_fd_sc_hd__mux2_1
XFILLER_0_123_673 vssd1 vssd1 vccd1 vccd1 sky130_ef_sc_hd__decap_12
XFILLER_0_13_638 vssd1 vssd1 vccd1 vccd1 sky130_fd_sc_hd__decap_4
Xhold506 temp1\[18\] vssd1 vssd1 vccd1 vccd1 net1721 sky130_fd_sc_hd__dlygate4sd3_1
Xhold517 temp1\[6\] vssd1 vssd1 vccd1 vccd1 net1732 sky130_fd_sc_hd__dlygate4sd3_1
XTAP_800 vssd1 vccd1 sky130_fd_sc_hd__tapvpwrvgnd_1
XFILLER_0_110_389 vssd1 vssd1 vccd1 vccd1 sky130_fd_sc_hd__decap_8
X_08830_ _02789_ _02792_ _02941_ _02943_ vssd1 vssd1 vccd1 vccd1 _02944_ sky130_fd_sc_hd__o211a_2
XFILLER_0_0_587 vssd1 vssd1 vccd1 vccd1 sky130_fd_sc_hd__fill_1
XTAP_811 vssd1 vccd1 sky130_fd_sc_hd__tapvpwrvgnd_1
XTAP_822 vssd1 vccd1 sky130_fd_sc_hd__tapvpwrvgnd_1
XTAP_833 vssd1 vccd1 sky130_fd_sc_hd__tapvpwrvgnd_1
XTAP_844 vssd1 vccd1 sky130_fd_sc_hd__tapvpwrvgnd_1
XTAP_855 vssd1 vccd1 sky130_fd_sc_hd__tapvpwrvgnd_1
XTAP_877 vssd1 vccd1 sky130_fd_sc_hd__tapvpwrvgnd_1
XTAP_866 vssd1 vccd1 sky130_fd_sc_hd__tapvpwrvgnd_1
X_08761_ _02868_ _02873_ vssd1 vssd1 vccd1 vccd1 _02875_ sky130_fd_sc_hd__xor2_1
XTAP_888 vssd1 vccd1 sky130_fd_sc_hd__tapvpwrvgnd_1
XTAP_899 vssd1 vccd1 sky130_fd_sc_hd__tapvpwrvgnd_1
X_08692_ _02674_ _02805_ _02806_ vssd1 vssd1 vccd1 vccd1 _02807_ sky130_fd_sc_hd__or3_1
X_07712_ _01814_ _01831_ _01832_ vssd1 vssd1 vccd1 vccd1 _01835_ sky130_fd_sc_hd__nand3_2
X_07643_ net1121 net806 _01684_ _01685_ vssd1 vssd1 vccd1 vccd1 _01766_ sky130_fd_sc_hd__a31o_1
XFILLER_0_73_85 vssd1 vssd1 vccd1 vccd1 sky130_ef_sc_hd__decap_12
X_09313_ _03301_ _03303_ vssd1 vssd1 vccd1 vccd1 _03423_ sky130_fd_sc_hd__nor2_1
X_07574_ _01688_ _01696_ vssd1 vssd1 vccd1 vccd1 _01698_ sky130_fd_sc_hd__xnor2_2
X_06525_ net544 _00784_ vssd1 vssd1 vccd1 vccd1 net297 sky130_fd_sc_hd__nor2_1
XFILLER_0_118_401 vssd1 vssd1 vccd1 vccd1 sky130_ef_sc_hd__decap_12
XFILLER_0_63_505 vssd1 vssd1 vccd1 vccd1 sky130_fd_sc_hd__decap_3
XFILLER_0_48_568 vssd1 vssd1 vccd1 vccd1 sky130_ef_sc_hd__decap_12
X_06456_ net546 _00754_ vssd1 vssd1 vccd1 vccd1 net325 sky130_fd_sc_hd__nor2_1
XFILLER_0_118_445 vssd1 vssd1 vccd1 vccd1 sky130_ef_sc_hd__decap_12
X_09244_ _03353_ _03354_ _03347_ vssd1 vssd1 vccd1 vccd1 _03355_ sky130_fd_sc_hd__a21o_1
XFILLER_0_8_643 vssd1 vssd1 vccd1 vccd1 sky130_fd_sc_hd__fill_1
XFILLER_0_7_120 vssd1 vssd1 vccd1 vccd1 sky130_fd_sc_hd__fill_1
XFILLER_0_118_489 vssd1 vssd1 vccd1 vccd1 sky130_ef_sc_hd__decap_12
X_09175_ net728 _03285_ _03284_ vssd1 vssd1 vccd1 vccd1 _03286_ sky130_fd_sc_hd__a21bo_1
X_08126_ net906 net986 vssd1 vssd1 vccd1 vccd1 _02245_ sky130_fd_sc_hd__and2_1
X_06387_ add1.a_i\[17\] add1.b_i\[17\] vssd1 vssd1 vccd1 vccd1 _00695_ sky130_fd_sc_hd__and2_1
XFILLER_0_120_109 vssd1 vssd1 vccd1 vccd1 sky130_ef_sc_hd__decap_12
XFILLER_0_102_802 vssd1 vssd1 vccd1 vccd1 sky130_fd_sc_hd__fill_1
XFILLER_0_71_593 vssd1 vssd1 vccd1 vccd1 sky130_fd_sc_hd__decap_6
XFILLER_0_113_161 vssd1 vssd1 vccd1 vccd1 sky130_fd_sc_hd__decap_6
X_08057_ net1139 net748 net740 net1147 vssd1 vssd1 vccd1 vccd1 _02176_ sky130_fd_sc_hd__a22o_1
XFILLER_0_101_334 vssd1 vssd1 vccd1 vccd1 sky130_fd_sc_hd__fill_2
X_07008_ _01120_ _01121_ _01132_ vssd1 vssd1 vccd1 vccd1 _01133_ sky130_fd_sc_hd__and3_1
XFILLER_0_101_389 vssd1 vssd1 vccd1 vccd1 sky130_fd_sc_hd__decap_3
Xinput126 v1x[13] vssd1 vssd1 vccd1 vccd1 net126 sky130_fd_sc_hd__buf_1
Xinput115 v0y[3] vssd1 vssd1 vccd1 vccd1 net115 sky130_fd_sc_hd__buf_1
Xinput104 v0y[22] vssd1 vssd1 vccd1 vccd1 net104 sky130_fd_sc_hd__buf_1
X_08959_ _02923_ _02924_ _02925_ vssd1 vssd1 vccd1 vccd1 _03072_ sky130_fd_sc_hd__a21bo_1
Xinput148 v1x[4] vssd1 vssd1 vccd1 vccd1 net148 sky130_fd_sc_hd__buf_1
Xinput159 v1y[14] vssd1 vssd1 vccd1 vccd1 net159 sky130_fd_sc_hd__buf_1
Xinput137 v1x[23] vssd1 vssd1 vccd1 vccd1 net137 sky130_fd_sc_hd__buf_1
X_11970_ net98 net622 net596 net66 vssd1 vssd1 vccd1 vccd1 _05982_ sky130_fd_sc_hd__a22o_1
XFILLER_0_98_446 vssd1 vssd1 vccd1 vccd1 sky130_fd_sc_hd__fill_1
X_10921_ _05018_ _05019_ _04983_ vssd1 vssd1 vccd1 vccd1 _05021_ sky130_fd_sc_hd__o21ai_1
XFILLER_0_79_671 vssd1 vssd1 vccd1 vccd1 sky130_fd_sc_hd__fill_1
XFILLER_0_79_693 vssd1 vssd1 vccd1 vccd1 sky130_fd_sc_hd__decap_4
X_10852_ temp1\[24\] _04952_ net542 vssd1 vssd1 vccd1 vccd1 _04953_ sky130_fd_sc_hd__mux2_1
XFILLER_0_78_192 vssd1 vssd1 vccd1 vccd1 sky130_fd_sc_hd__decap_4
XPHY_143 vssd1 vssd1 vccd1 vccd1 sky130_fd_sc_hd__decap_3
XPHY_132 vssd1 vssd1 vccd1 vccd1 sky130_fd_sc_hd__decap_3
X_10783_ _04882_ _04883_ _04871_ vssd1 vssd1 vccd1 vccd1 _04884_ sky130_fd_sc_hd__a21oi_2
XPHY_121 vssd1 vssd1 vccd1 vccd1 sky130_fd_sc_hd__decap_3
XPHY_110 vssd1 vssd1 vccd1 vccd1 sky130_fd_sc_hd__decap_3
X_12522_ net1251 net564 vssd1 vssd1 vccd1 vccd1 _06258_ sky130_fd_sc_hd__nand2_1
XFILLER_0_94_696 vssd1 vssd1 vccd1 vccd1 sky130_fd_sc_hd__decap_4
XPHY_176 vssd1 vssd1 vccd1 vccd1 sky130_fd_sc_hd__decap_3
XPHY_165 vssd1 vssd1 vccd1 vccd1 sky130_fd_sc_hd__decap_3
XPHY_154 vssd1 vssd1 vccd1 vccd1 sky130_fd_sc_hd__decap_3
XFILLER_0_54_538 vssd1 vssd1 vccd1 vccd1 sky130_fd_sc_hd__decap_6
XPHY_198 vssd1 vssd1 vccd1 vccd1 sky130_fd_sc_hd__decap_3
XPHY_187 vssd1 vssd1 vccd1 vccd1 sky130_fd_sc_hd__decap_3
XFILLER_0_81_335 vssd1 vssd1 vccd1 vccd1 sky130_fd_sc_hd__fill_1
XFILLER_0_19_281 vssd1 vssd1 vccd1 vccd1 sky130_fd_sc_hd__fill_1
XFILLER_0_81_368 vssd1 vssd1 vccd1 vccd1 sky130_fd_sc_hd__decap_3
X_12453_ _04222_ net577 _06220_ vssd1 vssd1 vccd1 vccd1 _06221_ sky130_fd_sc_hd__a21o_1
X_12384_ net1472 _00846_ net682 vssd1 vssd1 vccd1 vccd1 _00436_ sky130_fd_sc_hd__mux2_1
X_11404_ _05371_ _05374_ _05496_ _05498_ vssd1 vssd1 vccd1 vccd1 _05500_ sky130_fd_sc_hd__a211oi_2
X_11335_ _05385_ _05430_ _05431_ vssd1 vssd1 vccd1 vccd1 _05432_ sky130_fd_sc_hd__and3_2
XFILLER_0_120_643 vssd1 vssd1 vccd1 vccd1 sky130_fd_sc_hd__fill_1
XFILLER_0_104_194 vssd1 vssd1 vccd1 vccd1 sky130_fd_sc_hd__fill_2
X_11266_ net801 net791 net941 net935 vssd1 vssd1 vccd1 vccd1 _05363_ sky130_fd_sc_hd__and4_1
X_10217_ _04321_ _04320_ _04319_ vssd1 vssd1 vccd1 vccd1 _04322_ sky130_fd_sc_hd__nand3b_1
X_13005_ clknet_leaf_30_clk_i _00391_ net1165 vssd1 vssd1 vccd1 vccd1 x2mx1\[26\]
+ sky130_fd_sc_hd__dfrtp_1
XFILLER_0_94_29 vssd1 vssd1 vccd1 vccd1 sky130_ef_sc_hd__decap_12
X_11197_ _05113_ _05115_ _05293_ vssd1 vssd1 vccd1 vccd1 _05295_ sky130_fd_sc_hd__and3_1
X_10148_ _04247_ _04251_ _04252_ vssd1 vssd1 vccd1 vccd1 _04253_ sky130_fd_sc_hd__nand3_4
XFILLER_0_27_45 vssd1 vssd1 vccd1 vccd1 sky130_fd_sc_hd__fill_1
X_10079_ _04026_ _04028_ _04027_ vssd1 vssd1 vccd1 vccd1 _04185_ sky130_fd_sc_hd__a21bo_1
XFILLER_0_43_55 vssd1 vssd1 vccd1 vccd1 sky130_fd_sc_hd__fill_1
XPHY_1 vssd1 vssd1 vccd1 vccd1 sky130_fd_sc_hd__decap_3
XFILLER_0_43_88 vssd1 vssd1 vccd1 vccd1 sky130_fd_sc_hd__fill_2
XFILLER_0_85_685 vssd1 vssd1 vccd1 vccd1 sky130_fd_sc_hd__decap_8
XFILLER_0_57_365 vssd1 vssd1 vccd1 vccd1 sky130_ef_sc_hd__decap_12
X_06310_ add1.a_i\[12\] add1.b_i\[12\] vssd1 vssd1 vccd1 vccd1 _00622_ sky130_fd_sc_hd__or2_1
X_07290_ _01275_ _01277_ _01276_ vssd1 vssd1 vccd1 vccd1 _01415_ sky130_fd_sc_hd__a21o_1
XFILLER_0_84_195 vssd1 vssd1 vccd1 vccd1 sky130_fd_sc_hd__fill_1
XFILLER_0_102_109 vssd1 vssd1 vccd1 vccd1 sky130_fd_sc_hd__decap_8
Xhold325 _00075_ vssd1 vssd1 vccd1 vccd1 net1540 sky130_fd_sc_hd__dlygate4sd3_1
XFILLER_0_7_33 vssd1 vssd1 vccd1 vccd1 sky130_ef_sc_hd__decap_12
Xhold314 net369 vssd1 vssd1 vccd1 vccd1 net1529 sky130_fd_sc_hd__dlygate4sd3_1
Xhold303 l1\[7\] vssd1 vssd1 vccd1 vccd1 net1518 sky130_fd_sc_hd__dlygate4sd3_1
Xhold336 net336 vssd1 vssd1 vccd1 vccd1 net1551 sky130_fd_sc_hd__dlygate4sd3_1
Xhold347 net408 vssd1 vssd1 vccd1 vccd1 net1562 sky130_fd_sc_hd__dlygate4sd3_1
X_09931_ _04021_ _04022_ _04034_ _04036_ vssd1 vssd1 vccd1 vccd1 _04038_ sky130_fd_sc_hd__or4_4
XFILLER_0_68_63 vssd1 vssd1 vccd1 vccd1 sky130_fd_sc_hd__fill_2
Xhold369 _00041_ vssd1 vssd1 vccd1 vccd1 net1584 sky130_fd_sc_hd__dlygate4sd3_1
Xhold358 x0mx2\[19\] vssd1 vssd1 vccd1 vccd1 net1573 sky130_fd_sc_hd__dlygate4sd3_1
XFILLER_0_1_841 vssd1 vssd1 vccd1 vccd1 sky130_fd_sc_hd__fill_1
XFILLER_0_111_665 vssd1 vssd1 vccd1 vccd1 sky130_fd_sc_hd__decap_6
XFILLER_0_110_153 vssd1 vssd1 vccd1 vccd1 sky130_ef_sc_hd__decap_12
Xfanout805 net812 vssd1 vssd1 vccd1 vccd1 net805 sky130_fd_sc_hd__clkbuf_4
Xfanout816 net819 vssd1 vssd1 vccd1 vccd1 net816 sky130_fd_sc_hd__clkbuf_4
XFILLER_0_110_197 vssd1 vssd1 vccd1 vccd1 sky130_ef_sc_hd__decap_12
X_09862_ _03959_ _03968_ vssd1 vssd1 vccd1 vccd1 _03969_ sky130_fd_sc_hd__xnor2_2
Xfanout827 net828 vssd1 vssd1 vccd1 vccd1 net827 sky130_fd_sc_hd__clkbuf_2
Xfanout849 mul1.b\[9\] vssd1 vssd1 vccd1 vccd1 net849 sky130_fd_sc_hd__clkbuf_4
Xfanout838 net845 vssd1 vssd1 vccd1 vccd1 net838 sky130_fd_sc_hd__clkbuf_2
XTAP_630 vssd1 vccd1 sky130_fd_sc_hd__tapvpwrvgnd_1
XTAP_641 vssd1 vccd1 sky130_fd_sc_hd__tapvpwrvgnd_1
XTAP_652 vssd1 vccd1 sky130_fd_sc_hd__tapvpwrvgnd_1
X_09793_ _03741_ _03743_ _03899_ vssd1 vssd1 vccd1 vccd1 _03901_ sky130_fd_sc_hd__nor3_1
X_08813_ _02923_ _02924_ _02925_ vssd1 vssd1 vccd1 vccd1 _02927_ sky130_fd_sc_hd__nand3_1
XTAP_663 vssd1 vccd1 sky130_fd_sc_hd__tapvpwrvgnd_1
XTAP_685 vssd1 vccd1 sky130_fd_sc_hd__tapvpwrvgnd_1
XTAP_674 vssd1 vccd1 sky130_fd_sc_hd__tapvpwrvgnd_1
X_08744_ net1076 net773 net764 net1085 vssd1 vssd1 vccd1 vccd1 _02858_ sky130_fd_sc_hd__a22o_1
XTAP_696 vssd1 vccd1 sky130_fd_sc_hd__tapvpwrvgnd_1
XFILLER_0_30_3 vssd1 vssd1 vccd1 vccd1 sky130_ef_sc_hd__decap_12
XTAP_1807 vssd1 vccd1 sky130_fd_sc_hd__tapvpwrvgnd_1
X_08675_ _02786_ _02787_ _02644_ _02648_ vssd1 vssd1 vccd1 vccd1 _02790_ sky130_fd_sc_hd__o211a_1
XFILLER_0_67_107 vssd1 vssd1 vccd1 vccd1 sky130_fd_sc_hd__decap_4
XTAP_1829 vssd1 vccd1 sky130_fd_sc_hd__tapvpwrvgnd_1
XTAP_1818 vssd1 vccd1 sky130_fd_sc_hd__tapvpwrvgnd_1
XFILLER_0_67_129 vssd1 vssd1 vccd1 vccd1 sky130_fd_sc_hd__fill_1
X_07626_ _01747_ _01748_ _01335_ vssd1 vssd1 vccd1 vccd1 _01750_ sky130_fd_sc_hd__or3b_1
XFILLER_0_119_721 vssd1 vssd1 vccd1 vccd1 sky130_fd_sc_hd__decap_6
X_07557_ _01332_ _01680_ vssd1 vssd1 vccd1 vccd1 _01681_ sky130_fd_sc_hd__nor2_1
X_06508_ det_t\[18\] net529 vssd1 vssd1 vccd1 vccd1 net261 sky130_fd_sc_hd__and2_1
XFILLER_0_91_600 vssd1 vssd1 vccd1 vccd1 sky130_fd_sc_hd__decap_8
XFILLER_0_119_765 vssd1 vssd1 vccd1 vccd1 sky130_ef_sc_hd__decap_12
XFILLER_0_118_253 vssd1 vssd1 vccd1 vccd1 sky130_ef_sc_hd__decap_12
XFILLER_0_91_644 vssd1 vssd1 vccd1 vccd1 sky130_fd_sc_hd__fill_1
X_07488_ _01604_ _01611_ _01587_ vssd1 vssd1 vccd1 vccd1 _01613_ sky130_fd_sc_hd__o21ba_1
X_09227_ _03335_ _03336_ _03205_ _03208_ vssd1 vssd1 vccd1 vccd1 _03338_ sky130_fd_sc_hd__a211o_1
X_06439_ _00735_ _00737_ _00734_ vssd1 vssd1 vccd1 vccd1 _00740_ sky130_fd_sc_hd__a21oi_1
XFILLER_0_8_484 vssd1 vssd1 vccd1 vccd1 sky130_fd_sc_hd__decap_3
XFILLER_0_106_459 vssd1 vssd1 vccd1 vccd1 sky130_fd_sc_hd__decap_3
X_09158_ net1124 net1133 net716 net707 vssd1 vssd1 vccd1 vccd1 _03269_ sky130_fd_sc_hd__and4_1
XFILLER_0_91_699 vssd1 vssd1 vccd1 vccd1 sky130_ef_sc_hd__decap_12
XFILLER_0_90_176 vssd1 vssd1 vccd1 vccd1 sky130_fd_sc_hd__decap_4
XFILLER_0_17_785 vssd1 vssd1 vccd1 vccd1 sky130_fd_sc_hd__decap_3
XFILLER_0_17_796 vssd1 vssd1 vccd1 vccd1 sky130_fd_sc_hd__fill_2
XFILLER_0_121_429 vssd1 vssd1 vccd1 vccd1 sky130_ef_sc_hd__decap_12
XFILLER_0_102_621 vssd1 vssd1 vccd1 vccd1 sky130_fd_sc_hd__decap_4
X_09089_ _03199_ _03200_ vssd1 vssd1 vccd1 vccd1 _03201_ sky130_fd_sc_hd__nand2b_1
X_08109_ _02106_ _02108_ _02224_ _02225_ vssd1 vssd1 vccd1 vccd1 _02228_ sky130_fd_sc_hd__o211ai_2
X_11120_ _05217_ _05208_ vssd1 vssd1 vccd1 vccd1 _05218_ sky130_fd_sc_hd__nand2b_1
XFILLER_0_101_197 vssd1 vssd1 vccd1 vccd1 sky130_fd_sc_hd__fill_2
X_11051_ _05147_ _05148_ vssd1 vssd1 vccd1 vccd1 _05150_ sky130_fd_sc_hd__xor2_1
X_10002_ _03929_ _03944_ _03942_ vssd1 vssd1 vccd1 vccd1 _04108_ sky130_fd_sc_hd__a21oi_2
X_11953_ net1349 _05969_ net479 vssd1 vssd1 vccd1 vccd1 _00231_ sky130_fd_sc_hd__mux2_1
XFILLER_0_98_276 vssd1 vssd1 vccd1 vccd1 sky130_fd_sc_hd__fill_1
XFILLER_0_86_427 vssd1 vssd1 vccd1 vccd1 sky130_fd_sc_hd__fill_1
X_10904_ _05002_ _05003_ net783 net964 vssd1 vssd1 vccd1 vccd1 _05004_ sky130_fd_sc_hd__and4bb_1
X_11884_ temp1\[29\] net616 net672 net111 _05915_ vssd1 vssd1 vccd1 vccd1 _05916_
+ sky130_fd_sc_hd__a221o_1
XFILLER_0_104_27 vssd1 vssd1 vccd1 vccd1 sky130_fd_sc_hd__fill_1
X_10835_ _04895_ _04934_ _04935_ vssd1 vssd1 vccd1 vccd1 _04936_ sky130_fd_sc_hd__nand3_4
XFILLER_0_67_652 vssd1 vssd1 vccd1 vccd1 sky130_fd_sc_hd__fill_2
XFILLER_0_82_622 vssd1 vssd1 vccd1 vccd1 sky130_fd_sc_hd__decap_4
XFILLER_0_39_376 vssd1 vssd1 vccd1 vccd1 sky130_fd_sc_hd__decap_4
X_10766_ _04865_ _04866_ vssd1 vssd1 vccd1 vccd1 _04867_ sky130_fd_sc_hd__nand2b_1
XFILLER_0_13_69 vssd1 vssd1 vccd1 vccd1 sky130_ef_sc_hd__decap_12
X_12505_ _00796_ net566 _06249_ vssd1 vssd1 vccd1 vccd1 _00503_ sky130_fd_sc_hd__o21ai_1
XFILLER_0_124_212 vssd1 vssd1 vccd1 vccd1 sky130_fd_sc_hd__fill_1
XFILLER_0_120_15 vssd1 vssd1 vccd1 vccd1 sky130_ef_sc_hd__decap_12
X_10697_ _04607_ net456 _04797_ vssd1 vssd1 vccd1 vccd1 _04799_ sky130_fd_sc_hd__nor3_1
X_12436_ temp1\[12\] _06210_ net571 vssd1 vssd1 vccd1 vccd1 _00473_ sky130_fd_sc_hd__mux2_1
Xoutput408 net408 vssd1 vssd1 vccd1 vccd1 mstream_o[62] sky130_fd_sc_hd__clkbuf_4
Xoutput419 net419 vssd1 vssd1 vccd1 vccd1 mstream_o[72] sky130_fd_sc_hd__clkbuf_4
XFILLER_0_10_416 vssd1 vssd1 vccd1 vccd1 sky130_fd_sc_hd__decap_4
X_12367_ net1537 _00923_ net664 vssd1 vssd1 vccd1 vccd1 _00419_ sky130_fd_sc_hd__mux2_1
XFILLER_0_1_159 vssd1 vssd1 vccd1 vccd1 sky130_fd_sc_hd__fill_1
X_12298_ net1663 _00897_ net681 vssd1 vssd1 vccd1 vccd1 _00350_ sky130_fd_sc_hd__mux2_1
X_11318_ _05408_ _05413_ vssd1 vssd1 vccd1 vccd1 _05415_ sky130_fd_sc_hd__xor2_1
XFILLER_0_129_35 vssd1 vssd1 vccd1 vccd1 sky130_fd_sc_hd__decap_3
X_11249_ _05345_ vssd1 vssd1 vccd1 vccd1 _05346_ sky130_fd_sc_hd__inv_2
XFILLER_0_129_68 vssd1 vssd1 vccd1 vccd1 sky130_fd_sc_hd__fill_2
XFILLER_0_89_221 vssd1 vssd1 vccd1 vccd1 sky130_fd_sc_hd__decap_3
X_06790_ net1445 net1381 net641 vssd1 vssd1 vccd1 vccd1 _00064_ sky130_fd_sc_hd__mux2_1
XFILLER_0_77_405 vssd1 vssd1 vccd1 vccd1 sky130_fd_sc_hd__decap_4
XFILLER_0_54_65 vssd1 vssd1 vccd1 vccd1 sky130_fd_sc_hd__decap_4
X_08460_ net1067 net805 _02467_ _02468_ net823 vssd1 vssd1 vccd1 vccd1 _02576_ sky130_fd_sc_hd__a32o_1
X_08391_ _02505_ _02506_ _02507_ vssd1 vssd1 vccd1 vccd1 _02508_ sky130_fd_sc_hd__nand3_2
X_07411_ _01533_ _01534_ vssd1 vssd1 vccd1 vccd1 _01536_ sky130_fd_sc_hd__xnor2_1
X_07342_ _01410_ _01412_ _01411_ vssd1 vssd1 vccd1 vccd1 _01467_ sky130_fd_sc_hd__a21o_1
XFILLER_0_45_346 vssd1 vssd1 vccd1 vccd1 sky130_fd_sc_hd__decap_4
XFILLER_0_45_335 vssd1 vssd1 vccd1 vccd1 sky130_fd_sc_hd__fill_1
XFILLER_0_115_223 vssd1 vssd1 vccd1 vccd1 sky130_fd_sc_hd__fill_1
XFILLER_0_33_519 vssd1 vssd1 vccd1 vccd1 sky130_fd_sc_hd__decap_4
X_07273_ _01256_ _01266_ _01396_ _01397_ vssd1 vssd1 vccd1 vccd1 _01398_ sky130_fd_sc_hd__o211a_1
X_09012_ _03122_ _03123_ vssd1 vssd1 vccd1 vccd1 _03124_ sky130_fd_sc_hd__or2_1
XFILLER_0_61_839 vssd1 vssd1 vccd1 vccd1 sky130_fd_sc_hd__fill_1
XFILLER_0_78_3 vssd1 vssd1 vccd1 vccd1 sky130_ef_sc_hd__decap_12
Xhold100 sub1.b_i\[10\] vssd1 vssd1 vccd1 vccd1 net1315 sky130_fd_sc_hd__dlygate4sd3_1
XFILLER_0_14_755 vssd1 vssd1 vccd1 vccd1 sky130_fd_sc_hd__fill_1
XFILLER_0_41_541 vssd1 vssd1 vccd1 vccd1 sky130_fd_sc_hd__decap_6
Xhold122 l0\[2\] vssd1 vssd1 vccd1 vccd1 net1337 sky130_fd_sc_hd__dlygate4sd3_1
Xhold111 add1.b_i\[13\] vssd1 vssd1 vccd1 vccd1 net1326 sky130_fd_sc_hd__dlygate4sd3_1
Xhold133 sub1.b_i\[21\] vssd1 vssd1 vccd1 vccd1 net1348 sky130_fd_sc_hd__dlygate4sd3_1
Xhold144 sub1.b_i\[3\] vssd1 vssd1 vccd1 vccd1 net1359 sky130_fd_sc_hd__dlygate4sd3_1
XFILLER_0_111_473 vssd1 vssd1 vccd1 vccd1 sky130_ef_sc_hd__decap_12
Xhold177 _00066_ vssd1 vssd1 vccd1 vccd1 net1392 sky130_fd_sc_hd__dlygate4sd3_1
Xhold166 l1\[29\] vssd1 vssd1 vccd1 vccd1 net1381 sky130_fd_sc_hd__dlygate4sd3_1
Xhold155 l1\[16\] vssd1 vssd1 vccd1 vccd1 net1370 sky130_fd_sc_hd__dlygate4sd3_1
XFILLER_0_1_671 vssd1 vssd1 vccd1 vccd1 sky130_fd_sc_hd__fill_1
XFILLER_0_41_596 vssd1 vssd1 vccd1 vccd1 sky130_fd_sc_hd__decap_4
Xhold199 net338 vssd1 vssd1 vccd1 vccd1 net1414 sky130_fd_sc_hd__dlygate4sd3_1
Xhold188 l0\[21\] vssd1 vssd1 vccd1 vccd1 net1403 sky130_fd_sc_hd__dlygate4sd3_1
X_09914_ _04019_ _04020_ _04012_ vssd1 vssd1 vccd1 vccd1 _04021_ sky130_fd_sc_hd__a21oi_1
Xfanout613 net614 vssd1 vssd1 vccd1 vccd1 net613 sky130_fd_sc_hd__clkbuf_4
Xfanout602 net604 vssd1 vssd1 vccd1 vccd1 net602 sky130_fd_sc_hd__clkbuf_4
Xfanout624 _00986_ vssd1 vssd1 vccd1 vccd1 net624 sky130_fd_sc_hd__clkbuf_4
Xfanout646 net647 vssd1 vssd1 vccd1 vccd1 net646 sky130_fd_sc_hd__clkbuf_4
X_09845_ _03909_ _03951_ vssd1 vssd1 vccd1 vccd1 _03952_ sky130_fd_sc_hd__and2b_1
XTAP_460 vssd1 vccd1 sky130_fd_sc_hd__tapvpwrvgnd_1
Xfanout635 net636 vssd1 vssd1 vccd1 vccd1 net635 sky130_fd_sc_hd__clkbuf_4
Xfanout657 net658 vssd1 vssd1 vccd1 vccd1 net657 sky130_fd_sc_hd__buf_4
XFILLER_0_95_94 vssd1 vssd1 vccd1 vccd1 sky130_fd_sc_hd__decap_6
Xfanout679 net680 vssd1 vssd1 vccd1 vccd1 net679 sky130_fd_sc_hd__clkbuf_4
XTAP_471 vssd1 vccd1 sky130_fd_sc_hd__tapvpwrvgnd_1
XTAP_493 vssd1 vccd1 sky130_fd_sc_hd__tapvpwrvgnd_1
XTAP_482 vssd1 vccd1 sky130_fd_sc_hd__tapvpwrvgnd_1
Xfanout668 _00998_ vssd1 vssd1 vccd1 vccd1 net668 sky130_fd_sc_hd__clkbuf_4
X_09776_ _03693_ _03725_ _03724_ vssd1 vssd1 vccd1 vccd1 _03884_ sky130_fd_sc_hd__a21bo_2
X_06988_ net881 net1081 vssd1 vssd1 vccd1 vccd1 _01113_ sky130_fd_sc_hd__nand2_1
X_08727_ _02677_ _02686_ _02687_ _02689_ _02551_ vssd1 vssd1 vccd1 vccd1 _02841_ sky130_fd_sc_hd__o32a_1
XFILLER_0_96_725 vssd1 vssd1 vccd1 vccd1 sky130_ef_sc_hd__decap_12
XTAP_1615 vssd1 vccd1 sky130_fd_sc_hd__tapvpwrvgnd_1
XTAP_1604 vssd1 vccd1 sky130_fd_sc_hd__tapvpwrvgnd_1
X_08658_ net908 net961 vssd1 vssd1 vccd1 vccd1 _02773_ sky130_fd_sc_hd__and2_1
XTAP_1648 vssd1 vccd1 sky130_fd_sc_hd__tapvpwrvgnd_1
XTAP_1637 vssd1 vccd1 sky130_fd_sc_hd__tapvpwrvgnd_1
XTAP_1626 vssd1 vccd1 sky130_fd_sc_hd__tapvpwrvgnd_1
XFILLER_0_68_449 vssd1 vssd1 vccd1 vccd1 sky130_fd_sc_hd__decap_4
X_07609_ _01729_ _01730_ _01731_ vssd1 vssd1 vccd1 vccd1 _01733_ sky130_fd_sc_hd__a21o_1
X_08589_ _02702_ _02703_ vssd1 vssd1 vccd1 vccd1 _02704_ sky130_fd_sc_hd__xor2_1
XTAP_1659 vssd1 vccd1 sky130_fd_sc_hd__tapvpwrvgnd_1
XFILLER_0_119_573 vssd1 vssd1 vccd1 vccd1 sky130_ef_sc_hd__decap_12
XFILLER_0_91_430 vssd1 vssd1 vccd1 vccd1 sky130_fd_sc_hd__decap_3
XFILLER_0_76_482 vssd1 vssd1 vccd1 vccd1 sky130_fd_sc_hd__fill_1
X_10620_ _04719_ _04720_ vssd1 vssd1 vccd1 vccd1 _04722_ sky130_fd_sc_hd__xor2_1
XFILLER_0_107_735 vssd1 vssd1 vccd1 vccd1 sky130_fd_sc_hd__fill_1
X_10551_ _04607_ _04608_ _04650_ _04651_ vssd1 vssd1 vccd1 vccd1 _04654_ sky130_fd_sc_hd__o22ai_1
XFILLER_0_64_655 vssd1 vssd1 vccd1 vccd1 sky130_fd_sc_hd__decap_3
XFILLER_0_24_519 vssd1 vssd1 vccd1 vccd1 sky130_ef_sc_hd__decap_12
X_10482_ net803 net792 net977 net971 vssd1 vssd1 vccd1 vccd1 _04585_ sky130_fd_sc_hd__nand4_2
XFILLER_0_63_176 vssd1 vssd1 vccd1 vccd1 sky130_fd_sc_hd__decap_3
XFILLER_0_122_749 vssd1 vssd1 vccd1 vccd1 sky130_fd_sc_hd__decap_6
X_12221_ net776 _06167_ net516 vssd1 vssd1 vccd1 vccd1 _00301_ sky130_fd_sc_hd__mux2_1
XFILLER_0_121_237 vssd1 vssd1 vccd1 vccd1 sky130_ef_sc_hd__decap_12
X_12152_ x0mx2\[29\] net632 net593 y1my2\[29\] vssd1 vssd1 vccd1 vccd1 _06120_ sky130_fd_sc_hd__a22o_1
X_11103_ _04951_ _05079_ vssd1 vssd1 vccd1 vccd1 _05202_ sky130_fd_sc_hd__nand2_1
X_12083_ net1061 _06068_ net514 vssd1 vssd1 vccd1 vccd1 _00262_ sky130_fd_sc_hd__mux2_1
X_11034_ _04976_ _04978_ _05131_ _05132_ vssd1 vssd1 vccd1 vccd1 _05133_ sky130_fd_sc_hd__o211a_2
X_12985_ clknet_leaf_52_clk_i _00371_ net1153 vssd1 vssd1 vccd1 vccd1 x2mx1\[6\] sky130_fd_sc_hd__dfrtp_1
XFILLER_0_115_15 vssd1 vssd1 vccd1 vccd1 sky130_ef_sc_hd__decap_12
XFILLER_0_99_585 vssd1 vssd1 vccd1 vccd1 sky130_fd_sc_hd__fill_2
X_11936_ net152 net659 net502 net248 _05956_ vssd1 vssd1 vccd1 vccd1 _05957_ sky130_fd_sc_hd__a221o_1
XFILLER_0_59_449 vssd1 vssd1 vccd1 vccd1 sky130_fd_sc_hd__decap_3
XFILLER_0_129_337 vssd1 vssd1 vccd1 vccd1 sky130_fd_sc_hd__fill_2
X_11867_ net236 net600 net580 net140 _05901_ vssd1 vssd1 vccd1 vccd1 _05902_ sky130_fd_sc_hd__a221o_1
X_10818_ net1036 net719 _04916_ _04917_ vssd1 vssd1 vccd1 vccd1 _04919_ sky130_fd_sc_hd__o2bb2a_1
X_11798_ net65 net678 net601 net225 _00601_ vssd1 vssd1 vccd1 vccd1 _05843_ sky130_fd_sc_hd__a221o_1
X_10749_ _04829_ _04847_ _04848_ vssd1 vssd1 vccd1 vccd1 _04850_ sky130_fd_sc_hd__nand3_2
XFILLER_0_54_154 vssd1 vssd1 vccd1 vccd1 sky130_fd_sc_hd__fill_1
XFILLER_0_27_346 vssd1 vssd1 vccd1 vccd1 sky130_fd_sc_hd__fill_2
XFILLER_0_113_727 vssd1 vssd1 vccd1 vccd1 sky130_fd_sc_hd__fill_1
XFILLER_0_10_202 vssd1 vssd1 vccd1 vccd1 sky130_fd_sc_hd__decap_3
XFILLER_0_23_585 vssd1 vssd1 vccd1 vccd1 sky130_fd_sc_hd__fill_2
X_12419_ _00828_ net612 _02060_ net574 vssd1 vssd1 vccd1 vccd1 _06202_ sky130_fd_sc_hd__a22o_1
XFILLER_0_49_54 vssd1 vssd1 vccd1 vccd1 sky130_fd_sc_hd__fill_2
X_07960_ net795 _02079_ _02078_ vssd1 vssd1 vccd1 vccd1 _02080_ sky130_fd_sc_hd__a21oi_1
X_06911_ _01034_ _01035_ vssd1 vssd1 vccd1 vccd1 _01036_ sky130_fd_sc_hd__nand2_1
X_07891_ _02010_ _02011_ vssd1 vssd1 vccd1 vccd1 _02012_ sky130_fd_sc_hd__nor2_1
X_06842_ net1369 net1357 net649 vssd1 vssd1 vccd1 vccd1 _00116_ sky130_fd_sc_hd__mux2_1
X_09630_ _03589_ _03737_ _03738_ vssd1 vssd1 vccd1 vccd1 _03739_ sky130_fd_sc_hd__nand3_1
X_09561_ _03635_ _03667_ _03668_ vssd1 vssd1 vccd1 vccd1 _03670_ sky130_fd_sc_hd__and3_1
X_06773_ net1574 net1500 net638 vssd1 vssd1 vccd1 vccd1 _00047_ sky130_fd_sc_hd__mux2_1
X_08512_ net885 net987 vssd1 vssd1 vccd1 vccd1 _02628_ sky130_fd_sc_hd__nand2_1
X_09492_ _03426_ _03427_ vssd1 vssd1 vccd1 vccd1 _03601_ sky130_fd_sc_hd__or2_1
X_08443_ _02546_ _02557_ vssd1 vssd1 vccd1 vccd1 _02559_ sky130_fd_sc_hd__xnor2_2
XFILLER_0_77_279 vssd1 vssd1 vccd1 vccd1 sky130_fd_sc_hd__fill_1
XFILLER_0_19_814 vssd1 vssd1 vccd1 vccd1 sky130_fd_sc_hd__fill_2
XFILLER_0_105_81 vssd1 vssd1 vccd1 vccd1 sky130_ef_sc_hd__decap_12
XFILLER_0_92_238 vssd1 vssd1 vccd1 vccd1 sky130_fd_sc_hd__decap_4
X_08374_ net1015 net857 _02488_ _02489_ vssd1 vssd1 vccd1 vccd1 _02491_ sky130_fd_sc_hd__a22o_1
X_07325_ _01442_ _01447_ _01448_ vssd1 vssd1 vccd1 vccd1 _01450_ sky130_fd_sc_hd__and3_1
XFILLER_0_61_614 vssd1 vssd1 vccd1 vccd1 sky130_fd_sc_hd__fill_2
X_07256_ _01377_ _01378_ _01379_ vssd1 vssd1 vccd1 vccd1 _01381_ sky130_fd_sc_hd__a21o_1
XFILLER_0_5_240 vssd1 vssd1 vccd1 vccd1 sky130_fd_sc_hd__fill_1
XFILLER_0_116_587 vssd1 vssd1 vccd1 vccd1 sky130_fd_sc_hd__fill_1
XFILLER_0_104_749 vssd1 vssd1 vccd1 vccd1 sky130_fd_sc_hd__decap_6
XFILLER_0_60_179 vssd1 vssd1 vccd1 vccd1 sky130_fd_sc_hd__decap_4
X_07187_ _01059_ _01311_ vssd1 vssd1 vccd1 vccd1 _01312_ sky130_fd_sc_hd__nor2_1
XFILLER_0_111_281 vssd1 vssd1 vccd1 vccd1 sky130_ef_sc_hd__decap_12
X_09828_ net1086 net719 vssd1 vssd1 vccd1 vccd1 _03935_ sky130_fd_sc_hd__nand2_1
Xfanout476 _05765_ vssd1 vssd1 vccd1 vccd1 net476 sky130_fd_sc_hd__clkbuf_2
XTAP_290 vssd1 vccd1 sky130_fd_sc_hd__tapvpwrvgnd_1
X_09759_ net883 net940 _03865_ _03866_ vssd1 vssd1 vccd1 vccd1 _03867_ sky130_fd_sc_hd__nand4_2
XTAP_2135 vssd1 vccd1 sky130_fd_sc_hd__tapvpwrvgnd_1
XTAP_2124 vssd1 vccd1 sky130_fd_sc_hd__tapvpwrvgnd_1
XTAP_2113 vssd1 vccd1 sky130_fd_sc_hd__tapvpwrvgnd_1
XTAP_2102 vssd1 vccd1 sky130_fd_sc_hd__tapvpwrvgnd_1
XTAP_2157 vssd1 vccd1 sky130_fd_sc_hd__tapvpwrvgnd_1
XTAP_2168 vssd1 vccd1 sky130_fd_sc_hd__tapvpwrvgnd_1
XTAP_2146 vssd1 vccd1 sky130_fd_sc_hd__tapvpwrvgnd_1
XTAP_1423 vssd1 vccd1 sky130_fd_sc_hd__tapvpwrvgnd_1
XTAP_1412 vssd1 vccd1 sky130_fd_sc_hd__tapvpwrvgnd_1
XTAP_1401 vssd1 vccd1 sky130_fd_sc_hd__tapvpwrvgnd_1
X_12770_ clknet_leaf_57_clk_i _00156_ vssd1 vssd1 vccd1 vccd1 add1.b_i\[1\] sky130_fd_sc_hd__dfxtp_1
XTAP_2179 vssd1 vccd1 sky130_fd_sc_hd__tapvpwrvgnd_1
XFILLER_0_83_205 vssd1 vssd1 vccd1 vccd1 sky130_fd_sc_hd__decap_6
XTAP_1456 vssd1 vccd1 sky130_fd_sc_hd__tapvpwrvgnd_1
XTAP_1445 vssd1 vccd1 sky130_fd_sc_hd__tapvpwrvgnd_1
XTAP_1434 vssd1 vccd1 sky130_fd_sc_hd__tapvpwrvgnd_1
XFILLER_0_56_419 vssd1 vssd1 vccd1 vccd1 sky130_fd_sc_hd__fill_1
XFILLER_0_56_408 vssd1 vssd1 vccd1 vccd1 sky130_fd_sc_hd__fill_1
X_11721_ net83 net677 net607 net211 vssd1 vssd1 vccd1 vccd1 _05779_ sky130_fd_sc_hd__a22o_1
XFILLER_0_83_249 vssd1 vssd1 vccd1 vccd1 sky130_fd_sc_hd__fill_1
XTAP_1489 vssd1 vccd1 sky130_fd_sc_hd__tapvpwrvgnd_1
XTAP_1467 vssd1 vccd1 sky130_fd_sc_hd__tapvpwrvgnd_1
XTAP_1478 vssd1 vccd1 sky130_fd_sc_hd__tapvpwrvgnd_1
X_11652_ _05744_ _05745_ vssd1 vssd1 vccd1 vccd1 _05746_ sky130_fd_sc_hd__xnor2_1
XFILLER_0_107_510 vssd1 vssd1 vccd1 vccd1 sky130_fd_sc_hd__fill_2
X_10603_ _04702_ _04703_ _04684_ vssd1 vssd1 vccd1 vccd1 _04705_ sky130_fd_sc_hd__a21o_1
XFILLER_0_51_113 vssd1 vssd1 vccd1 vccd1 sky130_ef_sc_hd__decap_12
X_11583_ net969 net735 _05571_ _05572_ net957 vssd1 vssd1 vccd1 vccd1 _05677_ sky130_fd_sc_hd__a32o_1
XFILLER_0_37_699 vssd1 vssd1 vccd1 vccd1 sky130_fd_sc_hd__decap_3
XFILLER_0_122_513 vssd1 vssd1 vccd1 vccd1 sky130_ef_sc_hd__decap_12
XFILLER_0_107_598 vssd1 vssd1 vccd1 vccd1 sky130_ef_sc_hd__decap_12
XFILLER_0_101_39 vssd1 vssd1 vccd1 vccd1 sky130_ef_sc_hd__decap_12
X_10534_ _04634_ _04635_ _04630_ vssd1 vssd1 vccd1 vccd1 _04637_ sky130_fd_sc_hd__a21o_1
XFILLER_0_10_15 vssd1 vssd1 vccd1 vccd1 sky130_ef_sc_hd__decap_12
XFILLER_0_40_809 vssd1 vssd1 vccd1 vccd1 sky130_fd_sc_hd__decap_3
XFILLER_0_122_557 vssd1 vssd1 vccd1 vccd1 sky130_ef_sc_hd__decap_12
X_10465_ net1022 net1013 net744 vssd1 vssd1 vccd1 vccd1 _04568_ sky130_fd_sc_hd__and3_1
X_10396_ _04483_ _04496_ _04498_ vssd1 vssd1 vccd1 vccd1 _04500_ sky130_fd_sc_hd__and3_1
X_13184_ clknet_leaf_20_clk_i _00570_ net1180 vssd1 vssd1 vccd1 vccd1 l1\[13\] sky130_fd_sc_hd__dfrtp_1
X_12204_ x2mx1\[13\] net603 net584 temp1\[13\] vssd1 vssd1 vccd1 vccd1 _06156_ sky130_fd_sc_hd__a22o_1
XFILLER_0_32_382 vssd1 vssd1 vccd1 vccd1 sky130_fd_sc_hd__decap_4
X_12135_ net966 _06107_ net517 vssd1 vssd1 vccd1 vccd1 _00275_ sky130_fd_sc_hd__mux2_1
XFILLER_0_102_292 vssd1 vssd1 vccd1 vccd1 sky130_fd_sc_hd__decap_6
XFILLER_0_19_57 vssd1 vssd1 vccd1 vccd1 sky130_ef_sc_hd__decap_12
X_12066_ _00846_ _06055_ net499 vssd1 vssd1 vccd1 vccd1 _06056_ sky130_fd_sc_hd__mux2_1
X_11017_ _05106_ _05114_ vssd1 vssd1 vccd1 vccd1 _05116_ sky130_fd_sc_hd__nand2_1
XFILLER_0_99_382 vssd1 vssd1 vccd1 vccd1 sky130_fd_sc_hd__decap_4
XFILLER_0_99_393 vssd1 vssd1 vccd1 vccd1 sky130_fd_sc_hd__fill_1
X_12968_ clknet_leaf_35_clk_i _00354_ net1167 vssd1 vssd1 vccd1 vccd1 y1my2\[21\]
+ sky130_fd_sc_hd__dfrtp_1
XFILLER_0_59_279 vssd1 vssd1 vccd1 vccd1 sky130_fd_sc_hd__fill_1
X_11919_ net29 net549 net624 net212 _05943_ vssd1 vssd1 vccd1 vccd1 _05944_ sky130_fd_sc_hd__a221o_1
X_12899_ clknet_leaf_48_clk_i _00285_ vssd1 vssd1 vccd1 vccd1 mul1.b\[2\] sky130_fd_sc_hd__dfxtp_1
XFILLER_0_28_633 vssd1 vssd1 vccd1 vccd1 sky130_fd_sc_hd__fill_1
XFILLER_0_117_329 vssd1 vssd1 vccd1 vccd1 sky130_fd_sc_hd__decap_6
XTAP_1990 vssd1 vccd1 sky130_fd_sc_hd__tapvpwrvgnd_1
XFILLER_0_83_783 vssd1 vssd1 vccd1 vccd1 sky130_fd_sc_hd__fill_1
X_07110_ net1096 net847 net838 net1104 vssd1 vssd1 vccd1 vccd1 _01235_ sky130_fd_sc_hd__nand4_4
XFILLER_0_15_316 vssd1 vssd1 vccd1 vccd1 sky130_fd_sc_hd__decap_4
X_08090_ net1084 net805 vssd1 vssd1 vccd1 vccd1 _02209_ sky130_fd_sc_hd__nand2_1
XFILLER_0_43_647 vssd1 vssd1 vccd1 vccd1 sky130_fd_sc_hd__decap_3
XFILLER_0_3_700 vssd1 vssd1 vccd1 vccd1 sky130_fd_sc_hd__fill_1
X_07041_ _01162_ _01165_ vssd1 vssd1 vccd1 vccd1 _01166_ sky130_fd_sc_hd__xor2_2
XFILLER_0_100_207 vssd1 vssd1 vccd1 vccd1 sky130_fd_sc_hd__decap_3
XFILLER_0_23_393 vssd1 vssd1 vccd1 vccd1 sky130_fd_sc_hd__fill_1
X_08992_ _02958_ _03104_ vssd1 vssd1 vccd1 vccd1 _03105_ sky130_fd_sc_hd__nand2_1
XFILLER_0_76_85 vssd1 vssd1 vccd1 vccd1 sky130_fd_sc_hd__fill_2
X_07943_ _01963_ _01981_ _01983_ vssd1 vssd1 vccd1 vccd1 _02063_ sky130_fd_sc_hd__or3_1
X_07874_ _01993_ _01994_ vssd1 vssd1 vccd1 vccd1 _01995_ sky130_fd_sc_hd__nor2_1
X_06825_ net1335 net1334 net649 vssd1 vssd1 vccd1 vccd1 _00099_ sky130_fd_sc_hd__mux2_1
X_09613_ _03720_ _03721_ _03703_ vssd1 vssd1 vccd1 vccd1 _03722_ sky130_fd_sc_hd__a21oi_1
X_09544_ net1017 net793 net1009 net804 vssd1 vssd1 vccd1 vccd1 _03653_ sky130_fd_sc_hd__a22o_1
XFILLER_0_78_544 vssd1 vssd1 vccd1 vccd1 sky130_fd_sc_hd__fill_1
X_06756_ net1597 _00970_ net637 vssd1 vssd1 vccd1 vccd1 _00033_ sky130_fd_sc_hd__mux2_1
X_09475_ _03108_ _03109_ _03583_ vssd1 vssd1 vccd1 vccd1 _03584_ sky130_fd_sc_hd__a21o_1
X_06687_ _00904_ _00907_ _00905_ vssd1 vssd1 vccd1 vccd1 _00912_ sky130_fd_sc_hd__a21oi_4
XFILLER_0_108_307 vssd1 vssd1 vccd1 vccd1 sky130_fd_sc_hd__fill_1
XFILLER_0_59_780 vssd1 vssd1 vccd1 vccd1 sky130_fd_sc_hd__decap_4
X_08426_ temp1\[8\] _02542_ net540 vssd1 vssd1 vccd1 vccd1 _02543_ sky130_fd_sc_hd__mux2_1
XFILLER_0_18_132 vssd1 vssd1 vccd1 vccd1 sky130_fd_sc_hd__decap_8
XFILLER_0_117_841 vssd1 vssd1 vccd1 vccd1 sky130_fd_sc_hd__fill_1
X_08357_ _02472_ _02473_ _02471_ vssd1 vssd1 vccd1 vccd1 _02474_ sky130_fd_sc_hd__a21o_1
X_08288_ _02278_ _02279_ _02281_ _02283_ vssd1 vssd1 vccd1 vccd1 _02406_ sky130_fd_sc_hd__o22a_1
X_07308_ net871 net1118 net1126 net862 vssd1 vssd1 vccd1 vccd1 _01433_ sky130_fd_sc_hd__a22o_1
XFILLER_0_33_113 vssd1 vssd1 vccd1 vccd1 sky130_fd_sc_hd__fill_1
Xbary_pipe_m_1208 vssd1 vssd1 vccd1 vccd1 bary_pipe_m_1208/HI div_mstream_o[58] sky130_fd_sc_hd__conb_1
X_07239_ _01362_ _01363_ vssd1 vssd1 vccd1 vccd1 _01364_ sky130_fd_sc_hd__or2_1
XFILLER_0_21_308 vssd1 vssd1 vccd1 vccd1 sky130_fd_sc_hd__fill_2
X_10250_ _04197_ net506 _04353_ _04354_ vssd1 vssd1 vccd1 vccd1 _04355_ sky130_fd_sc_hd__o211ai_4
X_10181_ _04276_ _04285_ vssd1 vssd1 vccd1 vccd1 _04286_ sky130_fd_sc_hd__xnor2_2
X_12822_ clknet_leaf_35_clk_i _00208_ vssd1 vssd1 vccd1 vccd1 sub1.a_i\[21\] sky130_fd_sc_hd__dfxtp_1
XFILLER_0_69_577 vssd1 vssd1 vccd1 vccd1 sky130_fd_sc_hd__fill_2
XTAP_1231 vssd1 vccd1 sky130_fd_sc_hd__tapvpwrvgnd_1
XTAP_1220 vssd1 vccd1 sky130_fd_sc_hd__tapvpwrvgnd_1
X_12753_ clknet_leaf_41_clk_i _00139_ vssd1 vssd1 vccd1 vccd1 add1.a_i\[16\] sky130_fd_sc_hd__dfxtp_1
XTAP_1275 vssd1 vccd1 sky130_fd_sc_hd__tapvpwrvgnd_1
XTAP_1264 vssd1 vccd1 sky130_fd_sc_hd__tapvpwrvgnd_1
XTAP_1253 vssd1 vccd1 sky130_fd_sc_hd__tapvpwrvgnd_1
XTAP_1242 vssd1 vccd1 sky130_fd_sc_hd__tapvpwrvgnd_1
X_11704_ net671 _05756_ net580 vssd1 vssd1 vccd1 vccd1 _05765_ sky130_fd_sc_hd__nor3_4
XFILLER_0_127_649 vssd1 vssd1 vccd1 vccd1 sky130_fd_sc_hd__fill_2
X_12684_ clknet_leaf_14_clk_i net1231 net1184 vssd1 vssd1 vccd1 vccd1 net413 sky130_fd_sc_hd__dfrtp_1
XTAP_1297 vssd1 vccd1 sky130_fd_sc_hd__tapvpwrvgnd_1
XTAP_1286 vssd1 vccd1 sky130_fd_sc_hd__tapvpwrvgnd_1
XFILLER_0_37_430 vssd1 vssd1 vccd1 vccd1 sky130_fd_sc_hd__fill_2
XFILLER_0_112_27 vssd1 vssd1 vccd1 vccd1 sky130_fd_sc_hd__fill_1
X_11635_ net750 net954 vssd1 vssd1 vccd1 vccd1 _05729_ sky130_fd_sc_hd__nand2_1
XFILLER_0_21_69 vssd1 vssd1 vccd1 vccd1 sky130_fd_sc_hd__decap_4
XFILLER_0_25_647 vssd1 vssd1 vccd1 vccd1 sky130_fd_sc_hd__decap_3
X_11566_ _05550_ _05552_ _05659_ vssd1 vssd1 vccd1 vccd1 _05661_ sky130_fd_sc_hd__nor3_1
XFILLER_0_122_321 vssd1 vssd1 vccd1 vccd1 sky130_ef_sc_hd__decap_12
X_10517_ _04617_ _04618_ vssd1 vssd1 vccd1 vccd1 _04620_ sky130_fd_sc_hd__nor2_1
X_13236_ net508 vssd1 vssd1 vccd1 vccd1 net292 sky130_fd_sc_hd__clkbuf_1
XFILLER_0_122_365 vssd1 vssd1 vccd1 vccd1 sky130_ef_sc_hd__decap_12
X_11497_ _05586_ _05590_ _05591_ vssd1 vssd1 vccd1 vccd1 _05592_ sky130_fd_sc_hd__and3_1
X_10448_ net841 net942 net938 net851 vssd1 vssd1 vccd1 vccd1 _04551_ sky130_fd_sc_hd__a22o_1
XFILLER_0_0_725 vssd1 vssd1 vccd1 vccd1 sky130_fd_sc_hd__decap_3
X_13167_ clknet_leaf_9_clk_i _00553_ net1190 vssd1 vssd1 vccd1 vccd1 l0\[28\] sky130_fd_sc_hd__dfrtp_1
X_10379_ _04474_ _04482_ vssd1 vssd1 vccd1 vccd1 _04483_ sky130_fd_sc_hd__xnor2_2
X_13098_ clknet_leaf_17_clk_i _00484_ vssd1 vssd1 vccd1 vccd1 temp1\[23\] sky130_fd_sc_hd__dfxtp_1
X_12118_ _00913_ _06094_ net500 vssd1 vssd1 vccd1 vccd1 _06095_ sky130_fd_sc_hd__mux2_1
X_12049_ y2my0\[3\] net582 net531 x2mx1\[3\] _06042_ vssd1 vssd1 vccd1 vccd1 _06043_
+ sky130_fd_sc_hd__a221o_1
Xclkbuf_leaf_52_clk_i clknet_3_0__leaf_clk_i vssd1 vssd1 vccd1 vccd1 clknet_leaf_52_clk_i
+ sky130_fd_sc_hd__clkbuf_16
XFILLER_0_46_88 vssd1 vssd1 vccd1 vccd1 sky130_ef_sc_hd__decap_12
XFILLER_0_27_9 vssd1 vssd1 vccd1 vccd1 sky130_ef_sc_hd__decap_12
X_07590_ net1050 net882 vssd1 vssd1 vccd1 vccd1 _01714_ sky130_fd_sc_hd__and2_1
X_06610_ sub1.a_i\[8\] sub1.b_i\[8\] vssd1 vssd1 vccd1 vccd1 _00847_ sky130_fd_sc_hd__and2b_1
XFILLER_0_75_503 vssd1 vssd1 vccd1 vccd1 sky130_fd_sc_hd__fill_1
X_06541_ _00635_ _00666_ vssd1 vssd1 vccd1 vccd1 _00794_ sky130_fd_sc_hd__xor2_4
XFILLER_0_1_57 vssd1 vssd1 vccd1 vccd1 sky130_fd_sc_hd__fill_2
X_09260_ net883 net956 vssd1 vssd1 vccd1 vccd1 _03371_ sky130_fd_sc_hd__and2_1
X_06472_ _00765_ _00768_ vssd1 vssd1 vccd1 vccd1 _00769_ sky130_fd_sc_hd__xnor2_4
X_08211_ _02292_ _02326_ _02327_ vssd1 vssd1 vccd1 vccd1 _02329_ sky130_fd_sc_hd__nand3_2
XFILLER_0_117_137 vssd1 vssd1 vccd1 vccd1 sky130_ef_sc_hd__decap_12
X_09191_ _03299_ _03300_ _03185_ _03189_ vssd1 vssd1 vccd1 vccd1 _03302_ sky130_fd_sc_hd__o211a_1
XFILLER_0_43_400 vssd1 vssd1 vccd1 vccd1 sky130_fd_sc_hd__fill_1
XFILLER_0_71_753 vssd1 vssd1 vccd1 vccd1 sky130_fd_sc_hd__fill_1
X_08142_ _02142_ _02145_ _02258_ _02259_ vssd1 vssd1 vccd1 vccd1 _02261_ sky130_fd_sc_hd__a211oi_4
XFILLER_0_15_113 vssd1 vssd1 vccd1 vccd1 sky130_fd_sc_hd__decap_8
XFILLER_0_126_693 vssd1 vssd1 vccd1 vccd1 sky130_fd_sc_hd__decap_6
X_08073_ net1091 net795 net786 net1098 vssd1 vssd1 vccd1 vccd1 _02192_ sky130_fd_sc_hd__a22oi_1
XFILLER_0_31_606 vssd1 vssd1 vccd1 vccd1 sky130_fd_sc_hd__decap_8
XFILLER_0_31_628 vssd1 vssd1 vccd1 vccd1 sky130_ef_sc_hd__decap_12
XFILLER_0_101_505 vssd1 vssd1 vccd1 vccd1 sky130_ef_sc_hd__decap_12
XFILLER_0_3_552 vssd1 vssd1 vccd1 vccd1 sky130_fd_sc_hd__fill_1
X_07024_ _01147_ _01148_ _01143_ vssd1 vssd1 vccd1 vccd1 _01149_ sky130_fd_sc_hd__a21o_1
XFILLER_0_87_51 vssd1 vssd1 vccd1 vccd1 sky130_fd_sc_hd__decap_4
XFILLER_0_60_3 vssd1 vssd1 vccd1 vccd1 sky130_ef_sc_hd__decap_12
X_08975_ _02939_ _02942_ _03085_ _03087_ vssd1 vssd1 vccd1 vccd1 _03088_ sky130_fd_sc_hd__o211a_2
Xhold37 det_t\[25\] vssd1 vssd1 vccd1 vccd1 net1252 sky130_fd_sc_hd__dlygate4sd3_1
Xhold26 det_t\[15\] vssd1 vssd1 vccd1 vccd1 net1241 sky130_fd_sc_hd__dlygate4sd3_1
Xhold15 l0\[3\] vssd1 vssd1 vccd1 vccd1 net1230 sky130_fd_sc_hd__dlygate4sd3_1
X_07926_ _01935_ _01938_ _02045_ _02046_ vssd1 vssd1 vccd1 vccd1 _02047_ sky130_fd_sc_hd__o211a_1
Xhold59 sub1.b_i\[22\] vssd1 vssd1 vccd1 vccd1 net1274 sky130_fd_sc_hd__dlygate4sd3_1
Xhold48 _00037_ vssd1 vssd1 vccd1 vccd1 net1263 sky130_fd_sc_hd__dlygate4sd3_1
X_07857_ _01975_ _01976_ vssd1 vssd1 vccd1 vccd1 _01978_ sky130_fd_sc_hd__xor2_1
X_06808_ net1458 l0\[15\] net642 vssd1 vssd1 vccd1 vccd1 _00082_ sky130_fd_sc_hd__mux2_1
X_07788_ net1018 net898 net889 net1026 vssd1 vssd1 vccd1 vccd1 _01910_ sky130_fd_sc_hd__a22oi_2
X_09527_ net1063 net752 net744 net1071 vssd1 vssd1 vccd1 vccd1 _03636_ sky130_fd_sc_hd__a22oi_2
X_06739_ _00933_ _00952_ _00955_ vssd1 vssd1 vccd1 vccd1 _00956_ sky130_fd_sc_hd__a21bo_2
XFILLER_0_39_706 vssd1 vssd1 vccd1 vccd1 sky130_fd_sc_hd__fill_1
XFILLER_0_93_322 vssd1 vssd1 vccd1 vccd1 sky130_fd_sc_hd__fill_1
X_09458_ _03403_ _03405_ _03566_ _03567_ vssd1 vssd1 vccd1 vccd1 _03568_ sky130_fd_sc_hd__o211a_1
XFILLER_0_93_333 vssd1 vssd1 vccd1 vccd1 sky130_fd_sc_hd__decap_3
X_09389_ _03483_ _03496_ _03497_ vssd1 vssd1 vccd1 vccd1 _03499_ sky130_fd_sc_hd__nand3_1
X_08409_ _02462_ _02463_ _02523_ _02524_ vssd1 vssd1 vccd1 vccd1 _02526_ sky130_fd_sc_hd__a22o_1
XFILLER_0_117_671 vssd1 vssd1 vccd1 vccd1 sky130_fd_sc_hd__fill_1
X_11420_ net1036 net697 net696 net1027 vssd1 vssd1 vccd1 vccd1 _05516_ sky130_fd_sc_hd__and4b_2
XFILLER_0_61_263 vssd1 vssd1 vccd1 vccd1 sky130_fd_sc_hd__fill_1
X_11351_ _05327_ _05447_ vssd1 vssd1 vccd1 vccd1 _05448_ sky130_fd_sc_hd__or2_1
XFILLER_0_104_354 vssd1 vssd1 vccd1 vccd1 sky130_fd_sc_hd__decap_4
X_10302_ net1064 mul1.b\[26\] vssd1 vssd1 vccd1 vccd1 _04406_ sky130_fd_sc_hd__nand2_1
XFILLER_0_120_825 vssd1 vssd1 vccd1 vccd1 sky130_fd_sc_hd__fill_1
XFILLER_0_104_398 vssd1 vssd1 vccd1 vccd1 sky130_fd_sc_hd__decap_4
X_11282_ _05253_ _05256_ _05376_ _05377_ vssd1 vssd1 vccd1 vccd1 _05379_ sky130_fd_sc_hd__a211oi_2
X_10233_ _04336_ _04337_ vssd1 vssd1 vccd1 vccd1 _04338_ sky130_fd_sc_hd__xor2_1
X_13021_ clknet_leaf_44_clk_i _00407_ net1155 vssd1 vssd1 vccd1 vccd1 x0mx2\[10\]
+ sky130_fd_sc_hd__dfrtp_1
X_10164_ _04227_ _04268_ vssd1 vssd1 vccd1 vccd1 _04269_ sky130_fd_sc_hd__xnor2_4
Xfanout1002 mul1.a\[18\] vssd1 vssd1 vccd1 vccd1 net1002 sky130_fd_sc_hd__clkbuf_4
Xfanout1013 net1014 vssd1 vssd1 vccd1 vccd1 net1013 sky130_fd_sc_hd__clkbuf_4
Xfanout1046 net1047 vssd1 vssd1 vccd1 vccd1 net1046 sky130_fd_sc_hd__buf_2
Xfanout1035 net1040 vssd1 vssd1 vccd1 vccd1 net1035 sky130_fd_sc_hd__clkbuf_4
Xfanout1024 net1025 vssd1 vssd1 vccd1 vccd1 net1024 sky130_fd_sc_hd__clkbuf_4
Xfanout1068 net1069 vssd1 vssd1 vccd1 vccd1 net1068 sky130_fd_sc_hd__clkbuf_2
Xfanout1079 net1080 vssd1 vssd1 vccd1 vccd1 net1079 sky130_fd_sc_hd__clkbuf_2
X_10095_ _04199_ _04200_ vssd1 vssd1 vccd1 vccd1 _04201_ sky130_fd_sc_hd__or2_2
Xfanout1057 net1061 vssd1 vssd1 vccd1 vccd1 net1057 sky130_fd_sc_hd__clkbuf_4
XFILLER_0_107_27 vssd1 vssd1 vccd1 vccd1 sky130_ef_sc_hd__decap_12
XFILLER_0_57_503 vssd1 vssd1 vccd1 vccd1 sky130_fd_sc_hd__fill_1
X_12805_ clknet_leaf_55_clk_i _00191_ vssd1 vssd1 vccd1 vccd1 sub1.a_i\[4\] sky130_fd_sc_hd__dfxtp_1
XFILLER_0_123_15 vssd1 vssd1 vccd1 vccd1 sky130_ef_sc_hd__decap_12
XFILLER_0_96_182 vssd1 vssd1 vccd1 vccd1 sky130_fd_sc_hd__fill_1
X_10997_ _04972_ _04974_ _05094_ vssd1 vssd1 vccd1 vccd1 _05096_ sky130_fd_sc_hd__o21ai_2
XFILLER_0_29_216 vssd1 vssd1 vccd1 vccd1 sky130_fd_sc_hd__fill_1
X_12736_ clknet_leaf_8_clk_i _00122_ vssd1 vssd1 vccd1 vccd1 last sky130_fd_sc_hd__dfxtp_2
XFILLER_0_96_193 vssd1 vssd1 vccd1 vccd1 sky130_fd_sc_hd__decap_3
XTAP_1083 vssd1 vccd1 sky130_fd_sc_hd__tapvpwrvgnd_1
XTAP_1061 vssd1 vccd1 sky130_fd_sc_hd__tapvpwrvgnd_1
XTAP_1072 vssd1 vccd1 sky130_fd_sc_hd__tapvpwrvgnd_1
XTAP_1050 vssd1 vccd1 sky130_fd_sc_hd__tapvpwrvgnd_1
XFILLER_0_84_377 vssd1 vssd1 vccd1 vccd1 sky130_fd_sc_hd__decap_6
X_12667_ clknet_leaf_19_clk_i net1425 net1177 vssd1 vssd1 vccd1 vccd1 net395 sky130_fd_sc_hd__dfrtp_1
XTAP_1094 vssd1 vccd1 sky130_fd_sc_hd__tapvpwrvgnd_1
XFILLER_0_44_219 vssd1 vssd1 vccd1 vccd1 sky130_ef_sc_hd__decap_12
X_11618_ _05710_ _05711_ vssd1 vssd1 vccd1 vccd1 _05712_ sky130_fd_sc_hd__xnor2_1
XFILLER_0_108_693 vssd1 vssd1 vccd1 vccd1 sky130_fd_sc_hd__decap_6
XFILLER_0_107_181 vssd1 vssd1 vccd1 vccd1 sky130_ef_sc_hd__decap_12
XFILLER_0_80_561 vssd1 vssd1 vccd1 vccd1 sky130_fd_sc_hd__fill_1
X_12598_ net1370 net9 net556 vssd1 vssd1 vccd1 vccd1 _00573_ sky130_fd_sc_hd__mux2_1
XFILLER_0_13_617 vssd1 vssd1 vccd1 vccd1 sky130_fd_sc_hd__decap_4
XFILLER_0_123_641 vssd1 vssd1 vccd1 vccd1 sky130_ef_sc_hd__decap_12
Xhold507 net335 vssd1 vssd1 vccd1 vccd1 net1722 sky130_fd_sc_hd__dlygate4sd3_1
Xhold518 net372 vssd1 vssd1 vccd1 vccd1 net1733 sky130_fd_sc_hd__dlygate4sd3_1
X_11549_ _05642_ _05643_ _05630_ vssd1 vssd1 vccd1 vccd1 _05644_ sky130_fd_sc_hd__a21o_1
XFILLER_0_123_685 vssd1 vssd1 vccd1 vccd1 sky130_ef_sc_hd__decap_12
XFILLER_0_111_825 vssd1 vssd1 vccd1 vccd1 sky130_fd_sc_hd__decap_3
XFILLER_0_40_447 vssd1 vssd1 vccd1 vccd1 sky130_fd_sc_hd__fill_2
XFILLER_0_122_195 vssd1 vssd1 vccd1 vccd1 sky130_fd_sc_hd__fill_1
XTAP_801 vssd1 vccd1 sky130_fd_sc_hd__tapvpwrvgnd_1
XTAP_812 vssd1 vccd1 sky130_fd_sc_hd__tapvpwrvgnd_1
XTAP_823 vssd1 vccd1 sky130_fd_sc_hd__tapvpwrvgnd_1
XTAP_834 vssd1 vccd1 sky130_fd_sc_hd__tapvpwrvgnd_1
XTAP_845 vssd1 vccd1 sky130_fd_sc_hd__tapvpwrvgnd_1
XTAP_856 vssd1 vccd1 sky130_fd_sc_hd__tapvpwrvgnd_1
XTAP_867 vssd1 vccd1 sky130_fd_sc_hd__tapvpwrvgnd_1
X_08760_ _02868_ _02873_ vssd1 vssd1 vccd1 vccd1 _02874_ sky130_fd_sc_hd__nor2_1
XTAP_878 vssd1 vccd1 sky130_fd_sc_hd__tapvpwrvgnd_1
XTAP_889 vssd1 vccd1 sky130_fd_sc_hd__tapvpwrvgnd_1
X_08691_ _02803_ _02804_ _02675_ vssd1 vssd1 vccd1 vccd1 _02806_ sky130_fd_sc_hd__o21a_1
X_07711_ _01814_ _01831_ _01832_ vssd1 vssd1 vccd1 vccd1 _01834_ sky130_fd_sc_hd__and3_1
XFILLER_0_79_127 vssd1 vssd1 vccd1 vccd1 sky130_fd_sc_hd__fill_1
X_07642_ net1146 net781 _01672_ _01671_ vssd1 vssd1 vccd1 vccd1 _01765_ sky130_fd_sc_hd__a31o_1
XFILLER_0_88_672 vssd1 vssd1 vccd1 vccd1 sky130_fd_sc_hd__decap_4
XFILLER_0_73_97 vssd1 vssd1 vccd1 vccd1 sky130_ef_sc_hd__decap_12
XFILLER_0_48_503 vssd1 vssd1 vccd1 vccd1 sky130_fd_sc_hd__decap_4
X_09312_ _03417_ _03419_ _03416_ vssd1 vssd1 vccd1 vccd1 _03422_ sky130_fd_sc_hd__o21ba_2
X_07573_ _01688_ _01696_ vssd1 vssd1 vccd1 vccd1 _01697_ sky130_fd_sc_hd__and2_1
X_06524_ _00649_ _00652_ vssd1 vssd1 vccd1 vccd1 _00784_ sky130_fd_sc_hd__xnor2_4
XFILLER_0_118_413 vssd1 vssd1 vccd1 vccd1 sky130_fd_sc_hd__decap_6
XFILLER_0_118_457 vssd1 vssd1 vccd1 vccd1 sky130_ef_sc_hd__decap_12
X_09243_ _03351_ _03352_ _03196_ _03197_ vssd1 vssd1 vccd1 vccd1 _03354_ sky130_fd_sc_hd__o211ai_2
X_06455_ _00752_ _00753_ vssd1 vssd1 vccd1 vccd1 _00754_ sky130_fd_sc_hd__xnor2_4
XFILLER_0_7_110 vssd1 vssd1 vccd1 vccd1 sky130_fd_sc_hd__fill_2
XFILLER_0_113_81 vssd1 vssd1 vccd1 vccd1 sky130_ef_sc_hd__decap_12
X_09174_ net1100 net1108 net726 vssd1 vssd1 vccd1 vccd1 _03285_ sky130_fd_sc_hd__and3_1
X_06386_ add1.a_i\[17\] add1.b_i\[17\] vssd1 vssd1 vccd1 vccd1 _00694_ sky130_fd_sc_hd__or2_1
XFILLER_0_71_561 vssd1 vssd1 vccd1 vccd1 sky130_ef_sc_hd__decap_12
X_08125_ _02242_ _02243_ vssd1 vssd1 vccd1 vccd1 _02244_ sky130_fd_sc_hd__nor2_1
XFILLER_0_31_436 vssd1 vssd1 vccd1 vccd1 sky130_fd_sc_hd__decap_3
XFILLER_0_101_302 vssd1 vssd1 vccd1 vccd1 sky130_fd_sc_hd__fill_2
XFILLER_0_98_83 vssd1 vssd1 vccd1 vccd1 sky130_fd_sc_hd__fill_1
X_08056_ _02087_ _02090_ vssd1 vssd1 vccd1 vccd1 _02175_ sky130_fd_sc_hd__nor2_1
XFILLER_0_12_683 vssd1 vssd1 vccd1 vccd1 sky130_fd_sc_hd__fill_2
X_07007_ _01122_ _01130_ vssd1 vssd1 vccd1 vccd1 _01132_ sky130_fd_sc_hd__xor2_2
XFILLER_0_11_193 vssd1 vssd1 vccd1 vccd1 sky130_fd_sc_hd__decap_8
Xinput127 v1x[14] vssd1 vssd1 vccd1 vccd1 net127 sky130_fd_sc_hd__buf_1
Xinput116 v0y[4] vssd1 vssd1 vccd1 vccd1 net116 sky130_fd_sc_hd__buf_1
Xinput105 v0y[23] vssd1 vssd1 vccd1 vccd1 net105 sky130_fd_sc_hd__buf_1
X_08958_ _03067_ _03068_ _03069_ vssd1 vssd1 vccd1 vccd1 _03071_ sky130_fd_sc_hd__nand3_1
Xinput149 v1x[5] vssd1 vssd1 vccd1 vccd1 net149 sky130_fd_sc_hd__buf_1
Xinput138 v1x[24] vssd1 vssd1 vccd1 vccd1 net138 sky130_fd_sc_hd__buf_1
X_08889_ net1085 net756 _02999_ _03000_ vssd1 vssd1 vccd1 vccd1 _03002_ sky130_fd_sc_hd__o2bb2a_1
XFILLER_0_98_414 vssd1 vssd1 vccd1 vccd1 sky130_fd_sc_hd__decap_6
X_07909_ _02021_ _02028_ _02029_ vssd1 vssd1 vccd1 vccd1 _02030_ sky130_fd_sc_hd__nand3_2
X_10920_ _04983_ _05018_ _05019_ vssd1 vssd1 vccd1 vccd1 _05020_ sky130_fd_sc_hd__or3_4
X_10851_ _04820_ _04951_ vssd1 vssd1 vccd1 vccd1 _04952_ sky130_fd_sc_hd__xor2_2
XPHY_100 vssd1 vssd1 vccd1 vccd1 sky130_fd_sc_hd__decap_3
XFILLER_0_94_653 vssd1 vssd1 vccd1 vccd1 sky130_fd_sc_hd__decap_3
XFILLER_0_94_642 vssd1 vssd1 vccd1 vccd1 sky130_fd_sc_hd__fill_2
XFILLER_0_93_130 vssd1 vssd1 vccd1 vccd1 sky130_ef_sc_hd__decap_12
XPHY_133 vssd1 vssd1 vccd1 vccd1 sky130_fd_sc_hd__decap_3
X_10782_ _04733_ _04735_ _04881_ vssd1 vssd1 vccd1 vccd1 _04883_ sky130_fd_sc_hd__nand3_1
XPHY_122 vssd1 vssd1 vccd1 vccd1 sky130_fd_sc_hd__decap_3
XPHY_111 vssd1 vssd1 vccd1 vccd1 sky130_fd_sc_hd__decap_3
X_12521_ _00707_ net566 _06257_ vssd1 vssd1 vccd1 vccd1 _00511_ sky130_fd_sc_hd__o21ai_1
XFILLER_0_93_163 vssd1 vssd1 vccd1 vccd1 sky130_fd_sc_hd__fill_2
XPHY_166 vssd1 vssd1 vccd1 vccd1 sky130_fd_sc_hd__decap_3
XPHY_155 vssd1 vssd1 vccd1 vccd1 sky130_fd_sc_hd__decap_3
XPHY_144 vssd1 vssd1 vccd1 vccd1 sky130_fd_sc_hd__decap_3
XPHY_199 vssd1 vssd1 vccd1 vccd1 sky130_fd_sc_hd__decap_3
XPHY_188 vssd1 vssd1 vccd1 vccd1 sky130_fd_sc_hd__decap_3
XPHY_177 vssd1 vssd1 vccd1 vccd1 sky130_fd_sc_hd__decap_3
XFILLER_0_47_591 vssd1 vssd1 vccd1 vccd1 sky130_fd_sc_hd__fill_1
X_12452_ net51 net687 _00908_ net615 vssd1 vssd1 vccd1 vccd1 _06220_ sky130_fd_sc_hd__a22o_1
XFILLER_0_50_701 vssd1 vssd1 vccd1 vccd1 sky130_fd_sc_hd__fill_1
X_11403_ _05496_ _05498_ _05371_ _05374_ vssd1 vssd1 vccd1 vccd1 _05499_ sky130_fd_sc_hd__o211a_1
XFILLER_0_105_641 vssd1 vssd1 vccd1 vccd1 sky130_ef_sc_hd__decap_12
XFILLER_0_62_594 vssd1 vssd1 vccd1 vccd1 sky130_fd_sc_hd__fill_1
XFILLER_0_62_583 vssd1 vssd1 vccd1 vccd1 sky130_fd_sc_hd__decap_4
X_12383_ net1565 _00840_ net682 vssd1 vssd1 vccd1 vccd1 _00435_ sky130_fd_sc_hd__mux2_1
X_11334_ _05428_ _05429_ _05386_ vssd1 vssd1 vccd1 vccd1 _05431_ sky130_fd_sc_hd__a21o_1
X_11265_ net807 net935 _05211_ _05210_ vssd1 vssd1 vccd1 vccd1 _05362_ sky130_fd_sc_hd__a31o_1
X_10216_ net859 net942 vssd1 vssd1 vccd1 vccd1 _04321_ sky130_fd_sc_hd__nand2_1
X_13004_ clknet_leaf_33_clk_i _00390_ net1165 vssd1 vssd1 vccd1 vccd1 x2mx1\[25\]
+ sky130_fd_sc_hd__dfrtp_1
XFILLER_0_120_699 vssd1 vssd1 vccd1 vccd1 sky130_fd_sc_hd__fill_1
X_11196_ _05113_ _05115_ _05293_ vssd1 vssd1 vccd1 vccd1 _05294_ sky130_fd_sc_hd__a21oi_4
X_10147_ _04248_ _04249_ _04250_ vssd1 vssd1 vccd1 vccd1 _04252_ sky130_fd_sc_hd__a21bo_1
X_10078_ _04015_ _04017_ vssd1 vssd1 vccd1 vccd1 _04184_ sky130_fd_sc_hd__nand2_1
XFILLER_0_27_57 vssd1 vssd1 vccd1 vccd1 sky130_fd_sc_hd__decap_8
XFILLER_0_58_801 vssd1 vssd1 vccd1 vccd1 sky130_fd_sc_hd__fill_2
XFILLER_0_76_108 vssd1 vssd1 vccd1 vccd1 sky130_fd_sc_hd__decap_3
XPHY_2 vssd1 vssd1 vccd1 vccd1 sky130_fd_sc_hd__decap_3
XFILLER_0_57_355 vssd1 vssd1 vccd1 vccd1 sky130_fd_sc_hd__decap_4
XFILLER_0_128_755 vssd1 vssd1 vccd1 vccd1 sky130_fd_sc_hd__fill_1
X_12719_ clknet_leaf_10_clk_i _00105_ net1191 vssd1 vssd1 vccd1 vccd1 net338 sky130_fd_sc_hd__dfrtp_1
XFILLER_0_84_152 vssd1 vssd1 vccd1 vccd1 sky130_fd_sc_hd__fill_1
XFILLER_0_73_815 vssd1 vssd1 vccd1 vccd1 sky130_fd_sc_hd__decap_4
XFILLER_0_72_314 vssd1 vssd1 vccd1 vccd1 sky130_fd_sc_hd__decap_6
XFILLER_0_57_377 vssd1 vssd1 vccd1 vccd1 sky130_fd_sc_hd__decap_3
XFILLER_0_45_517 vssd1 vssd1 vccd1 vccd1 sky130_ef_sc_hd__decap_12
XFILLER_0_115_405 vssd1 vssd1 vccd1 vccd1 sky130_ef_sc_hd__decap_12
XFILLER_0_57_399 vssd1 vssd1 vccd1 vccd1 sky130_fd_sc_hd__decap_3
XFILLER_0_115_449 vssd1 vssd1 vccd1 vccd1 sky130_ef_sc_hd__decap_12
XFILLER_0_53_550 vssd1 vssd1 vccd1 vccd1 sky130_fd_sc_hd__decap_8
Xhold326 add1.a_i\[29\] vssd1 vssd1 vccd1 vccd1 net1541 sky130_fd_sc_hd__dlygate4sd3_1
XFILLER_0_7_45 vssd1 vssd1 vccd1 vccd1 sky130_fd_sc_hd__decap_8
Xhold304 y2my0\[30\] vssd1 vssd1 vccd1 vccd1 net1519 sky130_fd_sc_hd__dlygate4sd3_1
Xhold315 x0mx2\[12\] vssd1 vssd1 vccd1 vccd1 net1530 sky130_fd_sc_hd__dlygate4sd3_1
XFILLER_0_110_121 vssd1 vssd1 vccd1 vccd1 sky130_ef_sc_hd__decap_12
Xhold348 posx\[0\] vssd1 vssd1 vccd1 vccd1 net1563 sky130_fd_sc_hd__dlygate4sd3_1
Xhold337 _00103_ vssd1 vssd1 vccd1 vccd1 net1552 sky130_fd_sc_hd__dlygate4sd3_1
X_09930_ _04021_ _04022_ _04034_ _04036_ vssd1 vssd1 vccd1 vccd1 _04037_ sky130_fd_sc_hd__o22a_1
XFILLER_0_68_42 vssd1 vssd1 vccd1 vccd1 sky130_fd_sc_hd__fill_1
Xhold359 net388 vssd1 vssd1 vccd1 vccd1 net1574 sky130_fd_sc_hd__dlygate4sd3_1
XFILLER_0_110_165 vssd1 vssd1 vccd1 vccd1 sky130_ef_sc_hd__decap_12
Xfanout806 net812 vssd1 vssd1 vccd1 vccd1 net806 sky130_fd_sc_hd__buf_2
X_09861_ _03966_ _03967_ vssd1 vssd1 vccd1 vccd1 _03968_ sky130_fd_sc_hd__nand2b_1
Xfanout817 net819 vssd1 vssd1 vccd1 vccd1 net817 sky130_fd_sc_hd__buf_2
Xfanout839 net845 vssd1 vssd1 vccd1 vccd1 net839 sky130_fd_sc_hd__clkbuf_4
XTAP_620 vssd1 vccd1 sky130_fd_sc_hd__tapvpwrvgnd_1
XTAP_631 vssd1 vccd1 sky130_fd_sc_hd__tapvpwrvgnd_1
XTAP_642 vssd1 vccd1 sky130_fd_sc_hd__tapvpwrvgnd_1
Xfanout828 mul1.b\[12\] vssd1 vssd1 vccd1 vccd1 net828 sky130_fd_sc_hd__buf_2
X_09792_ _03741_ _03743_ _03899_ vssd1 vssd1 vccd1 vccd1 _03900_ sky130_fd_sc_hd__o21ai_1
XFILLER_0_84_41 vssd1 vssd1 vccd1 vccd1 sky130_ef_sc_hd__decap_12
X_08812_ _02924_ _02925_ _02923_ vssd1 vssd1 vccd1 vccd1 _02926_ sky130_fd_sc_hd__a21o_1
XTAP_653 vssd1 vccd1 sky130_fd_sc_hd__tapvpwrvgnd_1
XTAP_664 vssd1 vccd1 sky130_fd_sc_hd__tapvpwrvgnd_1
XTAP_686 vssd1 vccd1 sky130_fd_sc_hd__tapvpwrvgnd_1
XTAP_675 vssd1 vccd1 sky130_fd_sc_hd__tapvpwrvgnd_1
X_08743_ net1092 net756 vssd1 vssd1 vccd1 vccd1 _02857_ sky130_fd_sc_hd__nand2_1
XTAP_697 vssd1 vccd1 sky130_fd_sc_hd__tapvpwrvgnd_1
XFILLER_0_84_85 vssd1 vssd1 vccd1 vccd1 sky130_fd_sc_hd__fill_2
XFILLER_0_23_3 vssd1 vssd1 vccd1 vccd1 sky130_ef_sc_hd__decap_12
X_08674_ _02644_ _02648_ _02786_ _02787_ vssd1 vssd1 vccd1 vccd1 _02789_ sky130_fd_sc_hd__a211oi_4
XTAP_1819 vssd1 vccd1 sky130_fd_sc_hd__tapvpwrvgnd_1
XTAP_1808 vssd1 vccd1 sky130_fd_sc_hd__tapvpwrvgnd_1
X_07625_ _01747_ _01748_ _01335_ vssd1 vssd1 vccd1 vccd1 _01749_ sky130_fd_sc_hd__nor3b_1
X_07556_ _01669_ _01679_ vssd1 vssd1 vccd1 vccd1 _01680_ sky130_fd_sc_hd__xnor2_1
X_06507_ det_t\[17\] net527 vssd1 vssd1 vccd1 vccd1 net260 sky130_fd_sc_hd__and2_1
XFILLER_0_118_221 vssd1 vssd1 vccd1 vccd1 sky130_ef_sc_hd__decap_12
XFILLER_0_36_528 vssd1 vssd1 vccd1 vccd1 sky130_fd_sc_hd__decap_4
XFILLER_0_119_777 vssd1 vssd1 vccd1 vccd1 sky130_fd_sc_hd__decap_6
XFILLER_0_118_265 vssd1 vssd1 vccd1 vccd1 sky130_ef_sc_hd__decap_12
XFILLER_0_91_656 vssd1 vssd1 vccd1 vccd1 sky130_fd_sc_hd__decap_4
X_09226_ _03205_ _03208_ _03335_ _03336_ vssd1 vssd1 vccd1 vccd1 _03337_ sky130_fd_sc_hd__o211ai_4
X_07487_ _01604_ _01611_ vssd1 vssd1 vccd1 vccd1 _01612_ sky130_fd_sc_hd__or2_1
XFILLER_0_91_689 vssd1 vssd1 vccd1 vccd1 sky130_fd_sc_hd__decap_4
X_06438_ _00729_ _00735_ vssd1 vssd1 vccd1 vccd1 _00739_ sky130_fd_sc_hd__nand2_1
XFILLER_0_51_509 vssd1 vssd1 vccd1 vccd1 sky130_fd_sc_hd__fill_1
XFILLER_0_32_701 vssd1 vssd1 vccd1 vccd1 sky130_fd_sc_hd__fill_1
X_09157_ _03267_ vssd1 vssd1 vccd1 vccd1 _03268_ sky130_fd_sc_hd__inv_2
X_06369_ _00678_ _00679_ vssd1 vssd1 vccd1 vccd1 _00680_ sky130_fd_sc_hd__nand2_1
XFILLER_0_44_594 vssd1 vssd1 vccd1 vccd1 sky130_fd_sc_hd__decap_6
X_09088_ _03037_ _03038_ vssd1 vssd1 vccd1 vccd1 _03200_ sky130_fd_sc_hd__or2_1
X_08108_ _02106_ _02108_ _02224_ _02225_ vssd1 vssd1 vccd1 vccd1 _02227_ sky130_fd_sc_hd__o211a_1
XFILLER_0_71_391 vssd1 vssd1 vccd1 vccd1 sky130_fd_sc_hd__fill_1
X_08039_ _02064_ _02158_ vssd1 vssd1 vccd1 vccd1 _02159_ sky130_fd_sc_hd__xnor2_2
XFILLER_0_101_154 vssd1 vssd1 vccd1 vccd1 sky130_fd_sc_hd__fill_2
X_11050_ _05147_ _05148_ vssd1 vssd1 vccd1 vccd1 _05149_ sky130_fd_sc_hd__and2b_1
X_10001_ _04090_ _04105_ vssd1 vssd1 vccd1 vccd1 _04107_ sky130_fd_sc_hd__xnor2_4
XFILLER_0_98_211 vssd1 vssd1 vccd1 vccd1 sky130_fd_sc_hd__decap_4
XFILLER_0_98_233 vssd1 vssd1 vccd1 vccd1 sky130_fd_sc_hd__decap_4
X_11952_ net125 net656 net503 net221 _05968_ vssd1 vssd1 vccd1 vccd1 _05969_ sky130_fd_sc_hd__a221o_1
X_10903_ net790 net959 net951 net800 vssd1 vssd1 vccd1 vccd1 _05003_ sky130_fd_sc_hd__a22oi_1
X_11883_ net79 net679 net609 net207 vssd1 vssd1 vccd1 vccd1 _05915_ sky130_fd_sc_hd__a22o_1
X_10834_ _04932_ _04933_ _04742_ _04745_ vssd1 vssd1 vccd1 vccd1 _04935_ sky130_fd_sc_hd__o211ai_4
XFILLER_0_13_15 vssd1 vssd1 vccd1 vccd1 sky130_ef_sc_hd__decap_12
XFILLER_0_66_141 vssd1 vssd1 vccd1 vccd1 sky130_fd_sc_hd__decap_3
X_12504_ net1264 net566 vssd1 vssd1 vccd1 vccd1 _06249_ sky130_fd_sc_hd__nand2_1
XFILLER_0_94_483 vssd1 vssd1 vccd1 vccd1 sky130_fd_sc_hd__fill_2
XFILLER_0_81_111 vssd1 vssd1 vccd1 vccd1 sky130_fd_sc_hd__fill_1
X_10765_ net999 net760 _04716_ _04715_ vssd1 vssd1 vccd1 vccd1 _04866_ sky130_fd_sc_hd__a31o_1
XFILLER_0_54_314 vssd1 vssd1 vccd1 vccd1 sky130_fd_sc_hd__fill_2
X_10696_ _04607_ net456 _04797_ vssd1 vssd1 vccd1 vccd1 _04798_ sky130_fd_sc_hd__o21a_2
XFILLER_0_82_689 vssd1 vssd1 vccd1 vccd1 sky130_fd_sc_hd__decap_4
XFILLER_0_70_807 vssd1 vssd1 vccd1 vccd1 sky130_fd_sc_hd__decap_4
XFILLER_0_54_369 vssd1 vssd1 vccd1 vccd1 sky130_fd_sc_hd__fill_1
XFILLER_0_120_27 vssd1 vssd1 vccd1 vccd1 sky130_fd_sc_hd__fill_1
X_12435_ _00872_ net613 _03111_ net575 vssd1 vssd1 vccd1 vccd1 _06210_ sky130_fd_sc_hd__a22o_1
XFILLER_0_35_561 vssd1 vssd1 vccd1 vccd1 sky130_ef_sc_hd__decap_12
XFILLER_0_112_419 vssd1 vssd1 vccd1 vccd1 sky130_fd_sc_hd__fill_1
X_12366_ net1536 _00918_ net664 vssd1 vssd1 vccd1 vccd1 _00418_ sky130_fd_sc_hd__mux2_1
XFILLER_0_22_233 vssd1 vssd1 vccd1 vccd1 sky130_fd_sc_hd__fill_2
Xoutput409 net409 vssd1 vssd1 vccd1 vccd1 mstream_o[63] sky130_fd_sc_hd__clkbuf_4
X_11317_ _05408_ _05413_ vssd1 vssd1 vccd1 vccd1 _05414_ sky130_fd_sc_hd__nand2_1
X_12297_ net1690 _00892_ net676 vssd1 vssd1 vccd1 vccd1 _00349_ sky130_fd_sc_hd__mux2_1
X_11248_ net750 net978 net742 net972 vssd1 vssd1 vccd1 vccd1 _05345_ sky130_fd_sc_hd__and4_1
X_11179_ net1055 net697 net696 net1045 vssd1 vssd1 vccd1 vccd1 _05277_ sky130_fd_sc_hd__and4b_2
XFILLER_0_38_67 vssd1 vssd1 vccd1 vccd1 sky130_fd_sc_hd__fill_1
X_08390_ _02365_ _02366_ _02367_ vssd1 vssd1 vccd1 vccd1 _02507_ sky130_fd_sc_hd__a21bo_1
X_07410_ _01533_ _01534_ vssd1 vssd1 vccd1 vccd1 _01535_ sky130_fd_sc_hd__nand2_1
XFILLER_0_92_409 vssd1 vssd1 vccd1 vccd1 sky130_fd_sc_hd__decap_6
X_07341_ _01416_ _01422_ _01421_ vssd1 vssd1 vccd1 vccd1 _01466_ sky130_fd_sc_hd__a21o_1
XFILLER_0_72_100 vssd1 vssd1 vccd1 vccd1 sky130_ef_sc_hd__decap_12
XFILLER_0_58_697 vssd1 vssd1 vccd1 vccd1 sky130_fd_sc_hd__decap_3
XFILLER_0_57_196 vssd1 vssd1 vccd1 vccd1 sky130_ef_sc_hd__decap_12
XFILLER_0_45_314 vssd1 vssd1 vccd1 vccd1 sky130_fd_sc_hd__fill_1
XFILLER_0_72_155 vssd1 vssd1 vccd1 vccd1 sky130_ef_sc_hd__decap_12
X_07272_ _01337_ _01394_ _01395_ vssd1 vssd1 vccd1 vccd1 _01397_ sky130_fd_sc_hd__nand3_4
X_09011_ _02967_ _03121_ vssd1 vssd1 vccd1 vccd1 _03123_ sky130_fd_sc_hd__and2_1
XFILLER_0_72_188 vssd1 vssd1 vccd1 vccd1 sky130_fd_sc_hd__fill_1
XFILLER_0_60_306 vssd1 vssd1 vccd1 vccd1 sky130_fd_sc_hd__fill_2
XFILLER_0_115_279 vssd1 vssd1 vccd1 vccd1 sky130_fd_sc_hd__fill_1
Xhold101 add1.b_i\[14\] vssd1 vssd1 vccd1 vccd1 net1316 sky130_fd_sc_hd__dlygate4sd3_1
Xhold123 net337 vssd1 vssd1 vccd1 vccd1 net1338 sky130_fd_sc_hd__dlygate4sd3_1
Xhold112 sub1.a_i\[30\] vssd1 vssd1 vccd1 vccd1 net1327 sky130_fd_sc_hd__dlygate4sd3_1
Xhold134 sub1.b_i\[12\] vssd1 vssd1 vccd1 vccd1 net1349 sky130_fd_sc_hd__dlygate4sd3_1
XFILLER_0_41_564 vssd1 vssd1 vccd1 vccd1 sky130_fd_sc_hd__fill_2
XFILLER_0_111_441 vssd1 vssd1 vccd1 vccd1 sky130_fd_sc_hd__decap_6
Xhold156 posy\[6\] vssd1 vssd1 vccd1 vccd1 net1371 sky130_fd_sc_hd__dlygate4sd3_1
Xhold145 l1\[19\] vssd1 vssd1 vccd1 vccd1 net1360 sky130_fd_sc_hd__dlygate4sd3_1
Xhold167 add1.a_i\[18\] vssd1 vssd1 vccd1 vccd1 net1382 sky130_fd_sc_hd__dlygate4sd3_1
XFILLER_0_111_485 vssd1 vssd1 vccd1 vccd1 sky130_ef_sc_hd__decap_12
Xhold189 net423 vssd1 vssd1 vccd1 vccd1 net1404 sky130_fd_sc_hd__dlygate4sd3_1
X_09913_ _04017_ _04018_ _04013_ vssd1 vssd1 vccd1 vccd1 _04020_ sky130_fd_sc_hd__a21o_1
Xhold178 net389 vssd1 vssd1 vccd1 vccd1 net1393 sky130_fd_sc_hd__dlygate4sd3_1
XFILLER_0_0_160 vssd1 vssd1 vccd1 vccd1 sky130_fd_sc_hd__fill_1
Xfanout614 net619 vssd1 vssd1 vccd1 vccd1 net614 sky130_fd_sc_hd__buf_4
Xfanout603 net604 vssd1 vssd1 vccd1 vccd1 net603 sky130_fd_sc_hd__buf_2
Xfanout647 net648 vssd1 vssd1 vccd1 vccd1 net647 sky130_fd_sc_hd__clkbuf_2
X_09844_ _03910_ _03949_ vssd1 vssd1 vccd1 vccd1 _03951_ sky130_fd_sc_hd__xnor2_4
XFILLER_0_95_51 vssd1 vssd1 vccd1 vccd1 sky130_fd_sc_hd__decap_4
Xfanout625 _00986_ vssd1 vssd1 vccd1 vccd1 net625 sky130_fd_sc_hd__clkbuf_2
XTAP_450 vssd1 vccd1 sky130_fd_sc_hd__tapvpwrvgnd_1
Xfanout636 net640 vssd1 vssd1 vccd1 vccd1 net636 sky130_fd_sc_hd__buf_2
Xfanout658 net659 vssd1 vssd1 vccd1 vccd1 net658 sky130_fd_sc_hd__clkbuf_4
XTAP_461 vssd1 vccd1 sky130_fd_sc_hd__tapvpwrvgnd_1
XTAP_472 vssd1 vccd1 sky130_fd_sc_hd__tapvpwrvgnd_1
XTAP_494 vssd1 vccd1 sky130_fd_sc_hd__tapvpwrvgnd_1
Xfanout669 net670 vssd1 vssd1 vccd1 vccd1 net669 sky130_fd_sc_hd__clkbuf_4
XTAP_483 vssd1 vccd1 sky130_fd_sc_hd__tapvpwrvgnd_1
X_09775_ _03854_ _03882_ vssd1 vssd1 vccd1 vccd1 _03883_ sky130_fd_sc_hd__xnor2_4
X_06987_ _01105_ _01109_ _01110_ vssd1 vssd1 vccd1 vccd1 _01112_ sky130_fd_sc_hd__nand3_1
X_08726_ _02824_ _02838_ vssd1 vssd1 vccd1 vccd1 _02840_ sky130_fd_sc_hd__xnor2_1
XFILLER_0_96_737 vssd1 vssd1 vccd1 vccd1 sky130_ef_sc_hd__decap_12
XTAP_1605 vssd1 vccd1 sky130_fd_sc_hd__tapvpwrvgnd_1
X_08657_ _02768_ _02771_ vssd1 vssd1 vccd1 vccd1 _02772_ sky130_fd_sc_hd__xor2_2
XTAP_1649 vssd1 vccd1 sky130_fd_sc_hd__tapvpwrvgnd_1
XTAP_1638 vssd1 vccd1 sky130_fd_sc_hd__tapvpwrvgnd_1
XTAP_1627 vssd1 vccd1 sky130_fd_sc_hd__tapvpwrvgnd_1
XTAP_1616 vssd1 vccd1 sky130_fd_sc_hd__tapvpwrvgnd_1
X_07608_ _01729_ _01730_ _01731_ vssd1 vssd1 vccd1 vccd1 _01732_ sky130_fd_sc_hd__nand3_4
X_08588_ net1122 net734 vssd1 vssd1 vccd1 vccd1 _02703_ sky130_fd_sc_hd__nand2_1
XFILLER_0_49_686 vssd1 vssd1 vccd1 vccd1 sky130_fd_sc_hd__decap_8
XFILLER_0_48_141 vssd1 vssd1 vccd1 vccd1 sky130_fd_sc_hd__fill_2
XFILLER_0_119_541 vssd1 vssd1 vccd1 vccd1 sky130_ef_sc_hd__decap_12
XFILLER_0_63_122 vssd1 vssd1 vccd1 vccd1 sky130_ef_sc_hd__decap_12
X_07539_ _01273_ _01459_ _01663_ _01662_ vssd1 vssd1 vccd1 vccd1 _01664_ sky130_fd_sc_hd__or4b_2
XFILLER_0_119_585 vssd1 vssd1 vccd1 vccd1 sky130_ef_sc_hd__decap_12
XFILLER_0_107_714 vssd1 vssd1 vccd1 vccd1 sky130_fd_sc_hd__decap_4
XFILLER_0_106_213 vssd1 vssd1 vccd1 vccd1 sky130_fd_sc_hd__fill_1
X_10550_ _04607_ _04608_ _04650_ _04651_ vssd1 vssd1 vccd1 vccd1 _04653_ sky130_fd_sc_hd__or4_1
X_09209_ net802 _03172_ _03173_ _03174_ vssd1 vssd1 vccd1 vccd1 _03320_ sky130_fd_sc_hd__a22o_1
X_10481_ net792 net977 net971 net803 vssd1 vssd1 vccd1 vccd1 _04584_ sky130_fd_sc_hd__a22o_1
XFILLER_0_8_293 vssd1 vssd1 vccd1 vccd1 sky130_fd_sc_hd__fill_2
XFILLER_0_121_205 vssd1 vssd1 vccd1 vccd1 sky130_ef_sc_hd__decap_12
X_12220_ _00903_ net510 net467 y1my2\[18\] _06166_ vssd1 vssd1 vccd1 vccd1 _06167_
+ sky130_fd_sc_hd__a221o_1
XFILLER_0_32_520 vssd1 vssd1 vccd1 vccd1 sky130_fd_sc_hd__decap_6
XFILLER_0_121_249 vssd1 vssd1 vccd1 vccd1 sky130_ef_sc_hd__decap_12
XFILLER_0_32_575 vssd1 vssd1 vccd1 vccd1 sky130_ef_sc_hd__decap_12
XFILLER_0_102_463 vssd1 vssd1 vccd1 vccd1 sky130_fd_sc_hd__decap_4
XFILLER_0_20_748 vssd1 vssd1 vccd1 vccd1 sky130_fd_sc_hd__fill_1
X_12151_ net943 _06119_ net519 vssd1 vssd1 vccd1 vccd1 _00279_ sky130_fd_sc_hd__mux2_1
X_11102_ _04949_ _05077_ _05078_ vssd1 vssd1 vccd1 vccd1 _05201_ sky130_fd_sc_hd__a21o_1
X_12082_ _00867_ _06067_ net499 vssd1 vssd1 vccd1 vccd1 _06068_ sky130_fd_sc_hd__mux2_1
X_11033_ _05129_ _05130_ _05117_ vssd1 vssd1 vccd1 vccd1 _05132_ sky130_fd_sc_hd__a21o_1
XFILLER_0_99_553 vssd1 vssd1 vccd1 vccd1 sky130_fd_sc_hd__fill_2
XFILLER_0_99_542 vssd1 vssd1 vccd1 vccd1 sky130_fd_sc_hd__fill_1
XFILLER_0_87_704 vssd1 vssd1 vccd1 vccd1 sky130_ef_sc_hd__decap_12
X_12984_ clknet_leaf_52_clk_i _00370_ net1154 vssd1 vssd1 vccd1 vccd1 x2mx1\[5\] sky130_fd_sc_hd__dfrtp_1
XFILLER_0_115_27 vssd1 vssd1 vccd1 vccd1 sky130_ef_sc_hd__decap_12
X_11935_ net33 net549 net624 net216 _05955_ vssd1 vssd1 vccd1 vccd1 _05956_ sky130_fd_sc_hd__a221o_1
X_11866_ temp1\[26\] net616 net609 net204 _05900_ vssd1 vssd1 vccd1 vccd1 _05901_
+ sky130_fd_sc_hd__a221o_1
XFILLER_0_67_494 vssd1 vssd1 vccd1 vccd1 sky130_fd_sc_hd__decap_8
X_10817_ _04916_ _04917_ net1036 net719 vssd1 vssd1 vccd1 vccd1 _04918_ sky130_fd_sc_hd__and4bb_1
X_11797_ temp1\[16\] net615 net610 net193 _05841_ vssd1 vssd1 vccd1 vccd1 _05842_
+ sky130_fd_sc_hd__a221o_1
X_10748_ _04847_ _04848_ _04829_ vssd1 vssd1 vccd1 vccd1 _04849_ sky130_fd_sc_hd__a21oi_2
XFILLER_0_39_196 vssd1 vssd1 vccd1 vccd1 sky130_fd_sc_hd__decap_3
XFILLER_0_82_475 vssd1 vssd1 vccd1 vccd1 sky130_fd_sc_hd__fill_1
XFILLER_0_55_689 vssd1 vssd1 vccd1 vccd1 sky130_fd_sc_hd__fill_1
X_10679_ _04771_ _04779_ vssd1 vssd1 vccd1 vccd1 _04781_ sky130_fd_sc_hd__xnor2_2
X_12418_ net1728 _06201_ net570 vssd1 vssd1 vccd1 vccd1 _00464_ sky130_fd_sc_hd__mux2_1
XFILLER_0_49_11 vssd1 vssd1 vccd1 vccd1 sky130_fd_sc_hd__fill_2
XFILLER_0_23_553 vssd1 vssd1 vccd1 vccd1 sky130_fd_sc_hd__fill_2
XFILLER_0_50_394 vssd1 vssd1 vccd1 vccd1 sky130_fd_sc_hd__decap_4
X_12349_ net1479 _00828_ net656 vssd1 vssd1 vccd1 vccd1 _00401_ sky130_fd_sc_hd__mux2_1
XFILLER_0_23_597 vssd1 vssd1 vccd1 vccd1 sky130_fd_sc_hd__fill_1
XFILLER_0_121_783 vssd1 vssd1 vccd1 vccd1 sky130_fd_sc_hd__fill_1
X_06910_ _01023_ _01028_ vssd1 vssd1 vccd1 vccd1 _01035_ sky130_fd_sc_hd__xor2_2
X_07890_ _02008_ _02009_ net1051 net857 vssd1 vssd1 vccd1 vccd1 _02011_ sky130_fd_sc_hd__and4bb_1
X_06841_ net349 net1222 net647 vssd1 vssd1 vccd1 vccd1 _00115_ sky130_fd_sc_hd__mux2_1
X_09560_ _03667_ _03668_ _03635_ vssd1 vssd1 vccd1 vccd1 _03669_ sky130_fd_sc_hd__a21oi_1
X_06772_ net1364 l1\[11\] net638 vssd1 vssd1 vccd1 vccd1 _00046_ sky130_fd_sc_hd__mux2_1
X_09491_ _03598_ _03599_ vssd1 vssd1 vccd1 vccd1 _03600_ sky130_fd_sc_hd__xnor2_1
X_08511_ _02617_ _02625_ vssd1 vssd1 vccd1 vccd1 _02627_ sky130_fd_sc_hd__xor2_2
X_08442_ _02460_ _02463_ _02557_ vssd1 vssd1 vccd1 vccd1 _02558_ sky130_fd_sc_hd__a21oi_1
XFILLER_0_77_236 vssd1 vssd1 vccd1 vccd1 sky130_fd_sc_hd__fill_1
XFILLER_0_77_225 vssd1 vssd1 vccd1 vccd1 sky130_fd_sc_hd__decap_4
XFILLER_0_93_729 vssd1 vssd1 vccd1 vccd1 sky130_ef_sc_hd__decap_12
XFILLER_0_105_93 vssd1 vssd1 vccd1 vccd1 sky130_ef_sc_hd__decap_12
XFILLER_0_81_97 vssd1 vssd1 vccd1 vccd1 sky130_fd_sc_hd__fill_1
X_08373_ net1015 net857 _02488_ _02489_ vssd1 vssd1 vccd1 vccd1 _02490_ sky130_fd_sc_hd__nand4_2
XFILLER_0_73_420 vssd1 vssd1 vccd1 vccd1 sky130_ef_sc_hd__decap_12
XFILLER_0_73_453 vssd1 vssd1 vccd1 vccd1 sky130_fd_sc_hd__fill_1
X_07324_ _01440_ _01441_ vssd1 vssd1 vccd1 vccd1 _01449_ sky130_fd_sc_hd__xnor2_1
XFILLER_0_116_533 vssd1 vssd1 vccd1 vccd1 sky130_ef_sc_hd__decap_12
XFILLER_0_90_3 vssd1 vssd1 vccd1 vccd1 sky130_ef_sc_hd__decap_12
XFILLER_0_60_114 vssd1 vssd1 vccd1 vccd1 sky130_fd_sc_hd__fill_2
X_07255_ _01377_ _01378_ _01379_ vssd1 vssd1 vccd1 vccd1 _01380_ sky130_fd_sc_hd__nand3_1
XFILLER_0_45_166 vssd1 vssd1 vccd1 vccd1 sky130_fd_sc_hd__fill_2
XFILLER_0_121_81 vssd1 vssd1 vccd1 vccd1 sky130_ef_sc_hd__decap_12
XFILLER_0_60_136 vssd1 vssd1 vccd1 vccd1 sky130_fd_sc_hd__decap_4
X_07186_ net829 net1143 _01057_ _01058_ vssd1 vssd1 vccd1 vccd1 _01311_ sky130_fd_sc_hd__a22oi_1
XFILLER_0_111_293 vssd1 vssd1 vccd1 vccd1 sky130_ef_sc_hd__decap_12
Xfanout466 net467 vssd1 vssd1 vccd1 vccd1 net466 sky130_fd_sc_hd__clkbuf_4
X_09827_ net1070 net1078 net731 net724 vssd1 vssd1 vccd1 vccd1 _03934_ sky130_fd_sc_hd__nand4_2
Xfanout477 net485 vssd1 vssd1 vccd1 vccd1 net477 sky130_fd_sc_hd__clkbuf_4
XTAP_280 vssd1 vccd1 sky130_fd_sc_hd__tapvpwrvgnd_1
XTAP_291 vssd1 vccd1 sky130_fd_sc_hd__tapvpwrvgnd_1
Xfanout499 net501 vssd1 vssd1 vccd1 vccd1 net499 sky130_fd_sc_hd__buf_4
X_09758_ net901 net893 net937 net931 vssd1 vssd1 vccd1 vccd1 _03866_ sky130_fd_sc_hd__nand4_1
XTAP_2125 vssd1 vccd1 sky130_fd_sc_hd__tapvpwrvgnd_1
XTAP_2114 vssd1 vccd1 sky130_fd_sc_hd__tapvpwrvgnd_1
XTAP_2103 vssd1 vccd1 sky130_fd_sc_hd__tapvpwrvgnd_1
X_08709_ _02731_ _02734_ vssd1 vssd1 vccd1 vccd1 _02823_ sky130_fd_sc_hd__nand2_1
XFILLER_0_69_726 vssd1 vssd1 vccd1 vccd1 sky130_fd_sc_hd__fill_2
XTAP_2158 vssd1 vccd1 sky130_fd_sc_hd__tapvpwrvgnd_1
XTAP_2147 vssd1 vccd1 sky130_fd_sc_hd__tapvpwrvgnd_1
XTAP_2136 vssd1 vccd1 sky130_fd_sc_hd__tapvpwrvgnd_1
X_09689_ _03753_ _03795_ vssd1 vssd1 vccd1 vccd1 _03797_ sky130_fd_sc_hd__xnor2_4
XTAP_1424 vssd1 vccd1 sky130_fd_sc_hd__tapvpwrvgnd_1
XTAP_1413 vssd1 vccd1 sky130_fd_sc_hd__tapvpwrvgnd_1
XTAP_1402 vssd1 vccd1 sky130_fd_sc_hd__tapvpwrvgnd_1
X_11720_ net1319 _05778_ net477 vssd1 vssd1 vccd1 vccd1 _00189_ sky130_fd_sc_hd__mux2_1
XTAP_2169 vssd1 vccd1 sky130_fd_sc_hd__tapvpwrvgnd_1
XTAP_1457 vssd1 vccd1 sky130_fd_sc_hd__tapvpwrvgnd_1
XTAP_1446 vssd1 vccd1 sky130_fd_sc_hd__tapvpwrvgnd_1
XTAP_1435 vssd1 vccd1 sky130_fd_sc_hd__tapvpwrvgnd_1
XFILLER_0_127_809 vssd1 vssd1 vccd1 vccd1 sky130_ef_sc_hd__decap_12
XTAP_1468 vssd1 vccd1 sky130_fd_sc_hd__tapvpwrvgnd_1
XTAP_1479 vssd1 vccd1 sky130_fd_sc_hd__tapvpwrvgnd_1
X_11651_ net1012 net702 _05612_ _05613_ net712 vssd1 vssd1 vccd1 vccd1 _05745_ sky130_fd_sc_hd__a32o_1
X_10602_ _04684_ _04702_ _04703_ vssd1 vssd1 vccd1 vccd1 _04704_ sky130_fd_sc_hd__nand3_4
X_11582_ _05674_ _05675_ vssd1 vssd1 vccd1 vccd1 _05676_ sky130_fd_sc_hd__xnor2_1
XFILLER_0_36_122 vssd1 vssd1 vccd1 vccd1 sky130_fd_sc_hd__fill_1
XFILLER_0_119_393 vssd1 vssd1 vccd1 vccd1 sky130_ef_sc_hd__decap_12
XFILLER_0_91_261 vssd1 vssd1 vccd1 vccd1 sky130_fd_sc_hd__decap_4
X_10533_ _04630_ _04634_ _04635_ vssd1 vssd1 vccd1 vccd1 _04636_ sky130_fd_sc_hd__nand3_4
XFILLER_0_51_147 vssd1 vssd1 vccd1 vccd1 sky130_fd_sc_hd__decap_6
XFILLER_0_51_125 vssd1 vssd1 vccd1 vccd1 sky130_fd_sc_hd__decap_3
XFILLER_0_10_27 vssd1 vssd1 vccd1 vccd1 sky130_fd_sc_hd__fill_1
XFILLER_0_17_391 vssd1 vssd1 vccd1 vccd1 sky130_fd_sc_hd__fill_1
XFILLER_0_122_525 vssd1 vssd1 vccd1 vccd1 sky130_fd_sc_hd__decap_6
X_10464_ net1013 net753 net744 net1022 vssd1 vssd1 vccd1 vccd1 _04567_ sky130_fd_sc_hd__a22o_1
XFILLER_0_51_169 vssd1 vssd1 vccd1 vccd1 sky130_fd_sc_hd__decap_4
XFILLER_0_122_569 vssd1 vssd1 vccd1 vccd1 sky130_ef_sc_hd__decap_12
X_10395_ _04496_ _04498_ _04483_ vssd1 vssd1 vccd1 vccd1 _04499_ sky130_fd_sc_hd__a21o_1
X_13183_ clknet_leaf_21_clk_i _00569_ net1177 vssd1 vssd1 vccd1 vccd1 l1\[12\] sky130_fd_sc_hd__dfrtp_1
X_12203_ net828 _06155_ net515 vssd1 vssd1 vccd1 vccd1 _00295_ sky130_fd_sc_hd__mux2_1
X_12134_ _00935_ _06106_ net500 vssd1 vssd1 vccd1 vccd1 _06107_ sky130_fd_sc_hd__mux2_1
XFILLER_0_102_282 vssd1 vssd1 vccd1 vccd1 sky130_fd_sc_hd__decap_6
XFILLER_0_20_589 vssd1 vssd1 vccd1 vccd1 sky130_fd_sc_hd__decap_8
XFILLER_0_19_69 vssd1 vssd1 vccd1 vccd1 sky130_ef_sc_hd__decap_12
X_12065_ y2my0\[7\] net582 net531 x2mx1\[7\] _06054_ vssd1 vssd1 vccd1 vccd1 _06055_
+ sky130_fd_sc_hd__a221o_1
X_11016_ _05106_ _05114_ vssd1 vssd1 vccd1 vccd1 _05115_ sky130_fd_sc_hd__or2_2
XFILLER_0_126_15 vssd1 vssd1 vccd1 vccd1 sky130_ef_sc_hd__decap_12
XFILLER_0_35_57 vssd1 vssd1 vccd1 vccd1 sky130_fd_sc_hd__decap_6
XFILLER_0_87_545 vssd1 vssd1 vccd1 vccd1 sky130_fd_sc_hd__fill_2
X_12967_ clknet_leaf_35_clk_i _00353_ net1161 vssd1 vssd1 vccd1 vccd1 y1my2\[20\]
+ sky130_fd_sc_hd__dfrtp_1
X_11918_ net116 net620 net594 net84 vssd1 vssd1 vccd1 vccd1 _05943_ sky130_fd_sc_hd__a22o_1
X_12898_ clknet_leaf_45_clk_i _00284_ vssd1 vssd1 vccd1 vccd1 mul1.b\[1\] sky130_fd_sc_hd__dfxtp_2
XFILLER_0_51_23 vssd1 vssd1 vccd1 vccd1 sky130_fd_sc_hd__fill_1
X_11849_ net653 _00928_ net475 _05886_ vssd1 vssd1 vccd1 vccd1 _05887_ sky130_fd_sc_hd__a211o_1
XFILLER_0_28_623 vssd1 vssd1 vccd1 vccd1 sky130_fd_sc_hd__decap_4
XFILLER_0_129_3 vssd1 vssd1 vccd1 vccd1 sky130_ef_sc_hd__decap_12
XTAP_1991 vssd1 vccd1 sky130_fd_sc_hd__tapvpwrvgnd_1
XTAP_1980 vssd1 vccd1 sky130_fd_sc_hd__tapvpwrvgnd_1
XFILLER_0_28_656 vssd1 vssd1 vccd1 vccd1 sky130_ef_sc_hd__decap_12
XFILLER_0_43_615 vssd1 vssd1 vccd1 vccd1 sky130_fd_sc_hd__fill_1
XFILLER_0_16_829 vssd1 vssd1 vccd1 vccd1 sky130_fd_sc_hd__fill_1
XFILLER_0_27_166 vssd1 vssd1 vccd1 vccd1 sky130_fd_sc_hd__fill_2
XFILLER_0_125_341 vssd1 vssd1 vccd1 vccd1 sky130_fd_sc_hd__decap_8
XFILLER_0_113_503 vssd1 vssd1 vccd1 vccd1 sky130_fd_sc_hd__fill_1
XFILLER_0_43_659 vssd1 vssd1 vccd1 vccd1 sky130_fd_sc_hd__decap_4
XFILLER_0_42_114 vssd1 vssd1 vccd1 vccd1 sky130_fd_sc_hd__decap_3
XFILLER_0_70_456 vssd1 vssd1 vccd1 vccd1 sky130_fd_sc_hd__fill_1
X_07040_ net1081 _01164_ _01163_ vssd1 vssd1 vccd1 vccd1 _01165_ sky130_fd_sc_hd__a21bo_1
XFILLER_0_42_147 vssd1 vssd1 vccd1 vccd1 sky130_fd_sc_hd__fill_1
X_08991_ _02963_ _03102_ vssd1 vssd1 vccd1 vccd1 _03104_ sky130_fd_sc_hd__xor2_4
X_07942_ _01981_ _01983_ _01963_ vssd1 vssd1 vccd1 vccd1 _02062_ sky130_fd_sc_hd__o21ai_4
X_07873_ _01991_ _01992_ net1075 net831 vssd1 vssd1 vccd1 vccd1 _01994_ sky130_fd_sc_hd__and4bb_1
X_06824_ net1477 net1470 net648 vssd1 vssd1 vccd1 vccd1 _00098_ sky130_fd_sc_hd__mux2_1
X_09612_ _03717_ _03718_ _03719_ vssd1 vssd1 vccd1 vccd1 _03721_ sky130_fd_sc_hd__a21o_1
XFILLER_0_92_41 vssd1 vssd1 vccd1 vccd1 sky130_ef_sc_hd__decap_12
X_09543_ net818 mul1.a\[18\] _03507_ _03508_ net995 vssd1 vssd1 vccd1 vccd1 _03652_
+ sky130_fd_sc_hd__a32o_1
X_06755_ _00968_ _00969_ vssd1 vssd1 vccd1 vccd1 _00970_ sky130_fd_sc_hd__xnor2_4
X_09474_ _03578_ _03579_ _03106_ _03262_ _03417_ vssd1 vssd1 vccd1 vccd1 _03583_ sky130_fd_sc_hd__a2111o_1
X_06686_ _00909_ _00910_ vssd1 vssd1 vccd1 vccd1 _00911_ sky130_fd_sc_hd__nand2_4
XFILLER_0_25_90 vssd1 vssd1 vccd1 vccd1 sky130_fd_sc_hd__fill_2
XFILLER_0_109_809 vssd1 vssd1 vccd1 vccd1 sky130_fd_sc_hd__decap_4
XFILLER_0_65_239 vssd1 vssd1 vccd1 vccd1 sky130_ef_sc_hd__decap_12
X_08425_ _02415_ _02541_ vssd1 vssd1 vccd1 vccd1 _02542_ sky130_fd_sc_hd__xor2_2
X_08356_ net1025 net1033 net849 net840 vssd1 vssd1 vccd1 vccd1 _02473_ sky130_fd_sc_hd__nand4_1
XFILLER_0_74_740 vssd1 vssd1 vccd1 vccd1 sky130_fd_sc_hd__decap_8
X_07307_ net854 net1135 vssd1 vssd1 vccd1 vccd1 _01432_ sky130_fd_sc_hd__nand2_1
XFILLER_0_116_363 vssd1 vssd1 vccd1 vccd1 sky130_fd_sc_hd__fill_1
X_08287_ _02403_ _02404_ vssd1 vssd1 vccd1 vccd1 _02405_ sky130_fd_sc_hd__and2_1
X_07238_ net856 net1082 _01360_ _01361_ vssd1 vssd1 vccd1 vccd1 _01363_ sky130_fd_sc_hd__o2bb2a_1
XFILLER_0_33_169 vssd1 vssd1 vccd1 vccd1 sky130_fd_sc_hd__decap_6
Xbary_pipe_m_1209 vssd1 vssd1 vccd1 vccd1 bary_pipe_m_1209/HI div_mstream_o[59] sky130_fd_sc_hd__conb_1
XFILLER_0_104_569 vssd1 vssd1 vccd1 vccd1 sky130_fd_sc_hd__decap_3
X_07169_ _01291_ _01292_ vssd1 vssd1 vccd1 vccd1 _01294_ sky130_fd_sc_hd__nor2_1
XFILLER_0_42_692 vssd1 vssd1 vccd1 vccd1 sky130_fd_sc_hd__decap_8
XFILLER_0_100_731 vssd1 vssd1 vccd1 vccd1 sky130_ef_sc_hd__decap_12
X_10180_ _04283_ _04284_ vssd1 vssd1 vccd1 vccd1 _04285_ sky130_fd_sc_hd__nand2b_1
X_12821_ clknet_leaf_35_clk_i _00207_ vssd1 vssd1 vccd1 vccd1 sub1.a_i\[20\] sky130_fd_sc_hd__dfxtp_1
XFILLER_0_84_504 vssd1 vssd1 vccd1 vccd1 sky130_fd_sc_hd__decap_6
XTAP_1232 vssd1 vccd1 sky130_fd_sc_hd__tapvpwrvgnd_1
XTAP_1221 vssd1 vccd1 sky130_fd_sc_hd__tapvpwrvgnd_1
XTAP_1210 vssd1 vccd1 sky130_fd_sc_hd__tapvpwrvgnd_1
X_12752_ clknet_leaf_41_clk_i _00138_ vssd1 vssd1 vccd1 vccd1 add1.a_i\[15\] sky130_fd_sc_hd__dfxtp_1
X_12683_ clknet_leaf_16_clk_i _00069_ net1182 vssd1 vssd1 vccd1 vccd1 net412 sky130_fd_sc_hd__dfrtp_1
XTAP_1265 vssd1 vccd1 sky130_fd_sc_hd__tapvpwrvgnd_1
XTAP_1254 vssd1 vccd1 sky130_fd_sc_hd__tapvpwrvgnd_1
XTAP_1243 vssd1 vccd1 sky130_fd_sc_hd__tapvpwrvgnd_1
X_11703_ net218 net598 net578 net122 _05763_ vssd1 vssd1 vccd1 vccd1 _05764_ sky130_fd_sc_hd__a221o_1
XFILLER_0_127_617 vssd1 vssd1 vccd1 vccd1 sky130_fd_sc_hd__decap_3
XTAP_1298 vssd1 vccd1 sky130_fd_sc_hd__tapvpwrvgnd_1
XTAP_1276 vssd1 vccd1 sky130_fd_sc_hd__tapvpwrvgnd_1
XTAP_1287 vssd1 vccd1 sky130_fd_sc_hd__tapvpwrvgnd_1
X_11634_ net765 net943 vssd1 vssd1 vccd1 vccd1 _05728_ sky130_fd_sc_hd__nand2_1
XFILLER_0_126_149 vssd1 vssd1 vccd1 vccd1 sky130_fd_sc_hd__fill_1
XFILLER_0_21_15 vssd1 vssd1 vccd1 vccd1 sky130_ef_sc_hd__decap_12
X_11565_ _05550_ _05552_ _05659_ vssd1 vssd1 vccd1 vccd1 _05660_ sky130_fd_sc_hd__o21a_1
X_10516_ _04618_ vssd1 vssd1 vccd1 vccd1 _04619_ sky130_fd_sc_hd__inv_2
XFILLER_0_12_309 vssd1 vssd1 vccd1 vccd1 sky130_fd_sc_hd__decap_4
X_11496_ net782 net938 _05588_ _05589_ vssd1 vssd1 vccd1 vccd1 _05591_ sky130_fd_sc_hd__a22o_1
X_13235_ net508 vssd1 vssd1 vccd1 vccd1 net291 sky130_fd_sc_hd__clkbuf_1
XFILLER_0_122_333 vssd1 vssd1 vccd1 vccd1 sky130_ef_sc_hd__decap_12
X_10447_ _04548_ _04549_ vssd1 vssd1 vccd1 vccd1 _04550_ sky130_fd_sc_hd__xor2_1
XFILLER_0_122_377 vssd1 vssd1 vccd1 vccd1 sky130_ef_sc_hd__decap_12
X_13166_ clknet_leaf_9_clk_i _00552_ net1191 vssd1 vssd1 vccd1 vccd1 l0\[27\] sky130_fd_sc_hd__dfrtp_1
X_10378_ _04480_ _04481_ vssd1 vssd1 vccd1 vccd1 _04482_ sky130_fd_sc_hd__nand2b_1
X_12117_ y2my0\[20\] net589 net535 x2mx1\[20\] _06093_ vssd1 vssd1 vccd1 vccd1 _06094_
+ sky130_fd_sc_hd__a221o_1
X_13097_ clknet_leaf_17_clk_i _00483_ vssd1 vssd1 vccd1 vccd1 temp1\[22\] sky130_fd_sc_hd__dfxtp_1
X_12048_ x0mx2\[3\] net628 net590 y1my2\[3\] vssd1 vssd1 vccd1 vccd1 _06042_ sky130_fd_sc_hd__a22o_1
XFILLER_0_88_810 vssd1 vssd1 vccd1 vccd1 sky130_fd_sc_hd__fill_2
X_06540_ net544 _00793_ vssd1 vssd1 vccd1 vccd1 net304 sky130_fd_sc_hd__nor2_1
XFILLER_0_87_342 vssd1 vssd1 vccd1 vccd1 sky130_fd_sc_hd__decap_6
X_06471_ _00766_ _00767_ vssd1 vssd1 vccd1 vccd1 _00768_ sky130_fd_sc_hd__nand2b_2
XFILLER_0_48_729 vssd1 vssd1 vccd1 vccd1 sky130_fd_sc_hd__fill_2
XFILLER_0_117_105 vssd1 vssd1 vccd1 vccd1 sky130_fd_sc_hd__decap_6
X_08210_ _02326_ _02327_ _02292_ vssd1 vssd1 vccd1 vccd1 _02328_ sky130_fd_sc_hd__a21o_1
XFILLER_0_117_149 vssd1 vssd1 vccd1 vccd1 sky130_ef_sc_hd__decap_12
X_09190_ _03185_ _03189_ _03299_ _03300_ vssd1 vssd1 vccd1 vccd1 _03301_ sky130_fd_sc_hd__a211oi_2
XFILLER_0_56_773 vssd1 vssd1 vccd1 vccd1 sky130_fd_sc_hd__fill_2
XFILLER_0_83_581 vssd1 vssd1 vccd1 vccd1 sky130_fd_sc_hd__decap_8
X_08141_ _02237_ _02256_ _02257_ vssd1 vssd1 vccd1 vccd1 _02260_ sky130_fd_sc_hd__nand3_2
X_08072_ net821 _02097_ _02098_ _02095_ vssd1 vssd1 vccd1 vccd1 _02191_ sky130_fd_sc_hd__o2bb2a_1
XFILLER_0_70_253 vssd1 vssd1 vccd1 vccd1 sky130_fd_sc_hd__decap_3
XFILLER_0_15_169 vssd1 vssd1 vccd1 vccd1 sky130_fd_sc_hd__decap_4
XFILLER_0_102_83 vssd1 vssd1 vccd1 vccd1 sky130_fd_sc_hd__fill_1
XFILLER_0_11_81 vssd1 vssd1 vccd1 vccd1 sky130_fd_sc_hd__decap_8
X_07023_ _01144_ _01145_ _01146_ vssd1 vssd1 vccd1 vccd1 _01148_ sky130_fd_sc_hd__a21o_1
XFILLER_0_101_517 vssd1 vssd1 vccd1 vccd1 sky130_fd_sc_hd__decap_8
XFILLER_0_23_191 vssd1 vssd1 vccd1 vccd1 sky130_fd_sc_hd__fill_2
XFILLER_0_30_139 vssd1 vssd1 vccd1 vccd1 sky130_fd_sc_hd__fill_1
X_08974_ _03049_ _03050_ _03083_ _03084_ vssd1 vssd1 vccd1 vccd1 _03087_ sky130_fd_sc_hd__or4_4
Xhold27 det_t\[16\] vssd1 vssd1 vccd1 vccd1 net1242 sky130_fd_sc_hd__dlygate4sd3_1
Xhold38 l0\[25\] vssd1 vssd1 vccd1 vccd1 net1253 sky130_fd_sc_hd__dlygate4sd3_1
Xhold16 _00070_ vssd1 vssd1 vccd1 vccd1 net1231 sky130_fd_sc_hd__dlygate4sd3_1
X_07925_ _01983_ _01984_ _02043_ _02044_ vssd1 vssd1 vccd1 vccd1 _02046_ sky130_fd_sc_hd__a2bb2o_1
Xhold49 det_t\[10\] vssd1 vssd1 vccd1 vccd1 net1264 sky130_fd_sc_hd__dlygate4sd3_1
XFILLER_0_79_810 vssd1 vssd1 vccd1 vccd1 sky130_fd_sc_hd__fill_1
X_07856_ _01975_ _01976_ vssd1 vssd1 vccd1 vccd1 _01977_ sky130_fd_sc_hd__nand2b_1
X_06807_ net425 net1269 net642 vssd1 vssd1 vccd1 vccd1 _00081_ sky130_fd_sc_hd__mux2_1
X_07787_ net1040 net882 vssd1 vssd1 vccd1 vccd1 _01909_ sky130_fd_sc_hd__nand2_1
X_09526_ _03496_ _03499_ vssd1 vssd1 vccd1 vccd1 _03635_ sky130_fd_sc_hd__nand2_1
X_06738_ _00942_ _00947_ _00948_ _00954_ vssd1 vssd1 vccd1 vccd1 _00955_ sky130_fd_sc_hd__o211a_1
X_09457_ _03467_ _03468_ _03564_ _03565_ vssd1 vssd1 vccd1 vccd1 _03567_ sky130_fd_sc_hd__a2bb2o_1
XFILLER_0_109_617 vssd1 vssd1 vccd1 vccd1 sky130_ef_sc_hd__decap_12
X_08408_ _02462_ _02463_ _02523_ _02524_ vssd1 vssd1 vccd1 vccd1 _02525_ sky130_fd_sc_hd__nand4_4
X_06669_ _00895_ _00896_ vssd1 vssd1 vccd1 vccd1 _00897_ sky130_fd_sc_hd__xnor2_4
XFILLER_0_93_367 vssd1 vssd1 vccd1 vccd1 sky130_fd_sc_hd__decap_8
X_09388_ _03496_ _03497_ _03483_ vssd1 vssd1 vccd1 vccd1 _03498_ sky130_fd_sc_hd__a21o_1
XFILLER_0_47_762 vssd1 vssd1 vccd1 vccd1 sky130_fd_sc_hd__fill_1
XFILLER_0_34_401 vssd1 vssd1 vccd1 vccd1 sky130_fd_sc_hd__decap_3
X_08339_ _02452_ _02453_ _02454_ vssd1 vssd1 vccd1 vccd1 _02456_ sky130_fd_sc_hd__a21o_1
X_11350_ _05445_ _05446_ vssd1 vssd1 vccd1 vccd1 _05447_ sky130_fd_sc_hd__nand2_1
X_10301_ net1047 net1056 net732 net725 vssd1 vssd1 vccd1 vccd1 _04405_ sky130_fd_sc_hd__nand4_2
X_11281_ _05376_ _05377_ _05253_ _05256_ vssd1 vssd1 vccd1 vccd1 _05378_ sky130_fd_sc_hd__o211a_1
X_13020_ clknet_leaf_53_clk_i _00406_ net1155 vssd1 vssd1 vccd1 vccd1 x0mx2\[9\] sky130_fd_sc_hd__dfrtp_1
X_10232_ net809 net976 vssd1 vssd1 vccd1 vccd1 _04337_ sky130_fd_sc_hd__nand2_1
X_10163_ _04244_ _04265_ vssd1 vssd1 vccd1 vccd1 _04268_ sky130_fd_sc_hd__xnor2_2
Xfanout1003 net1004 vssd1 vssd1 vccd1 vccd1 net1003 sky130_fd_sc_hd__clkbuf_4
Xfanout1047 net1048 vssd1 vssd1 vccd1 vccd1 net1047 sky130_fd_sc_hd__clkbuf_4
Xfanout1025 net1031 vssd1 vssd1 vccd1 vccd1 net1025 sky130_fd_sc_hd__clkbuf_4
Xfanout1014 mul1.a\[17\] vssd1 vssd1 vccd1 vccd1 net1014 sky130_fd_sc_hd__buf_2
Xfanout1036 net1040 vssd1 vssd1 vccd1 vccd1 net1036 sky130_fd_sc_hd__buf_2
X_10094_ _04171_ _04172_ _04197_ _04198_ vssd1 vssd1 vccd1 vccd1 _04200_ sky130_fd_sc_hd__nor4_1
Xfanout1058 net1061 vssd1 vssd1 vccd1 vccd1 net1058 sky130_fd_sc_hd__dlymetal6s2s_1
Xfanout1069 mul1.a\[10\] vssd1 vssd1 vccd1 vccd1 net1069 sky130_fd_sc_hd__buf_4
XFILLER_0_107_39 vssd1 vssd1 vccd1 vccd1 sky130_ef_sc_hd__decap_12
XFILLER_0_16_15 vssd1 vssd1 vccd1 vccd1 sky130_ef_sc_hd__decap_12
X_12804_ clknet_leaf_55_clk_i _00190_ vssd1 vssd1 vccd1 vccd1 sub1.a_i\[3\] sky130_fd_sc_hd__dfxtp_1
XFILLER_0_97_673 vssd1 vssd1 vccd1 vccd1 sky130_ef_sc_hd__decap_12
XTAP_1040 vssd1 vccd1 sky130_fd_sc_hd__tapvpwrvgnd_1
X_10996_ _04972_ _04974_ _05094_ vssd1 vssd1 vccd1 vccd1 _05095_ sky130_fd_sc_hd__or3_1
XFILLER_0_123_27 vssd1 vssd1 vccd1 vccd1 sky130_ef_sc_hd__decap_12
XFILLER_0_84_345 vssd1 vssd1 vccd1 vccd1 sky130_ef_sc_hd__decap_12
XTAP_1062 vssd1 vccd1 sky130_fd_sc_hd__tapvpwrvgnd_1
XTAP_1073 vssd1 vccd1 sky130_fd_sc_hd__tapvpwrvgnd_1
XTAP_1051 vssd1 vccd1 sky130_fd_sc_hd__tapvpwrvgnd_1
X_12735_ clknet_leaf_25_clk_i _00121_ net1172 vssd1 vssd1 vccd1 vccd1 state\[4\] sky130_fd_sc_hd__dfrtp_4
XFILLER_0_32_36 vssd1 vssd1 vccd1 vccd1 sky130_ef_sc_hd__decap_12
XFILLER_0_127_447 vssd1 vssd1 vccd1 vccd1 sky130_fd_sc_hd__fill_1
XFILLER_0_127_425 vssd1 vssd1 vccd1 vccd1 sky130_fd_sc_hd__fill_2
X_12666_ clknet_leaf_20_clk_i _00052_ net1180 vssd1 vssd1 vccd1 vccd1 net393 sky130_fd_sc_hd__dfrtp_1
XTAP_1095 vssd1 vccd1 sky130_fd_sc_hd__tapvpwrvgnd_1
XTAP_1084 vssd1 vccd1 sky130_fd_sc_hd__tapvpwrvgnd_1
XFILLER_0_115_609 vssd1 vssd1 vccd1 vccd1 sky130_fd_sc_hd__decap_6
X_12597_ net1566 net8 net556 vssd1 vssd1 vccd1 vccd1 _00572_ sky130_fd_sc_hd__mux2_1
XFILLER_0_5_818 vssd1 vssd1 vccd1 vccd1 sky130_fd_sc_hd__fill_2
X_11617_ _05646_ _05649_ vssd1 vssd1 vccd1 vccd1 _05711_ sky130_fd_sc_hd__or2_1
XFILLER_0_53_765 vssd1 vssd1 vccd1 vccd1 sky130_fd_sc_hd__fill_2
X_11548_ _05477_ _05479_ _05641_ vssd1 vssd1 vccd1 vccd1 _05643_ sky130_fd_sc_hd__nand3_1
XFILLER_0_123_653 vssd1 vssd1 vccd1 vccd1 sky130_ef_sc_hd__decap_12
XFILLER_0_107_193 vssd1 vssd1 vccd1 vccd1 sky130_ef_sc_hd__decap_12
Xhold508 temp1\[21\] vssd1 vssd1 vccd1 vccd1 net1723 sky130_fd_sc_hd__dlygate4sd3_1
XFILLER_0_123_697 vssd1 vssd1 vccd1 vccd1 sky130_ef_sc_hd__decap_12
XFILLER_0_122_141 vssd1 vssd1 vccd1 vccd1 sky130_ef_sc_hd__decap_12
XFILLER_0_111_837 vssd1 vssd1 vccd1 vccd1 sky130_fd_sc_hd__decap_3
XFILLER_0_12_139 vssd1 vssd1 vccd1 vccd1 sky130_fd_sc_hd__fill_1
Xhold519 net354 vssd1 vssd1 vccd1 vccd1 net1734 sky130_fd_sc_hd__dlygate4sd3_1
X_11479_ net969 net736 vssd1 vssd1 vccd1 vccd1 _05574_ sky130_fd_sc_hd__nand2_1
X_13149_ clknet_leaf_14_clk_i _00535_ net1186 vssd1 vssd1 vccd1 vccd1 l0\[10\] sky130_fd_sc_hd__dfrtp_1
XFILLER_0_57_11 vssd1 vssd1 vccd1 vccd1 sky130_fd_sc_hd__decap_3
XTAP_802 vssd1 vccd1 sky130_fd_sc_hd__tapvpwrvgnd_1
XTAP_813 vssd1 vccd1 sky130_fd_sc_hd__tapvpwrvgnd_1
XTAP_824 vssd1 vccd1 sky130_fd_sc_hd__tapvpwrvgnd_1
XTAP_835 vssd1 vccd1 sky130_fd_sc_hd__tapvpwrvgnd_1
XFILLER_0_57_55 vssd1 vssd1 vccd1 vccd1 sky130_fd_sc_hd__fill_1
XTAP_846 vssd1 vccd1 sky130_fd_sc_hd__tapvpwrvgnd_1
XTAP_857 vssd1 vccd1 sky130_fd_sc_hd__tapvpwrvgnd_1
XTAP_868 vssd1 vccd1 sky130_fd_sc_hd__tapvpwrvgnd_1
X_07710_ _01831_ _01832_ _01814_ vssd1 vssd1 vccd1 vccd1 _01833_ sky130_fd_sc_hd__a21oi_2
XTAP_879 vssd1 vccd1 sky130_fd_sc_hd__tapvpwrvgnd_1
X_08690_ _02675_ _02803_ _02804_ vssd1 vssd1 vccd1 vccd1 _02805_ sky130_fd_sc_hd__nor3_1
XFILLER_0_73_65 vssd1 vssd1 vccd1 vccd1 sky130_fd_sc_hd__decap_4
XFILLER_0_73_54 vssd1 vssd1 vccd1 vccd1 sky130_fd_sc_hd__fill_2
X_07641_ _01669_ _01679_ _01681_ vssd1 vssd1 vccd1 vccd1 _01764_ sky130_fd_sc_hd__a21oi_1
X_07572_ _01693_ _01694_ vssd1 vssd1 vccd1 vccd1 _01696_ sky130_fd_sc_hd__xnor2_2
X_06523_ net528 _00649_ _00783_ vssd1 vssd1 vccd1 vccd1 net296 sky130_fd_sc_hd__and3_2
X_09311_ net1307 _03421_ net523 vssd1 vssd1 vccd1 vccd1 _00137_ sky130_fd_sc_hd__mux2_1
XFILLER_0_48_559 vssd1 vssd1 vccd1 vccd1 sky130_fd_sc_hd__decap_6
X_09242_ _03196_ _03197_ _03351_ _03352_ vssd1 vssd1 vccd1 vccd1 _03353_ sky130_fd_sc_hd__a211o_1
X_06454_ _00745_ _00748_ _00746_ vssd1 vssd1 vccd1 vccd1 _00753_ sky130_fd_sc_hd__a21bo_2
X_06385_ net545 _00693_ vssd1 vssd1 vccd1 vccd1 net314 sky130_fd_sc_hd__nor2_1
XFILLER_0_118_469 vssd1 vssd1 vccd1 vccd1 sky130_fd_sc_hd__decap_6
X_09173_ net1100 net728 net726 net1108 vssd1 vssd1 vccd1 vccd1 _03284_ sky130_fd_sc_hd__a22o_1
XFILLER_0_113_93 vssd1 vssd1 vccd1 vccd1 sky130_ef_sc_hd__decap_12
X_08124_ _02238_ _02239_ _02241_ vssd1 vssd1 vccd1 vccd1 _02243_ sky130_fd_sc_hd__and3_1
XFILLER_0_71_573 vssd1 vssd1 vccd1 vccd1 sky130_fd_sc_hd__decap_6
X_08055_ _02170_ _02172_ vssd1 vssd1 vccd1 vccd1 _02174_ sky130_fd_sc_hd__xnor2_1
X_07006_ _01122_ _01130_ vssd1 vssd1 vccd1 vccd1 _01131_ sky130_fd_sc_hd__nand2_1
XFILLER_0_11_161 vssd1 vssd1 vccd1 vccd1 sky130_fd_sc_hd__decap_6
Xinput117 v0y[5] vssd1 vssd1 vccd1 vccd1 net117 sky130_fd_sc_hd__buf_1
Xinput106 v0y[24] vssd1 vssd1 vccd1 vccd1 net106 sky130_fd_sc_hd__buf_1
X_08957_ _03068_ _03069_ _03067_ vssd1 vssd1 vccd1 vccd1 _03070_ sky130_fd_sc_hd__a21o_1
Xinput128 v1x[15] vssd1 vssd1 vccd1 vccd1 net128 sky130_fd_sc_hd__buf_1
Xinput139 v1x[25] vssd1 vssd1 vccd1 vccd1 net139 sky130_fd_sc_hd__clkbuf_1
X_08888_ _02999_ _03000_ net1085 net756 vssd1 vssd1 vccd1 vccd1 _03001_ sky130_fd_sc_hd__and4bb_1
X_07908_ _02025_ _02026_ _02027_ vssd1 vssd1 vccd1 vccd1 _02029_ sky130_fd_sc_hd__a21o_1
XFILLER_0_98_426 vssd1 vssd1 vccd1 vccd1 sky130_fd_sc_hd__decap_4
X_07839_ _01958_ _01959_ vssd1 vssd1 vccd1 vccd1 _01960_ sky130_fd_sc_hd__nand2_1
X_10850_ _04949_ _04950_ vssd1 vssd1 vccd1 vccd1 _04951_ sky130_fd_sc_hd__and2_1
XFILLER_0_2_90 vssd1 vssd1 vccd1 vccd1 sky130_fd_sc_hd__fill_2
X_09509_ _03614_ _03615_ _03616_ vssd1 vssd1 vccd1 vccd1 _03618_ sky130_fd_sc_hd__a21bo_1
XPHY_134 vssd1 vssd1 vccd1 vccd1 sky130_fd_sc_hd__decap_3
X_10781_ _04733_ _04735_ _04881_ vssd1 vssd1 vccd1 vccd1 _04882_ sky130_fd_sc_hd__a21o_1
XPHY_123 vssd1 vssd1 vccd1 vccd1 sky130_fd_sc_hd__decap_3
XPHY_112 vssd1 vssd1 vccd1 vccd1 sky130_fd_sc_hd__decap_3
XPHY_101 vssd1 vssd1 vccd1 vccd1 sky130_fd_sc_hd__decap_3
XFILLER_0_39_559 vssd1 vssd1 vccd1 vccd1 sky130_fd_sc_hd__fill_1
X_12520_ net1356 net566 vssd1 vssd1 vccd1 vccd1 _06257_ sky130_fd_sc_hd__nand2_1
XFILLER_0_93_142 vssd1 vssd1 vccd1 vccd1 sky130_fd_sc_hd__decap_3
XPHY_167 vssd1 vssd1 vccd1 vccd1 sky130_fd_sc_hd__decap_3
XPHY_156 vssd1 vssd1 vccd1 vccd1 sky130_fd_sc_hd__decap_3
XPHY_145 vssd1 vssd1 vccd1 vccd1 sky130_fd_sc_hd__decap_3
XPHY_189 vssd1 vssd1 vccd1 vccd1 sky130_fd_sc_hd__decap_3
XFILLER_0_93_175 vssd1 vssd1 vccd1 vccd1 sky130_fd_sc_hd__decap_8
XPHY_178 vssd1 vssd1 vccd1 vccd1 sky130_fd_sc_hd__decap_3
XFILLER_0_81_337 vssd1 vssd1 vccd1 vccd1 sky130_fd_sc_hd__decap_6
X_12451_ net1721 _06219_ net571 vssd1 vssd1 vccd1 vccd1 _00479_ sky130_fd_sc_hd__mux2_1
Xclkbuf_leaf_51_clk_i clknet_3_0__leaf_clk_i vssd1 vssd1 vccd1 vccd1 clknet_leaf_51_clk_i
+ sky130_fd_sc_hd__clkbuf_16
X_11402_ _05494_ _05495_ _05335_ _05338_ vssd1 vssd1 vccd1 vccd1 _05498_ sky130_fd_sc_hd__o211a_1
XFILLER_0_105_653 vssd1 vssd1 vccd1 vccd1 sky130_ef_sc_hd__decap_12
X_12382_ net1561 net526 net682 vssd1 vssd1 vccd1 vccd1 _00434_ sky130_fd_sc_hd__mux2_1
XFILLER_0_120_601 vssd1 vssd1 vccd1 vccd1 sky130_ef_sc_hd__decap_12
XFILLER_0_104_141 vssd1 vssd1 vccd1 vccd1 sky130_ef_sc_hd__decap_12
X_11333_ _05386_ _05428_ _05429_ vssd1 vssd1 vccd1 vccd1 _05430_ sky130_fd_sc_hd__nand3_2
XFILLER_0_120_645 vssd1 vssd1 vccd1 vccd1 sky130_ef_sc_hd__decap_12
X_11264_ _05244_ _05246_ vssd1 vssd1 vccd1 vccd1 _05361_ sky130_fd_sc_hd__or2_1
X_10215_ net878 net867 net936 net933 vssd1 vssd1 vccd1 vccd1 _04320_ sky130_fd_sc_hd__nand4_2
X_13003_ clknet_leaf_32_clk_i _00389_ net1166 vssd1 vssd1 vccd1 vccd1 x2mx1\[24\]
+ sky130_fd_sc_hd__dfrtp_1
X_11195_ _05284_ _05291_ vssd1 vssd1 vccd1 vccd1 _05293_ sky130_fd_sc_hd__xnor2_2
XFILLER_0_118_27 vssd1 vssd1 vccd1 vccd1 sky130_fd_sc_hd__fill_1
X_10146_ _04250_ _04249_ _04248_ vssd1 vssd1 vccd1 vccd1 _04251_ sky130_fd_sc_hd__nand3b_2
X_10077_ _04178_ _04179_ _04180_ vssd1 vssd1 vccd1 vccd1 _04183_ sky130_fd_sc_hd__a21o_1
XFILLER_0_85_610 vssd1 vssd1 vccd1 vccd1 sky130_fd_sc_hd__decap_6
XFILLER_0_58_813 vssd1 vssd1 vccd1 vccd1 sky130_fd_sc_hd__fill_1
XPHY_3 vssd1 vssd1 vccd1 vccd1 sky130_fd_sc_hd__decap_3
XFILLER_0_128_701 vssd1 vssd1 vccd1 vccd1 sky130_ef_sc_hd__decap_12
X_10979_ _05076_ _05078_ vssd1 vssd1 vccd1 vccd1 _05079_ sky130_fd_sc_hd__nor2_1
X_12718_ clknet_leaf_6_clk_i _00104_ net1192 vssd1 vssd1 vccd1 vccd1 net337 sky130_fd_sc_hd__dfrtp_1
XFILLER_0_127_244 vssd1 vssd1 vccd1 vccd1 sky130_fd_sc_hd__fill_2
Xclkbuf_leaf_19_clk_i clknet_3_7__leaf_clk_i vssd1 vssd1 vccd1 vccd1 clknet_leaf_19_clk_i
+ sky130_fd_sc_hd__clkbuf_16
XFILLER_0_45_529 vssd1 vssd1 vccd1 vccd1 sky130_ef_sc_hd__decap_12
XFILLER_0_115_417 vssd1 vssd1 vccd1 vccd1 sky130_ef_sc_hd__decap_12
X_12649_ clknet_leaf_22_clk_i net1390 net1174 vssd1 vssd1 vccd1 vccd1 net375 sky130_fd_sc_hd__dfrtp_1
XFILLER_0_41_724 vssd1 vssd1 vccd1 vccd1 sky130_fd_sc_hd__decap_4
XFILLER_0_123_461 vssd1 vssd1 vccd1 vccd1 sky130_ef_sc_hd__decap_12
Xhold316 net341 vssd1 vssd1 vccd1 vccd1 net1531 sky130_fd_sc_hd__dlygate4sd3_1
Xhold305 x0mx2\[20\] vssd1 vssd1 vccd1 vccd1 net1520 sky130_fd_sc_hd__dlygate4sd3_1
Xhold327 l0\[29\] vssd1 vssd1 vccd1 vccd1 net1542 sky130_fd_sc_hd__dlygate4sd3_1
Xhold349 sub1.a_i\[4\] vssd1 vssd1 vccd1 vccd1 net1564 sky130_fd_sc_hd__dlygate4sd3_1
XFILLER_0_7_57 vssd1 vssd1 vccd1 vccd1 sky130_ef_sc_hd__decap_12
XFILLER_0_1_832 vssd1 vssd1 vccd1 vccd1 sky130_fd_sc_hd__fill_2
Xhold338 x0mx2\[13\] vssd1 vssd1 vccd1 vccd1 net1553 sky130_fd_sc_hd__dlygate4sd3_1
XFILLER_0_110_133 vssd1 vssd1 vccd1 vccd1 sky130_fd_sc_hd__decap_6
X_09860_ _03964_ _03965_ _03805_ _03807_ vssd1 vssd1 vccd1 vccd1 _03967_ sky130_fd_sc_hd__a211o_1
Xfanout807 net808 vssd1 vssd1 vccd1 vccd1 net807 sky130_fd_sc_hd__clkbuf_4
XFILLER_0_110_177 vssd1 vssd1 vccd1 vccd1 sky130_ef_sc_hd__decap_12
Xfanout818 net819 vssd1 vssd1 vccd1 vccd1 net818 sky130_fd_sc_hd__buf_2
XFILLER_0_68_98 vssd1 vssd1 vccd1 vccd1 sky130_fd_sc_hd__decap_4
XTAP_610 vssd1 vccd1 sky130_fd_sc_hd__tapvpwrvgnd_1
XTAP_621 vssd1 vccd1 sky130_fd_sc_hd__tapvpwrvgnd_1
XTAP_632 vssd1 vccd1 sky130_fd_sc_hd__tapvpwrvgnd_1
XTAP_643 vssd1 vccd1 sky130_fd_sc_hd__tapvpwrvgnd_1
Xfanout829 net830 vssd1 vssd1 vccd1 vccd1 net829 sky130_fd_sc_hd__buf_2
X_09791_ _03751_ _03898_ vssd1 vssd1 vccd1 vccd1 _03899_ sky130_fd_sc_hd__xor2_1
X_08811_ net924 net916 net950 net944 vssd1 vssd1 vccd1 vccd1 _02925_ sky130_fd_sc_hd__nand4_1
XTAP_654 vssd1 vccd1 sky130_fd_sc_hd__tapvpwrvgnd_1
XTAP_665 vssd1 vccd1 sky130_fd_sc_hd__tapvpwrvgnd_1
XTAP_676 vssd1 vccd1 sky130_fd_sc_hd__tapvpwrvgnd_1
X_08742_ _02854_ _02855_ vssd1 vssd1 vccd1 vccd1 _02856_ sky130_fd_sc_hd__or2_1
XFILLER_0_84_53 vssd1 vssd1 vccd1 vccd1 sky130_fd_sc_hd__decap_4
XTAP_687 vssd1 vccd1 sky130_fd_sc_hd__tapvpwrvgnd_1
XTAP_698 vssd1 vccd1 sky130_fd_sc_hd__tapvpwrvgnd_1
X_08673_ _02767_ _02784_ _02785_ vssd1 vssd1 vccd1 vccd1 _02788_ sky130_fd_sc_hd__nand3_2
X_07624_ _01745_ _01746_ _01394_ _01397_ vssd1 vssd1 vccd1 vccd1 _01748_ sky130_fd_sc_hd__o211a_1
XFILLER_0_16_3 vssd1 vssd1 vccd1 vccd1 sky130_ef_sc_hd__decap_12
XTAP_1809 vssd1 vccd1 sky130_fd_sc_hd__tapvpwrvgnd_1
XFILLER_0_88_470 vssd1 vssd1 vccd1 vccd1 sky130_fd_sc_hd__fill_2
XFILLER_0_88_481 vssd1 vssd1 vccd1 vccd1 sky130_fd_sc_hd__fill_1
XFILLER_0_76_643 vssd1 vssd1 vccd1 vccd1 sky130_fd_sc_hd__fill_1
X_07555_ _01677_ _01678_ vssd1 vssd1 vccd1 vccd1 _01679_ sky130_fd_sc_hd__xnor2_1
X_06506_ det_t\[16\] net527 vssd1 vssd1 vccd1 vccd1 net259 sky130_fd_sc_hd__and2_1
X_07486_ _01609_ _01610_ vssd1 vssd1 vccd1 vccd1 _01611_ sky130_fd_sc_hd__and2b_1
X_06437_ net546 _00738_ vssd1 vssd1 vccd1 vccd1 net321 sky130_fd_sc_hd__nor2_1
XFILLER_0_118_233 vssd1 vssd1 vccd1 vccd1 sky130_ef_sc_hd__decap_12
XFILLER_0_91_635 vssd1 vssd1 vccd1 vccd1 sky130_fd_sc_hd__fill_1
XFILLER_0_91_624 vssd1 vssd1 vccd1 vccd1 sky130_fd_sc_hd__decap_8
X_09225_ _03319_ _03334_ vssd1 vssd1 vccd1 vccd1 _03336_ sky130_fd_sc_hd__nand2_2
XFILLER_0_63_337 vssd1 vssd1 vccd1 vccd1 sky130_fd_sc_hd__fill_2
XFILLER_0_17_721 vssd1 vssd1 vccd1 vccd1 sky130_fd_sc_hd__fill_2
XFILLER_0_33_90 vssd1 vssd1 vccd1 vccd1 sky130_fd_sc_hd__fill_1
XFILLER_0_118_277 vssd1 vssd1 vccd1 vccd1 sky130_ef_sc_hd__decap_12
XFILLER_0_63_359 vssd1 vssd1 vccd1 vccd1 sky130_fd_sc_hd__decap_6
X_09156_ net1124 net716 net707 net1133 vssd1 vssd1 vccd1 vccd1 _03267_ sky130_fd_sc_hd__a22o_1
X_06368_ add1.a_i\[14\] add1.b_i\[14\] vssd1 vssd1 vccd1 vccd1 _00679_ sky130_fd_sc_hd__or2_1
X_06299_ net546 vssd1 vssd1 vccd1 vccd1 net331 sky130_fd_sc_hd__inv_2
X_09087_ _03197_ _03198_ vssd1 vssd1 vccd1 vccd1 _03199_ sky130_fd_sc_hd__nand2_1
X_08107_ _02224_ _02225_ _02106_ _02108_ vssd1 vssd1 vccd1 vccd1 _02226_ sky130_fd_sc_hd__a211oi_2
XFILLER_0_31_223 vssd1 vssd1 vccd1 vccd1 sky130_fd_sc_hd__fill_1
XFILLER_0_102_645 vssd1 vssd1 vccd1 vccd1 sky130_fd_sc_hd__decap_6
XFILLER_0_101_122 vssd1 vssd1 vccd1 vccd1 sky130_fd_sc_hd__fill_1
XFILLER_0_101_111 vssd1 vssd1 vccd1 vccd1 sky130_fd_sc_hd__fill_1
X_08038_ _02156_ _02157_ vssd1 vssd1 vccd1 vccd1 _02158_ sky130_fd_sc_hd__nand2b_1
X_10000_ _03938_ _03941_ _04103_ _04104_ vssd1 vssd1 vccd1 vccd1 _04106_ sky130_fd_sc_hd__a211oi_1
X_09989_ net1062 net1072 net731 net724 vssd1 vssd1 vccd1 vccd1 _04095_ sky130_fd_sc_hd__nand4_2
XFILLER_0_98_223 vssd1 vssd1 vccd1 vccd1 sky130_fd_sc_hd__fill_2
X_11951_ net5 net550 net625 net189 _05967_ vssd1 vssd1 vccd1 vccd1 _05968_ sky130_fd_sc_hd__a221o_1
X_10902_ net800 net790 net959 net951 vssd1 vssd1 vccd1 vccd1 _05002_ sky130_fd_sc_hd__and4_1
X_11882_ net1300 _05914_ net482 vssd1 vssd1 vccd1 vccd1 _00215_ sky130_fd_sc_hd__mux2_1
XFILLER_0_39_301 vssd1 vssd1 vccd1 vccd1 sky130_fd_sc_hd__decap_3
X_10833_ _04742_ _04745_ _04932_ _04933_ vssd1 vssd1 vccd1 vccd1 _04934_ sky130_fd_sc_hd__a211o_2
XFILLER_0_104_29 vssd1 vssd1 vccd1 vccd1 sky130_ef_sc_hd__decap_12
X_10764_ _04863_ _04864_ vssd1 vssd1 vccd1 vccd1 _04865_ sky130_fd_sc_hd__xnor2_1
XFILLER_0_13_27 vssd1 vssd1 vccd1 vccd1 sky130_ef_sc_hd__decap_12
X_12503_ _00795_ net564 _06248_ vssd1 vssd1 vccd1 vccd1 _00502_ sky130_fd_sc_hd__o21ai_1
XFILLER_0_82_635 vssd1 vssd1 vccd1 vccd1 sky130_fd_sc_hd__fill_1
XFILLER_0_54_326 vssd1 vssd1 vccd1 vccd1 sky130_fd_sc_hd__decap_4
XFILLER_0_109_277 vssd1 vssd1 vccd1 vccd1 sky130_fd_sc_hd__decap_3
X_10695_ _04795_ _04796_ vssd1 vssd1 vccd1 vccd1 _04797_ sky130_fd_sc_hd__nor2_1
XFILLER_0_54_359 vssd1 vssd1 vccd1 vccd1 sky130_fd_sc_hd__decap_4
X_12434_ temp1\[11\] _06209_ net571 vssd1 vssd1 vccd1 vccd1 _00472_ sky130_fd_sc_hd__mux2_1
X_12365_ net1520 _00913_ net660 vssd1 vssd1 vccd1 vccd1 _00417_ sky130_fd_sc_hd__mux2_1
XFILLER_0_105_472 vssd1 vssd1 vccd1 vccd1 sky130_fd_sc_hd__fill_1
X_11316_ _05411_ _05412_ vssd1 vssd1 vccd1 vccd1 _05413_ sky130_fd_sc_hd__xnor2_1
XFILLER_0_129_15 vssd1 vssd1 vccd1 vccd1 sky130_ef_sc_hd__decap_12
X_12296_ net1688 _00887_ net676 vssd1 vssd1 vccd1 vccd1 _00348_ sky130_fd_sc_hd__mux2_1
XFILLER_0_120_475 vssd1 vssd1 vccd1 vccd1 sky130_fd_sc_hd__fill_1
X_11247_ net978 net742 net969 net750 vssd1 vssd1 vccd1 vccd1 _05344_ sky130_fd_sc_hd__a22o_1
X_11178_ net1045 net697 net694 net1055 vssd1 vssd1 vccd1 vccd1 _05276_ sky130_fd_sc_hd__o2bb2a_1
X_10129_ _04232_ _04233_ vssd1 vssd1 vccd1 vccd1 _04234_ sky130_fd_sc_hd__nand2b_1
XFILLER_0_54_56 vssd1 vssd1 vccd1 vccd1 sky130_fd_sc_hd__fill_1
XFILLER_0_77_429 vssd1 vssd1 vccd1 vccd1 sky130_fd_sc_hd__decap_3
XFILLER_0_54_89 vssd1 vssd1 vccd1 vccd1 sky130_fd_sc_hd__fill_1
XFILLER_0_128_531 vssd1 vssd1 vccd1 vccd1 sky130_fd_sc_hd__fill_1
X_07340_ _01426_ _01438_ _01437_ vssd1 vssd1 vccd1 vccd1 _01465_ sky130_fd_sc_hd__a21o_1
XFILLER_0_72_112 vssd1 vssd1 vccd1 vccd1 sky130_fd_sc_hd__fill_1
XFILLER_0_70_77 vssd1 vssd1 vccd1 vccd1 sky130_fd_sc_hd__decap_6
X_09010_ _02967_ _03121_ vssd1 vssd1 vccd1 vccd1 _03122_ sky130_fd_sc_hd__nor2_1
XFILLER_0_73_668 vssd1 vssd1 vccd1 vccd1 sky130_fd_sc_hd__decap_4
X_07271_ _01394_ _01395_ _01337_ vssd1 vssd1 vccd1 vccd1 _01396_ sky130_fd_sc_hd__a21o_1
XFILLER_0_115_225 vssd1 vssd1 vccd1 vccd1 sky130_ef_sc_hd__decap_12
XFILLER_0_72_167 vssd1 vssd1 vccd1 vccd1 sky130_fd_sc_hd__fill_2
XFILLER_0_79_53 vssd1 vssd1 vccd1 vccd1 sky130_fd_sc_hd__decap_3
XFILLER_0_5_489 vssd1 vssd1 vccd1 vccd1 sky130_fd_sc_hd__decap_4
XFILLER_0_124_781 vssd1 vssd1 vccd1 vccd1 sky130_ef_sc_hd__decap_12
XFILLER_0_79_75 vssd1 vssd1 vccd1 vccd1 sky130_fd_sc_hd__decap_3
Xhold113 sub1.b_i\[28\] vssd1 vssd1 vccd1 vccd1 net1328 sky130_fd_sc_hd__dlygate4sd3_1
Xhold102 sub1.b_i\[14\] vssd1 vssd1 vccd1 vccd1 net1317 sky130_fd_sc_hd__dlygate4sd3_1
Xhold135 net370 vssd1 vssd1 vccd1 vccd1 net1350 sky130_fd_sc_hd__dlygate4sd3_1
Xhold124 net367 vssd1 vssd1 vccd1 vccd1 net1339 sky130_fd_sc_hd__dlygate4sd3_1
XFILLER_0_110_83 vssd1 vssd1 vccd1 vccd1 sky130_fd_sc_hd__fill_1
Xhold146 add1.a_i\[7\] vssd1 vssd1 vccd1 vccd1 net1361 sky130_fd_sc_hd__dlygate4sd3_1
Xhold157 y2my0\[23\] vssd1 vssd1 vccd1 vccd1 net1372 sky130_fd_sc_hd__dlygate4sd3_1
Xhold168 x0mx2\[17\] vssd1 vssd1 vccd1 vccd1 net1383 sky130_fd_sc_hd__dlygate4sd3_1
XFILLER_0_111_497 vssd1 vssd1 vccd1 vccd1 sky130_fd_sc_hd__decap_6
X_09912_ _04013_ _04017_ _04018_ vssd1 vssd1 vccd1 vccd1 _04019_ sky130_fd_sc_hd__nand3_1
Xhold179 _00048_ vssd1 vssd1 vccd1 vccd1 net1394 sky130_fd_sc_hd__dlygate4sd3_1
Xfanout615 net618 vssd1 vssd1 vccd1 vccd1 net615 sky130_fd_sc_hd__clkbuf_4
XFILLER_0_1_673 vssd1 vssd1 vccd1 vccd1 sky130_fd_sc_hd__fill_1
Xfanout604 _00996_ vssd1 vssd1 vccd1 vccd1 net604 sky130_fd_sc_hd__buf_2
X_09843_ _03949_ _03910_ vssd1 vssd1 vccd1 vccd1 _03950_ sky130_fd_sc_hd__and2b_1
Xfanout648 net649 vssd1 vssd1 vccd1 vccd1 net648 sky130_fd_sc_hd__clkbuf_2
Xfanout626 net627 vssd1 vssd1 vccd1 vccd1 net626 sky130_fd_sc_hd__clkbuf_4
XTAP_440 vssd1 vccd1 sky130_fd_sc_hd__tapvpwrvgnd_1
XTAP_451 vssd1 vccd1 sky130_fd_sc_hd__tapvpwrvgnd_1
Xfanout637 net640 vssd1 vssd1 vccd1 vccd1 net637 sky130_fd_sc_hd__clkbuf_4
XFILLER_0_119_81 vssd1 vssd1 vccd1 vccd1 sky130_ef_sc_hd__decap_12
XFILLER_0_95_85 vssd1 vssd1 vccd1 vccd1 sky130_fd_sc_hd__fill_1
XTAP_462 vssd1 vccd1 sky130_fd_sc_hd__tapvpwrvgnd_1
XTAP_473 vssd1 vccd1 sky130_fd_sc_hd__tapvpwrvgnd_1
XTAP_484 vssd1 vccd1 sky130_fd_sc_hd__tapvpwrvgnd_1
Xfanout659 _01006_ vssd1 vssd1 vccd1 vccd1 net659 sky130_fd_sc_hd__buf_4
X_09774_ _03879_ _03880_ vssd1 vssd1 vccd1 vccd1 _03882_ sky130_fd_sc_hd__xnor2_4
XTAP_495 vssd1 vccd1 sky130_fd_sc_hd__tapvpwrvgnd_1
X_06986_ _01109_ _01110_ _01105_ vssd1 vssd1 vccd1 vccd1 _01111_ sky130_fd_sc_hd__a21o_1
X_08725_ _02824_ _02838_ vssd1 vssd1 vccd1 vccd1 _02839_ sky130_fd_sc_hd__nand2_1
XTAP_1606 vssd1 vccd1 sky130_fd_sc_hd__tapvpwrvgnd_1
X_08656_ net967 _02770_ _02769_ vssd1 vssd1 vccd1 vccd1 _02771_ sky130_fd_sc_hd__a21bo_1
X_08587_ _02700_ _02701_ vssd1 vssd1 vccd1 vccd1 _02702_ sky130_fd_sc_hd__nor2_1
XFILLER_0_96_749 vssd1 vssd1 vccd1 vccd1 sky130_fd_sc_hd__fill_1
XTAP_1639 vssd1 vccd1 sky130_fd_sc_hd__tapvpwrvgnd_1
XTAP_1628 vssd1 vccd1 sky130_fd_sc_hd__tapvpwrvgnd_1
XTAP_1617 vssd1 vccd1 sky130_fd_sc_hd__tapvpwrvgnd_1
X_07607_ _01373_ _01381_ _01380_ vssd1 vssd1 vccd1 vccd1 _01731_ sky130_fd_sc_hd__a21bo_1
XFILLER_0_76_451 vssd1 vssd1 vccd1 vccd1 sky130_fd_sc_hd__decap_6
X_07538_ _01409_ _01456_ vssd1 vssd1 vccd1 vccd1 _01663_ sky130_fd_sc_hd__xnor2_1
XFILLER_0_119_553 vssd1 vssd1 vccd1 vccd1 sky130_fd_sc_hd__decap_6
XFILLER_0_64_624 vssd1 vssd1 vccd1 vccd1 sky130_fd_sc_hd__fill_2
XFILLER_0_63_101 vssd1 vssd1 vccd1 vccd1 sky130_fd_sc_hd__fill_1
XFILLER_0_119_597 vssd1 vssd1 vccd1 vccd1 sky130_ef_sc_hd__decap_12
XFILLER_0_107_726 vssd1 vssd1 vccd1 vccd1 sky130_fd_sc_hd__fill_2
XFILLER_0_63_145 vssd1 vssd1 vccd1 vccd1 sky130_fd_sc_hd__decap_6
XFILLER_0_48_197 vssd1 vssd1 vccd1 vccd1 sky130_fd_sc_hd__fill_1
XFILLER_0_8_250 vssd1 vssd1 vccd1 vccd1 sky130_fd_sc_hd__fill_2
X_07469_ _01591_ _01592_ _01590_ vssd1 vssd1 vccd1 vccd1 _01594_ sky130_fd_sc_hd__o21bai_1
X_09208_ _03309_ _03318_ vssd1 vssd1 vccd1 vccd1 _03319_ sky130_fd_sc_hd__xnor2_2
X_10480_ net809 net971 _04447_ _04448_ net959 vssd1 vssd1 vccd1 vccd1 _04583_ sky130_fd_sc_hd__a32o_1
XFILLER_0_63_156 vssd1 vssd1 vccd1 vccd1 sky130_fd_sc_hd__decap_6
X_09139_ _03248_ _03249_ _03088_ net1748 vssd1 vssd1 vccd1 vccd1 _03251_ sky130_fd_sc_hd__a211oi_2
XFILLER_0_121_217 vssd1 vssd1 vccd1 vccd1 sky130_fd_sc_hd__decap_6
X_12150_ _00960_ _06118_ net500 vssd1 vssd1 vccd1 vccd1 _06119_ sky130_fd_sc_hd__mux2_1
X_11101_ _05197_ _05198_ vssd1 vssd1 vccd1 vccd1 _05200_ sky130_fd_sc_hd__xnor2_2
XFILLER_0_32_587 vssd1 vssd1 vccd1 vccd1 sky130_fd_sc_hd__fill_1
XFILLER_0_5_3 vssd1 vssd1 vccd1 vccd1 sky130_ef_sc_hd__decap_12
X_12081_ y2my0\[11\] net583 net532 x2mx1\[11\] _06066_ vssd1 vssd1 vccd1 vccd1 _06067_
+ sky130_fd_sc_hd__a221o_1
X_11032_ _05117_ _05129_ _05130_ vssd1 vssd1 vccd1 vccd1 _05131_ sky130_fd_sc_hd__nand3_2
X_12983_ clknet_leaf_52_clk_i _00369_ net1152 vssd1 vssd1 vccd1 vccd1 x2mx1\[4\] sky130_fd_sc_hd__dfrtp_1
XFILLER_0_87_716 vssd1 vssd1 vccd1 vccd1 sky130_ef_sc_hd__decap_12
X_11934_ net120 net620 net594 net88 vssd1 vssd1 vccd1 vccd1 _05955_ sky130_fd_sc_hd__a22o_1
XFILLER_0_24_15 vssd1 vssd1 vccd1 vccd1 sky130_ef_sc_hd__decap_12
XFILLER_0_115_39 vssd1 vssd1 vccd1 vccd1 sky130_ef_sc_hd__decap_12
XFILLER_0_129_328 vssd1 vssd1 vccd1 vccd1 sky130_fd_sc_hd__decap_8
XFILLER_0_95_771 vssd1 vssd1 vccd1 vccd1 sky130_fd_sc_hd__fill_1
X_11865_ net76 net679 net671 net108 vssd1 vssd1 vccd1 vccd1 _05900_ sky130_fd_sc_hd__a22o_1
XFILLER_0_82_421 vssd1 vssd1 vccd1 vccd1 sky130_fd_sc_hd__fill_1
X_10816_ net1022 net730 net725 net1027 vssd1 vssd1 vccd1 vccd1 _04917_ sky130_fd_sc_hd__a22oi_1
XFILLER_0_55_635 vssd1 vssd1 vccd1 vccd1 sky130_fd_sc_hd__fill_1
X_11796_ net57 net687 net669 net97 vssd1 vssd1 vccd1 vccd1 _05841_ sky130_fd_sc_hd__a22o_1
XFILLER_0_82_454 vssd1 vssd1 vccd1 vccd1 sky130_fd_sc_hd__fill_1
X_10747_ _04845_ _04846_ _04830_ vssd1 vssd1 vccd1 vccd1 _04848_ sky130_fd_sc_hd__a21bo_1
X_10678_ _04771_ _04779_ vssd1 vssd1 vccd1 vccd1 _04780_ sky130_fd_sc_hd__nand2_1
XFILLER_0_40_58 vssd1 vssd1 vccd1 vccd1 sky130_fd_sc_hd__decap_4
XFILLER_0_113_729 vssd1 vssd1 vccd1 vccd1 sky130_ef_sc_hd__decap_12
XFILLER_0_54_189 vssd1 vssd1 vccd1 vccd1 sky130_fd_sc_hd__decap_6
XFILLER_0_51_841 vssd1 vssd1 vccd1 vccd1 sky130_fd_sc_hd__fill_1
X_12417_ _00823_ net613 _01952_ net574 vssd1 vssd1 vccd1 vccd1 _06201_ sky130_fd_sc_hd__a22o_1
X_12348_ net1547 _00823_ net658 vssd1 vssd1 vccd1 vccd1 _00400_ sky130_fd_sc_hd__mux2_1
XFILLER_0_11_727 vssd1 vssd1 vccd1 vccd1 sky130_fd_sc_hd__fill_1
X_12279_ net56 net691 vssd1 vssd1 vccd1 vccd1 _06195_ sky130_fd_sc_hd__and2_4
X_06840_ net1503 posx\[6\] net647 vssd1 vssd1 vccd1 vccd1 _00114_ sky130_fd_sc_hd__mux2_1
X_06771_ net1517 net1497 net638 vssd1 vssd1 vccd1 vccd1 _00045_ sky130_fd_sc_hd__mux2_1
X_09490_ net1124 net705 vssd1 vssd1 vccd1 vccd1 _03599_ sky130_fd_sc_hd__nand2_1
XFILLER_0_78_716 vssd1 vssd1 vccd1 vccd1 sky130_ef_sc_hd__decap_12
X_08510_ _02617_ _02625_ vssd1 vssd1 vccd1 vccd1 _02626_ sky130_fd_sc_hd__nand2_1
X_08441_ _02555_ _02556_ vssd1 vssd1 vccd1 vccd1 _02557_ sky130_fd_sc_hd__xnor2_2
X_08372_ net875 net866 net1007 net1000 vssd1 vssd1 vccd1 vccd1 _02489_ sky130_fd_sc_hd__nand4_2
XFILLER_0_116_501 vssd1 vssd1 vccd1 vccd1 sky130_ef_sc_hd__decap_12
XFILLER_0_73_432 vssd1 vssd1 vccd1 vccd1 sky130_fd_sc_hd__decap_6
XFILLER_0_46_657 vssd1 vssd1 vccd1 vccd1 sky130_fd_sc_hd__fill_1
XFILLER_0_45_123 vssd1 vssd1 vccd1 vccd1 sky130_fd_sc_hd__fill_2
XFILLER_0_18_359 vssd1 vssd1 vccd1 vccd1 sky130_fd_sc_hd__decap_4
X_07323_ _01440_ _01441_ vssd1 vssd1 vccd1 vccd1 _01448_ sky130_fd_sc_hd__or2_1
XFILLER_0_116_545 vssd1 vssd1 vccd1 vccd1 sky130_ef_sc_hd__decap_12
X_07254_ _01204_ _01205_ _01206_ vssd1 vssd1 vccd1 vccd1 _01379_ sky130_fd_sc_hd__a21bo_1
XFILLER_0_34_819 vssd1 vssd1 vccd1 vccd1 sky130_fd_sc_hd__fill_1
XFILLER_0_116_589 vssd1 vssd1 vccd1 vccd1 sky130_ef_sc_hd__decap_12
XFILLER_0_103_206 vssd1 vssd1 vccd1 vccd1 sky130_fd_sc_hd__decap_3
XFILLER_0_83_3 vssd1 vssd1 vccd1 vccd1 sky130_ef_sc_hd__decap_12
XFILLER_0_121_93 vssd1 vssd1 vccd1 vccd1 sky130_ef_sc_hd__decap_12
XFILLER_0_5_275 vssd1 vssd1 vccd1 vccd1 sky130_fd_sc_hd__fill_2
X_07185_ _01307_ _01308_ vssd1 vssd1 vccd1 vccd1 _01310_ sky130_fd_sc_hd__xnor2_1
XFILLER_0_41_340 vssd1 vssd1 vccd1 vccd1 sky130_fd_sc_hd__fill_2
XFILLER_0_14_598 vssd1 vssd1 vccd1 vccd1 sky130_fd_sc_hd__decap_4
XFILLER_0_41_362 vssd1 vssd1 vccd1 vccd1 sky130_fd_sc_hd__fill_2
XFILLER_0_111_261 vssd1 vssd1 vccd1 vccd1 sky130_ef_sc_hd__decap_12
XFILLER_0_10_771 vssd1 vssd1 vccd1 vccd1 sky130_ef_sc_hd__decap_12
X_09826_ net1070 net731 net724 net1078 vssd1 vssd1 vccd1 vccd1 _03933_ sky130_fd_sc_hd__a22o_1
XTAP_292 vssd1 vccd1 sky130_fd_sc_hd__tapvpwrvgnd_1
XTAP_270 vssd1 vccd1 sky130_fd_sc_hd__tapvpwrvgnd_1
XTAP_281 vssd1 vccd1 sky130_fd_sc_hd__tapvpwrvgnd_1
Xfanout478 net485 vssd1 vssd1 vccd1 vccd1 net478 sky130_fd_sc_hd__clkbuf_4
Xfanout467 net469 vssd1 vssd1 vccd1 vccd1 net467 sky130_fd_sc_hd__buf_4
X_09757_ net892 net937 net931 net901 vssd1 vssd1 vccd1 vccd1 _03865_ sky130_fd_sc_hd__a22o_1
X_06969_ net896 net888 net1073 net1083 vssd1 vssd1 vccd1 vccd1 _01094_ sky130_fd_sc_hd__and4_1
XTAP_2126 vssd1 vccd1 sky130_fd_sc_hd__tapvpwrvgnd_1
XTAP_2115 vssd1 vccd1 sky130_fd_sc_hd__tapvpwrvgnd_1
XTAP_2104 vssd1 vccd1 sky130_fd_sc_hd__tapvpwrvgnd_1
X_08708_ _02697_ _02698_ _02696_ vssd1 vssd1 vccd1 vccd1 _02822_ sky130_fd_sc_hd__a21o_2
XTAP_2159 vssd1 vccd1 sky130_fd_sc_hd__tapvpwrvgnd_1
XTAP_2148 vssd1 vccd1 sky130_fd_sc_hd__tapvpwrvgnd_1
XTAP_2137 vssd1 vccd1 sky130_fd_sc_hd__tapvpwrvgnd_1
X_09688_ _03753_ _03795_ vssd1 vssd1 vccd1 vccd1 _03796_ sky130_fd_sc_hd__and2b_1
XTAP_1414 vssd1 vccd1 sky130_fd_sc_hd__tapvpwrvgnd_1
XTAP_1403 vssd1 vccd1 sky130_fd_sc_hd__tapvpwrvgnd_1
XFILLER_0_69_749 vssd1 vssd1 vccd1 vccd1 sky130_fd_sc_hd__decap_3
XFILLER_0_68_226 vssd1 vssd1 vccd1 vccd1 sky130_fd_sc_hd__decap_3
XFILLER_0_96_579 vssd1 vssd1 vccd1 vccd1 sky130_fd_sc_hd__fill_2
X_08639_ _02752_ _02753_ _02736_ vssd1 vssd1 vccd1 vccd1 _02754_ sky130_fd_sc_hd__a21oi_2
XTAP_1447 vssd1 vccd1 sky130_fd_sc_hd__tapvpwrvgnd_1
XTAP_1436 vssd1 vccd1 sky130_fd_sc_hd__tapvpwrvgnd_1
XTAP_1425 vssd1 vccd1 sky130_fd_sc_hd__tapvpwrvgnd_1
XFILLER_0_68_259 vssd1 vssd1 vccd1 vccd1 sky130_fd_sc_hd__fill_1
XTAP_1469 vssd1 vccd1 sky130_fd_sc_hd__tapvpwrvgnd_1
XTAP_1458 vssd1 vccd1 sky130_fd_sc_hd__tapvpwrvgnd_1
XFILLER_0_77_771 vssd1 vssd1 vccd1 vccd1 sky130_fd_sc_hd__decap_4
X_11650_ _05611_ _05652_ _05650_ vssd1 vssd1 vccd1 vccd1 _05744_ sky130_fd_sc_hd__a21o_1
XFILLER_0_119_361 vssd1 vssd1 vccd1 vccd1 sky130_ef_sc_hd__decap_12
XFILLER_0_107_501 vssd1 vssd1 vccd1 vccd1 sky130_fd_sc_hd__decap_3
X_10601_ _04555_ _04558_ _04699_ _04701_ vssd1 vssd1 vccd1 vccd1 _04703_ sky130_fd_sc_hd__a211o_2
X_11581_ net972 net729 vssd1 vssd1 vccd1 vccd1 _05675_ sky130_fd_sc_hd__nand2_1
XFILLER_0_37_668 vssd1 vssd1 vccd1 vccd1 sky130_fd_sc_hd__decap_4
XFILLER_0_91_273 vssd1 vssd1 vccd1 vccd1 sky130_fd_sc_hd__decap_6
X_10532_ _04631_ _04632_ _04633_ vssd1 vssd1 vccd1 vccd1 _04635_ sky130_fd_sc_hd__a21bo_1
XFILLER_0_33_841 vssd1 vssd1 vccd1 vccd1 sky130_fd_sc_hd__fill_1
XFILLER_0_36_189 vssd1 vssd1 vccd1 vccd1 sky130_fd_sc_hd__fill_1
X_10463_ _04563_ _04564_ _04444_ net1756 vssd1 vssd1 vccd1 vccd1 _04566_ sky130_fd_sc_hd__a211oi_2
X_10394_ _04493_ _04494_ _04495_ vssd1 vssd1 vccd1 vccd1 _04498_ sky130_fd_sc_hd__a21o_1
X_13182_ clknet_leaf_21_clk_i _00568_ net1176 vssd1 vssd1 vccd1 vccd1 l1\[11\] sky130_fd_sc_hd__dfrtp_1
X_12202_ _00872_ net510 net467 net1679 _06154_ vssd1 vssd1 vccd1 vccd1 _06155_ sky130_fd_sc_hd__a221o_1
XFILLER_0_102_261 vssd1 vssd1 vccd1 vccd1 sky130_fd_sc_hd__decap_3
X_12133_ y2my0\[24\] net587 net534 x2mx1\[24\] _06105_ vssd1 vssd1 vccd1 vccd1 _06106_
+ sky130_fd_sc_hd__a221o_1
XFILLER_0_19_15 vssd1 vssd1 vccd1 vccd1 sky130_ef_sc_hd__decap_12
X_12064_ x0mx2\[7\] net628 net590 y1my2\[7\] vssd1 vssd1 vccd1 vccd1 _06054_ sky130_fd_sc_hd__a22o_1
X_11015_ _05111_ _05112_ vssd1 vssd1 vccd1 vccd1 _05114_ sky130_fd_sc_hd__xor2_1
XFILLER_0_126_27 vssd1 vssd1 vccd1 vccd1 sky130_fd_sc_hd__fill_1
Xfanout990 mul1.a\[20\] vssd1 vssd1 vccd1 vccd1 net990 sky130_fd_sc_hd__buf_2
X_12966_ clknet_leaf_37_clk_i _00352_ net1161 vssd1 vssd1 vccd1 vccd1 y1my2\[19\]
+ sky130_fd_sc_hd__dfrtp_1
XFILLER_0_75_719 vssd1 vssd1 vccd1 vccd1 sky130_fd_sc_hd__fill_1
X_11917_ net1359 _05942_ net477 vssd1 vssd1 vccd1 vccd1 _00222_ sky130_fd_sc_hd__mux2_1
X_12897_ clknet_leaf_52_clk_i _00283_ vssd1 vssd1 vccd1 vccd1 mul1.b\[0\] sky130_fd_sc_hd__dfxtp_1
XFILLER_0_129_136 vssd1 vssd1 vccd1 vccd1 sky130_fd_sc_hd__decap_4
XTAP_1970 vssd1 vccd1 sky130_fd_sc_hd__tapvpwrvgnd_1
XFILLER_0_74_207 vssd1 vssd1 vccd1 vccd1 sky130_fd_sc_hd__fill_2
X_11848_ net105 net671 _05883_ _05885_ vssd1 vssd1 vccd1 vccd1 _05886_ sky130_fd_sc_hd__a211o_1
XFILLER_0_129_169 vssd1 vssd1 vccd1 vccd1 sky130_fd_sc_hd__fill_1
XTAP_1992 vssd1 vccd1 sky130_fd_sc_hd__tapvpwrvgnd_1
XTAP_1981 vssd1 vccd1 sky130_fd_sc_hd__tapvpwrvgnd_1
XFILLER_0_83_741 vssd1 vssd1 vccd1 vccd1 sky130_ef_sc_hd__decap_12
XFILLER_0_67_281 vssd1 vssd1 vccd1 vccd1 sky130_fd_sc_hd__fill_1
XFILLER_0_51_57 vssd1 vssd1 vccd1 vccd1 sky130_fd_sc_hd__fill_2
XFILLER_0_16_808 vssd1 vssd1 vccd1 vccd1 sky130_fd_sc_hd__decap_4
X_11779_ temp1\[13\] net614 net665 net94 _05826_ vssd1 vssd1 vccd1 vccd1 _05827_ sky130_fd_sc_hd__a221o_1
XFILLER_0_42_104 vssd1 vssd1 vccd1 vccd1 sky130_fd_sc_hd__decap_3
XFILLER_0_125_353 vssd1 vssd1 vccd1 vccd1 sky130_ef_sc_hd__decap_12
XFILLER_0_113_559 vssd1 vssd1 vccd1 vccd1 sky130_fd_sc_hd__fill_1
XFILLER_0_51_671 vssd1 vssd1 vccd1 vccd1 sky130_fd_sc_hd__fill_1
X_08990_ _02963_ _03102_ vssd1 vssd1 vccd1 vccd1 _03103_ sky130_fd_sc_hd__or2_2
XFILLER_0_76_54 vssd1 vssd1 vccd1 vccd1 sky130_fd_sc_hd__decap_3
X_07941_ net1684 _02061_ net523 vssd1 vssd1 vccd1 vccd1 _00127_ sky130_fd_sc_hd__mux2_1
X_07872_ net1075 net831 _01991_ _01992_ vssd1 vssd1 vccd1 vccd1 _01993_ sky130_fd_sc_hd__o2bb2a_1
X_06823_ net1605 l0\[30\] net645 vssd1 vssd1 vccd1 vccd1 _00097_ sky130_fd_sc_hd__mux2_1
X_09611_ _03717_ _03718_ _03719_ vssd1 vssd1 vccd1 vccd1 _03720_ sky130_fd_sc_hd__nand3_1
XFILLER_0_92_53 vssd1 vssd1 vccd1 vccd1 sky130_ef_sc_hd__decap_12
X_09542_ _03487_ _03489_ vssd1 vssd1 vccd1 vccd1 _03651_ sky130_fd_sc_hd__nand2_1
X_06754_ _00961_ _00962_ _00963_ vssd1 vssd1 vccd1 vccd1 _00969_ sky130_fd_sc_hd__a21boi_4
X_09473_ net1331 _03582_ net524 vssd1 vssd1 vccd1 vccd1 _00138_ sky130_fd_sc_hd__mux2_1
X_06685_ sub1.a_i\[20\] sub1.b_i\[20\] vssd1 vssd1 vccd1 vccd1 _00910_ sky130_fd_sc_hd__nand2b_1
XFILLER_0_65_229 vssd1 vssd1 vccd1 vccd1 sky130_fd_sc_hd__fill_1
X_08424_ _02401_ _02539_ vssd1 vssd1 vccd1 vccd1 _02541_ sky130_fd_sc_hd__xor2_2
XFILLER_0_117_821 vssd1 vssd1 vccd1 vccd1 sky130_fd_sc_hd__decap_4
XFILLER_0_108_309 vssd1 vssd1 vccd1 vccd1 sky130_fd_sc_hd__fill_1
X_08355_ net1025 net849 net840 net1033 vssd1 vssd1 vccd1 vccd1 _02472_ sky130_fd_sc_hd__a22o_1
XFILLER_0_46_465 vssd1 vssd1 vccd1 vccd1 sky130_fd_sc_hd__decap_3
X_07306_ net871 net862 net1118 net1126 vssd1 vssd1 vccd1 vccd1 _01431_ sky130_fd_sc_hd__and4_1
X_08286_ _02161_ _02278_ _02402_ vssd1 vssd1 vccd1 vccd1 _02404_ sky130_fd_sc_hd__or3_1
XFILLER_0_34_649 vssd1 vssd1 vccd1 vccd1 sky130_fd_sc_hd__fill_1
X_07237_ _01360_ _01361_ net856 net1082 vssd1 vssd1 vccd1 vccd1 _01362_ sky130_fd_sc_hd__and4bb_1
XFILLER_0_15_841 vssd1 vssd1 vccd1 vccd1 sky130_fd_sc_hd__fill_1
X_07168_ _01291_ _01292_ vssd1 vssd1 vccd1 vccd1 _01293_ sky130_fd_sc_hd__and2_1
XFILLER_0_112_581 vssd1 vssd1 vccd1 vccd1 sky130_fd_sc_hd__decap_6
XFILLER_0_100_743 vssd1 vssd1 vccd1 vccd1 sky130_fd_sc_hd__decap_6
X_07099_ net855 net1089 _01221_ _01222_ vssd1 vssd1 vccd1 vccd1 _01224_ sky130_fd_sc_hd__a22o_1
X_09809_ net1116 net704 _03755_ _03756_ net714 vssd1 vssd1 vccd1 vccd1 _03916_ sky130_fd_sc_hd__a32o_1
X_12820_ clknet_leaf_35_clk_i _00206_ vssd1 vssd1 vccd1 vccd1 sub1.a_i\[19\] sky130_fd_sc_hd__dfxtp_1
XFILLER_0_96_321 vssd1 vssd1 vccd1 vccd1 sky130_fd_sc_hd__fill_1
XFILLER_0_69_524 vssd1 vssd1 vccd1 vccd1 sky130_fd_sc_hd__decap_3
XFILLER_0_69_513 vssd1 vssd1 vccd1 vccd1 sky130_fd_sc_hd__decap_4
XTAP_1222 vssd1 vccd1 sky130_fd_sc_hd__tapvpwrvgnd_1
XTAP_1211 vssd1 vccd1 sky130_fd_sc_hd__tapvpwrvgnd_1
XTAP_1200 vssd1 vccd1 sky130_fd_sc_hd__tapvpwrvgnd_1
XFILLER_0_57_708 vssd1 vssd1 vccd1 vccd1 sky130_fd_sc_hd__decap_3
X_12751_ clknet_leaf_43_clk_i _00137_ vssd1 vssd1 vccd1 vccd1 add1.a_i\[14\] sky130_fd_sc_hd__dfxtp_1
XFILLER_0_96_387 vssd1 vssd1 vccd1 vccd1 sky130_fd_sc_hd__decap_6
X_12682_ clknet_leaf_15_clk_i net1451 net1183 vssd1 vssd1 vccd1 vccd1 net411 sky130_fd_sc_hd__dfrtp_1
XTAP_1266 vssd1 vccd1 sky130_fd_sc_hd__tapvpwrvgnd_1
XTAP_1255 vssd1 vccd1 sky130_fd_sc_hd__tapvpwrvgnd_1
XTAP_1244 vssd1 vccd1 sky130_fd_sc_hd__tapvpwrvgnd_1
XTAP_1233 vssd1 vccd1 sky130_fd_sc_hd__tapvpwrvgnd_1
X_11702_ net58 net677 net668 net90 vssd1 vssd1 vccd1 vccd1 _05763_ sky130_fd_sc_hd__a22o_1
XTAP_1299 vssd1 vccd1 sky130_fd_sc_hd__tapvpwrvgnd_1
XTAP_1277 vssd1 vccd1 sky130_fd_sc_hd__tapvpwrvgnd_1
XTAP_1288 vssd1 vccd1 sky130_fd_sc_hd__tapvpwrvgnd_1
XFILLER_0_49_270 vssd1 vssd1 vccd1 vccd1 sky130_fd_sc_hd__fill_2
X_11633_ _05725_ _05726_ vssd1 vssd1 vccd1 vccd1 _05727_ sky130_fd_sc_hd__nand2_1
XFILLER_0_126_139 vssd1 vssd1 vccd1 vccd1 sky130_fd_sc_hd__fill_1
XFILLER_0_112_29 vssd1 vssd1 vccd1 vccd1 sky130_ef_sc_hd__decap_12
XFILLER_0_65_785 vssd1 vssd1 vccd1 vccd1 sky130_fd_sc_hd__fill_1
XFILLER_0_21_27 vssd1 vssd1 vccd1 vccd1 sky130_ef_sc_hd__decap_12
XFILLER_0_37_465 vssd1 vssd1 vccd1 vccd1 sky130_fd_sc_hd__fill_1
XFILLER_0_92_593 vssd1 vssd1 vccd1 vccd1 sky130_fd_sc_hd__decap_8
XFILLER_0_24_104 vssd1 vssd1 vccd1 vccd1 sky130_fd_sc_hd__decap_3
X_11564_ _05656_ _05657_ vssd1 vssd1 vccd1 vccd1 _05659_ sky130_fd_sc_hd__xnor2_1
XFILLER_0_122_301 vssd1 vssd1 vccd1 vccd1 sky130_fd_sc_hd__decap_6
X_10515_ net1093 net701 net695 net1086 vssd1 vssd1 vccd1 vccd1 _04618_ sky130_fd_sc_hd__and4b_1
X_11495_ net782 net938 _05588_ _05589_ vssd1 vssd1 vccd1 vccd1 _05590_ sky130_fd_sc_hd__nand4_1
X_13234_ net508 vssd1 vssd1 vccd1 vccd1 net290 sky130_fd_sc_hd__clkbuf_1
XFILLER_0_122_345 vssd1 vssd1 vccd1 vccd1 sky130_ef_sc_hd__decap_12
X_10446_ net809 net965 vssd1 vssd1 vccd1 vccd1 _04549_ sky130_fd_sc_hd__nand2_1
XFILLER_0_33_671 vssd1 vssd1 vccd1 vccd1 sky130_fd_sc_hd__fill_1
XFILLER_0_33_682 vssd1 vssd1 vccd1 vccd1 sky130_fd_sc_hd__fill_1
XFILLER_0_122_389 vssd1 vssd1 vccd1 vccd1 sky130_ef_sc_hd__decap_12
X_13165_ clknet_leaf_9_clk_i _00551_ net1190 vssd1 vssd1 vccd1 vccd1 l0\[26\] sky130_fd_sc_hd__dfrtp_1
X_10377_ _04478_ _04479_ _04278_ _04280_ vssd1 vssd1 vccd1 vccd1 _04481_ sky130_fd_sc_hd__a211o_1
XFILLER_0_20_365 vssd1 vssd1 vccd1 vccd1 sky130_fd_sc_hd__decap_4
X_12116_ x0mx2\[20\] net632 net592 y1my2\[20\] vssd1 vssd1 vccd1 vccd1 _06093_ sky130_fd_sc_hd__a22o_1
X_13096_ clknet_leaf_39_clk_i _00482_ vssd1 vssd1 vccd1 vccd1 temp1\[21\] sky130_fd_sc_hd__dfxtp_1
X_12047_ net1130 _06041_ net516 vssd1 vssd1 vccd1 vccd1 _00253_ sky130_fd_sc_hd__mux2_1
XFILLER_0_99_192 vssd1 vssd1 vccd1 vccd1 sky130_fd_sc_hd__fill_1
XFILLER_0_62_34 vssd1 vssd1 vccd1 vccd1 sky130_ef_sc_hd__decap_12
X_12949_ clknet_leaf_50_clk_i _00335_ net1159 vssd1 vssd1 vccd1 vccd1 y1my2\[2\] sky130_fd_sc_hd__dfrtp_1
X_06470_ add1.a_i\[28\] add1.b_i\[28\] vssd1 vssd1 vccd1 vccd1 _00767_ sky130_fd_sc_hd__nand2_1
XFILLER_0_28_421 vssd1 vssd1 vccd1 vccd1 sky130_fd_sc_hd__decap_4
X_08140_ _02237_ _02256_ _02257_ vssd1 vssd1 vccd1 vccd1 _02259_ sky130_fd_sc_hd__and3_1
XFILLER_0_7_337 vssd1 vssd1 vccd1 vccd1 sky130_fd_sc_hd__fill_1
XFILLER_0_16_638 vssd1 vssd1 vccd1 vccd1 sky130_fd_sc_hd__decap_6
XFILLER_0_125_161 vssd1 vssd1 vccd1 vccd1 sky130_fd_sc_hd__decap_4
X_08071_ net795 _02079_ _02080_ _02081_ vssd1 vssd1 vccd1 vccd1 _02190_ sky130_fd_sc_hd__a22o_1
X_07022_ _01144_ _01145_ _01146_ vssd1 vssd1 vccd1 vccd1 _01147_ sky130_fd_sc_hd__nand3_1
XFILLER_0_12_833 vssd1 vssd1 vccd1 vccd1 sky130_fd_sc_hd__decap_3
X_08973_ _03049_ _03050_ _03083_ _03084_ vssd1 vssd1 vccd1 vccd1 _03086_ sky130_fd_sc_hd__nor4_1
Xhold28 det_t\[12\] vssd1 vssd1 vccd1 vccd1 net1243 sky130_fd_sc_hd__dlygate4sd3_1
Xhold17 det_t\[0\] vssd1 vssd1 vccd1 vccd1 net1232 sky130_fd_sc_hd__dlygate4sd3_1
X_07924_ _01983_ _01984_ _02043_ _02044_ vssd1 vssd1 vccd1 vccd1 _02045_ sky130_fd_sc_hd__or4bb_2
XFILLER_0_46_3 vssd1 vssd1 vccd1 vccd1 sky130_fd_sc_hd__fill_2
Xhold39 _00092_ vssd1 vssd1 vccd1 vccd1 net1254 sky130_fd_sc_hd__dlygate4sd3_1
X_07855_ _01859_ _01867_ _01866_ vssd1 vssd1 vccd1 vccd1 _01976_ sky130_fd_sc_hd__a21o_1
XFILLER_0_127_81 vssd1 vssd1 vccd1 vccd1 sky130_ef_sc_hd__decap_12
X_06806_ net1558 net1556 net642 vssd1 vssd1 vccd1 vccd1 _00080_ sky130_fd_sc_hd__mux2_1
X_07786_ _01898_ _01906_ vssd1 vssd1 vccd1 vccd1 _01908_ sky130_fd_sc_hd__xor2_2
X_09525_ _03590_ _03632_ vssd1 vssd1 vccd1 vccd1 _03634_ sky130_fd_sc_hd__xnor2_2
X_06737_ _00937_ _00943_ _00949_ _00953_ vssd1 vssd1 vccd1 vccd1 _00954_ sky130_fd_sc_hd__or4_1
X_09456_ _03467_ _03468_ _03564_ _03565_ vssd1 vssd1 vccd1 vccd1 _03566_ sky130_fd_sc_hd__or4bb_4
X_06668_ _00888_ _00891_ _00890_ vssd1 vssd1 vccd1 vccd1 _00896_ sky130_fd_sc_hd__a21oi_2
XFILLER_0_109_629 vssd1 vssd1 vccd1 vccd1 sky130_ef_sc_hd__decap_12
X_08407_ _02520_ _02522_ _02381_ _02384_ vssd1 vssd1 vccd1 vccd1 _02524_ sky130_fd_sc_hd__a211o_1
XFILLER_0_108_139 vssd1 vssd1 vccd1 vccd1 sky130_fd_sc_hd__fill_1
X_09387_ _03493_ _03494_ _03495_ vssd1 vssd1 vccd1 vccd1 _03497_ sky130_fd_sc_hd__a21o_1
XFILLER_0_74_560 vssd1 vssd1 vccd1 vccd1 sky130_fd_sc_hd__fill_2
X_06599_ sub1.a_i\[4\] _00837_ _00830_ vssd1 vssd1 vccd1 vccd1 _00838_ sky130_fd_sc_hd__a21o_1
X_08338_ _02452_ _02453_ _02454_ vssd1 vssd1 vccd1 vccd1 _02455_ sky130_fd_sc_hd__nand3_2
XFILLER_0_117_673 vssd1 vssd1 vccd1 vccd1 sky130_ef_sc_hd__decap_12
X_08269_ _02261_ net1754 _02383_ _02385_ vssd1 vssd1 vccd1 vccd1 _02387_ sky130_fd_sc_hd__o211ai_2
XFILLER_0_62_777 vssd1 vssd1 vccd1 vccd1 sky130_fd_sc_hd__fill_1
XFILLER_0_61_243 vssd1 vssd1 vccd1 vccd1 sky130_ef_sc_hd__decap_12
X_10300_ net1046 net732 net725 net1056 vssd1 vssd1 vccd1 vccd1 _04404_ sky130_fd_sc_hd__a22o_1
X_11280_ _05373_ _05375_ _05216_ _05218_ vssd1 vssd1 vccd1 vccd1 _05377_ sky130_fd_sc_hd__o211a_1
XFILLER_0_22_619 vssd1 vssd1 vccd1 vccd1 sky130_fd_sc_hd__decap_8
X_10231_ net964 _04335_ _04334_ vssd1 vssd1 vccd1 vccd1 _04336_ sky130_fd_sc_hd__a21bo_1
X_10162_ _04244_ _04265_ vssd1 vssd1 vccd1 vccd1 _04267_ sky130_fd_sc_hd__or2_1
Xfanout1004 mul1.a\[18\] vssd1 vssd1 vccd1 vccd1 net1004 sky130_fd_sc_hd__clkbuf_2
X_10093_ _04171_ _04172_ _04197_ _04198_ vssd1 vssd1 vccd1 vccd1 _04199_ sky130_fd_sc_hd__o22a_1
Xfanout1037 net1039 vssd1 vssd1 vccd1 vccd1 net1037 sky130_fd_sc_hd__clkbuf_4
Xfanout1015 net1016 vssd1 vssd1 vccd1 vccd1 net1015 sky130_fd_sc_hd__clkbuf_4
Xoutput390 net390 vssd1 vssd1 vccd1 vccd1 mstream_o[46] sky130_fd_sc_hd__clkbuf_4
Xfanout1026 net1031 vssd1 vssd1 vccd1 vccd1 net1026 sky130_fd_sc_hd__clkbuf_4
Xfanout1059 net1060 vssd1 vssd1 vccd1 vccd1 net1059 sky130_fd_sc_hd__buf_2
Xfanout1048 mul1.a\[13\] vssd1 vssd1 vccd1 vccd1 net1048 sky130_fd_sc_hd__clkbuf_8
XFILLER_0_97_630 vssd1 vssd1 vccd1 vccd1 sky130_fd_sc_hd__fill_2
XFILLER_0_16_27 vssd1 vssd1 vccd1 vccd1 sky130_fd_sc_hd__fill_1
X_12803_ clknet_leaf_55_clk_i _00189_ vssd1 vssd1 vccd1 vccd1 sub1.a_i\[2\] sky130_fd_sc_hd__dfxtp_1
XFILLER_0_97_685 vssd1 vssd1 vccd1 vccd1 sky130_fd_sc_hd__decap_4
XFILLER_0_96_151 vssd1 vssd1 vccd1 vccd1 sky130_fd_sc_hd__decap_8
XFILLER_0_57_505 vssd1 vssd1 vccd1 vccd1 sky130_fd_sc_hd__decap_4
XTAP_1030 vssd1 vccd1 sky130_fd_sc_hd__tapvpwrvgnd_1
X_10995_ _04960_ _05092_ vssd1 vssd1 vccd1 vccd1 _05094_ sky130_fd_sc_hd__xnor2_1
X_12734_ clknet_leaf_27_clk_i _00120_ net1171 vssd1 vssd1 vccd1 vccd1 state\[3\] sky130_fd_sc_hd__dfrtp_4
XFILLER_0_123_39 vssd1 vssd1 vccd1 vccd1 sky130_ef_sc_hd__decap_12
XFILLER_0_69_398 vssd1 vssd1 vccd1 vccd1 sky130_fd_sc_hd__decap_3
XTAP_1063 vssd1 vccd1 sky130_fd_sc_hd__tapvpwrvgnd_1
XTAP_1074 vssd1 vccd1 sky130_fd_sc_hd__tapvpwrvgnd_1
XTAP_1052 vssd1 vccd1 sky130_fd_sc_hd__tapvpwrvgnd_1
XTAP_1041 vssd1 vccd1 sky130_fd_sc_hd__tapvpwrvgnd_1
XFILLER_0_32_15 vssd1 vssd1 vccd1 vccd1 sky130_fd_sc_hd__decap_6
X_12665_ clknet_leaf_19_clk_i _00051_ net1177 vssd1 vssd1 vccd1 vccd1 net392 sky130_fd_sc_hd__dfrtp_1
XTAP_1096 vssd1 vccd1 sky130_fd_sc_hd__tapvpwrvgnd_1
XTAP_1085 vssd1 vccd1 sky130_fd_sc_hd__tapvpwrvgnd_1
XFILLER_0_32_48 vssd1 vssd1 vccd1 vccd1 sky130_fd_sc_hd__decap_4
X_12596_ net1218 net7 net556 vssd1 vssd1 vccd1 vccd1 _00571_ sky130_fd_sc_hd__mux2_1
X_11616_ net989 net717 _05635_ _05634_ vssd1 vssd1 vccd1 vccd1 _05710_ sky130_fd_sc_hd__a31o_1
XFILLER_0_25_435 vssd1 vssd1 vccd1 vccd1 sky130_fd_sc_hd__decap_3
XFILLER_0_114_109 vssd1 vssd1 vccd1 vccd1 sky130_ef_sc_hd__decap_12
XFILLER_0_107_161 vssd1 vssd1 vccd1 vccd1 sky130_fd_sc_hd__decap_6
XFILLER_0_92_390 vssd1 vssd1 vccd1 vccd1 sky130_fd_sc_hd__decap_6
XFILLER_0_80_530 vssd1 vssd1 vccd1 vccd1 sky130_fd_sc_hd__fill_2
X_11547_ _05477_ _05479_ _05641_ vssd1 vssd1 vccd1 vccd1 _05642_ sky130_fd_sc_hd__a21o_1
Xhold509 net352 vssd1 vssd1 vccd1 vccd1 net1724 sky130_fd_sc_hd__dlygate4sd3_1
XFILLER_0_123_665 vssd1 vssd1 vccd1 vccd1 sky130_fd_sc_hd__decap_6
XFILLER_0_122_153 vssd1 vssd1 vccd1 vccd1 sky130_ef_sc_hd__decap_12
X_11478_ net957 _05572_ _05571_ vssd1 vssd1 vccd1 vccd1 _05573_ sky130_fd_sc_hd__a21bo_1
XFILLER_0_122_197 vssd1 vssd1 vccd1 vccd1 sky130_ef_sc_hd__decap_12
X_10429_ net878 net867 net927 vssd1 vssd1 vccd1 vccd1 _04532_ sky130_fd_sc_hd__o21a_1
X_13148_ clknet_leaf_14_clk_i _00534_ net1185 vssd1 vssd1 vccd1 vccd1 l0\[9\] sky130_fd_sc_hd__dfrtp_1
XTAP_803 vssd1 vccd1 sky130_fd_sc_hd__tapvpwrvgnd_1
XTAP_814 vssd1 vccd1 sky130_fd_sc_hd__tapvpwrvgnd_1
XTAP_825 vssd1 vccd1 sky130_fd_sc_hd__tapvpwrvgnd_1
XTAP_836 vssd1 vccd1 sky130_fd_sc_hd__tapvpwrvgnd_1
XTAP_847 vssd1 vccd1 sky130_fd_sc_hd__tapvpwrvgnd_1
XTAP_858 vssd1 vccd1 sky130_fd_sc_hd__tapvpwrvgnd_1
XFILLER_0_57_89 vssd1 vssd1 vccd1 vccd1 sky130_fd_sc_hd__decap_8
X_13079_ clknet_leaf_57_clk_i _00465_ vssd1 vssd1 vccd1 vccd1 temp1\[4\] sky130_fd_sc_hd__dfxtp_2
XTAP_869 vssd1 vccd1 sky130_fd_sc_hd__tapvpwrvgnd_1
X_07640_ _01758_ _01759_ _01762_ vssd1 vssd1 vccd1 vccd1 _01763_ sky130_fd_sc_hd__nand3_2
X_07571_ _01694_ _01693_ vssd1 vssd1 vccd1 vccd1 _01695_ sky130_fd_sc_hd__and2b_1
XFILLER_0_87_140 vssd1 vssd1 vccd1 vccd1 sky130_fd_sc_hd__decap_6
XFILLER_0_75_302 vssd1 vssd1 vccd1 vccd1 sky130_fd_sc_hd__decap_6
X_09310_ temp1\[14\] _03420_ net541 vssd1 vssd1 vccd1 vccd1 _03421_ sky130_fd_sc_hd__mux2_1
X_06522_ add1.a_i\[0\] add1.b_i\[0\] vssd1 vssd1 vccd1 vccd1 _00783_ sky130_fd_sc_hd__or2_2
XFILLER_0_48_549 vssd1 vssd1 vccd1 vccd1 sky130_fd_sc_hd__decap_3
XFILLER_0_91_817 vssd1 vssd1 vccd1 vccd1 sky130_fd_sc_hd__decap_3
X_09241_ _03348_ _03349_ _03350_ vssd1 vssd1 vccd1 vccd1 _03352_ sky130_fd_sc_hd__a21oi_1
XFILLER_0_56_560 vssd1 vssd1 vccd1 vccd1 sky130_fd_sc_hd__fill_1
X_06453_ _00750_ _00751_ vssd1 vssd1 vccd1 vccd1 _00752_ sky130_fd_sc_hd__nand2_2
XFILLER_0_28_251 vssd1 vssd1 vccd1 vccd1 sky130_fd_sc_hd__fill_1
X_09172_ _03153_ _03155_ vssd1 vssd1 vccd1 vccd1 _03283_ sky130_fd_sc_hd__or2_1
XFILLER_0_56_593 vssd1 vssd1 vccd1 vccd1 sky130_fd_sc_hd__fill_1
X_06384_ _00691_ _00692_ vssd1 vssd1 vccd1 vccd1 _00693_ sky130_fd_sc_hd__or2_4
XFILLER_0_16_402 vssd1 vssd1 vccd1 vccd1 sky130_fd_sc_hd__decap_4
XFILLER_0_28_262 vssd1 vssd1 vccd1 vccd1 sky130_fd_sc_hd__decap_4
XFILLER_0_29_785 vssd1 vssd1 vccd1 vccd1 sky130_fd_sc_hd__fill_2
X_08123_ _02239_ _02241_ _02238_ vssd1 vssd1 vccd1 vccd1 _02242_ sky130_fd_sc_hd__a21oi_1
XFILLER_0_114_643 vssd1 vssd1 vccd1 vccd1 sky130_fd_sc_hd__fill_1
XFILLER_0_98_41 vssd1 vssd1 vccd1 vccd1 sky130_ef_sc_hd__decap_12
X_08054_ _02170_ _02172_ vssd1 vssd1 vccd1 vccd1 _02173_ sky130_fd_sc_hd__and2_1
XFILLER_0_98_85 vssd1 vssd1 vccd1 vccd1 sky130_fd_sc_hd__fill_2
X_07005_ _01123_ _01128_ vssd1 vssd1 vccd1 vccd1 _01130_ sky130_fd_sc_hd__xnor2_2
XFILLER_0_101_337 vssd1 vssd1 vccd1 vccd1 sky130_fd_sc_hd__fill_2
Xinput118 v0y[6] vssd1 vssd1 vccd1 vccd1 net118 sky130_fd_sc_hd__buf_1
Xinput107 v0y[25] vssd1 vssd1 vccd1 vccd1 net107 sky130_fd_sc_hd__buf_1
X_08956_ net924 net916 net944 net939 vssd1 vssd1 vccd1 vccd1 _03069_ sky130_fd_sc_hd__nand4_1
Xinput129 v1x[16] vssd1 vssd1 vccd1 vccd1 net129 sky130_fd_sc_hd__clkbuf_1
X_08887_ net1069 net1076 net774 net764 vssd1 vssd1 vccd1 vccd1 _03000_ sky130_fd_sc_hd__and4_1
X_07907_ _02025_ _02026_ _02027_ vssd1 vssd1 vccd1 vccd1 _02028_ sky130_fd_sc_hd__nand3_1
X_07838_ net1132 net1139 net772 net763 vssd1 vssd1 vccd1 vccd1 _01959_ sky130_fd_sc_hd__nand4_1
X_09508_ _03616_ _03615_ _03614_ vssd1 vssd1 vccd1 vccd1 _03617_ sky130_fd_sc_hd__nand3b_2
X_07769_ _01887_ _01888_ _01889_ vssd1 vssd1 vccd1 vccd1 _01891_ sky130_fd_sc_hd__a21o_1
XPHY_124 vssd1 vssd1 vccd1 vccd1 sky130_fd_sc_hd__decap_3
X_10780_ _04872_ _04879_ vssd1 vssd1 vccd1 vccd1 _04881_ sky130_fd_sc_hd__xnor2_1
XPHY_113 vssd1 vssd1 vccd1 vccd1 sky130_fd_sc_hd__decap_3
XPHY_102 vssd1 vssd1 vccd1 vccd1 sky130_fd_sc_hd__decap_3
XFILLER_0_109_415 vssd1 vssd1 vccd1 vccd1 sky130_fd_sc_hd__decap_6
XPHY_157 vssd1 vssd1 vccd1 vccd1 sky130_fd_sc_hd__decap_3
XPHY_146 vssd1 vssd1 vccd1 vccd1 sky130_fd_sc_hd__decap_3
XPHY_135 vssd1 vssd1 vccd1 vccd1 sky130_fd_sc_hd__decap_3
X_09439_ _03539_ _03546_ _03547_ vssd1 vssd1 vccd1 vccd1 _03549_ sky130_fd_sc_hd__nand3_1
XPHY_179 vssd1 vssd1 vccd1 vccd1 sky130_fd_sc_hd__decap_3
XPHY_168 vssd1 vssd1 vccd1 vccd1 sky130_fd_sc_hd__decap_3
X_12450_ _04065_ net575 _06218_ vssd1 vssd1 vccd1 vccd1 _06219_ sky130_fd_sc_hd__a21o_1
XFILLER_0_81_349 vssd1 vssd1 vccd1 vccd1 sky130_fd_sc_hd__fill_1
XFILLER_0_62_552 vssd1 vssd1 vccd1 vccd1 sky130_ef_sc_hd__decap_12
X_11401_ _05335_ _05338_ _05494_ _05495_ vssd1 vssd1 vccd1 vccd1 _05497_ sky130_fd_sc_hd__a211o_1
XFILLER_0_50_714 vssd1 vssd1 vccd1 vccd1 sky130_fd_sc_hd__fill_1
X_12381_ net1482 _00828_ net682 vssd1 vssd1 vccd1 vccd1 _00433_ sky130_fd_sc_hd__mux2_1
XFILLER_0_120_613 vssd1 vssd1 vccd1 vccd1 sky130_ef_sc_hd__decap_12
XFILLER_0_105_665 vssd1 vssd1 vccd1 vccd1 sky130_fd_sc_hd__decap_6
XFILLER_0_104_153 vssd1 vssd1 vccd1 vccd1 sky130_ef_sc_hd__decap_12
X_11332_ _05426_ _05427_ _05387_ vssd1 vssd1 vccd1 vccd1 _05429_ sky130_fd_sc_hd__a21bo_1
X_11263_ _05358_ _05359_ vssd1 vssd1 vccd1 vccd1 _05360_ sky130_fd_sc_hd__and2_1
XFILLER_0_120_657 vssd1 vssd1 vccd1 vccd1 sky130_ef_sc_hd__decap_12
X_10214_ net867 net936 net933 net878 vssd1 vssd1 vccd1 vccd1 _04319_ sky130_fd_sc_hd__a22o_1
X_13002_ clknet_leaf_33_clk_i _00388_ net1165 vssd1 vssd1 vccd1 vccd1 x2mx1\[23\]
+ sky130_fd_sc_hd__dfrtp_1
X_11194_ _05284_ _05291_ vssd1 vssd1 vccd1 vccd1 _05292_ sky130_fd_sc_hd__nand2_1
X_10145_ net1072 net719 vssd1 vssd1 vccd1 vccd1 _04250_ sky130_fd_sc_hd__nand2_1
X_10076_ _04178_ _04179_ _04180_ vssd1 vssd1 vccd1 vccd1 _04182_ sky130_fd_sc_hd__nand3_2
XFILLER_0_89_438 vssd1 vssd1 vccd1 vccd1 sky130_fd_sc_hd__fill_1
XFILLER_0_128_713 vssd1 vssd1 vccd1 vccd1 sky130_fd_sc_hd__decap_8
XFILLER_0_85_644 vssd1 vssd1 vccd1 vccd1 sky130_fd_sc_hd__decap_4
X_10978_ _04944_ _04947_ _05075_ vssd1 vssd1 vccd1 vccd1 _05078_ sky130_fd_sc_hd__and3_1
XPHY_4 vssd1 vssd1 vccd1 vccd1 sky130_fd_sc_hd__decap_3
X_12717_ clknet_leaf_8_clk_i net1552 net1191 vssd1 vssd1 vccd1 vccd1 net336 sky130_fd_sc_hd__dfrtp_1
XFILLER_0_128_757 vssd1 vssd1 vccd1 vccd1 sky130_fd_sc_hd__decap_3
XFILLER_0_72_338 vssd1 vssd1 vccd1 vccd1 sky130_ef_sc_hd__decap_12
X_12648_ clknet_leaf_22_clk_i _00034_ net1171 vssd1 vssd1 vccd1 vccd1 net374 sky130_fd_sc_hd__dfrtp_1
XFILLER_0_38_593 vssd1 vssd1 vccd1 vccd1 sky130_fd_sc_hd__decap_6
XFILLER_0_127_267 vssd1 vssd1 vccd1 vccd1 sky130_fd_sc_hd__fill_1
XFILLER_0_115_429 vssd1 vssd1 vccd1 vccd1 sky130_ef_sc_hd__decap_12
XFILLER_0_25_210 vssd1 vssd1 vccd1 vccd1 sky130_fd_sc_hd__decap_4
XFILLER_0_104_3 vssd1 vssd1 vccd1 vccd1 sky130_ef_sc_hd__decap_12
X_12579_ l0\[30\] net25 net561 vssd1 vssd1 vccd1 vccd1 _00555_ sky130_fd_sc_hd__mux2_1
Xhold317 _00108_ vssd1 vssd1 vccd1 vccd1 net1532 sky130_fd_sc_hd__dlygate4sd3_1
Xhold306 net429 vssd1 vssd1 vccd1 vccd1 net1521 sky130_fd_sc_hd__dlygate4sd3_1
XFILLER_0_53_596 vssd1 vssd1 vccd1 vccd1 sky130_fd_sc_hd__fill_1
XFILLER_0_123_473 vssd1 vssd1 vccd1 vccd1 sky130_ef_sc_hd__decap_12
XFILLER_0_7_69 vssd1 vssd1 vccd1 vccd1 sky130_fd_sc_hd__decap_4
Xhold328 net374 vssd1 vssd1 vccd1 vccd1 net1543 sky130_fd_sc_hd__dlygate4sd3_1
Xhold339 x0mx2\[14\] vssd1 vssd1 vccd1 vccd1 net1554 sky130_fd_sc_hd__dlygate4sd3_1
XTAP_600 vssd1 vccd1 sky130_fd_sc_hd__tapvpwrvgnd_1
XFILLER_0_110_189 vssd1 vssd1 vccd1 vccd1 sky130_fd_sc_hd__decap_6
X_08810_ net916 net950 net944 net924 vssd1 vssd1 vccd1 vccd1 _02924_ sky130_fd_sc_hd__a22o_1
XTAP_611 vssd1 vccd1 sky130_fd_sc_hd__tapvpwrvgnd_1
XTAP_622 vssd1 vccd1 sky130_fd_sc_hd__tapvpwrvgnd_1
XTAP_633 vssd1 vccd1 sky130_fd_sc_hd__tapvpwrvgnd_1
Xfanout808 net811 vssd1 vssd1 vccd1 vccd1 net808 sky130_fd_sc_hd__clkbuf_2
Xfanout819 mul1.b\[13\] vssd1 vssd1 vccd1 vccd1 net819 sky130_fd_sc_hd__clkbuf_4
X_09790_ _03895_ _03896_ vssd1 vssd1 vccd1 vccd1 _03898_ sky130_fd_sc_hd__xor2_2
XTAP_644 vssd1 vccd1 sky130_fd_sc_hd__tapvpwrvgnd_1
XTAP_655 vssd1 vccd1 sky130_fd_sc_hd__tapvpwrvgnd_1
XTAP_666 vssd1 vccd1 sky130_fd_sc_hd__tapvpwrvgnd_1
XTAP_677 vssd1 vccd1 sky130_fd_sc_hd__tapvpwrvgnd_1
X_08741_ net1115 net734 _02851_ _02853_ vssd1 vssd1 vccd1 vccd1 _02855_ sky130_fd_sc_hd__a22oi_1
XTAP_688 vssd1 vccd1 sky130_fd_sc_hd__tapvpwrvgnd_1
XTAP_699 vssd1 vccd1 sky130_fd_sc_hd__tapvpwrvgnd_1
X_08672_ _02767_ _02784_ _02785_ vssd1 vssd1 vccd1 vccd1 _02787_ sky130_fd_sc_hd__and3_1
XFILLER_0_108_83 vssd1 vssd1 vccd1 vccd1 sky130_fd_sc_hd__fill_1
XFILLER_0_17_81 vssd1 vssd1 vccd1 vccd1 sky130_ef_sc_hd__decap_12
X_07623_ _01394_ _01397_ _01745_ _01746_ vssd1 vssd1 vccd1 vccd1 _01747_ sky130_fd_sc_hd__a211oi_4
X_07554_ _01327_ _01329_ vssd1 vssd1 vccd1 vccd1 _01678_ sky130_fd_sc_hd__nor2_1
X_06505_ det_t\[15\] net527 vssd1 vssd1 vccd1 vccd1 net258 sky130_fd_sc_hd__and2_1
X_07485_ _01588_ _01603_ vssd1 vssd1 vccd1 vccd1 _01610_ sky130_fd_sc_hd__xnor2_1
XFILLER_0_118_245 vssd1 vssd1 vccd1 vccd1 sky130_fd_sc_hd__decap_6
X_09224_ _03319_ _03334_ vssd1 vssd1 vccd1 vccd1 _03335_ sky130_fd_sc_hd__or2_2
XFILLER_0_76_699 vssd1 vssd1 vccd1 vccd1 sky130_fd_sc_hd__fill_1
X_06436_ _00736_ _00737_ vssd1 vssd1 vccd1 vccd1 _00738_ sky130_fd_sc_hd__xnor2_4
XFILLER_0_118_289 vssd1 vssd1 vccd1 vccd1 sky130_ef_sc_hd__decap_12
XFILLER_0_106_429 vssd1 vssd1 vccd1 vccd1 sky130_fd_sc_hd__fill_1
XFILLER_0_90_135 vssd1 vssd1 vccd1 vccd1 sky130_fd_sc_hd__decap_4
XFILLER_0_44_530 vssd1 vssd1 vccd1 vccd1 sky130_fd_sc_hd__fill_2
X_09155_ _03148_ _03150_ vssd1 vssd1 vccd1 vccd1 _03266_ sky130_fd_sc_hd__nor2_1
XFILLER_0_71_360 vssd1 vssd1 vccd1 vccd1 sky130_ef_sc_hd__decap_12
X_06367_ add1.a_i\[14\] add1.b_i\[14\] vssd1 vssd1 vccd1 vccd1 _00678_ sky130_fd_sc_hd__nand2_1
XFILLER_0_44_563 vssd1 vssd1 vccd1 vccd1 sky130_fd_sc_hd__decap_4
X_09086_ net835 net1002 _03195_ _03196_ vssd1 vssd1 vccd1 vccd1 _03198_ sky130_fd_sc_hd__a22o_1
X_08106_ _02122_ _02124_ _02223_ vssd1 vssd1 vccd1 vccd1 _02225_ sky130_fd_sc_hd__nand3_2
X_06298_ state\[2\] state\[3\] _00611_ _00609_ vssd1 vssd1 vccd1 vccd1 _00612_ sky130_fd_sc_hd__o31a_1
X_08037_ net461 _02155_ _02043_ _02045_ vssd1 vssd1 vccd1 vccd1 _02157_ sky130_fd_sc_hd__o211ai_2
XFILLER_0_31_279 vssd1 vssd1 vccd1 vccd1 sky130_fd_sc_hd__fill_1
X_09988_ net1062 net731 net724 net1070 vssd1 vssd1 vccd1 vccd1 _04094_ sky130_fd_sc_hd__a22o_1
X_08939_ net885 net974 _02919_ _02920_ net961 vssd1 vssd1 vccd1 vccd1 _03052_ sky130_fd_sc_hd__a32o_1
X_11950_ net93 net621 net595 net61 vssd1 vssd1 vccd1 vccd1 _05967_ sky130_fd_sc_hd__a22o_1
X_10901_ net808 net953 _04832_ _04831_ vssd1 vssd1 vccd1 vccd1 _05001_ sky130_fd_sc_hd__a31oi_2
XFILLER_0_86_419 vssd1 vssd1 vccd1 vccd1 sky130_fd_sc_hd__fill_1
X_11881_ net174 net472 _05913_ vssd1 vssd1 vccd1 vccd1 _05914_ sky130_fd_sc_hd__o21a_1
XFILLER_0_79_482 vssd1 vssd1 vccd1 vccd1 sky130_fd_sc_hd__decap_3
X_10832_ _04914_ _04930_ _04931_ vssd1 vssd1 vccd1 vccd1 _04933_ sky130_fd_sc_hd__nor3_2
X_10763_ net992 net758 vssd1 vssd1 vccd1 vccd1 _04864_ sky130_fd_sc_hd__nand2_1
XFILLER_0_13_39 vssd1 vssd1 vccd1 vccd1 sky130_ef_sc_hd__decap_12
XFILLER_0_39_346 vssd1 vssd1 vccd1 vccd1 sky130_fd_sc_hd__fill_1
X_12502_ net1266 net564 vssd1 vssd1 vccd1 vccd1 _06248_ sky130_fd_sc_hd__nand2_1
XFILLER_0_109_223 vssd1 vssd1 vccd1 vccd1 sky130_fd_sc_hd__fill_1
XFILLER_0_67_688 vssd1 vssd1 vccd1 vccd1 sky130_fd_sc_hd__fill_2
XFILLER_0_66_165 vssd1 vssd1 vccd1 vccd1 sky130_fd_sc_hd__fill_1
XFILLER_0_125_727 vssd1 vssd1 vccd1 vccd1 sky130_fd_sc_hd__fill_1
XFILLER_0_124_204 vssd1 vssd1 vccd1 vccd1 sky130_fd_sc_hd__fill_1
XFILLER_0_82_669 vssd1 vssd1 vccd1 vccd1 sky130_fd_sc_hd__decap_3
X_10694_ _04748_ _04749_ _04793_ _04794_ vssd1 vssd1 vccd1 vccd1 _04796_ sky130_fd_sc_hd__o22a_1
XFILLER_0_120_29 vssd1 vssd1 vccd1 vccd1 sky130_ef_sc_hd__decap_12
X_12433_ _00867_ net613 _02961_ net575 vssd1 vssd1 vccd1 vccd1 _06209_ sky130_fd_sc_hd__a22o_1
XFILLER_0_50_533 vssd1 vssd1 vccd1 vccd1 sky130_ef_sc_hd__decap_12
X_12364_ net1573 _00908_ net660 vssd1 vssd1 vccd1 vccd1 _00416_ sky130_fd_sc_hd__mux2_1
XFILLER_0_120_421 vssd1 vssd1 vccd1 vccd1 sky130_ef_sc_hd__decap_12
X_11315_ net1003 net717 vssd1 vssd1 vccd1 vccd1 _05412_ sky130_fd_sc_hd__nand2_1
X_12295_ net1613 _00882_ net675 vssd1 vssd1 vccd1 vccd1 _00347_ sky130_fd_sc_hd__mux2_1
XFILLER_0_129_27 vssd1 vssd1 vccd1 vccd1 sky130_fd_sc_hd__decap_8
X_11246_ _05341_ _05342_ vssd1 vssd1 vccd1 vccd1 _05343_ sky130_fd_sc_hd__or2_1
X_11177_ _05272_ _05273_ vssd1 vssd1 vccd1 vccd1 _05275_ sky130_fd_sc_hd__xor2_2
X_10128_ _04230_ _04231_ _04073_ _04074_ vssd1 vssd1 vccd1 vccd1 _04233_ sky130_fd_sc_hd__a211o_1
X_10059_ _04000_ _04001_ _04163_ _04164_ vssd1 vssd1 vccd1 vccd1 _04165_ sky130_fd_sc_hd__o211ai_4
XFILLER_0_54_79 vssd1 vssd1 vccd1 vccd1 sky130_fd_sc_hd__decap_4
XFILLER_0_57_110 vssd1 vssd1 vccd1 vccd1 sky130_fd_sc_hd__fill_2
XFILLER_0_9_207 vssd1 vssd1 vccd1 vccd1 sky130_fd_sc_hd__fill_1
X_07270_ _01392_ _01393_ _01233_ _01253_ vssd1 vssd1 vccd1 vccd1 _01395_ sky130_fd_sc_hd__a211o_1
XFILLER_0_128_587 vssd1 vssd1 vccd1 vccd1 sky130_fd_sc_hd__fill_1
XFILLER_0_115_237 vssd1 vssd1 vccd1 vccd1 sky130_ef_sc_hd__decap_12
XFILLER_0_79_21 vssd1 vssd1 vccd1 vccd1 sky130_ef_sc_hd__decap_12
XFILLER_0_53_393 vssd1 vssd1 vccd1 vccd1 sky130_ef_sc_hd__decap_12
XFILLER_0_13_202 vssd1 vssd1 vccd1 vccd1 sky130_ef_sc_hd__decap_12
XFILLER_0_124_793 vssd1 vssd1 vccd1 vccd1 sky130_ef_sc_hd__decap_12
Xhold114 add1.b_i\[26\] vssd1 vssd1 vccd1 vccd1 net1329 sky130_fd_sc_hd__dlygate4sd3_1
Xhold103 sub1.a_i\[19\] vssd1 vssd1 vccd1 vccd1 net1318 sky130_fd_sc_hd__dlygate4sd3_1
Xhold125 sub1.b_i\[5\] vssd1 vssd1 vccd1 vccd1 net1340 sky130_fd_sc_hd__dlygate4sd3_1
Xhold136 posy\[2\] vssd1 vssd1 vccd1 vccd1 net1351 sky130_fd_sc_hd__dlygate4sd3_1
X_09911_ _04014_ _04015_ _04016_ vssd1 vssd1 vccd1 vccd1 _04018_ sky130_fd_sc_hd__a21bo_1
Xhold147 l1\[23\] vssd1 vssd1 vccd1 vccd1 net1362 sky130_fd_sc_hd__dlygate4sd3_1
XFILLER_0_1_652 vssd1 vssd1 vccd1 vccd1 sky130_fd_sc_hd__decap_4
Xhold158 y2my0\[18\] vssd1 vssd1 vccd1 vccd1 net1373 sky130_fd_sc_hd__dlygate4sd3_1
Xhold169 net447 vssd1 vssd1 vccd1 vccd1 net1384 sky130_fd_sc_hd__dlygate4sd3_1
Xfanout605 net606 vssd1 vssd1 vccd1 vccd1 net605 sky130_fd_sc_hd__clkbuf_4
X_09842_ _03928_ _03948_ vssd1 vssd1 vccd1 vccd1 _03949_ sky130_fd_sc_hd__xnor2_4
Xfanout649 net650 vssd1 vssd1 vccd1 vccd1 net649 sky130_fd_sc_hd__buf_2
Xfanout638 net639 vssd1 vssd1 vccd1 vccd1 net638 sky130_fd_sc_hd__clkbuf_4
XTAP_430 vssd1 vccd1 sky130_fd_sc_hd__tapvpwrvgnd_1
Xfanout627 _00986_ vssd1 vssd1 vccd1 vccd1 net627 sky130_fd_sc_hd__clkbuf_4
XTAP_441 vssd1 vccd1 sky130_fd_sc_hd__tapvpwrvgnd_1
Xfanout616 net617 vssd1 vssd1 vccd1 vccd1 net616 sky130_fd_sc_hd__clkbuf_4
X_09773_ _03879_ _03880_ vssd1 vssd1 vccd1 vccd1 _03881_ sky130_fd_sc_hd__and2b_1
XTAP_452 vssd1 vccd1 sky130_fd_sc_hd__tapvpwrvgnd_1
XTAP_463 vssd1 vccd1 sky130_fd_sc_hd__tapvpwrvgnd_1
XTAP_474 vssd1 vccd1 sky130_fd_sc_hd__tapvpwrvgnd_1
XTAP_485 vssd1 vccd1 sky130_fd_sc_hd__tapvpwrvgnd_1
XFILLER_0_119_93 vssd1 vssd1 vccd1 vccd1 sky130_ef_sc_hd__decap_12
X_08724_ _02825_ _02836_ vssd1 vssd1 vccd1 vccd1 _02838_ sky130_fd_sc_hd__xor2_1
Xclkbuf_leaf_50_clk_i clknet_3_1__leaf_clk_i vssd1 vssd1 vccd1 vccd1 clknet_leaf_50_clk_i
+ sky130_fd_sc_hd__clkbuf_16
XTAP_496 vssd1 vccd1 sky130_fd_sc_hd__tapvpwrvgnd_1
X_06985_ _01106_ _01107_ _01108_ vssd1 vssd1 vccd1 vccd1 _01110_ sky130_fd_sc_hd__a21o_1
XFILLER_0_68_408 vssd1 vssd1 vccd1 vccd1 sky130_fd_sc_hd__decap_6
X_08655_ net903 net894 net973 vssd1 vssd1 vccd1 vccd1 _02770_ sky130_fd_sc_hd__and3_1
X_08586_ net1107 net1114 net749 net740 vssd1 vssd1 vccd1 vccd1 _02701_ sky130_fd_sc_hd__and4_1
XTAP_1629 vssd1 vccd1 sky130_fd_sc_hd__tapvpwrvgnd_1
XTAP_1618 vssd1 vccd1 sky130_fd_sc_hd__tapvpwrvgnd_1
XTAP_1607 vssd1 vccd1 sky130_fd_sc_hd__tapvpwrvgnd_1
X_07606_ _01720_ _01727_ _01728_ vssd1 vssd1 vccd1 vccd1 _01730_ sky130_fd_sc_hd__nand3_2
X_07537_ _01659_ _01660_ _01661_ _01509_ vssd1 vssd1 vccd1 vccd1 _01662_ sky130_fd_sc_hd__a31o_1
XFILLER_0_48_187 vssd1 vssd1 vccd1 vccd1 sky130_fd_sc_hd__decap_3
X_07468_ _01590_ _01591_ _01592_ vssd1 vssd1 vccd1 vccd1 _01593_ sky130_fd_sc_hd__or3_1
X_09207_ _03316_ _03317_ vssd1 vssd1 vccd1 vccd1 _03318_ sky130_fd_sc_hd__nand2b_1
XFILLER_0_106_237 vssd1 vssd1 vccd1 vccd1 sky130_fd_sc_hd__fill_1
X_06419_ add1.a_i\[21\] add1.b_i\[21\] vssd1 vssd1 vccd1 vccd1 _00723_ sky130_fd_sc_hd__or2_1
XFILLER_0_51_308 vssd1 vssd1 vccd1 vccd1 sky130_fd_sc_hd__decap_6
X_07399_ _01522_ _01523_ vssd1 vssd1 vccd1 vccd1 _01524_ sky130_fd_sc_hd__and2b_1
X_09138_ _03088_ _03090_ _03248_ _03249_ vssd1 vssd1 vccd1 vccd1 _03250_ sky130_fd_sc_hd__o211a_1
XFILLER_0_32_533 vssd1 vssd1 vccd1 vccd1 sky130_fd_sc_hd__decap_6
XFILLER_0_102_421 vssd1 vssd1 vccd1 vccd1 sky130_fd_sc_hd__decap_4
XFILLER_0_102_432 vssd1 vssd1 vccd1 vccd1 sky130_fd_sc_hd__fill_2
X_09069_ _03178_ _03179_ vssd1 vssd1 vccd1 vccd1 _03181_ sky130_fd_sc_hd__xnor2_1
X_11100_ _05197_ _05198_ vssd1 vssd1 vccd1 vccd1 _05199_ sky130_fd_sc_hd__and2b_1
X_12080_ x0mx2\[11\] net629 net591 y1my2\[11\] vssd1 vssd1 vccd1 vccd1 _06066_ sky130_fd_sc_hd__a22o_1
X_11031_ _05007_ _05009_ _05128_ vssd1 vssd1 vccd1 vccd1 _05130_ sky130_fd_sc_hd__nand3_1
Xclkbuf_leaf_18_clk_i clknet_3_5__leaf_clk_i vssd1 vssd1 vccd1 vccd1 clknet_leaf_18_clk_i
+ sky130_fd_sc_hd__clkbuf_16
X_12982_ clknet_leaf_50_clk_i _00368_ net1152 vssd1 vssd1 vccd1 vccd1 x2mx1\[3\] sky130_fd_sc_hd__dfrtp_1
XFILLER_0_99_577 vssd1 vssd1 vccd1 vccd1 sky130_fd_sc_hd__decap_8
X_11933_ net1590 _05954_ net478 vssd1 vssd1 vccd1 vccd1 _00226_ sky130_fd_sc_hd__mux2_1
X_11864_ net1292 _05899_ net482 vssd1 vssd1 vccd1 vccd1 _00212_ sky130_fd_sc_hd__mux2_1
XFILLER_0_24_27 vssd1 vssd1 vccd1 vccd1 sky130_fd_sc_hd__fill_1
XFILLER_0_39_110 vssd1 vssd1 vccd1 vccd1 sky130_fd_sc_hd__fill_2
X_10815_ net1022 net1027 net730 net725 vssd1 vssd1 vccd1 vccd1 _04916_ sky130_fd_sc_hd__and4_1
X_11795_ net1286 _05840_ net480 vssd1 vssd1 vccd1 vccd1 _00202_ sky130_fd_sc_hd__mux2_1
XFILLER_0_27_327 vssd1 vssd1 vccd1 vccd1 sky130_fd_sc_hd__fill_1
X_10746_ _04830_ _04845_ _04846_ vssd1 vssd1 vccd1 vccd1 _04847_ sky130_fd_sc_hd__nand3b_4
XFILLER_0_54_146 vssd1 vssd1 vccd1 vccd1 sky130_fd_sc_hd__decap_8
XFILLER_0_82_477 vssd1 vssd1 vccd1 vccd1 sky130_fd_sc_hd__fill_1
X_10677_ _04772_ _04777_ vssd1 vssd1 vccd1 vccd1 _04779_ sky130_fd_sc_hd__xor2_2
XFILLER_0_23_533 vssd1 vssd1 vccd1 vccd1 sky130_ef_sc_hd__decap_12
XFILLER_0_35_393 vssd1 vssd1 vccd1 vccd1 sky130_fd_sc_hd__fill_2
X_12416_ net1739 _06200_ net571 vssd1 vssd1 vccd1 vccd1 _00463_ sky130_fd_sc_hd__mux2_1
XFILLER_0_50_341 vssd1 vssd1 vccd1 vccd1 sky130_fd_sc_hd__fill_1
XFILLER_0_121_741 vssd1 vssd1 vccd1 vccd1 sky130_ef_sc_hd__decap_12
XFILLER_0_105_281 vssd1 vssd1 vccd1 vccd1 sky130_fd_sc_hd__decap_4
XFILLER_0_50_363 vssd1 vssd1 vccd1 vccd1 sky130_fd_sc_hd__fill_1
X_12347_ net1461 _00818_ net656 vssd1 vssd1 vccd1 vccd1 _00399_ sky130_fd_sc_hd__mux2_1
XFILLER_0_121_785 vssd1 vssd1 vccd1 vccd1 sky130_ef_sc_hd__decap_12
XFILLER_0_120_251 vssd1 vssd1 vccd1 vccd1 sky130_fd_sc_hd__fill_1
X_12278_ net1715 _00605_ _06194_ vssd1 vssd1 vccd1 vccd1 _00331_ sky130_fd_sc_hd__a21o_1
X_11229_ _05318_ _05324_ _05325_ vssd1 vssd1 vccd1 vccd1 _05326_ sky130_fd_sc_hd__and3b_1
XFILLER_0_4_15 vssd1 vssd1 vccd1 vccd1 sky130_ef_sc_hd__decap_12
XFILLER_0_65_67 vssd1 vssd1 vccd1 vccd1 sky130_fd_sc_hd__fill_1
X_06770_ net1579 l1\[9\] net640 vssd1 vssd1 vccd1 vccd1 _00044_ sky130_fd_sc_hd__mux2_1
XFILLER_0_78_728 vssd1 vssd1 vccd1 vccd1 sky130_ef_sc_hd__decap_12
XFILLER_0_77_205 vssd1 vssd1 vccd1 vccd1 sky130_fd_sc_hd__fill_1
X_08440_ _02417_ _02420_ vssd1 vssd1 vccd1 vccd1 _02556_ sky130_fd_sc_hd__nor2_1
XFILLER_0_93_709 vssd1 vssd1 vccd1 vccd1 sky130_ef_sc_hd__decap_12
XFILLER_0_81_77 vssd1 vssd1 vccd1 vccd1 sky130_ef_sc_hd__decap_12
XFILLER_0_81_55 vssd1 vssd1 vccd1 vccd1 sky130_fd_sc_hd__fill_1
XFILLER_0_129_841 vssd1 vssd1 vccd1 vccd1 sky130_fd_sc_hd__fill_1
X_08371_ net865 net1007 net1000 net875 vssd1 vssd1 vccd1 vccd1 _02488_ sky130_fd_sc_hd__a22o_1
XFILLER_0_58_474 vssd1 vssd1 vccd1 vccd1 sky130_fd_sc_hd__fill_2
XFILLER_0_116_513 vssd1 vssd1 vccd1 vccd1 sky130_ef_sc_hd__decap_12
XFILLER_0_73_444 vssd1 vssd1 vccd1 vccd1 sky130_fd_sc_hd__decap_4
X_07322_ _01445_ _01446_ vssd1 vssd1 vccd1 vccd1 _01447_ sky130_fd_sc_hd__nor2_1
X_07253_ _01374_ _01375_ _01376_ vssd1 vssd1 vccd1 vccd1 _01378_ sky130_fd_sc_hd__nand3_1
XFILLER_0_116_557 vssd1 vssd1 vccd1 vccd1 sky130_ef_sc_hd__decap_12
XFILLER_0_6_766 vssd1 vssd1 vccd1 vccd1 sky130_fd_sc_hd__fill_1
X_07184_ _01307_ _01308_ vssd1 vssd1 vccd1 vccd1 _01309_ sky130_fd_sc_hd__nand2b_1
XFILLER_0_76_3 vssd1 vssd1 vccd1 vccd1 sky130_ef_sc_hd__decap_12
XFILLER_0_111_273 vssd1 vssd1 vccd1 vccd1 sky130_fd_sc_hd__decap_6
X_09825_ _03799_ _03802_ _03800_ vssd1 vssd1 vccd1 vccd1 _03932_ sky130_fd_sc_hd__o21bai_1
XFILLER_0_10_783 vssd1 vssd1 vccd1 vccd1 sky130_ef_sc_hd__decap_12
XFILLER_0_39_90 vssd1 vssd1 vccd1 vccd1 sky130_ef_sc_hd__decap_12
Xfanout479 net485 vssd1 vssd1 vccd1 vccd1 net479 sky130_fd_sc_hd__clkbuf_4
XTAP_293 vssd1 vccd1 sky130_fd_sc_hd__tapvpwrvgnd_1
XTAP_271 vssd1 vccd1 sky130_fd_sc_hd__tapvpwrvgnd_1
XTAP_282 vssd1 vccd1 sky130_fd_sc_hd__tapvpwrvgnd_1
Xfanout468 net469 vssd1 vssd1 vccd1 vccd1 net468 sky130_fd_sc_hd__clkbuf_4
X_09756_ _03855_ _03863_ vssd1 vssd1 vccd1 vccd1 _03864_ sky130_fd_sc_hd__xnor2_4
X_06968_ net896 net1077 net1083 net888 vssd1 vssd1 vccd1 vccd1 _01093_ sky130_fd_sc_hd__a22oi_2
XTAP_2116 vssd1 vccd1 sky130_fd_sc_hd__tapvpwrvgnd_1
XTAP_2105 vssd1 vccd1 sky130_fd_sc_hd__tapvpwrvgnd_1
X_09687_ _03754_ _03793_ vssd1 vssd1 vccd1 vccd1 _03795_ sky130_fd_sc_hd__xnor2_4
X_08707_ _02811_ _02817_ vssd1 vssd1 vccd1 vccd1 _02821_ sky130_fd_sc_hd__or2_1
XTAP_2149 vssd1 vccd1 sky130_fd_sc_hd__tapvpwrvgnd_1
XTAP_2138 vssd1 vccd1 sky130_fd_sc_hd__tapvpwrvgnd_1
XTAP_2127 vssd1 vccd1 sky130_fd_sc_hd__tapvpwrvgnd_1
X_08638_ _02624_ _02626_ _02751_ vssd1 vssd1 vccd1 vccd1 _02753_ sky130_fd_sc_hd__nand3_2
XTAP_1415 vssd1 vccd1 sky130_fd_sc_hd__tapvpwrvgnd_1
XTAP_1404 vssd1 vccd1 sky130_fd_sc_hd__tapvpwrvgnd_1
X_06899_ net871 net1095 net1103 net862 vssd1 vssd1 vccd1 vccd1 _01024_ sky130_fd_sc_hd__a22oi_1
XTAP_1448 vssd1 vccd1 sky130_fd_sc_hd__tapvpwrvgnd_1
XTAP_1437 vssd1 vccd1 sky130_fd_sc_hd__tapvpwrvgnd_1
XTAP_1426 vssd1 vccd1 sky130_fd_sc_hd__tapvpwrvgnd_1
X_08569_ _02678_ _02682_ _02683_ vssd1 vssd1 vccd1 vccd1 _02684_ sky130_fd_sc_hd__nand3_1
XTAP_1459 vssd1 vccd1 sky130_fd_sc_hd__tapvpwrvgnd_1
XFILLER_0_64_411 vssd1 vssd1 vccd1 vccd1 sky130_fd_sc_hd__fill_1
XFILLER_0_37_603 vssd1 vssd1 vccd1 vccd1 sky130_ef_sc_hd__decap_12
XFILLER_0_37_625 vssd1 vssd1 vccd1 vccd1 sky130_fd_sc_hd__fill_2
XFILLER_0_92_731 vssd1 vssd1 vccd1 vccd1 sky130_ef_sc_hd__decap_12
X_10600_ _04699_ _04701_ _04555_ _04558_ vssd1 vssd1 vccd1 vccd1 _04702_ sky130_fd_sc_hd__o211ai_4
X_11580_ net776 mul1.a\[29\] vssd1 vssd1 vccd1 vccd1 _05674_ sky130_fd_sc_hd__nand2_1
XFILLER_0_119_373 vssd1 vssd1 vccd1 vccd1 sky130_ef_sc_hd__decap_12
X_10531_ _04633_ _04632_ _04631_ vssd1 vssd1 vccd1 vccd1 _04634_ sky130_fd_sc_hd__nand3b_2
XFILLER_0_64_477 vssd1 vssd1 vccd1 vccd1 sky130_fd_sc_hd__decap_4
XFILLER_0_17_360 vssd1 vssd1 vccd1 vccd1 sky130_fd_sc_hd__decap_3
X_10462_ _04444_ _04465_ _04563_ _04564_ vssd1 vssd1 vccd1 vccd1 _04565_ sky130_fd_sc_hd__o211a_4
XFILLER_0_10_29 vssd1 vssd1 vccd1 vccd1 sky130_ef_sc_hd__decap_12
X_12201_ x2mx1\[12\] net603 net584 temp1\[12\] vssd1 vssd1 vccd1 vccd1 _06154_ sky130_fd_sc_hd__a22o_1
XFILLER_0_103_741 vssd1 vssd1 vccd1 vccd1 sky130_ef_sc_hd__decap_12
X_10393_ _04496_ vssd1 vssd1 vccd1 vccd1 _04497_ sky130_fd_sc_hd__inv_2
X_13181_ clknet_leaf_21_clk_i _00567_ net1175 vssd1 vssd1 vccd1 vccd1 l1\[10\] sky130_fd_sc_hd__dfrtp_1
XFILLER_0_20_503 vssd1 vssd1 vccd1 vccd1 sky130_fd_sc_hd__fill_2
X_12132_ x0mx2\[24\] net632 net592 y1my2\[24\] vssd1 vssd1 vccd1 vccd1 _06105_ sky130_fd_sc_hd__a22o_1
XFILLER_0_20_547 vssd1 vssd1 vccd1 vccd1 sky130_fd_sc_hd__fill_2
XFILLER_0_130_593 vssd1 vssd1 vccd1 vccd1 sky130_fd_sc_hd__fill_2
XFILLER_0_19_27 vssd1 vssd1 vccd1 vccd1 sky130_ef_sc_hd__decap_12
X_12063_ net1102 _06053_ net515 vssd1 vssd1 vccd1 vccd1 _00257_ sky130_fd_sc_hd__mux2_1
XFILLER_0_20_569 vssd1 vssd1 vccd1 vccd1 sky130_fd_sc_hd__decap_6
X_11014_ _05111_ _05112_ vssd1 vssd1 vccd1 vccd1 _05113_ sky130_fd_sc_hd__nand2b_1
Xfanout991 mul1.a\[20\] vssd1 vssd1 vccd1 vccd1 net991 sky130_fd_sc_hd__clkbuf_4
Xfanout980 net981 vssd1 vssd1 vccd1 vccd1 net980 sky130_fd_sc_hd__buf_1
XFILLER_0_35_15 vssd1 vssd1 vccd1 vccd1 sky130_ef_sc_hd__decap_12
X_12965_ clknet_leaf_48_clk_i _00351_ net1159 vssd1 vssd1 vccd1 vccd1 y1my2\[18\]
+ sky130_fd_sc_hd__dfrtp_1
XFILLER_0_35_37 vssd1 vssd1 vccd1 vccd1 sky130_fd_sc_hd__fill_2
X_11916_ net147 net659 net502 net243 _05941_ vssd1 vssd1 vccd1 vccd1 _05942_ sky130_fd_sc_hd__a221o_1
XFILLER_0_87_569 vssd1 vssd1 vccd1 vccd1 sky130_fd_sc_hd__decap_6
XFILLER_0_59_249 vssd1 vssd1 vccd1 vccd1 sky130_fd_sc_hd__decap_3
X_12896_ clknet_leaf_37_clk_i _00282_ vssd1 vssd1 vccd1 vccd1 mul1.a\[31\] sky130_fd_sc_hd__dfxtp_1
XTAP_1960 vssd1 vccd1 sky130_fd_sc_hd__tapvpwrvgnd_1
XFILLER_0_68_761 vssd1 vssd1 vccd1 vccd1 sky130_fd_sc_hd__fill_1
X_11847_ net233 net600 net580 net137 _05884_ vssd1 vssd1 vccd1 vccd1 _05885_ sky130_fd_sc_hd__a221o_1
XFILLER_0_126_811 vssd1 vssd1 vccd1 vccd1 sky130_fd_sc_hd__fill_1
XTAP_1993 vssd1 vccd1 sky130_fd_sc_hd__tapvpwrvgnd_1
XTAP_1971 vssd1 vccd1 sky130_fd_sc_hd__tapvpwrvgnd_1
XTAP_1982 vssd1 vccd1 sky130_fd_sc_hd__tapvpwrvgnd_1
XFILLER_0_83_753 vssd1 vssd1 vccd1 vccd1 sky130_fd_sc_hd__fill_2
X_11778_ net62 net674 net608 net190 vssd1 vssd1 vccd1 vccd1 _05826_ sky130_fd_sc_hd__a22o_1
XFILLER_0_27_135 vssd1 vssd1 vccd1 vccd1 sky130_fd_sc_hd__fill_1
XFILLER_0_126_833 vssd1 vssd1 vccd1 vccd1 sky130_fd_sc_hd__fill_1
X_10729_ _04677_ _04679_ _04675_ vssd1 vssd1 vccd1 vccd1 _04830_ sky130_fd_sc_hd__a21oi_1
XFILLER_0_43_617 vssd1 vssd1 vccd1 vccd1 sky130_fd_sc_hd__decap_6
XFILLER_0_125_365 vssd1 vssd1 vccd1 vccd1 sky130_ef_sc_hd__decap_12
XFILLER_0_113_505 vssd1 vssd1 vccd1 vccd1 sky130_ef_sc_hd__decap_12
X_07940_ temp1\[4\] _02060_ net540 vssd1 vssd1 vccd1 vccd1 _02061_ sky130_fd_sc_hd__mux2_1
X_07871_ net1059 net1067 net848 net839 vssd1 vssd1 vccd1 vccd1 _01992_ sky130_fd_sc_hd__and4_1
X_06822_ net1586 net1542 net645 vssd1 vssd1 vccd1 vccd1 _00096_ sky130_fd_sc_hd__mux2_1
XFILLER_0_92_21 vssd1 vssd1 vccd1 vccd1 sky130_fd_sc_hd__decap_6
X_09610_ _03539_ _03547_ _03546_ vssd1 vssd1 vccd1 vccd1 _03719_ sky130_fd_sc_hd__a21bo_1
X_09541_ _03640_ _03649_ vssd1 vssd1 vccd1 vccd1 _03650_ sky130_fd_sc_hd__xnor2_2
X_06753_ _00966_ _00967_ vssd1 vssd1 vccd1 vccd1 _00968_ sky130_fd_sc_hd__nor2_2
XFILLER_0_92_65 vssd1 vssd1 vccd1 vccd1 sky130_ef_sc_hd__decap_12
XFILLER_0_78_536 vssd1 vssd1 vccd1 vccd1 sky130_fd_sc_hd__decap_8
XFILLER_0_78_514 vssd1 vssd1 vccd1 vccd1 sky130_fd_sc_hd__fill_1
XFILLER_0_116_83 vssd1 vssd1 vccd1 vccd1 sky130_fd_sc_hd__fill_1
X_09472_ temp1\[15\] _03581_ net541 vssd1 vssd1 vccd1 vccd1 _03582_ sky130_fd_sc_hd__mux2_1
X_06684_ sub1.b_i\[20\] sub1.a_i\[20\] vssd1 vssd1 vccd1 vccd1 _00909_ sky130_fd_sc_hd__nand2b_2
X_08423_ _02401_ _02539_ vssd1 vssd1 vccd1 vccd1 _02540_ sky130_fd_sc_hd__nand2b_1
X_08354_ net1043 net832 vssd1 vssd1 vccd1 vccd1 _02471_ sky130_fd_sc_hd__and2_1
XFILLER_0_74_720 vssd1 vssd1 vccd1 vccd1 sky130_fd_sc_hd__fill_1
XFILLER_0_129_693 vssd1 vssd1 vccd1 vccd1 sky130_fd_sc_hd__fill_2
XFILLER_0_116_321 vssd1 vssd1 vccd1 vccd1 sky130_ef_sc_hd__decap_12
XFILLER_0_18_157 vssd1 vssd1 vccd1 vccd1 sky130_fd_sc_hd__fill_1
XFILLER_0_19_669 vssd1 vssd1 vccd1 vccd1 sky130_fd_sc_hd__decap_3
X_07305_ _01427_ _01428_ vssd1 vssd1 vccd1 vccd1 _01430_ sky130_fd_sc_hd__xnor2_1
XFILLER_0_73_274 vssd1 vssd1 vccd1 vccd1 sky130_fd_sc_hd__fill_1
X_08285_ _02161_ _02278_ _02402_ vssd1 vssd1 vccd1 vccd1 _02403_ sky130_fd_sc_hd__o21ai_1
XFILLER_0_116_365 vssd1 vssd1 vccd1 vccd1 sky130_ef_sc_hd__decap_12
X_07236_ net1066 net873 net864 net1074 vssd1 vssd1 vccd1 vccd1 _01361_ sky130_fd_sc_hd__and4_1
XFILLER_0_6_574 vssd1 vssd1 vccd1 vccd1 sky130_fd_sc_hd__fill_1
XFILLER_0_33_149 vssd1 vssd1 vccd1 vccd1 sky130_ef_sc_hd__decap_12
X_07167_ _01031_ _01033_ vssd1 vssd1 vccd1 vccd1 _01292_ sky130_fd_sc_hd__xnor2_1
XFILLER_0_42_661 vssd1 vssd1 vccd1 vccd1 sky130_fd_sc_hd__decap_3
X_07098_ net856 net1088 _01221_ _01222_ vssd1 vssd1 vccd1 vccd1 _01223_ sky130_fd_sc_hd__nand4_1
X_09808_ _03913_ _03914_ vssd1 vssd1 vccd1 vccd1 _03915_ sky130_fd_sc_hd__xnor2_1
X_09739_ _03845_ _03846_ _03839_ vssd1 vssd1 vccd1 vccd1 _03847_ sky130_fd_sc_hd__a21o_1
XTAP_1223 vssd1 vccd1 sky130_fd_sc_hd__tapvpwrvgnd_1
XTAP_1212 vssd1 vccd1 sky130_fd_sc_hd__tapvpwrvgnd_1
XTAP_1201 vssd1 vccd1 sky130_fd_sc_hd__tapvpwrvgnd_1
X_12750_ clknet_leaf_1_clk_i _00136_ vssd1 vssd1 vccd1 vccd1 add1.a_i\[13\] sky130_fd_sc_hd__dfxtp_1
X_12681_ clknet_leaf_15_clk_i net1400 net1182 vssd1 vssd1 vccd1 vccd1 net410 sky130_fd_sc_hd__dfrtp_1
XTAP_1256 vssd1 vccd1 sky130_fd_sc_hd__tapvpwrvgnd_1
XTAP_1245 vssd1 vccd1 sky130_fd_sc_hd__tapvpwrvgnd_1
XTAP_1234 vssd1 vccd1 sky130_fd_sc_hd__tapvpwrvgnd_1
XFILLER_0_56_219 vssd1 vssd1 vccd1 vccd1 sky130_fd_sc_hd__fill_1
X_11701_ net651 _00810_ _05761_ vssd1 vssd1 vccd1 vccd1 _05762_ sky130_fd_sc_hd__a21o_1
XTAP_1278 vssd1 vccd1 sky130_fd_sc_hd__tapvpwrvgnd_1
XTAP_1289 vssd1 vccd1 sky130_fd_sc_hd__tapvpwrvgnd_1
XTAP_1267 vssd1 vccd1 sky130_fd_sc_hd__tapvpwrvgnd_1
XFILLER_0_65_742 vssd1 vssd1 vccd1 vccd1 sky130_fd_sc_hd__fill_2
X_11632_ _05601_ _05604_ net1011 net697 vssd1 vssd1 vccd1 vccd1 _05726_ sky130_fd_sc_hd__o211ai_1
XFILLER_0_119_181 vssd1 vssd1 vccd1 vccd1 sky130_ef_sc_hd__decap_12
XFILLER_0_108_833 vssd1 vssd1 vccd1 vccd1 sky130_fd_sc_hd__fill_1
XFILLER_0_64_241 vssd1 vssd1 vccd1 vccd1 sky130_fd_sc_hd__fill_1
XFILLER_0_21_39 vssd1 vssd1 vccd1 vccd1 sky130_ef_sc_hd__decap_12
X_11563_ _05656_ _05657_ vssd1 vssd1 vccd1 vccd1 _05658_ sky130_fd_sc_hd__nand2b_1
X_10514_ net1086 net701 net693 net1093 vssd1 vssd1 vccd1 vccd1 _04617_ sky130_fd_sc_hd__o2bb2a_1
XFILLER_0_24_138 vssd1 vssd1 vccd1 vccd1 sky130_fd_sc_hd__fill_2
X_11494_ net799 net789 net930 net929 vssd1 vssd1 vccd1 vccd1 _05589_ sky130_fd_sc_hd__nand4_2
XFILLER_0_40_609 vssd1 vssd1 vccd1 vccd1 sky130_ef_sc_hd__decap_12
X_13233_ net508 vssd1 vssd1 vccd1 vccd1 net289 sky130_fd_sc_hd__clkbuf_1
X_10445_ net953 _04547_ _04546_ vssd1 vssd1 vccd1 vccd1 _04548_ sky130_fd_sc_hd__a21bo_1
XFILLER_0_21_812 vssd1 vssd1 vccd1 vccd1 sky130_fd_sc_hd__fill_1
XFILLER_0_122_357 vssd1 vssd1 vccd1 vccd1 sky130_fd_sc_hd__decap_6
X_13164_ clknet_leaf_9_clk_i _00550_ net1191 vssd1 vssd1 vccd1 vccd1 l0\[25\] sky130_fd_sc_hd__dfrtp_1
XFILLER_0_0_706 vssd1 vssd1 vccd1 vccd1 sky130_fd_sc_hd__fill_2
XFILLER_0_0_717 vssd1 vssd1 vccd1 vccd1 sky130_fd_sc_hd__fill_2
X_10376_ _04278_ _04280_ _04478_ _04479_ vssd1 vssd1 vccd1 vccd1 _04480_ sky130_fd_sc_hd__o211a_1
X_12115_ net997 _06092_ net516 vssd1 vssd1 vccd1 vccd1 _00270_ sky130_fd_sc_hd__mux2_1
X_13095_ clknet_leaf_39_clk_i _00481_ vssd1 vssd1 vccd1 vccd1 temp1\[20\] sky130_fd_sc_hd__dfxtp_1
X_12046_ _00818_ _05752_ _06032_ _06040_ vssd1 vssd1 vccd1 vccd1 _06041_ sky130_fd_sc_hd__a31o_1
XFILLER_0_62_46 vssd1 vssd1 vccd1 vccd1 sky130_fd_sc_hd__fill_1
X_12948_ clknet_leaf_52_clk_i _00334_ net1152 vssd1 vssd1 vccd1 vccd1 y1my2\[1\] sky130_fd_sc_hd__dfrtp_1
XFILLER_0_87_388 vssd1 vssd1 vccd1 vccd1 sky130_fd_sc_hd__decap_4
XFILLER_0_87_377 vssd1 vssd1 vccd1 vccd1 sky130_fd_sc_hd__fill_1
XFILLER_0_75_528 vssd1 vssd1 vccd1 vccd1 sky130_fd_sc_hd__decap_3
X_12879_ clknet_leaf_42_clk_i _00265_ vssd1 vssd1 vccd1 vccd1 mul1.a\[14\] sky130_fd_sc_hd__dfxtp_1
XTAP_1790 vssd1 vccd1 sky130_fd_sc_hd__tapvpwrvgnd_1
XFILLER_0_83_561 vssd1 vssd1 vccd1 vccd1 sky130_fd_sc_hd__fill_1
XFILLER_0_126_641 vssd1 vssd1 vccd1 vccd1 sky130_fd_sc_hd__decap_3
XFILLER_0_15_105 vssd1 vssd1 vccd1 vccd1 sky130_fd_sc_hd__decap_6
XFILLER_0_16_628 vssd1 vssd1 vccd1 vccd1 sky130_fd_sc_hd__fill_1
XFILLER_0_28_477 vssd1 vssd1 vccd1 vccd1 sky130_fd_sc_hd__decap_8
XFILLER_0_102_41 vssd1 vssd1 vccd1 vccd1 sky130_ef_sc_hd__decap_12
X_08070_ _02179_ _02188_ vssd1 vssd1 vccd1 vccd1 _02189_ sky130_fd_sc_hd__xnor2_1
XFILLER_0_43_469 vssd1 vssd1 vccd1 vccd1 sky130_fd_sc_hd__decap_8
XFILLER_0_113_335 vssd1 vssd1 vccd1 vccd1 sky130_fd_sc_hd__fill_1
XFILLER_0_102_85 vssd1 vssd1 vccd1 vccd1 sky130_ef_sc_hd__decap_12
X_07021_ net906 net1049 vssd1 vssd1 vccd1 vccd1 _01146_ sky130_fd_sc_hd__and2_1
X_08972_ _03049_ _03050_ _03083_ _03084_ vssd1 vssd1 vccd1 vccd1 _03085_ sky130_fd_sc_hd__o22ai_2
Xhold18 det_t\[27\] vssd1 vssd1 vccd1 vccd1 net1233 sky130_fd_sc_hd__dlygate4sd3_1
Xhold29 det_t\[8\] vssd1 vssd1 vccd1 vccd1 net1244 sky130_fd_sc_hd__dlygate4sd3_1
X_07923_ _02041_ _02042_ _01930_ _01933_ vssd1 vssd1 vccd1 vccd1 _02044_ sky130_fd_sc_hd__a211o_1
X_07854_ _01966_ _01974_ vssd1 vssd1 vccd1 vccd1 _01975_ sky130_fd_sc_hd__xnor2_1
XFILLER_0_39_3 vssd1 vssd1 vccd1 vccd1 sky130_ef_sc_hd__decap_12
X_06805_ net1404 l0\[12\] net642 vssd1 vssd1 vccd1 vccd1 _00079_ sky130_fd_sc_hd__mux2_1
XFILLER_0_127_93 vssd1 vssd1 vccd1 vccd1 sky130_ef_sc_hd__decap_12
XFILLER_0_97_108 vssd1 vssd1 vccd1 vccd1 sky130_fd_sc_hd__decap_4
X_07785_ _01898_ _01906_ vssd1 vssd1 vccd1 vccd1 _01907_ sky130_fd_sc_hd__nand2_1
X_09524_ _03590_ _03632_ vssd1 vssd1 vccd1 vccd1 _03633_ sky130_fd_sc_hd__nand2b_1
XFILLER_0_78_355 vssd1 vssd1 vccd1 vccd1 sky130_fd_sc_hd__fill_1
X_06736_ _00930_ _00936_ vssd1 vssd1 vccd1 vccd1 _00953_ sky130_fd_sc_hd__nor2_1
X_09455_ _03562_ _03563_ _03398_ _03400_ vssd1 vssd1 vccd1 vccd1 _03565_ sky130_fd_sc_hd__a211o_1
XFILLER_0_93_314 vssd1 vssd1 vccd1 vccd1 sky130_fd_sc_hd__fill_2
XFILLER_0_78_377 vssd1 vssd1 vccd1 vccd1 sky130_fd_sc_hd__decap_4
X_06667_ _00893_ _00894_ vssd1 vssd1 vccd1 vccd1 _00895_ sky130_fd_sc_hd__nor2_2
X_08406_ _02381_ net492 _02520_ _02522_ vssd1 vssd1 vccd1 vccd1 _02523_ sky130_fd_sc_hd__o211ai_4
X_09386_ _03493_ _03494_ _03495_ vssd1 vssd1 vccd1 vccd1 _03496_ sky130_fd_sc_hd__nand3_1
XFILLER_0_81_509 vssd1 vssd1 vccd1 vccd1 sky130_fd_sc_hd__fill_1
X_06598_ sub1.b_i\[4\] _00829_ vssd1 vssd1 vccd1 vccd1 _00837_ sky130_fd_sc_hd__nor2_1
XFILLER_0_129_490 vssd1 vssd1 vccd1 vccd1 sky130_fd_sc_hd__decap_6
XFILLER_0_117_641 vssd1 vssd1 vccd1 vccd1 sky130_ef_sc_hd__decap_12
X_08337_ _02310_ _02318_ _02317_ vssd1 vssd1 vccd1 vccd1 _02454_ sky130_fd_sc_hd__a21o_1
XFILLER_0_62_734 vssd1 vssd1 vccd1 vccd1 sky130_fd_sc_hd__decap_6
XFILLER_0_117_685 vssd1 vssd1 vccd1 vccd1 sky130_ef_sc_hd__decap_12
XFILLER_0_104_313 vssd1 vssd1 vccd1 vccd1 sky130_fd_sc_hd__decap_3
X_08268_ _02261_ net493 _02383_ _02385_ vssd1 vssd1 vccd1 vccd1 _02386_ sky130_fd_sc_hd__o211a_1
XFILLER_0_61_233 vssd1 vssd1 vccd1 vccd1 sky130_fd_sc_hd__fill_1
XFILLER_0_61_222 vssd1 vssd1 vccd1 vccd1 sky130_fd_sc_hd__fill_2
XFILLER_0_116_195 vssd1 vssd1 vccd1 vccd1 sky130_fd_sc_hd__fill_1
XFILLER_0_61_255 vssd1 vssd1 vccd1 vccd1 sky130_fd_sc_hd__decap_8
X_07219_ net806 net1129 _01342_ vssd1 vssd1 vccd1 vccd1 _01344_ sky130_fd_sc_hd__and3_1
XFILLER_0_21_108 vssd1 vssd1 vccd1 vccd1 sky130_fd_sc_hd__decap_4
X_08199_ _02311_ _02315_ _02316_ vssd1 vssd1 vccd1 vccd1 _02317_ sky130_fd_sc_hd__and3_1
X_10230_ net826 net817 net970 vssd1 vssd1 vccd1 vccd1 _04335_ sky130_fd_sc_hd__and3_1
XFILLER_0_30_675 vssd1 vssd1 vccd1 vccd1 sky130_fd_sc_hd__decap_4
X_10161_ _04244_ _04265_ vssd1 vssd1 vccd1 vccd1 _04266_ sky130_fd_sc_hd__nand2_1
Xoutput380 net380 vssd1 vssd1 vccd1 vccd1 mstream_o[37] sky130_fd_sc_hd__clkbuf_4
Xfanout1038 net1039 vssd1 vssd1 vccd1 vccd1 net1038 sky130_fd_sc_hd__clkbuf_2
Xfanout1016 net1017 vssd1 vssd1 vccd1 vccd1 net1016 sky130_fd_sc_hd__buf_2
X_10092_ _04195_ _04196_ _04035_ _04038_ vssd1 vssd1 vccd1 vccd1 _04198_ sky130_fd_sc_hd__o211a_1
Xfanout1005 net1006 vssd1 vssd1 vccd1 vccd1 net1005 sky130_fd_sc_hd__clkbuf_4
Xoutput391 net391 vssd1 vssd1 vccd1 vccd1 mstream_o[47] sky130_fd_sc_hd__clkbuf_4
Xfanout1027 net1030 vssd1 vssd1 vccd1 vccd1 net1027 sky130_fd_sc_hd__buf_2
Xfanout1049 net1056 vssd1 vssd1 vccd1 vccd1 net1049 sky130_fd_sc_hd__buf_2
XFILLER_0_97_642 vssd1 vssd1 vccd1 vccd1 sky130_fd_sc_hd__fill_1
X_10994_ _04961_ _05092_ vssd1 vssd1 vccd1 vccd1 _05093_ sky130_fd_sc_hd__nand2_1
X_12802_ clknet_leaf_56_clk_i _00188_ vssd1 vssd1 vccd1 vccd1 sub1.a_i\[1\] sky130_fd_sc_hd__dfxtp_1
XFILLER_0_69_388 vssd1 vssd1 vccd1 vccd1 sky130_fd_sc_hd__decap_4
XFILLER_0_69_377 vssd1 vssd1 vccd1 vccd1 sky130_fd_sc_hd__decap_3
XTAP_1031 vssd1 vccd1 sky130_fd_sc_hd__tapvpwrvgnd_1
XTAP_1020 vssd1 vccd1 sky130_fd_sc_hd__tapvpwrvgnd_1
X_12733_ clknet_leaf_26_clk_i _00119_ net1171 vssd1 vssd1 vccd1 vccd1 state\[2\] sky130_fd_sc_hd__dfrtp_4
XFILLER_0_96_174 vssd1 vssd1 vccd1 vccd1 sky130_fd_sc_hd__decap_8
XTAP_1064 vssd1 vccd1 sky130_fd_sc_hd__tapvpwrvgnd_1
XTAP_1053 vssd1 vccd1 sky130_fd_sc_hd__tapvpwrvgnd_1
XTAP_1042 vssd1 vccd1 sky130_fd_sc_hd__tapvpwrvgnd_1
XFILLER_0_32_27 vssd1 vssd1 vccd1 vccd1 sky130_fd_sc_hd__fill_1
XFILLER_0_65_561 vssd1 vssd1 vccd1 vccd1 sky130_fd_sc_hd__fill_2
X_12664_ clknet_leaf_20_clk_i net1514 net1177 vssd1 vssd1 vccd1 vccd1 net391 sky130_fd_sc_hd__dfrtp_1
XTAP_1097 vssd1 vccd1 sky130_fd_sc_hd__tapvpwrvgnd_1
XTAP_1086 vssd1 vccd1 sky130_fd_sc_hd__tapvpwrvgnd_1
XTAP_1075 vssd1 vccd1 sky130_fd_sc_hd__tapvpwrvgnd_1
XFILLER_0_127_449 vssd1 vssd1 vccd1 vccd1 sky130_ef_sc_hd__decap_12
X_12595_ net1495 net6 net557 vssd1 vssd1 vccd1 vccd1 _00570_ sky130_fd_sc_hd__mux2_1
X_11615_ _05704_ _05708_ vssd1 vssd1 vccd1 vccd1 _05709_ sky130_fd_sc_hd__xnor2_1
XFILLER_0_80_553 vssd1 vssd1 vccd1 vccd1 sky130_fd_sc_hd__decap_8
XFILLER_0_80_542 vssd1 vssd1 vccd1 vccd1 sky130_fd_sc_hd__fill_1
X_11546_ _05631_ _05640_ vssd1 vssd1 vccd1 vccd1 _05641_ sky130_fd_sc_hd__xnor2_1
XFILLER_0_25_447 vssd1 vssd1 vccd1 vccd1 sky130_fd_sc_hd__fill_1
XFILLER_0_122_121 vssd1 vssd1 vccd1 vccd1 sky130_ef_sc_hd__decap_12
XFILLER_0_80_586 vssd1 vssd1 vccd1 vccd1 sky130_fd_sc_hd__fill_2
XFILLER_0_40_417 vssd1 vssd1 vccd1 vccd1 sky130_fd_sc_hd__decap_3
XFILLER_0_122_165 vssd1 vssd1 vccd1 vccd1 sky130_ef_sc_hd__decap_12
X_11477_ net750 net742 net963 vssd1 vssd1 vccd1 vccd1 _05572_ sky130_fd_sc_hd__and3_1
XFILLER_0_40_428 vssd1 vssd1 vccd1 vccd1 sky130_fd_sc_hd__decap_4
X_10428_ net878 net867 net927 vssd1 vssd1 vccd1 vccd1 _04531_ sky130_fd_sc_hd__nand3_4
XFILLER_0_103_390 vssd1 vssd1 vccd1 vccd1 sky130_fd_sc_hd__fill_2
X_13147_ clknet_leaf_14_clk_i _00533_ net1185 vssd1 vssd1 vccd1 vccd1 l0\[8\] sky130_fd_sc_hd__dfrtp_1
X_10359_ _04461_ _04462_ _04344_ _04347_ vssd1 vssd1 vccd1 vccd1 _04463_ sky130_fd_sc_hd__o211a_1
XFILLER_0_57_24 vssd1 vssd1 vccd1 vccd1 sky130_ef_sc_hd__decap_12
XTAP_804 vssd1 vccd1 sky130_fd_sc_hd__tapvpwrvgnd_1
XTAP_815 vssd1 vccd1 sky130_fd_sc_hd__tapvpwrvgnd_1
XTAP_826 vssd1 vccd1 sky130_fd_sc_hd__tapvpwrvgnd_1
XFILLER_0_57_68 vssd1 vssd1 vccd1 vccd1 sky130_fd_sc_hd__decap_3
XTAP_837 vssd1 vccd1 sky130_fd_sc_hd__tapvpwrvgnd_1
XTAP_848 vssd1 vccd1 sky130_fd_sc_hd__tapvpwrvgnd_1
XTAP_859 vssd1 vccd1 sky130_fd_sc_hd__tapvpwrvgnd_1
X_13078_ clknet_leaf_0_clk_i _00464_ vssd1 vssd1 vccd1 vccd1 temp1\[3\] sky130_fd_sc_hd__dfxtp_2
X_12029_ net1630 _06026_ net483 vssd1 vssd1 vccd1 vccd1 _00250_ sky130_fd_sc_hd__mux2_1
XFILLER_0_79_119 vssd1 vssd1 vccd1 vccd1 sky130_fd_sc_hd__fill_1
XFILLER_0_88_642 vssd1 vssd1 vccd1 vccd1 sky130_fd_sc_hd__fill_2
X_07570_ _01347_ _01348_ vssd1 vssd1 vccd1 vccd1 _01694_ sky130_fd_sc_hd__nor2_1
X_06521_ det_t\[31\] net530 vssd1 vssd1 vccd1 vccd1 net293 sky130_fd_sc_hd__and2_1
XFILLER_0_87_163 vssd1 vssd1 vccd1 vccd1 sky130_fd_sc_hd__fill_1
XFILLER_0_48_517 vssd1 vssd1 vccd1 vccd1 sky130_fd_sc_hd__decap_3
XFILLER_0_88_697 vssd1 vssd1 vccd1 vccd1 sky130_fd_sc_hd__decap_3
XFILLER_0_75_347 vssd1 vssd1 vccd1 vccd1 sky130_fd_sc_hd__decap_3
X_09240_ _03348_ _03349_ _03350_ vssd1 vssd1 vccd1 vccd1 _03351_ sky130_fd_sc_hd__and3_1
X_06452_ add1.a_i\[26\] add1.b_i\[26\] vssd1 vssd1 vccd1 vccd1 _00751_ sky130_fd_sc_hd__nand2_1
XFILLER_0_29_742 vssd1 vssd1 vccd1 vccd1 sky130_fd_sc_hd__fill_2
XFILLER_0_113_51 vssd1 vssd1 vccd1 vccd1 sky130_fd_sc_hd__decap_4
X_09171_ net1124 net720 _03129_ _03128_ vssd1 vssd1 vccd1 vccd1 _03282_ sky130_fd_sc_hd__a31o_1
X_06383_ _00684_ _00687_ _00690_ vssd1 vssd1 vccd1 vccd1 _00692_ sky130_fd_sc_hd__and3_1
XFILLER_0_126_460 vssd1 vssd1 vccd1 vccd1 sky130_ef_sc_hd__decap_12
X_08122_ net898 net889 net1001 net994 vssd1 vssd1 vccd1 vccd1 _02241_ sky130_fd_sc_hd__nand4_1
XFILLER_0_98_53 vssd1 vssd1 vccd1 vccd1 sky130_ef_sc_hd__decap_12
X_08053_ _02171_ vssd1 vssd1 vccd1 vccd1 _02172_ sky130_fd_sc_hd__inv_2
X_07004_ _01123_ _01126_ _01127_ vssd1 vssd1 vccd1 vccd1 _01129_ sky130_fd_sc_hd__or3_1
XFILLER_0_114_699 vssd1 vssd1 vccd1 vccd1 sky130_fd_sc_hd__fill_1
XFILLER_0_12_653 vssd1 vssd1 vccd1 vccd1 sky130_fd_sc_hd__fill_2
X_08955_ net916 net944 net939 net924 vssd1 vssd1 vccd1 vccd1 _03068_ sky130_fd_sc_hd__a22o_1
Xinput108 v0y[26] vssd1 vssd1 vccd1 vccd1 net108 sky130_fd_sc_hd__buf_1
X_07906_ _01914_ _01915_ _01916_ vssd1 vssd1 vccd1 vccd1 _02027_ sky130_fd_sc_hd__a21bo_1
Xinput119 v0y[7] vssd1 vssd1 vccd1 vccd1 net119 sky130_fd_sc_hd__buf_1
X_08886_ net1069 net773 net764 net1076 vssd1 vssd1 vccd1 vccd1 _02999_ sky130_fd_sc_hd__a22oi_1
X_07837_ net1132 net772 net763 net1139 vssd1 vssd1 vccd1 vccd1 _01958_ sky130_fd_sc_hd__a22o_1
X_07768_ _01887_ _01888_ _01889_ vssd1 vssd1 vccd1 vccd1 _01890_ sky130_fd_sc_hd__nand3_1
X_09507_ net1100 net719 vssd1 vssd1 vccd1 vccd1 _03616_ sky130_fd_sc_hd__nand2_1
XFILLER_0_78_141 vssd1 vssd1 vccd1 vccd1 sky130_fd_sc_hd__fill_2
X_06719_ _00930_ _00933_ vssd1 vssd1 vccd1 vccd1 _00939_ sky130_fd_sc_hd__or2_2
XFILLER_0_93_100 vssd1 vssd1 vccd1 vccd1 sky130_ef_sc_hd__decap_12
XFILLER_0_79_697 vssd1 vssd1 vccd1 vccd1 sky130_fd_sc_hd__fill_1
XPHY_125 vssd1 vssd1 vccd1 vccd1 sky130_fd_sc_hd__decap_3
XPHY_114 vssd1 vssd1 vccd1 vccd1 sky130_fd_sc_hd__decap_3
X_07699_ net920 net912 net1010 net1001 vssd1 vssd1 vccd1 vccd1 _01822_ sky130_fd_sc_hd__nand4_1
XPHY_103 vssd1 vssd1 vccd1 vccd1 sky130_fd_sc_hd__decap_3
XPHY_158 vssd1 vssd1 vccd1 vccd1 sky130_fd_sc_hd__decap_3
XPHY_147 vssd1 vssd1 vccd1 vccd1 sky130_fd_sc_hd__decap_3
XPHY_136 vssd1 vssd1 vccd1 vccd1 sky130_fd_sc_hd__decap_3
X_09438_ _03546_ _03547_ _03539_ vssd1 vssd1 vccd1 vccd1 _03548_ sky130_fd_sc_hd__a21o_1
X_09369_ net1054 net767 _03474_ _03476_ vssd1 vssd1 vccd1 vccd1 _03479_ sky130_fd_sc_hd__a22o_1
XFILLER_0_93_199 vssd1 vssd1 vccd1 vccd1 sky130_fd_sc_hd__fill_2
XPHY_169 vssd1 vssd1 vccd1 vccd1 sky130_fd_sc_hd__decap_3
XFILLER_0_124_419 vssd1 vssd1 vccd1 vccd1 sky130_fd_sc_hd__fill_1
X_12380_ net1464 _00823_ net682 vssd1 vssd1 vccd1 vccd1 _00432_ sky130_fd_sc_hd__mux2_1
XFILLER_0_34_222 vssd1 vssd1 vccd1 vccd1 sky130_fd_sc_hd__fill_2
X_11400_ _05335_ _05338_ _05494_ _05495_ vssd1 vssd1 vccd1 vccd1 _05496_ sky130_fd_sc_hd__a211oi_2
XFILLER_0_104_121 vssd1 vssd1 vccd1 vccd1 sky130_ef_sc_hd__decap_12
XFILLER_0_62_564 vssd1 vssd1 vccd1 vccd1 sky130_ef_sc_hd__decap_12
X_11331_ _05387_ _05425_ _05427_ vssd1 vssd1 vccd1 vccd1 _05428_ sky130_fd_sc_hd__or3b_4
XANTENNA_70 net553 vssd1 vssd1 vccd1 vccd1 sky130_fd_sc_hd__diode_2
XFILLER_0_34_277 vssd1 vssd1 vccd1 vccd1 sky130_fd_sc_hd__decap_3
XFILLER_0_120_625 vssd1 vssd1 vccd1 vccd1 sky130_ef_sc_hd__decap_12
X_11262_ _05349_ _05357_ vssd1 vssd1 vccd1 vccd1 _05359_ sky130_fd_sc_hd__or2_1
XFILLER_0_120_669 vssd1 vssd1 vccd1 vccd1 sky130_ef_sc_hd__decap_12
X_10213_ net884 net932 _04175_ _04173_ vssd1 vssd1 vccd1 vccd1 _04318_ sky130_fd_sc_hd__a31o_1
X_13001_ clknet_leaf_33_clk_i _00387_ net1167 vssd1 vssd1 vccd1 vccd1 x2mx1\[22\]
+ sky130_fd_sc_hd__dfrtp_1
X_11193_ _05289_ _05290_ vssd1 vssd1 vccd1 vccd1 _05291_ sky130_fd_sc_hd__and2_1
X_10144_ net1055 net1064 net732 net725 vssd1 vssd1 vccd1 vccd1 _04249_ sky130_fd_sc_hd__nand4_2
XFILLER_0_118_29 vssd1 vssd1 vccd1 vccd1 sky130_ef_sc_hd__decap_12
X_10075_ _04178_ _04179_ _04180_ vssd1 vssd1 vccd1 vccd1 _04181_ sky130_fd_sc_hd__and3_1
XFILLER_0_89_406 vssd1 vssd1 vccd1 vccd1 sky130_ef_sc_hd__decap_12
XFILLER_0_57_303 vssd1 vssd1 vccd1 vccd1 sky130_fd_sc_hd__decap_6
XFILLER_0_43_37 vssd1 vssd1 vccd1 vccd1 sky130_ef_sc_hd__decap_12
X_10977_ _04944_ _04947_ _05075_ vssd1 vssd1 vccd1 vccd1 _05077_ sky130_fd_sc_hd__a21o_1
XFILLER_0_69_185 vssd1 vssd1 vccd1 vccd1 sky130_fd_sc_hd__fill_1
XPHY_5 vssd1 vssd1 vccd1 vccd1 sky130_fd_sc_hd__decap_3
X_12716_ clknet_leaf_9_clk_i _00102_ net1191 vssd1 vssd1 vccd1 vccd1 net448 sky130_fd_sc_hd__dfrtp_1
XFILLER_0_72_328 vssd1 vssd1 vccd1 vccd1 sky130_fd_sc_hd__decap_4
X_12647_ clknet_leaf_22_clk_i _00033_ net1173 vssd1 vssd1 vccd1 vccd1 net373 sky130_fd_sc_hd__dfrtp_1
XFILLER_0_38_572 vssd1 vssd1 vccd1 vccd1 sky130_fd_sc_hd__decap_3
XFILLER_0_4_105 vssd1 vssd1 vccd1 vccd1 sky130_fd_sc_hd__fill_2
XFILLER_0_108_493 vssd1 vssd1 vccd1 vccd1 sky130_fd_sc_hd__decap_6
X_12578_ net1542 net23 net561 vssd1 vssd1 vccd1 vccd1 _00554_ sky130_fd_sc_hd__mux2_1
XFILLER_0_13_406 vssd1 vssd1 vccd1 vccd1 sky130_fd_sc_hd__decap_4
XFILLER_0_25_255 vssd1 vssd1 vccd1 vccd1 sky130_fd_sc_hd__decap_4
XFILLER_0_123_441 vssd1 vssd1 vccd1 vccd1 sky130_fd_sc_hd__decap_6
X_11529_ _05620_ _05623_ vssd1 vssd1 vccd1 vccd1 _05624_ sky130_fd_sc_hd__xnor2_1
Xhold307 l1\[5\] vssd1 vssd1 vccd1 vccd1 net1522 sky130_fd_sc_hd__dlygate4sd3_1
XFILLER_0_123_485 vssd1 vssd1 vccd1 vccd1 sky130_ef_sc_hd__decap_12
Xhold318 net428 vssd1 vssd1 vccd1 vccd1 net1533 sky130_fd_sc_hd__dlygate4sd3_1
Xhold329 add1.a_i\[19\] vssd1 vssd1 vccd1 vccd1 net1544 sky130_fd_sc_hd__dlygate4sd3_1
Xfanout809 net810 vssd1 vssd1 vccd1 vccd1 net809 sky130_fd_sc_hd__clkbuf_4
XTAP_601 vssd1 vccd1 sky130_fd_sc_hd__tapvpwrvgnd_1
XTAP_612 vssd1 vccd1 sky130_fd_sc_hd__tapvpwrvgnd_1
XTAP_623 vssd1 vccd1 sky130_fd_sc_hd__tapvpwrvgnd_1
XTAP_634 vssd1 vccd1 sky130_fd_sc_hd__tapvpwrvgnd_1
XTAP_645 vssd1 vccd1 sky130_fd_sc_hd__tapvpwrvgnd_1
XTAP_656 vssd1 vccd1 sky130_fd_sc_hd__tapvpwrvgnd_1
XTAP_667 vssd1 vccd1 sky130_fd_sc_hd__tapvpwrvgnd_1
X_08740_ _02852_ net734 net1115 _02851_ vssd1 vssd1 vccd1 vccd1 _02854_ sky130_fd_sc_hd__and4b_1
XTAP_689 vssd1 vccd1 sky130_fd_sc_hd__tapvpwrvgnd_1
XTAP_678 vssd1 vccd1 sky130_fd_sc_hd__tapvpwrvgnd_1
X_08671_ _02784_ _02785_ _02767_ vssd1 vssd1 vccd1 vccd1 _02786_ sky130_fd_sc_hd__a21oi_2
X_07622_ _01743_ _01744_ _01682_ vssd1 vssd1 vccd1 vccd1 _01746_ sky130_fd_sc_hd__o21ba_1
XFILLER_0_76_601 vssd1 vssd1 vccd1 vccd1 sky130_fd_sc_hd__decap_4
XFILLER_0_17_93 vssd1 vssd1 vccd1 vccd1 sky130_fd_sc_hd__decap_3
XFILLER_0_76_645 vssd1 vssd1 vccd1 vccd1 sky130_fd_sc_hd__decap_3
X_07553_ _01675_ _01676_ vssd1 vssd1 vccd1 vccd1 _01677_ sky130_fd_sc_hd__and2b_1
X_06504_ det_t\[14\] net527 vssd1 vssd1 vccd1 vccd1 net257 sky130_fd_sc_hd__and2_1
XFILLER_0_124_83 vssd1 vssd1 vccd1 vccd1 sky130_fd_sc_hd__fill_1
XFILLER_0_75_144 vssd1 vssd1 vccd1 vccd1 sky130_ef_sc_hd__decap_12
X_07484_ _01607_ _01608_ vssd1 vssd1 vccd1 vccd1 _01609_ sky130_fd_sc_hd__nand2_1
XFILLER_0_90_103 vssd1 vssd1 vccd1 vccd1 sky130_fd_sc_hd__fill_1
X_09223_ _03330_ _03331_ vssd1 vssd1 vccd1 vccd1 _03334_ sky130_fd_sc_hd__xor2_1
X_06435_ add1.a_i\[22\] add1.b_i\[22\] _00731_ vssd1 vssd1 vccd1 vccd1 _00737_ sky130_fd_sc_hd__a21oi_4
XFILLER_0_29_561 vssd1 vssd1 vccd1 vccd1 sky130_fd_sc_hd__decap_3
XFILLER_0_106_408 vssd1 vssd1 vccd1 vccd1 sky130_ef_sc_hd__decap_12
X_09154_ _03114_ _03257_ _03255_ vssd1 vssd1 vccd1 vccd1 _03265_ sky130_fd_sc_hd__a21oi_4
XFILLER_0_56_391 vssd1 vssd1 vccd1 vccd1 sky130_fd_sc_hd__decap_3
X_06366_ net544 _00677_ vssd1 vssd1 vccd1 vccd1 net310 sky130_fd_sc_hd__nor2_1
XFILLER_0_127_780 vssd1 vssd1 vccd1 vccd1 sky130_fd_sc_hd__decap_4
X_08105_ _02122_ _02124_ _02223_ vssd1 vssd1 vccd1 vccd1 _02224_ sky130_fd_sc_hd__a21o_2
X_09085_ net835 net1002 _03195_ _03196_ vssd1 vssd1 vccd1 vccd1 _03197_ sky130_fd_sc_hd__nand4_2
XFILLER_0_71_372 vssd1 vssd1 vccd1 vccd1 sky130_ef_sc_hd__decap_12
X_06297_ _00589_ _00610_ vssd1 vssd1 vccd1 vccd1 _00611_ sky130_fd_sc_hd__or2_1
XFILLER_0_102_625 vssd1 vssd1 vccd1 vccd1 sky130_fd_sc_hd__fill_1
XFILLER_0_101_113 vssd1 vssd1 vccd1 vccd1 sky130_fd_sc_hd__fill_2
X_08036_ _02043_ _02045_ net461 _02155_ vssd1 vssd1 vccd1 vccd1 _02156_ sky130_fd_sc_hd__a211oi_1
Xinput90 v0y[0] vssd1 vssd1 vccd1 vccd1 net90 sky130_fd_sc_hd__buf_1
X_09987_ _03955_ _03958_ _03956_ vssd1 vssd1 vccd1 vccd1 _04093_ sky130_fd_sc_hd__o21bai_1
X_08938_ _02910_ _02911_ vssd1 vssd1 vccd1 vccd1 _03051_ sky130_fd_sc_hd__nor2_1
X_08869_ _02979_ _02981_ _02833_ _02835_ vssd1 vssd1 vccd1 vccd1 _02982_ sky130_fd_sc_hd__o211a_1
X_10900_ _04873_ _04875_ vssd1 vssd1 vccd1 vccd1 _05000_ sky130_fd_sc_hd__or2_1
XFILLER_0_98_258 vssd1 vssd1 vccd1 vccd1 sky130_fd_sc_hd__decap_4
X_11880_ net653 _00960_ net476 _05912_ vssd1 vssd1 vccd1 vccd1 _05913_ sky130_fd_sc_hd__a211o_1
X_10831_ _04930_ _04931_ _04914_ vssd1 vssd1 vccd1 vccd1 _04932_ sky130_fd_sc_hd__o21a_1
X_10762_ _04861_ _04862_ vssd1 vssd1 vccd1 vccd1 _04863_ sky130_fd_sc_hd__nand2b_1
X_12501_ _00794_ net563 _06247_ vssd1 vssd1 vccd1 vccd1 _00501_ sky130_fd_sc_hd__o21ai_1
X_10693_ _04748_ _04749_ _04793_ _04794_ vssd1 vssd1 vccd1 vccd1 _04795_ sky130_fd_sc_hd__nor4_1
XFILLER_0_35_531 vssd1 vssd1 vccd1 vccd1 sky130_fd_sc_hd__decap_3
X_12432_ temp1\[10\] _06208_ net570 vssd1 vssd1 vccd1 vccd1 _00471_ sky130_fd_sc_hd__mux2_1
XFILLER_0_124_227 vssd1 vssd1 vccd1 vccd1 sky130_fd_sc_hd__fill_2
XFILLER_0_81_169 vssd1 vssd1 vccd1 vccd1 sky130_fd_sc_hd__fill_1
X_12363_ net1435 _00903_ net660 vssd1 vssd1 vccd1 vccd1 _00415_ sky130_fd_sc_hd__mux2_1
XFILLER_0_22_225 vssd1 vssd1 vccd1 vccd1 sky130_fd_sc_hd__fill_2
XFILLER_0_50_545 vssd1 vssd1 vccd1 vccd1 sky130_fd_sc_hd__decap_6
X_11314_ _05409_ _05410_ vssd1 vssd1 vccd1 vccd1 _05411_ sky130_fd_sc_hd__nor2_1
X_12294_ net1644 _00877_ net675 vssd1 vssd1 vccd1 vccd1 _00346_ sky130_fd_sc_hd__mux2_1
XFILLER_0_120_433 vssd1 vssd1 vccd1 vccd1 sky130_ef_sc_hd__decap_12
XFILLER_0_50_589 vssd1 vssd1 vccd1 vccd1 sky130_fd_sc_hd__decap_4
X_11245_ _04954_ _05220_ _05340_ vssd1 vssd1 vccd1 vccd1 _05342_ sky130_fd_sc_hd__nor3_1
XFILLER_0_120_477 vssd1 vssd1 vccd1 vccd1 sky130_ef_sc_hd__decap_12
XFILLER_0_38_15 vssd1 vssd1 vccd1 vccd1 sky130_fd_sc_hd__fill_2
X_11176_ _05270_ _05271_ _05273_ vssd1 vssd1 vccd1 vccd1 _05274_ sky130_fd_sc_hd__or3b_1
XFILLER_0_38_59 vssd1 vssd1 vccd1 vccd1 sky130_fd_sc_hd__decap_8
X_10127_ _04073_ _04074_ _04230_ _04231_ vssd1 vssd1 vccd1 vccd1 _04232_ sky130_fd_sc_hd__o211a_1
XFILLER_0_89_203 vssd1 vssd1 vccd1 vccd1 sky130_fd_sc_hd__fill_2
X_10058_ net833 net964 _04161_ _04162_ vssd1 vssd1 vccd1 vccd1 _04164_ sky130_fd_sc_hd__a22o_1
XFILLER_0_58_645 vssd1 vssd1 vccd1 vccd1 sky130_fd_sc_hd__decap_4
XFILLER_0_128_533 vssd1 vssd1 vccd1 vccd1 sky130_ef_sc_hd__decap_12
XFILLER_0_115_205 vssd1 vssd1 vccd1 vccd1 sky130_ef_sc_hd__decap_12
XFILLER_0_73_659 vssd1 vssd1 vccd1 vccd1 sky130_fd_sc_hd__fill_1
XFILLER_0_38_391 vssd1 vssd1 vccd1 vccd1 sky130_fd_sc_hd__fill_2
XFILLER_0_92_9 vssd1 vssd1 vccd1 vccd1 sky130_ef_sc_hd__decap_12
XFILLER_0_5_447 vssd1 vssd1 vccd1 vccd1 sky130_fd_sc_hd__fill_1
XFILLER_0_115_249 vssd1 vssd1 vccd1 vccd1 sky130_ef_sc_hd__decap_12
XFILLER_0_79_33 vssd1 vssd1 vccd1 vccd1 sky130_ef_sc_hd__decap_12
XFILLER_0_53_383 vssd1 vssd1 vccd1 vccd1 sky130_fd_sc_hd__fill_1
XFILLER_0_13_214 vssd1 vssd1 vccd1 vccd1 sky130_fd_sc_hd__decap_6
XFILLER_0_13_225 vssd1 vssd1 vccd1 vccd1 sky130_fd_sc_hd__fill_1
XFILLER_0_41_523 vssd1 vssd1 vccd1 vccd1 sky130_fd_sc_hd__fill_1
XFILLER_0_110_41 vssd1 vssd1 vccd1 vccd1 sky130_ef_sc_hd__decap_12
Xhold126 posy\[1\] vssd1 vssd1 vccd1 vccd1 net1341 sky130_fd_sc_hd__dlygate4sd3_1
Xhold104 sub1.a_i\[2\] vssd1 vssd1 vccd1 vccd1 net1319 sky130_fd_sc_hd__dlygate4sd3_1
Xhold115 sub1.b_i\[18\] vssd1 vssd1 vccd1 vccd1 net1330 sky130_fd_sc_hd__dlygate4sd3_1
XFILLER_0_13_258 vssd1 vssd1 vccd1 vccd1 sky130_fd_sc_hd__fill_2
XFILLER_0_110_85 vssd1 vssd1 vccd1 vccd1 sky130_ef_sc_hd__decap_12
Xhold148 net446 vssd1 vssd1 vccd1 vccd1 net1363 sky130_fd_sc_hd__dlygate4sd3_1
X_09910_ _04016_ _04015_ _04014_ vssd1 vssd1 vccd1 vccd1 _04017_ sky130_fd_sc_hd__nand3b_1
Xhold159 sub1.a_i\[20\] vssd1 vssd1 vccd1 vccd1 net1374 sky130_fd_sc_hd__dlygate4sd3_1
Xhold137 sub1.b_i\[16\] vssd1 vssd1 vccd1 vccd1 net1352 sky130_fd_sc_hd__dlygate4sd3_1
XFILLER_0_0_141 vssd1 vssd1 vccd1 vccd1 sky130_fd_sc_hd__fill_2
Xfanout606 _00996_ vssd1 vssd1 vccd1 vccd1 net606 sky130_fd_sc_hd__buf_2
X_09841_ _03945_ _03946_ vssd1 vssd1 vccd1 vccd1 _03948_ sky130_fd_sc_hd__xnor2_4
Xfanout639 net640 vssd1 vssd1 vccd1 vccd1 net639 sky130_fd_sc_hd__clkbuf_2
XTAP_431 vssd1 vccd1 sky130_fd_sc_hd__tapvpwrvgnd_1
XTAP_420 vssd1 vccd1 sky130_fd_sc_hd__tapvpwrvgnd_1
Xfanout628 net630 vssd1 vssd1 vccd1 vccd1 net628 sky130_fd_sc_hd__buf_4
XTAP_442 vssd1 vccd1 sky130_fd_sc_hd__tapvpwrvgnd_1
Xfanout617 net618 vssd1 vssd1 vccd1 vccd1 net617 sky130_fd_sc_hd__clkbuf_4
X_09772_ _03703_ _03721_ _03720_ vssd1 vssd1 vccd1 vccd1 _03880_ sky130_fd_sc_hd__a21bo_2
XTAP_453 vssd1 vccd1 sky130_fd_sc_hd__tapvpwrvgnd_1
XTAP_464 vssd1 vccd1 sky130_fd_sc_hd__tapvpwrvgnd_1
XTAP_475 vssd1 vccd1 sky130_fd_sc_hd__tapvpwrvgnd_1
X_06984_ _01106_ _01107_ _01108_ vssd1 vssd1 vccd1 vccd1 _01109_ sky130_fd_sc_hd__nand3_1
X_08723_ _02825_ _02836_ vssd1 vssd1 vccd1 vccd1 _02837_ sky130_fd_sc_hd__or2_1
XTAP_497 vssd1 vccd1 sky130_fd_sc_hd__tapvpwrvgnd_1
XTAP_486 vssd1 vccd1 sky130_fd_sc_hd__tapvpwrvgnd_1
XFILLER_0_21_3 vssd1 vssd1 vccd1 vccd1 sky130_ef_sc_hd__decap_12
X_08654_ net894 net973 net967 net903 vssd1 vssd1 vccd1 vccd1 _02769_ sky130_fd_sc_hd__a22o_1
X_08585_ net1107 net749 net740 net1114 vssd1 vssd1 vccd1 vccd1 _02700_ sky130_fd_sc_hd__a22oi_1
XTAP_1619 vssd1 vccd1 sky130_fd_sc_hd__tapvpwrvgnd_1
XTAP_1608 vssd1 vccd1 sky130_fd_sc_hd__tapvpwrvgnd_1
X_07605_ _01727_ _01728_ _01720_ vssd1 vssd1 vccd1 vccd1 _01729_ sky130_fd_sc_hd__a21o_1
X_07536_ _01511_ _01547_ vssd1 vssd1 vccd1 vccd1 _01661_ sky130_fd_sc_hd__nand2b_1
XFILLER_0_91_401 vssd1 vssd1 vccd1 vccd1 sky130_fd_sc_hd__decap_4
X_09206_ _03314_ _03315_ _03159_ _03160_ vssd1 vssd1 vccd1 vccd1 _03317_ sky130_fd_sc_hd__a211o_1
XFILLER_0_91_445 vssd1 vssd1 vccd1 vccd1 sky130_fd_sc_hd__decap_3
XFILLER_0_9_764 vssd1 vssd1 vccd1 vccd1 sky130_fd_sc_hd__fill_1
X_07467_ net917 net1112 net1119 net909 vssd1 vssd1 vccd1 vccd1 _01592_ sky130_fd_sc_hd__a22oi_2
X_06418_ _00721_ vssd1 vssd1 vccd1 vccd1 _00722_ sky130_fd_sc_hd__inv_2
XFILLER_0_9_797 vssd1 vssd1 vccd1 vccd1 sky130_ef_sc_hd__decap_12
X_07398_ net895 net1111 net1119 net887 vssd1 vssd1 vccd1 vccd1 _01523_ sky130_fd_sc_hd__a22o_1
X_09137_ _03187_ _03188_ _03245_ _03246_ vssd1 vssd1 vccd1 vccd1 _03249_ sky130_fd_sc_hd__o22ai_2
XFILLER_0_60_810 vssd1 vssd1 vccd1 vccd1 sky130_fd_sc_hd__fill_2
X_06349_ _00658_ _00660_ _00638_ vssd1 vssd1 vccd1 vccd1 _00661_ sky130_fd_sc_hd__a21oi_1
XFILLER_0_115_794 vssd1 vssd1 vccd1 vccd1 sky130_fd_sc_hd__decap_4
X_09068_ _03178_ _03179_ vssd1 vssd1 vccd1 vccd1 _03180_ sky130_fd_sc_hd__and2b_1
XFILLER_0_130_753 vssd1 vssd1 vccd1 vccd1 sky130_fd_sc_hd__decap_3
X_08019_ _02130_ _02137_ _02138_ vssd1 vssd1 vccd1 vccd1 _02139_ sky130_fd_sc_hd__nand3_2
XFILLER_0_102_477 vssd1 vssd1 vccd1 vccd1 sky130_fd_sc_hd__decap_6
X_11030_ _05007_ _05009_ _05128_ vssd1 vssd1 vccd1 vccd1 _05129_ sky130_fd_sc_hd__a21o_1
X_12981_ clknet_leaf_48_clk_i _00367_ net1159 vssd1 vssd1 vccd1 vccd1 x2mx1\[2\] sky130_fd_sc_hd__dfrtp_1
XFILLER_0_87_729 vssd1 vssd1 vccd1 vccd1 sky130_ef_sc_hd__decap_12
X_11932_ net151 net659 net502 net247 _05953_ vssd1 vssd1 vccd1 vccd1 _05954_ sky130_fd_sc_hd__a221o_1
X_11863_ net171 net471 _05898_ vssd1 vssd1 vccd1 vccd1 _05899_ sky130_fd_sc_hd__o21a_1
X_10814_ _04773_ _04775_ vssd1 vssd1 vccd1 vccd1 _04915_ sky130_fd_sc_hd__or2_1
XFILLER_0_39_122 vssd1 vssd1 vccd1 vccd1 sky130_fd_sc_hd__decap_4
XFILLER_0_54_103 vssd1 vssd1 vccd1 vccd1 sky130_fd_sc_hd__fill_1
X_11794_ net160 net470 _05839_ vssd1 vssd1 vccd1 vccd1 _05840_ sky130_fd_sc_hd__o21a_1
XFILLER_0_39_166 vssd1 vssd1 vccd1 vccd1 sky130_fd_sc_hd__fill_2
XFILLER_0_125_503 vssd1 vssd1 vccd1 vccd1 sky130_fd_sc_hd__fill_1
X_10745_ _04843_ _04844_ _04835_ vssd1 vssd1 vccd1 vccd1 _04846_ sky130_fd_sc_hd__a21o_1
XFILLER_0_82_467 vssd1 vssd1 vccd1 vccd1 sky130_fd_sc_hd__decap_8
X_10676_ _04772_ _04777_ vssd1 vssd1 vccd1 vccd1 _04778_ sky130_fd_sc_hd__or2_1
XFILLER_0_40_49 vssd1 vssd1 vccd1 vccd1 sky130_fd_sc_hd__fill_2
XFILLER_0_113_709 vssd1 vssd1 vccd1 vccd1 sky130_ef_sc_hd__decap_12
X_12415_ _00818_ net613 _01853_ net575 vssd1 vssd1 vccd1 vccd1 _06200_ sky130_fd_sc_hd__a22o_1
X_12346_ net1499 _00813_ net657 vssd1 vssd1 vccd1 vccd1 _00398_ sky130_fd_sc_hd__mux2_1
XFILLER_0_23_545 vssd1 vssd1 vccd1 vccd1 sky130_fd_sc_hd__decap_8
XFILLER_0_121_753 vssd1 vssd1 vccd1 vccd1 sky130_ef_sc_hd__decap_12
X_12277_ net55 net691 vssd1 vssd1 vccd1 vccd1 _06194_ sky130_fd_sc_hd__and2_2
XFILLER_0_121_797 vssd1 vssd1 vccd1 vccd1 sky130_ef_sc_hd__decap_12
X_11228_ _05317_ _05197_ _05198_ vssd1 vssd1 vccd1 vccd1 _05325_ sky130_fd_sc_hd__or3b_1
X_11159_ _05253_ _05254_ _05241_ vssd1 vssd1 vccd1 vccd1 _05257_ sky130_fd_sc_hd__a21oi_1
XFILLER_0_4_27 vssd1 vssd1 vccd1 vccd1 sky130_fd_sc_hd__fill_1
X_08370_ net886 net1000 _02361_ _02362_ net986 vssd1 vssd1 vccd1 vccd1 _02487_ sky130_fd_sc_hd__a32o_1
XFILLER_0_92_209 vssd1 vssd1 vccd1 vccd1 sky130_ef_sc_hd__decap_12
XFILLER_0_81_89 vssd1 vssd1 vccd1 vccd1 sky130_fd_sc_hd__decap_8
X_07321_ _01429_ _01436_ _01444_ vssd1 vssd1 vccd1 vccd1 _01446_ sky130_fd_sc_hd__and3_1
XFILLER_0_14_83 vssd1 vssd1 vccd1 vccd1 sky130_fd_sc_hd__fill_1
XFILLER_0_116_525 vssd1 vssd1 vccd1 vccd1 sky130_fd_sc_hd__decap_6
X_07252_ _01375_ _01376_ _01374_ vssd1 vssd1 vccd1 vccd1 _01377_ sky130_fd_sc_hd__a21o_1
XFILLER_0_33_309 vssd1 vssd1 vccd1 vccd1 sky130_fd_sc_hd__decap_3
XFILLER_0_121_51 vssd1 vssd1 vccd1 vccd1 sky130_fd_sc_hd__decap_4
XFILLER_0_116_569 vssd1 vssd1 vccd1 vccd1 sky130_ef_sc_hd__decap_12
X_07183_ _01062_ _01063_ vssd1 vssd1 vccd1 vccd1 _01308_ sky130_fd_sc_hd__xnor2_1
XFILLER_0_103_219 vssd1 vssd1 vccd1 vccd1 sky130_fd_sc_hd__fill_2
XFILLER_0_5_288 vssd1 vssd1 vccd1 vccd1 sky130_fd_sc_hd__fill_1
XFILLER_0_69_3 vssd1 vssd1 vccd1 vccd1 sky130_ef_sc_hd__decap_12
XFILLER_0_10_751 vssd1 vssd1 vccd1 vccd1 sky130_fd_sc_hd__fill_2
X_09824_ _03778_ _03780_ vssd1 vssd1 vccd1 vccd1 _03931_ sky130_fd_sc_hd__nand2_1
XFILLER_0_10_795 vssd1 vssd1 vccd1 vccd1 sky130_ef_sc_hd__decap_12
Xfanout469 _06129_ vssd1 vssd1 vccd1 vccd1 net469 sky130_fd_sc_hd__buf_2
XTAP_272 vssd1 vccd1 sky130_fd_sc_hd__tapvpwrvgnd_1
XTAP_283 vssd1 vccd1 sky130_fd_sc_hd__tapvpwrvgnd_1
X_09755_ _03861_ _03862_ vssd1 vssd1 vccd1 vccd1 _03863_ sky130_fd_sc_hd__and2b_1
XTAP_294 vssd1 vccd1 sky130_fd_sc_hd__tapvpwrvgnd_1
X_06967_ net881 net1090 vssd1 vssd1 vccd1 vccd1 _01092_ sky130_fd_sc_hd__nand2_1
XTAP_2117 vssd1 vccd1 sky130_fd_sc_hd__tapvpwrvgnd_1
XTAP_2106 vssd1 vccd1 sky130_fd_sc_hd__tapvpwrvgnd_1
X_09686_ _03793_ _03754_ vssd1 vssd1 vccd1 vccd1 _03794_ sky130_fd_sc_hd__and2b_1
X_08706_ net1311 _02820_ net522 vssd1 vssd1 vccd1 vccd1 _00133_ sky130_fd_sc_hd__mux2_1
X_06898_ net880 net1095 _01021_ _01019_ vssd1 vssd1 vccd1 vccd1 _01023_ sky130_fd_sc_hd__a31o_1
XTAP_2139 vssd1 vccd1 sky130_fd_sc_hd__tapvpwrvgnd_1
XTAP_2128 vssd1 vccd1 sky130_fd_sc_hd__tapvpwrvgnd_1
X_08637_ _02624_ _02626_ _02751_ vssd1 vssd1 vccd1 vccd1 _02752_ sky130_fd_sc_hd__a21o_2
XTAP_1405 vssd1 vccd1 sky130_fd_sc_hd__tapvpwrvgnd_1
XFILLER_0_69_729 vssd1 vssd1 vccd1 vccd1 sky130_ef_sc_hd__decap_12
XTAP_1438 vssd1 vccd1 sky130_fd_sc_hd__tapvpwrvgnd_1
XTAP_1427 vssd1 vccd1 sky130_fd_sc_hd__tapvpwrvgnd_1
XTAP_1416 vssd1 vccd1 sky130_fd_sc_hd__tapvpwrvgnd_1
X_08568_ _02679_ _02680_ _02681_ vssd1 vssd1 vccd1 vccd1 _02683_ sky130_fd_sc_hd__a21bo_1
XTAP_1449 vssd1 vccd1 sky130_fd_sc_hd__tapvpwrvgnd_1
XFILLER_0_37_615 vssd1 vssd1 vccd1 vccd1 sky130_fd_sc_hd__fill_1
XFILLER_0_92_743 vssd1 vssd1 vccd1 vccd1 sky130_ef_sc_hd__decap_12
X_08499_ _02596_ _02612_ _02613_ vssd1 vssd1 vccd1 vccd1 _02615_ sky130_fd_sc_hd__nand3_2
XFILLER_0_64_445 vssd1 vssd1 vccd1 vccd1 sky130_fd_sc_hd__decap_3
X_07519_ net896 net1145 _01642_ _01643_ vssd1 vssd1 vccd1 vccd1 _01644_ sky130_fd_sc_hd__a22oi_1
XFILLER_0_36_103 vssd1 vssd1 vccd1 vccd1 sky130_fd_sc_hd__fill_1
XFILLER_0_36_114 vssd1 vssd1 vccd1 vccd1 sky130_fd_sc_hd__decap_8
XFILLER_0_36_136 vssd1 vssd1 vccd1 vccd1 sky130_fd_sc_hd__decap_4
XFILLER_0_119_385 vssd1 vssd1 vccd1 vccd1 sky130_fd_sc_hd__decap_6
XFILLER_0_107_525 vssd1 vssd1 vccd1 vccd1 sky130_fd_sc_hd__fill_1
X_10530_ net1053 net719 vssd1 vssd1 vccd1 vccd1 _04633_ sky130_fd_sc_hd__nand2_1
XFILLER_0_107_558 vssd1 vssd1 vccd1 vccd1 sky130_fd_sc_hd__fill_2
X_10461_ _04543_ _04544_ _04561_ _04562_ vssd1 vssd1 vccd1 vccd1 _04564_ sky130_fd_sc_hd__o22ai_2
XFILLER_0_45_681 vssd1 vssd1 vccd1 vccd1 sky130_fd_sc_hd__fill_1
XFILLER_0_60_640 vssd1 vssd1 vccd1 vccd1 sky130_fd_sc_hd__decap_4
X_12200_ net836 _06153_ net514 vssd1 vssd1 vccd1 vccd1 _00294_ sky130_fd_sc_hd__mux2_1
XFILLER_0_103_753 vssd1 vssd1 vccd1 vccd1 sky130_ef_sc_hd__decap_12
X_10392_ _04493_ _04494_ _04495_ vssd1 vssd1 vccd1 vccd1 _04496_ sky130_fd_sc_hd__nand3_2
X_13180_ clknet_leaf_21_clk_i _00566_ net1176 vssd1 vssd1 vccd1 vccd1 l1\[9\] sky130_fd_sc_hd__dfrtp_1
X_12131_ net972 _06104_ net517 vssd1 vssd1 vccd1 vccd1 _00274_ sky130_fd_sc_hd__mux2_1
XFILLER_0_32_386 vssd1 vssd1 vccd1 vccd1 sky130_fd_sc_hd__fill_1
XFILLER_0_130_583 vssd1 vssd1 vccd1 vccd1 sky130_fd_sc_hd__fill_2
X_12062_ _00840_ _05752_ _06032_ _06052_ vssd1 vssd1 vccd1 vccd1 _06053_ sky130_fd_sc_hd__a31o_1
Xhold490 temp1\[20\] vssd1 vssd1 vccd1 vccd1 net1705 sky130_fd_sc_hd__dlygate4sd3_1
XFILLER_0_19_39 vssd1 vssd1 vccd1 vccd1 sky130_ef_sc_hd__decap_12
X_11013_ net757 net982 _04990_ _04989_ vssd1 vssd1 vccd1 vccd1 _05112_ sky130_fd_sc_hd__a31o_1
Xfanout970 net971 vssd1 vssd1 vccd1 vccd1 net970 sky130_fd_sc_hd__buf_2
XFILLER_0_126_29 vssd1 vssd1 vccd1 vccd1 sky130_ef_sc_hd__decap_12
Xfanout981 mul1.a\[21\] vssd1 vssd1 vccd1 vccd1 net981 sky130_fd_sc_hd__buf_4
Xfanout992 mul1.a\[20\] vssd1 vssd1 vccd1 vccd1 net992 sky130_fd_sc_hd__clkbuf_2
X_12964_ clknet_leaf_46_clk_i _00350_ net1160 vssd1 vssd1 vccd1 vccd1 y1my2\[17\]
+ sky130_fd_sc_hd__dfrtp_1
XFILLER_0_35_27 vssd1 vssd1 vccd1 vccd1 sky130_fd_sc_hd__decap_3
X_11915_ net27 net549 net624 net211 _05940_ vssd1 vssd1 vccd1 vccd1 _05941_ sky130_fd_sc_hd__a221o_1
XFILLER_0_59_239 vssd1 vssd1 vccd1 vccd1 sky130_fd_sc_hd__fill_1
X_12895_ clknet_leaf_25_clk_i _00281_ vssd1 vssd1 vccd1 vccd1 mul1.a\[30\] sky130_fd_sc_hd__dfxtp_1
XTAP_1961 vssd1 vccd1 sky130_fd_sc_hd__tapvpwrvgnd_1
XTAP_1950 vssd1 vccd1 sky130_fd_sc_hd__tapvpwrvgnd_1
XFILLER_0_51_15 vssd1 vssd1 vccd1 vccd1 sky130_fd_sc_hd__decap_3
X_11846_ net45 net688 net679 net73 vssd1 vssd1 vccd1 vccd1 _05884_ sky130_fd_sc_hd__a22o_1
XFILLER_0_28_615 vssd1 vssd1 vccd1 vccd1 sky130_fd_sc_hd__fill_1
XTAP_1994 vssd1 vccd1 sky130_fd_sc_hd__tapvpwrvgnd_1
XTAP_1983 vssd1 vccd1 sky130_fd_sc_hd__tapvpwrvgnd_1
XTAP_1972 vssd1 vccd1 sky130_fd_sc_hd__tapvpwrvgnd_1
X_11777_ net1305 _05825_ net479 vssd1 vssd1 vccd1 vccd1 _00199_ sky130_fd_sc_hd__mux2_1
X_10728_ _04689_ _04697_ _04696_ vssd1 vssd1 vccd1 vccd1 _04829_ sky130_fd_sc_hd__o21ai_2
XFILLER_0_27_169 vssd1 vssd1 vccd1 vccd1 sky130_fd_sc_hd__fill_1
XFILLER_0_125_333 vssd1 vssd1 vccd1 vccd1 sky130_fd_sc_hd__decap_3
XFILLER_0_82_297 vssd1 vssd1 vccd1 vccd1 sky130_fd_sc_hd__decap_8
XFILLER_0_125_377 vssd1 vssd1 vccd1 vccd1 sky130_ef_sc_hd__decap_12
XFILLER_0_113_517 vssd1 vssd1 vccd1 vccd1 sky130_ef_sc_hd__decap_12
X_10659_ net1078 net699 net693 net1086 vssd1 vssd1 vccd1 vccd1 _04761_ sky130_fd_sc_hd__o2bb2a_1
XFILLER_0_3_726 vssd1 vssd1 vccd1 vccd1 sky130_fd_sc_hd__fill_2
XFILLER_0_51_673 vssd1 vssd1 vccd1 vccd1 sky130_fd_sc_hd__fill_1
XFILLER_0_121_561 vssd1 vssd1 vccd1 vccd1 sky130_ef_sc_hd__decap_12
XFILLER_0_50_172 vssd1 vssd1 vccd1 vccd1 sky130_fd_sc_hd__decap_4
X_12329_ net1661 _00892_ net670 vssd1 vssd1 vccd1 vccd1 _00381_ sky130_fd_sc_hd__mux2_1
XFILLER_0_11_559 vssd1 vssd1 vccd1 vccd1 sky130_fd_sc_hd__fill_1
X_07870_ net1059 net848 net839 net1067 vssd1 vssd1 vccd1 vccd1 _01991_ sky130_fd_sc_hd__a22oi_1
X_06821_ net1436 l0\[28\] net645 vssd1 vssd1 vccd1 vccd1 _00095_ sky130_fd_sc_hd__mux2_1
X_09540_ _03647_ _03648_ vssd1 vssd1 vccd1 vccd1 _03649_ sky130_fd_sc_hd__nand2b_1
X_06752_ sub1.a_i\[30\] sub1.b_i\[30\] vssd1 vssd1 vccd1 vccd1 _00967_ sky130_fd_sc_hd__and2b_1
XFILLER_0_92_77 vssd1 vssd1 vccd1 vccd1 sky130_fd_sc_hd__decap_6
X_09471_ _03422_ _03580_ vssd1 vssd1 vccd1 vccd1 _03581_ sky130_fd_sc_hd__xor2_4
X_08422_ _02416_ _02536_ vssd1 vssd1 vccd1 vccd1 _02539_ sky130_fd_sc_hd__xnor2_2
X_06683_ net1353 _00908_ net635 vssd1 vssd1 vccd1 vccd1 _00022_ sky130_fd_sc_hd__mux2_1
XFILLER_0_58_261 vssd1 vssd1 vccd1 vccd1 sky130_ef_sc_hd__decap_12
X_08353_ _02466_ _02469_ vssd1 vssd1 vccd1 vccd1 _02470_ sky130_fd_sc_hd__xor2_1
X_08284_ _02399_ _02400_ vssd1 vssd1 vccd1 vccd1 _02402_ sky130_fd_sc_hd__xnor2_2
X_07304_ _01427_ _01428_ vssd1 vssd1 vccd1 vccd1 _01429_ sky130_fd_sc_hd__nand2b_1
XFILLER_0_116_333 vssd1 vssd1 vccd1 vccd1 sky130_ef_sc_hd__decap_12
X_07235_ net1065 net873 net864 net1074 vssd1 vssd1 vccd1 vccd1 _01360_ sky130_fd_sc_hd__a22oi_1
Xclkbuf_leaf_17_clk_i clknet_3_4__leaf_clk_i vssd1 vssd1 vccd1 vccd1 clknet_leaf_17_clk_i
+ sky130_fd_sc_hd__clkbuf_16
XFILLER_0_6_553 vssd1 vssd1 vccd1 vccd1 sky130_fd_sc_hd__fill_1
XFILLER_0_15_821 vssd1 vssd1 vccd1 vccd1 sky130_fd_sc_hd__decap_4
XFILLER_0_33_106 vssd1 vssd1 vccd1 vccd1 sky130_fd_sc_hd__decap_3
XFILLER_0_41_81 vssd1 vssd1 vccd1 vccd1 sky130_ef_sc_hd__decap_12
XFILLER_0_116_377 vssd1 vssd1 vccd1 vccd1 sky130_ef_sc_hd__decap_12
XFILLER_0_61_459 vssd1 vssd1 vccd1 vccd1 sky130_fd_sc_hd__decap_3
X_07166_ net880 net1103 _01282_ _01018_ net1095 vssd1 vssd1 vccd1 vccd1 _01291_ sky130_fd_sc_hd__a32o_1
XFILLER_0_30_813 vssd1 vssd1 vccd1 vccd1 sky130_fd_sc_hd__fill_2
X_07097_ net873 net864 net1073 net1081 vssd1 vssd1 vccd1 vccd1 _01222_ sky130_fd_sc_hd__nand4_1
XFILLER_0_14_386 vssd1 vssd1 vccd1 vccd1 sky130_fd_sc_hd__decap_4
XFILLER_0_41_183 vssd1 vssd1 vccd1 vccd1 sky130_fd_sc_hd__fill_2
X_09807_ net1109 net704 vssd1 vssd1 vccd1 vccd1 _03914_ sky130_fd_sc_hd__nand2_1
X_07999_ net1024 net1033 net865 vssd1 vssd1 vccd1 vccd1 _02119_ sky130_fd_sc_hd__and3_1
X_09738_ _03842_ _03843_ _03844_ vssd1 vssd1 vccd1 vccd1 _03846_ sky130_fd_sc_hd__a21o_1
X_09669_ net1078 net731 net724 net1086 vssd1 vssd1 vccd1 vccd1 _03777_ sky130_fd_sc_hd__a22o_1
XTAP_1213 vssd1 vccd1 sky130_fd_sc_hd__tapvpwrvgnd_1
XTAP_1202 vssd1 vccd1 sky130_fd_sc_hd__tapvpwrvgnd_1
X_12680_ clknet_leaf_15_clk_i net1392 net1182 vssd1 vssd1 vccd1 vccd1 net409 sky130_fd_sc_hd__dfrtp_1
XTAP_1257 vssd1 vccd1 sky130_fd_sc_hd__tapvpwrvgnd_1
XTAP_1246 vssd1 vccd1 sky130_fd_sc_hd__tapvpwrvgnd_1
XTAP_1235 vssd1 vccd1 sky130_fd_sc_hd__tapvpwrvgnd_1
XTAP_1224 vssd1 vccd1 sky130_fd_sc_hd__tapvpwrvgnd_1
X_11700_ temp1\[0\] net611 net607 net186 vssd1 vssd1 vccd1 vccd1 _05761_ sky130_fd_sc_hd__a22o_1
XFILLER_0_127_609 vssd1 vssd1 vccd1 vccd1 sky130_fd_sc_hd__decap_6
XTAP_1279 vssd1 vccd1 sky130_fd_sc_hd__tapvpwrvgnd_1
XTAP_1268 vssd1 vccd1 sky130_fd_sc_hd__tapvpwrvgnd_1
X_11631_ net1011 net697 _05601_ _05604_ vssd1 vssd1 vccd1 vccd1 _05725_ sky130_fd_sc_hd__a211o_1
XFILLER_0_64_253 vssd1 vssd1 vccd1 vccd1 sky130_fd_sc_hd__decap_6
X_11562_ _05543_ _05546_ vssd1 vssd1 vccd1 vccd1 _05657_ sky130_fd_sc_hd__nand2_1
XFILLER_0_119_193 vssd1 vssd1 vccd1 vccd1 sky130_ef_sc_hd__decap_12
X_10513_ _04613_ _04614_ vssd1 vssd1 vccd1 vccd1 _04616_ sky130_fd_sc_hd__xor2_1
XFILLER_0_52_415 vssd1 vssd1 vccd1 vccd1 sky130_fd_sc_hd__decap_4
XFILLER_0_9_391 vssd1 vssd1 vccd1 vccd1 sky130_fd_sc_hd__fill_1
XFILLER_0_37_489 vssd1 vssd1 vccd1 vccd1 sky130_fd_sc_hd__fill_1
XFILLER_0_107_366 vssd1 vssd1 vccd1 vccd1 sky130_fd_sc_hd__decap_4
XFILLER_0_80_757 vssd1 vssd1 vccd1 vccd1 sky130_fd_sc_hd__fill_1
XFILLER_0_80_746 vssd1 vssd1 vccd1 vccd1 sky130_fd_sc_hd__decap_4
X_11493_ net789 net930 net929 net799 vssd1 vssd1 vccd1 vccd1 _05588_ sky130_fd_sc_hd__a22o_1
X_13232_ net508 vssd1 vssd1 vccd1 vccd1 net288 sky130_fd_sc_hd__clkbuf_1
X_10444_ net826 net817 net959 vssd1 vssd1 vccd1 vccd1 _04547_ sky130_fd_sc_hd__and3_1
X_13163_ clknet_leaf_12_clk_i _00549_ net1190 vssd1 vssd1 vccd1 vccd1 l0\[24\] sky130_fd_sc_hd__dfrtp_1
X_10375_ _04475_ _04476_ _04477_ vssd1 vssd1 vccd1 vccd1 _04479_ sky130_fd_sc_hd__a21o_1
XFILLER_0_60_470 vssd1 vssd1 vccd1 vccd1 sky130_fd_sc_hd__decap_6
XFILLER_0_103_583 vssd1 vssd1 vccd1 vccd1 sky130_ef_sc_hd__decap_12
X_12114_ _00908_ _06091_ net501 vssd1 vssd1 vccd1 vccd1 _06092_ sky130_fd_sc_hd__mux2_1
X_13094_ clknet_leaf_46_clk_i _00480_ vssd1 vssd1 vccd1 vccd1 temp1\[19\] sky130_fd_sc_hd__dfxtp_2
X_12045_ y2my0\[2\] net585 net533 x2mx1\[2\] _06039_ vssd1 vssd1 vccd1 vccd1 _06040_
+ sky130_fd_sc_hd__a221o_1
XFILLER_0_87_334 vssd1 vssd1 vccd1 vccd1 sky130_fd_sc_hd__fill_2
X_12947_ clknet_leaf_54_clk_i _00333_ net1154 vssd1 vssd1 vccd1 vccd1 y1my2\[0\] sky130_fd_sc_hd__dfrtp_1
XFILLER_0_87_356 vssd1 vssd1 vccd1 vccd1 sky130_fd_sc_hd__decap_4
XFILLER_0_47_209 vssd1 vssd1 vccd1 vccd1 sky130_ef_sc_hd__decap_12
X_12878_ clknet_leaf_42_clk_i _00264_ vssd1 vssd1 vccd1 vccd1 mul1.a\[13\] sky130_fd_sc_hd__dfxtp_1
XFILLER_0_68_592 vssd1 vssd1 vccd1 vccd1 sky130_fd_sc_hd__fill_1
XFILLER_0_8_807 vssd1 vssd1 vccd1 vccd1 sky130_fd_sc_hd__decap_4
X_11829_ net166 net471 _05869_ vssd1 vssd1 vccd1 vccd1 _05870_ sky130_fd_sc_hd__o21a_1
XFILLER_0_127_3 vssd1 vssd1 vccd1 vccd1 sky130_ef_sc_hd__decap_12
XTAP_1791 vssd1 vccd1 sky130_fd_sc_hd__tapvpwrvgnd_1
XTAP_1780 vssd1 vccd1 sky130_fd_sc_hd__tapvpwrvgnd_1
XFILLER_0_102_53 vssd1 vssd1 vccd1 vccd1 sky130_ef_sc_hd__decap_12
XFILLER_0_70_223 vssd1 vssd1 vccd1 vccd1 sky130_fd_sc_hd__decap_3
XFILLER_0_11_51 vssd1 vssd1 vccd1 vccd1 sky130_fd_sc_hd__decap_4
XFILLER_0_102_97 vssd1 vssd1 vccd1 vccd1 sky130_ef_sc_hd__decap_12
XFILLER_0_12_813 vssd1 vssd1 vccd1 vccd1 sky130_ef_sc_hd__decap_12
X_07020_ net922 net914 net1032 net1041 vssd1 vssd1 vccd1 vccd1 _01145_ sky130_fd_sc_hd__nand4_1
XFILLER_0_11_323 vssd1 vssd1 vccd1 vccd1 sky130_fd_sc_hd__fill_2
XFILLER_0_23_183 vssd1 vssd1 vccd1 vccd1 sky130_fd_sc_hd__decap_8
XFILLER_0_87_55 vssd1 vssd1 vccd1 vccd1 sky130_fd_sc_hd__fill_1
XFILLER_0_11_334 vssd1 vssd1 vccd1 vccd1 sky130_fd_sc_hd__fill_2
XFILLER_0_121_391 vssd1 vssd1 vccd1 vccd1 sky130_fd_sc_hd__fill_1
X_08971_ _03080_ _03081_ _02934_ _02938_ vssd1 vssd1 vccd1 vccd1 _03084_ sky130_fd_sc_hd__o211a_1
Xhold19 det_t\[11\] vssd1 vssd1 vccd1 vccd1 net1234 sky130_fd_sc_hd__dlygate4sd3_1
X_07922_ _01930_ net495 _02041_ _02042_ vssd1 vssd1 vccd1 vccd1 _02043_ sky130_fd_sc_hd__o211ai_2
X_07853_ _01967_ _01972_ vssd1 vssd1 vccd1 vccd1 _01974_ sky130_fd_sc_hd__xor2_1
X_06804_ net1427 l0\[11\] net642 vssd1 vssd1 vccd1 vccd1 _00078_ sky130_fd_sc_hd__mux2_1
X_07784_ _01899_ _01904_ vssd1 vssd1 vccd1 vccd1 _01906_ sky130_fd_sc_hd__xnor2_2
X_09523_ _03591_ _03631_ vssd1 vssd1 vccd1 vccd1 _03632_ sky130_fd_sc_hd__xnor2_2
XFILLER_0_78_334 vssd1 vssd1 vccd1 vccd1 sky130_fd_sc_hd__fill_2
X_06735_ _00938_ _00943_ _00949_ vssd1 vssd1 vccd1 vccd1 _00952_ sky130_fd_sc_hd__nor3_1
X_09454_ _03398_ net459 _03562_ _03563_ vssd1 vssd1 vccd1 vccd1 _03564_ sky130_fd_sc_hd__o211ai_4
X_06666_ sub1.a_i\[17\] _00595_ vssd1 vssd1 vccd1 vccd1 _00894_ sky130_fd_sc_hd__and2_1
XFILLER_0_109_609 vssd1 vssd1 vccd1 vccd1 sky130_fd_sc_hd__decap_6
XFILLER_0_93_337 vssd1 vssd1 vccd1 vccd1 sky130_fd_sc_hd__decap_4
X_09385_ _03320_ _03328_ _03327_ vssd1 vssd1 vccd1 vccd1 _03495_ sky130_fd_sc_hd__a21o_1
X_08405_ _02485_ _02518_ _02519_ vssd1 vssd1 vccd1 vccd1 _02522_ sky130_fd_sc_hd__or3_2
XFILLER_0_19_401 vssd1 vssd1 vccd1 vccd1 sky130_fd_sc_hd__fill_1
XFILLER_0_129_480 vssd1 vssd1 vccd1 vccd1 sky130_fd_sc_hd__decap_6
X_08336_ _02443_ _02450_ _02451_ vssd1 vssd1 vccd1 vccd1 _02453_ sky130_fd_sc_hd__nand3_1
XFILLER_0_52_91 vssd1 vssd1 vccd1 vccd1 sky130_fd_sc_hd__fill_2
X_06597_ _00834_ _00835_ vssd1 vssd1 vccd1 vccd1 _00836_ sky130_fd_sc_hd__nor2_2
XFILLER_0_117_653 vssd1 vssd1 vccd1 vccd1 sky130_ef_sc_hd__decap_12
XFILLER_0_116_141 vssd1 vssd1 vccd1 vccd1 sky130_ef_sc_hd__decap_12
X_08267_ _02350_ _02381_ _02382_ vssd1 vssd1 vccd1 vccd1 _02385_ sky130_fd_sc_hd__or3_2
XFILLER_0_61_212 vssd1 vssd1 vccd1 vccd1 sky130_fd_sc_hd__fill_2
XFILLER_0_117_697 vssd1 vssd1 vccd1 vccd1 sky130_ef_sc_hd__decap_12
X_08198_ _02312_ _02313_ _02314_ vssd1 vssd1 vccd1 vccd1 _02316_ sky130_fd_sc_hd__a21bo_1
X_07218_ net806 net1129 vssd1 vssd1 vccd1 vccd1 _01343_ sky130_fd_sc_hd__nand2_1
X_07149_ _01197_ _01199_ _01200_ vssd1 vssd1 vccd1 vccd1 _01274_ sky130_fd_sc_hd__o21ai_1
XFILLER_0_30_643 vssd1 vssd1 vccd1 vccd1 sky130_fd_sc_hd__fill_1
X_10160_ _04262_ _04264_ vssd1 vssd1 vccd1 vccd1 _04265_ sky130_fd_sc_hd__or2_1
Xoutput370 net370 vssd1 vssd1 vccd1 vccd1 mstream_o[28] sky130_fd_sc_hd__clkbuf_4
Xfanout1028 net1029 vssd1 vssd1 vccd1 vccd1 net1028 sky130_fd_sc_hd__buf_2
Xfanout1017 net1018 vssd1 vssd1 vccd1 vccd1 net1017 sky130_fd_sc_hd__buf_2
X_10091_ _04035_ _04038_ _04195_ _04196_ vssd1 vssd1 vccd1 vccd1 _04197_ sky130_fd_sc_hd__a211oi_4
Xfanout1006 mul1.a\[18\] vssd1 vssd1 vccd1 vccd1 net1006 sky130_fd_sc_hd__clkbuf_4
Xoutput392 net392 vssd1 vssd1 vccd1 vccd1 mstream_o[48] sky130_fd_sc_hd__clkbuf_4
Xoutput381 net381 vssd1 vssd1 vccd1 vccd1 mstream_o[38] sky130_fd_sc_hd__clkbuf_4
Xfanout1039 net1040 vssd1 vssd1 vccd1 vccd1 net1039 sky130_fd_sc_hd__clkbuf_4
XFILLER_0_16_29 vssd1 vssd1 vccd1 vccd1 sky130_ef_sc_hd__decap_12
XFILLER_0_69_345 vssd1 vssd1 vccd1 vccd1 sky130_fd_sc_hd__decap_6
X_10993_ _05087_ _05090_ vssd1 vssd1 vccd1 vccd1 _05092_ sky130_fd_sc_hd__xnor2_1
X_12801_ clknet_leaf_56_clk_i _00187_ vssd1 vssd1 vccd1 vccd1 sub1.a_i\[0\] sky130_fd_sc_hd__dfxtp_1
XTAP_1021 vssd1 vccd1 sky130_fd_sc_hd__tapvpwrvgnd_1
XTAP_1010 vssd1 vccd1 sky130_fd_sc_hd__tapvpwrvgnd_1
X_12732_ clknet_leaf_28_clk_i _00118_ net1169 vssd1 vssd1 vccd1 vccd1 state\[1\] sky130_fd_sc_hd__dfrtp_1
XTAP_1065 vssd1 vccd1 sky130_fd_sc_hd__tapvpwrvgnd_1
XTAP_1054 vssd1 vccd1 sky130_fd_sc_hd__tapvpwrvgnd_1
XTAP_1043 vssd1 vccd1 sky130_fd_sc_hd__tapvpwrvgnd_1
XTAP_1032 vssd1 vccd1 sky130_fd_sc_hd__tapvpwrvgnd_1
X_12663_ clknet_leaf_21_clk_i net1219 net1177 vssd1 vssd1 vccd1 vccd1 net390 sky130_fd_sc_hd__dfrtp_1
XTAP_1098 vssd1 vccd1 sky130_fd_sc_hd__tapvpwrvgnd_1
XTAP_1087 vssd1 vccd1 sky130_fd_sc_hd__tapvpwrvgnd_1
XTAP_1076 vssd1 vccd1 sky130_fd_sc_hd__tapvpwrvgnd_1
X_12594_ net1500 net5 net557 vssd1 vssd1 vccd1 vccd1 _00569_ sky130_fd_sc_hd__mux2_1
X_11614_ _05705_ _05707_ vssd1 vssd1 vccd1 vccd1 _05708_ sky130_fd_sc_hd__xnor2_1
XFILLER_0_4_309 vssd1 vssd1 vccd1 vccd1 sky130_fd_sc_hd__fill_1
X_11545_ _05638_ _05639_ vssd1 vssd1 vccd1 vccd1 _05640_ sky130_fd_sc_hd__and2b_1
XFILLER_0_12_109 vssd1 vssd1 vccd1 vccd1 sky130_ef_sc_hd__decap_12
X_11476_ net742 net963 net957 net750 vssd1 vssd1 vccd1 vccd1 _05571_ sky130_fd_sc_hd__a22o_1
XFILLER_0_122_133 vssd1 vssd1 vccd1 vccd1 sky130_fd_sc_hd__decap_6
X_10427_ _04434_ _04435_ vssd1 vssd1 vccd1 vccd1 _04530_ sky130_fd_sc_hd__nand2_1
XFILLER_0_122_177 vssd1 vssd1 vccd1 vccd1 sky130_ef_sc_hd__decap_12
XFILLER_0_110_306 vssd1 vssd1 vccd1 vccd1 sky130_fd_sc_hd__fill_2
XFILLER_0_20_131 vssd1 vssd1 vccd1 vccd1 sky130_fd_sc_hd__decap_4
X_13146_ clknet_leaf_16_clk_i _00532_ net1184 vssd1 vssd1 vccd1 vccd1 l0\[7\] sky130_fd_sc_hd__dfrtp_1
X_10358_ _04459_ _04460_ _04446_ vssd1 vssd1 vccd1 vccd1 _04462_ sky130_fd_sc_hd__a21oi_2
XFILLER_0_20_164 vssd1 vssd1 vccd1 vccd1 sky130_fd_sc_hd__fill_1
XFILLER_0_21_698 vssd1 vssd1 vccd1 vccd1 sky130_fd_sc_hd__fill_1
XTAP_805 vssd1 vccd1 sky130_fd_sc_hd__tapvpwrvgnd_1
XTAP_816 vssd1 vccd1 sky130_fd_sc_hd__tapvpwrvgnd_1
X_10289_ net1101 net699 net695 net1094 vssd1 vssd1 vccd1 vccd1 _04393_ sky130_fd_sc_hd__and4b_1
XFILLER_0_57_47 vssd1 vssd1 vccd1 vccd1 sky130_fd_sc_hd__decap_8
XFILLER_0_57_36 vssd1 vssd1 vccd1 vccd1 sky130_fd_sc_hd__fill_2
XFILLER_0_20_197 vssd1 vssd1 vccd1 vccd1 sky130_fd_sc_hd__fill_2
XTAP_827 vssd1 vccd1 sky130_fd_sc_hd__tapvpwrvgnd_1
XTAP_838 vssd1 vccd1 sky130_fd_sc_hd__tapvpwrvgnd_1
XTAP_849 vssd1 vccd1 sky130_fd_sc_hd__tapvpwrvgnd_1
X_13077_ clknet_leaf_43_clk_i _00463_ vssd1 vssd1 vccd1 vccd1 temp1\[2\] sky130_fd_sc_hd__dfxtp_2
X_12028_ net146 net662 net505 net242 _06025_ vssd1 vssd1 vccd1 vccd1 _06026_ sky130_fd_sc_hd__a221o_1
XFILLER_0_88_632 vssd1 vssd1 vccd1 vccd1 sky130_fd_sc_hd__decap_3
XFILLER_0_88_621 vssd1 vssd1 vccd1 vccd1 sky130_fd_sc_hd__decap_4
X_06520_ det_t\[30\] net530 vssd1 vssd1 vccd1 vccd1 net275 sky130_fd_sc_hd__and2_1
XFILLER_0_88_676 vssd1 vssd1 vccd1 vccd1 sky130_fd_sc_hd__fill_1
X_06451_ add1.a_i\[26\] add1.b_i\[26\] vssd1 vssd1 vccd1 vccd1 _00750_ sky130_fd_sc_hd__or2_1
XFILLER_0_8_626 vssd1 vssd1 vccd1 vccd1 sky130_fd_sc_hd__fill_1
X_09170_ _03279_ _03280_ vssd1 vssd1 vccd1 vccd1 _03281_ sky130_fd_sc_hd__or2_1
XFILLER_0_90_329 vssd1 vssd1 vccd1 vccd1 sky130_fd_sc_hd__decap_3
X_06382_ _00684_ _00687_ _00690_ vssd1 vssd1 vccd1 vccd1 _00691_ sky130_fd_sc_hd__a21oi_1
XFILLER_0_114_601 vssd1 vssd1 vccd1 vccd1 sky130_ef_sc_hd__decap_12
XFILLER_0_71_532 vssd1 vssd1 vccd1 vccd1 sky130_fd_sc_hd__fill_1
X_08121_ net898 net889 net1000 net993 vssd1 vssd1 vccd1 vccd1 _02240_ sky130_fd_sc_hd__and4_1
XFILLER_0_126_472 vssd1 vssd1 vccd1 vccd1 sky130_fd_sc_hd__decap_4
XFILLER_0_114_645 vssd1 vssd1 vccd1 vccd1 sky130_ef_sc_hd__decap_12
XFILLER_0_113_111 vssd1 vssd1 vccd1 vccd1 sky130_fd_sc_hd__fill_1
XFILLER_0_98_21 vssd1 vssd1 vccd1 vccd1 sky130_fd_sc_hd__decap_6
X_08052_ net1147 net748 _02073_ _02072_ vssd1 vssd1 vccd1 vccd1 _02171_ sky130_fd_sc_hd__a31oi_1
XFILLER_0_4_821 vssd1 vssd1 vccd1 vccd1 sky130_fd_sc_hd__fill_2
XFILLER_0_98_65 vssd1 vssd1 vccd1 vccd1 sky130_ef_sc_hd__decap_12
X_07003_ _01126_ _01127_ vssd1 vssd1 vccd1 vccd1 _01128_ sky130_fd_sc_hd__nor2_1
X_08954_ net907 net950 vssd1 vssd1 vccd1 vccd1 _03067_ sky130_fd_sc_hd__and2_1
XFILLER_0_51_3 vssd1 vssd1 vccd1 vccd1 sky130_ef_sc_hd__decap_12
Xinput109 v0y[27] vssd1 vssd1 vccd1 vccd1 net109 sky130_fd_sc_hd__buf_1
X_07905_ _02023_ _02024_ _02022_ vssd1 vssd1 vccd1 vccd1 _02026_ sky130_fd_sc_hd__a21o_1
X_08885_ _02996_ _02997_ vssd1 vssd1 vccd1 vccd1 _02998_ sky130_fd_sc_hd__or2_1
X_07836_ _01879_ _01892_ _01893_ _01897_ vssd1 vssd1 vccd1 vccd1 _01957_ sky130_fd_sc_hd__a31o_1
X_07767_ net1089 net831 _01792_ _01793_ net848 vssd1 vssd1 vccd1 vccd1 _01889_ sky130_fd_sc_hd__a32o_1
X_09506_ net1087 net1094 net732 net724 vssd1 vssd1 vccd1 vccd1 _03615_ sky130_fd_sc_hd__nand4_2
XFILLER_0_94_602 vssd1 vssd1 vccd1 vccd1 sky130_fd_sc_hd__decap_6
X_06718_ _00936_ _00937_ vssd1 vssd1 vccd1 vccd1 _00938_ sky130_fd_sc_hd__or2_2
XFILLER_0_78_197 vssd1 vssd1 vccd1 vccd1 sky130_fd_sc_hd__decap_8
XPHY_115 vssd1 vssd1 vccd1 vccd1 sky130_fd_sc_hd__decap_3
X_07698_ net912 net1010 net1001 net920 vssd1 vssd1 vccd1 vccd1 _01821_ sky130_fd_sc_hd__a22o_1
XPHY_104 vssd1 vssd1 vccd1 vccd1 sky130_fd_sc_hd__decap_3
XFILLER_0_82_808 vssd1 vssd1 vccd1 vccd1 sky130_fd_sc_hd__decap_4
XPHY_148 vssd1 vssd1 vccd1 vccd1 sky130_fd_sc_hd__decap_3
XPHY_137 vssd1 vssd1 vccd1 vccd1 sky130_fd_sc_hd__decap_3
XPHY_126 vssd1 vssd1 vccd1 vccd1 sky130_fd_sc_hd__decap_3
X_09437_ _03543_ _03544_ _03545_ vssd1 vssd1 vccd1 vccd1 _03547_ sky130_fd_sc_hd__a21o_1
XFILLER_0_47_540 vssd1 vssd1 vccd1 vccd1 sky130_ef_sc_hd__decap_12
X_06649_ _00878_ _00879_ vssd1 vssd1 vccd1 vccd1 _00880_ sky130_fd_sc_hd__nor2_2
X_09368_ net1054 net767 _03474_ _03476_ vssd1 vssd1 vccd1 vccd1 _03478_ sky130_fd_sc_hd__nand4_1
XPHY_159 vssd1 vssd1 vccd1 vccd1 sky130_fd_sc_hd__decap_3
XFILLER_0_117_461 vssd1 vssd1 vccd1 vccd1 sky130_ef_sc_hd__decap_12
X_08319_ net772 _02435_ _02434_ vssd1 vssd1 vccd1 vccd1 _02436_ sky130_fd_sc_hd__a21bo_1
X_09299_ _03266_ _03408_ _03409_ vssd1 vssd1 vccd1 vccd1 _03410_ sky130_fd_sc_hd__nor3_2
XFILLER_0_90_841 vssd1 vssd1 vccd1 vccd1 sky130_fd_sc_hd__fill_1
XFILLER_0_7_670 vssd1 vssd1 vccd1 vccd1 sky130_fd_sc_hd__fill_2
XFILLER_0_62_576 vssd1 vssd1 vccd1 vccd1 sky130_fd_sc_hd__fill_2
X_11330_ _05423_ _05424_ _05406_ vssd1 vssd1 vccd1 vccd1 _05427_ sky130_fd_sc_hd__o21ai_1
XANTENNA_60 v2x[13] vssd1 vssd1 vccd1 vccd1 sky130_fd_sc_hd__diode_2
XFILLER_0_104_133 vssd1 vssd1 vccd1 vccd1 sky130_fd_sc_hd__decap_6
XFILLER_0_62_587 vssd1 vssd1 vccd1 vccd1 sky130_fd_sc_hd__fill_1
XFILLER_0_120_637 vssd1 vssd1 vccd1 vccd1 sky130_fd_sc_hd__decap_6
X_11261_ _05349_ _05357_ vssd1 vssd1 vccd1 vccd1 _05358_ sky130_fd_sc_hd__nand2_1
X_10212_ _04187_ _04189_ vssd1 vssd1 vccd1 vccd1 _04317_ sky130_fd_sc_hd__nand2_1
X_13000_ clknet_leaf_35_clk_i _00386_ net1167 vssd1 vssd1 vccd1 vccd1 x2mx1\[21\]
+ sky130_fd_sc_hd__dfrtp_1
X_11192_ _05287_ _05288_ _05102_ _05104_ vssd1 vssd1 vccd1 vccd1 _05290_ sky130_fd_sc_hd__o211ai_1
X_10143_ net1053 net732 net724 net1062 vssd1 vssd1 vccd1 vccd1 _04248_ sky130_fd_sc_hd__a22o_1
XFILLER_0_30_484 vssd1 vssd1 vccd1 vccd1 sky130_fd_sc_hd__decap_6
XFILLER_0_100_372 vssd1 vssd1 vccd1 vccd1 sky130_ef_sc_hd__decap_12
X_10074_ _04025_ _04029_ _04030_ _04023_ vssd1 vssd1 vccd1 vccd1 _04180_ sky130_fd_sc_hd__a31o_1
XFILLER_0_89_418 vssd1 vssd1 vccd1 vccd1 sky130_ef_sc_hd__decap_12
X_10976_ _04944_ _04947_ _05075_ vssd1 vssd1 vccd1 vccd1 _05076_ sky130_fd_sc_hd__a21oi_1
XFILLER_0_69_164 vssd1 vssd1 vccd1 vccd1 sky130_fd_sc_hd__decap_4
XFILLER_0_43_49 vssd1 vssd1 vccd1 vccd1 sky130_fd_sc_hd__decap_6
XPHY_6 vssd1 vssd1 vccd1 vccd1 sky130_fd_sc_hd__decap_3
X_12715_ clknet_leaf_10_clk_i _00101_ net1192 vssd1 vssd1 vccd1 vccd1 net447 sky130_fd_sc_hd__dfrtp_1
XFILLER_0_73_819 vssd1 vssd1 vccd1 vccd1 sky130_fd_sc_hd__fill_1
XFILLER_0_84_189 vssd1 vssd1 vccd1 vccd1 sky130_fd_sc_hd__decap_6
XFILLER_0_72_307 vssd1 vssd1 vccd1 vccd1 sky130_fd_sc_hd__fill_1
X_12646_ clknet_leaf_22_clk_i _00032_ net1170 vssd1 vssd1 vccd1 vccd1 net371 sky130_fd_sc_hd__dfrtp_1
XFILLER_0_127_258 vssd1 vssd1 vccd1 vccd1 sky130_fd_sc_hd__fill_1
XFILLER_0_81_841 vssd1 vssd1 vccd1 vccd1 sky130_fd_sc_hd__fill_1
X_12577_ net1448 net22 net561 vssd1 vssd1 vccd1 vccd1 _00553_ sky130_fd_sc_hd__mux2_1
X_11528_ _05621_ _05622_ vssd1 vssd1 vccd1 vccd1 _05623_ sky130_fd_sc_hd__nand2_1
Xhold308 x0mx2\[10\] vssd1 vssd1 vccd1 vccd1 net1523 sky130_fd_sc_hd__dlygate4sd3_1
XFILLER_0_123_497 vssd1 vssd1 vccd1 vccd1 sky130_fd_sc_hd__decap_6
XFILLER_0_111_615 vssd1 vssd1 vccd1 vccd1 sky130_fd_sc_hd__fill_1
X_11459_ _05552_ _05553_ _05434_ _05436_ vssd1 vssd1 vccd1 vccd1 _05555_ sky130_fd_sc_hd__o211a_1
Xhold319 y2my0\[10\] vssd1 vssd1 vccd1 vccd1 net1534 sky130_fd_sc_hd__dlygate4sd3_1
X_13129_ clknet_leaf_3_clk_i _00515_ vssd1 vssd1 vccd1 vccd1 det_t\[22\] sky130_fd_sc_hd__dfxtp_1
XTAP_602 vssd1 vccd1 sky130_fd_sc_hd__tapvpwrvgnd_1
XTAP_613 vssd1 vccd1 sky130_fd_sc_hd__tapvpwrvgnd_1
XTAP_624 vssd1 vccd1 sky130_fd_sc_hd__tapvpwrvgnd_1
XTAP_635 vssd1 vccd1 sky130_fd_sc_hd__tapvpwrvgnd_1
XTAP_646 vssd1 vccd1 sky130_fd_sc_hd__tapvpwrvgnd_1
XTAP_657 vssd1 vccd1 sky130_fd_sc_hd__tapvpwrvgnd_1
XTAP_668 vssd1 vccd1 sky130_fd_sc_hd__tapvpwrvgnd_1
XTAP_679 vssd1 vccd1 sky130_fd_sc_hd__tapvpwrvgnd_1
XFILLER_0_108_41 vssd1 vssd1 vccd1 vccd1 sky130_ef_sc_hd__decap_12
X_08670_ _02781_ _02782_ _02783_ vssd1 vssd1 vccd1 vccd1 _02785_ sky130_fd_sc_hd__a21o_1
XFILLER_0_108_85 vssd1 vssd1 vccd1 vccd1 sky130_ef_sc_hd__decap_12
X_07621_ _01743_ _01744_ _01682_ vssd1 vssd1 vccd1 vccd1 _01745_ sky130_fd_sc_hd__nor3b_2
X_07552_ _01341_ _01344_ _01674_ vssd1 vssd1 vccd1 vccd1 _01676_ sky130_fd_sc_hd__or3_1
X_06503_ det_t\[13\] net527 vssd1 vssd1 vccd1 vccd1 net256 sky130_fd_sc_hd__and2_1
XFILLER_0_75_101 vssd1 vssd1 vccd1 vccd1 sky130_fd_sc_hd__decap_8
XFILLER_0_64_808 vssd1 vssd1 vccd1 vccd1 sky130_fd_sc_hd__decap_4
X_07483_ net876 net1145 _01597_ _01598_ vssd1 vssd1 vccd1 vccd1 _01608_ sky130_fd_sc_hd__a211o_1
X_09222_ _03332_ vssd1 vssd1 vccd1 vccd1 _03333_ sky130_fd_sc_hd__inv_2
XFILLER_0_75_156 vssd1 vssd1 vccd1 vccd1 sky130_fd_sc_hd__decap_4
X_06434_ _00734_ _00735_ vssd1 vssd1 vccd1 vccd1 _00736_ sky130_fd_sc_hd__nand2b_2
XFILLER_0_99_3 vssd1 vssd1 vccd1 vccd1 sky130_ef_sc_hd__decap_12
XFILLER_0_90_126 vssd1 vssd1 vccd1 vccd1 sky130_fd_sc_hd__decap_3
X_06365_ _00620_ _00675_ vssd1 vssd1 vccd1 vccd1 _00677_ sky130_fd_sc_hd__xnor2_4
X_09153_ net1336 _03264_ net522 vssd1 vssd1 vccd1 vccd1 _00136_ sky130_fd_sc_hd__mux2_1
X_08104_ _02213_ _02221_ vssd1 vssd1 vccd1 vccd1 _02223_ sky130_fd_sc_hd__xnor2_1
X_09084_ net852 net843 net995 net988 vssd1 vssd1 vccd1 vccd1 _03196_ sky130_fd_sc_hd__nand4_4
X_06296_ net1151 net1150 vssd1 vssd1 vccd1 vccd1 _00610_ sky130_fd_sc_hd__or2_1
XFILLER_0_114_475 vssd1 vssd1 vccd1 vccd1 sky130_fd_sc_hd__fill_1
X_08035_ _02093_ _02094_ _02152_ _02153_ vssd1 vssd1 vccd1 vccd1 _02155_ sky130_fd_sc_hd__o22a_1
Xinput91 v0y[10] vssd1 vssd1 vccd1 vccd1 net91 sky130_fd_sc_hd__buf_1
Xinput80 v0x[2] vssd1 vssd1 vccd1 vccd1 net80 sky130_fd_sc_hd__buf_1
XFILLER_0_7_9 vssd1 vssd1 vccd1 vccd1 sky130_ef_sc_hd__decap_12
XFILLER_0_110_681 vssd1 vssd1 vccd1 vccd1 sky130_ef_sc_hd__decap_12
X_09986_ _03934_ _03936_ vssd1 vssd1 vccd1 vccd1 _04092_ sky130_fd_sc_hd__nand2_1
X_08937_ _02898_ _02900_ _03047_ _03048_ vssd1 vssd1 vccd1 vccd1 _03050_ sky130_fd_sc_hd__o211a_2
X_08868_ _02863_ _02865_ _02978_ vssd1 vssd1 vccd1 vccd1 _02981_ sky130_fd_sc_hd__and3_1
XFILLER_0_99_727 vssd1 vssd1 vccd1 vccd1 sky130_fd_sc_hd__fill_1
XFILLER_0_98_248 vssd1 vssd1 vccd1 vccd1 sky130_fd_sc_hd__decap_4
XFILLER_0_98_237 vssd1 vssd1 vccd1 vccd1 sky130_fd_sc_hd__fill_1
XFILLER_0_98_215 vssd1 vssd1 vccd1 vccd1 sky130_fd_sc_hd__fill_1
X_07819_ _01938_ _01939_ _01840_ _01842_ vssd1 vssd1 vccd1 vccd1 _01941_ sky130_fd_sc_hd__o211ai_1
X_08799_ _02911_ _02912_ vssd1 vssd1 vccd1 vccd1 _02913_ sky130_fd_sc_hd__or2_1
XFILLER_0_79_495 vssd1 vssd1 vccd1 vccd1 sky130_fd_sc_hd__fill_2
X_10830_ _04928_ _04929_ _04782_ _04785_ vssd1 vssd1 vccd1 vccd1 _04931_ sky130_fd_sc_hd__a211oi_2
X_10761_ net766 net984 net976 net776 vssd1 vssd1 vccd1 vccd1 _04862_ sky130_fd_sc_hd__a22o_1
X_12500_ net1244 net562 vssd1 vssd1 vccd1 vccd1 _06247_ sky130_fd_sc_hd__nand2_1
XFILLER_0_109_225 vssd1 vssd1 vccd1 vccd1 sky130_ef_sc_hd__decap_12
X_10692_ _04791_ _04792_ _04751_ vssd1 vssd1 vccd1 vccd1 _04794_ sky130_fd_sc_hd__o21a_1
XFILLER_0_66_178 vssd1 vssd1 vccd1 vccd1 sky130_ef_sc_hd__decap_12
XFILLER_0_125_729 vssd1 vssd1 vccd1 vccd1 sky130_ef_sc_hd__decap_12
XFILLER_0_109_269 vssd1 vssd1 vccd1 vccd1 sky130_fd_sc_hd__fill_2
XFILLER_0_63_841 vssd1 vssd1 vccd1 vccd1 sky130_fd_sc_hd__fill_1
X_12431_ _00862_ net613 _02819_ net574 vssd1 vssd1 vccd1 vccd1 _06208_ sky130_fd_sc_hd__a22o_1
XFILLER_0_124_217 vssd1 vssd1 vccd1 vccd1 sky130_fd_sc_hd__fill_2
X_12362_ net1383 _00897_ net664 vssd1 vssd1 vccd1 vccd1 _00414_ sky130_fd_sc_hd__mux2_1
XFILLER_0_35_576 vssd1 vssd1 vccd1 vccd1 sky130_ef_sc_hd__decap_12
XFILLER_0_35_598 vssd1 vssd1 vccd1 vccd1 sky130_ef_sc_hd__decap_12
XFILLER_0_120_401 vssd1 vssd1 vccd1 vccd1 sky130_ef_sc_hd__decap_12
XFILLER_0_105_464 vssd1 vssd1 vccd1 vccd1 sky130_fd_sc_hd__fill_2
X_11313_ net996 net989 net729 net721 vssd1 vssd1 vccd1 vccd1 _05410_ sky130_fd_sc_hd__and4_1
X_12293_ net1679 _00872_ net675 vssd1 vssd1 vccd1 vccd1 _00345_ sky130_fd_sc_hd__mux2_1
XFILLER_0_120_445 vssd1 vssd1 vccd1 vccd1 sky130_ef_sc_hd__decap_12
X_11244_ _04954_ _05220_ _05340_ vssd1 vssd1 vccd1 vccd1 _05341_ sky130_fd_sc_hd__o21a_1
XFILLER_0_31_782 vssd1 vssd1 vccd1 vccd1 sky130_fd_sc_hd__fill_2
XFILLER_0_120_489 vssd1 vssd1 vccd1 vccd1 sky130_ef_sc_hd__decap_12
XFILLER_0_30_270 vssd1 vssd1 vccd1 vccd1 sky130_fd_sc_hd__decap_3
XFILLER_0_30_281 vssd1 vssd1 vccd1 vccd1 sky130_fd_sc_hd__fill_2
X_11175_ net1045 net703 _05144_ _05143_ vssd1 vssd1 vccd1 vccd1 _05273_ sky130_fd_sc_hd__a31o_1
X_10126_ net1093 net706 _04228_ _04229_ vssd1 vssd1 vccd1 vccd1 _04231_ sky130_fd_sc_hd__a22o_1
X_10057_ net833 net964 _04161_ _04162_ vssd1 vssd1 vccd1 vccd1 _04163_ sky130_fd_sc_hd__nand4_4
XFILLER_0_54_26 vssd1 vssd1 vccd1 vccd1 sky130_fd_sc_hd__fill_2
XFILLER_0_54_15 vssd1 vssd1 vccd1 vccd1 sky130_fd_sc_hd__fill_1
XFILLER_0_128_501 vssd1 vssd1 vccd1 vccd1 sky130_ef_sc_hd__decap_12
XFILLER_0_97_281 vssd1 vssd1 vccd1 vccd1 sky130_fd_sc_hd__fill_2
XFILLER_0_85_421 vssd1 vssd1 vccd1 vccd1 sky130_ef_sc_hd__decap_12
X_10959_ _05041_ _05056_ _05057_ vssd1 vssd1 vccd1 vccd1 _05059_ sky130_fd_sc_hd__or3_2
XFILLER_0_128_545 vssd1 vssd1 vccd1 vccd1 sky130_ef_sc_hd__decap_12
XFILLER_0_57_178 vssd1 vssd1 vccd1 vccd1 sky130_fd_sc_hd__decap_3
XFILLER_0_128_589 vssd1 vssd1 vccd1 vccd1 sky130_ef_sc_hd__decap_12
XFILLER_0_72_137 vssd1 vssd1 vccd1 vccd1 sky130_fd_sc_hd__decap_3
XFILLER_0_57_189 vssd1 vssd1 vccd1 vccd1 sky130_fd_sc_hd__fill_1
XFILLER_0_115_217 vssd1 vssd1 vccd1 vccd1 sky130_fd_sc_hd__decap_6
X_12629_ clknet_leaf_47_clk_i _00015_ net1160 vssd1 vssd1 vccd1 vccd1 net353 sky130_fd_sc_hd__dfrtp_2
XFILLER_0_108_291 vssd1 vssd1 vccd1 vccd1 sky130_fd_sc_hd__fill_1
XFILLER_0_85_9 vssd1 vssd1 vccd1 vccd1 sky130_ef_sc_hd__decap_12
XFILLER_0_79_45 vssd1 vssd1 vccd1 vccd1 sky130_fd_sc_hd__decap_8
XFILLER_0_26_576 vssd1 vssd1 vccd1 vccd1 sky130_fd_sc_hd__decap_6
XFILLER_0_26_587 vssd1 vssd1 vccd1 vccd1 sky130_fd_sc_hd__fill_1
XFILLER_0_41_513 vssd1 vssd1 vccd1 vccd1 sky130_fd_sc_hd__fill_1
XFILLER_0_110_53 vssd1 vssd1 vccd1 vccd1 sky130_ef_sc_hd__decap_12
XFILLER_0_79_67 vssd1 vssd1 vccd1 vccd1 sky130_fd_sc_hd__decap_8
Xhold116 add1.a_i\[15\] vssd1 vssd1 vccd1 vccd1 net1331 sky130_fd_sc_hd__dlygate4sd3_1
Xhold105 add1.b_i\[31\] vssd1 vssd1 vccd1 vccd1 net1320 sky130_fd_sc_hd__dlygate4sd3_1
Xhold149 net387 vssd1 vssd1 vccd1 vccd1 net1364 sky130_fd_sc_hd__dlygate4sd3_1
Xhold127 net359 vssd1 vssd1 vccd1 vccd1 net1342 sky130_fd_sc_hd__dlygate4sd3_1
Xhold138 net360 vssd1 vssd1 vccd1 vccd1 net1353 sky130_fd_sc_hd__dlygate4sd3_1
XFILLER_0_110_97 vssd1 vssd1 vccd1 vccd1 sky130_ef_sc_hd__decap_12
XFILLER_0_21_281 vssd1 vssd1 vccd1 vccd1 sky130_fd_sc_hd__decap_4
X_09840_ _03945_ _03946_ vssd1 vssd1 vccd1 vccd1 _03947_ sky130_fd_sc_hd__nor2_1
XFILLER_0_95_55 vssd1 vssd1 vccd1 vccd1 sky130_fd_sc_hd__fill_1
XTAP_421 vssd1 vccd1 sky130_fd_sc_hd__tapvpwrvgnd_1
XTAP_410 vssd1 vccd1 sky130_fd_sc_hd__tapvpwrvgnd_1
XFILLER_0_0_197 vssd1 vssd1 vccd1 vccd1 sky130_fd_sc_hd__fill_2
Xfanout607 _00993_ vssd1 vssd1 vccd1 vccd1 net607 sky130_fd_sc_hd__clkbuf_4
XTAP_432 vssd1 vccd1 sky130_fd_sc_hd__tapvpwrvgnd_1
Xfanout618 _00992_ vssd1 vssd1 vccd1 vccd1 net618 sky130_fd_sc_hd__clkbuf_4
Xfanout629 net630 vssd1 vssd1 vccd1 vccd1 net629 sky130_fd_sc_hd__buf_2
XFILLER_0_119_51 vssd1 vssd1 vccd1 vccd1 sky130_fd_sc_hd__decap_4
X_09771_ _03864_ _03878_ vssd1 vssd1 vccd1 vccd1 _03879_ sky130_fd_sc_hd__xnor2_4
XTAP_443 vssd1 vccd1 sky130_fd_sc_hd__tapvpwrvgnd_1
XTAP_454 vssd1 vccd1 sky130_fd_sc_hd__tapvpwrvgnd_1
XTAP_465 vssd1 vccd1 sky130_fd_sc_hd__tapvpwrvgnd_1
XTAP_476 vssd1 vccd1 sky130_fd_sc_hd__tapvpwrvgnd_1
X_06983_ net906 net1057 vssd1 vssd1 vccd1 vccd1 _01108_ sky130_fd_sc_hd__and2_1
X_08722_ _02826_ _02834_ vssd1 vssd1 vccd1 vccd1 _02836_ sky130_fd_sc_hd__xnor2_1
XTAP_487 vssd1 vccd1 sky130_fd_sc_hd__tapvpwrvgnd_1
XTAP_498 vssd1 vccd1 sky130_fd_sc_hd__tapvpwrvgnd_1
XFILLER_0_28_82 vssd1 vssd1 vccd1 vccd1 sky130_fd_sc_hd__fill_2
X_08653_ net885 net979 vssd1 vssd1 vccd1 vccd1 _02768_ sky130_fd_sc_hd__nand2_1
X_08584_ _02697_ _02698_ vssd1 vssd1 vccd1 vccd1 _02699_ sky130_fd_sc_hd__xor2_1
XTAP_1609 vssd1 vccd1 sky130_fd_sc_hd__tapvpwrvgnd_1
X_07604_ _01724_ _01725_ _01726_ vssd1 vssd1 vccd1 vccd1 _01728_ sky130_fd_sc_hd__a21o_1
XFILLER_0_44_70 vssd1 vssd1 vccd1 vccd1 sky130_fd_sc_hd__fill_1
X_07535_ _01455_ _01463_ _01506_ _01508_ vssd1 vssd1 vccd1 vccd1 _01660_ sky130_fd_sc_hd__a211o_1
XFILLER_0_9_721 vssd1 vssd1 vccd1 vccd1 sky130_fd_sc_hd__fill_2
X_07466_ net904 net1128 vssd1 vssd1 vccd1 vccd1 _01591_ sky130_fd_sc_hd__nand2_1
XFILLER_0_36_307 vssd1 vssd1 vccd1 vccd1 sky130_fd_sc_hd__fill_1
X_09205_ _03159_ _03160_ _03314_ _03315_ vssd1 vssd1 vccd1 vccd1 _03316_ sky130_fd_sc_hd__o211a_1
XFILLER_0_107_729 vssd1 vssd1 vccd1 vccd1 sky130_fd_sc_hd__decap_6
X_06417_ add1.a_i\[21\] add1.b_i\[21\] vssd1 vssd1 vccd1 vccd1 _00721_ sky130_fd_sc_hd__nand2_1
XFILLER_0_45_841 vssd1 vssd1 vccd1 vccd1 sky130_fd_sc_hd__fill_1
X_07397_ net895 net887 net1111 net1119 vssd1 vssd1 vccd1 vccd1 _01522_ sky130_fd_sc_hd__and4_1
X_09136_ _03187_ _03188_ _03245_ _03246_ vssd1 vssd1 vccd1 vccd1 _03248_ sky130_fd_sc_hd__or4_1
X_06348_ _00641_ _00655_ _00659_ vssd1 vssd1 vccd1 vccd1 _00660_ sky130_fd_sc_hd__or3b_1
X_09067_ _03010_ _03018_ _03017_ vssd1 vssd1 vccd1 vccd1 _03179_ sky130_fd_sc_hd__a21o_1
XFILLER_0_44_395 vssd1 vssd1 vccd1 vccd1 sky130_fd_sc_hd__fill_2
X_06279_ sub1.b_i\[17\] vssd1 vssd1 vccd1 vccd1 _00595_ sky130_fd_sc_hd__inv_2
X_08018_ _02134_ _02135_ _02136_ vssd1 vssd1 vccd1 vccd1 _02138_ sky130_fd_sc_hd__a21o_1
XFILLER_0_13_782 vssd1 vssd1 vccd1 vccd1 sky130_fd_sc_hd__fill_2
X_09969_ net1101 net704 _04072_ _04073_ vssd1 vssd1 vccd1 vccd1 _04075_ sky130_fd_sc_hd__o2bb2a_1
XFILLER_0_99_513 vssd1 vssd1 vccd1 vccd1 sky130_fd_sc_hd__decap_4
X_12980_ clknet_leaf_45_clk_i _00366_ net1153 vssd1 vssd1 vccd1 vccd1 x2mx1\[1\] sky130_fd_sc_hd__dfrtp_1
X_11931_ net32 net549 net624 net215 _05952_ vssd1 vssd1 vccd1 vccd1 _05953_ sky130_fd_sc_hd__a221o_1
X_11862_ net653 _00940_ net475 _05897_ vssd1 vssd1 vccd1 vccd1 _05898_ sky130_fd_sc_hd__a211o_1
XFILLER_0_24_29 vssd1 vssd1 vccd1 vccd1 sky130_ef_sc_hd__decap_12
XFILLER_0_95_741 vssd1 vssd1 vccd1 vccd1 sky130_fd_sc_hd__decap_8
X_10813_ _04762_ _04912_ vssd1 vssd1 vccd1 vccd1 _04914_ sky130_fd_sc_hd__xor2_1
XFILLER_0_28_808 vssd1 vssd1 vccd1 vccd1 sky130_fd_sc_hd__decap_4
XFILLER_0_94_251 vssd1 vssd1 vccd1 vccd1 sky130_fd_sc_hd__fill_1
XFILLER_0_55_605 vssd1 vssd1 vccd1 vccd1 sky130_fd_sc_hd__decap_6
X_11793_ net652 _00887_ net474 _05838_ vssd1 vssd1 vccd1 vccd1 _05839_ sky130_fd_sc_hd__a211o_1
XFILLER_0_55_649 vssd1 vssd1 vccd1 vccd1 sky130_fd_sc_hd__decap_4
X_10744_ _04835_ _04843_ _04844_ vssd1 vssd1 vccd1 vccd1 _04845_ sky130_fd_sc_hd__nand3_2
XFILLER_0_40_17 vssd1 vssd1 vccd1 vccd1 sky130_fd_sc_hd__fill_2
X_10675_ _04775_ _04776_ vssd1 vssd1 vccd1 vccd1 _04777_ sky130_fd_sc_hd__or2_1
XFILLER_0_125_559 vssd1 vssd1 vccd1 vccd1 sky130_fd_sc_hd__fill_1
XFILLER_0_63_671 vssd1 vssd1 vccd1 vccd1 sky130_fd_sc_hd__fill_1
XFILLER_0_23_513 vssd1 vssd1 vccd1 vccd1 sky130_fd_sc_hd__decap_3
X_12414_ net1711 _06199_ net570 vssd1 vssd1 vccd1 vccd1 _00462_ sky130_fd_sc_hd__mux2_1
XFILLER_0_112_209 vssd1 vssd1 vccd1 vccd1 sky130_ef_sc_hd__decap_12
XFILLER_0_2_418 vssd1 vssd1 vccd1 vccd1 sky130_fd_sc_hd__fill_2
X_12345_ net1375 _00810_ net656 vssd1 vssd1 vccd1 vccd1 _00397_ sky130_fd_sc_hd__mux2_1
XFILLER_0_121_721 vssd1 vssd1 vccd1 vccd1 sky130_fd_sc_hd__decap_6
XFILLER_0_121_765 vssd1 vssd1 vccd1 vccd1 sky130_ef_sc_hd__decap_12
XFILLER_0_120_253 vssd1 vssd1 vccd1 vccd1 sky130_ef_sc_hd__decap_12
X_12276_ net1371 net54 net689 vssd1 vssd1 vccd1 vccd1 _00330_ sky130_fd_sc_hd__mux2_1
XFILLER_0_50_398 vssd1 vssd1 vccd1 vccd1 sky130_fd_sc_hd__fill_1
XFILLER_0_10_229 vssd1 vssd1 vccd1 vccd1 sky130_fd_sc_hd__fill_2
X_11227_ _05201_ _05323_ vssd1 vssd1 vccd1 vccd1 _05324_ sky130_fd_sc_hd__or2_1
X_11158_ _05255_ vssd1 vssd1 vccd1 vccd1 _05256_ sky130_fd_sc_hd__inv_2
X_10109_ _04213_ _04214_ vssd1 vssd1 vccd1 vccd1 _04215_ sky130_fd_sc_hd__nor2_1
X_11089_ _05140_ _05141_ _05184_ _05185_ vssd1 vssd1 vccd1 vccd1 _05188_ sky130_fd_sc_hd__a22o_1
XFILLER_0_81_57 vssd1 vssd1 vccd1 vccd1 sky130_fd_sc_hd__fill_1
XFILLER_0_58_421 vssd1 vssd1 vccd1 vccd1 sky130_fd_sc_hd__decap_4
XFILLER_0_105_53 vssd1 vssd1 vccd1 vccd1 sky130_fd_sc_hd__decap_3
XFILLER_0_46_616 vssd1 vssd1 vccd1 vccd1 sky130_fd_sc_hd__decap_4
X_07320_ _01429_ _01436_ _01444_ vssd1 vssd1 vccd1 vccd1 _01445_ sky130_fd_sc_hd__a21oi_2
X_07251_ net922 net1018 net914 net1026 vssd1 vssd1 vccd1 vccd1 _01376_ sky130_fd_sc_hd__nand4_1
XFILLER_0_45_137 vssd1 vssd1 vccd1 vccd1 sky130_ef_sc_hd__decap_12
XFILLER_0_27_841 vssd1 vssd1 vccd1 vccd1 sky130_fd_sc_hd__fill_1
XFILLER_0_60_107 vssd1 vssd1 vccd1 vccd1 sky130_fd_sc_hd__fill_1
XFILLER_0_5_223 vssd1 vssd1 vccd1 vccd1 sky130_fd_sc_hd__fill_1
X_07182_ _01295_ _01300_ _01293_ vssd1 vssd1 vccd1 vccd1 _01307_ sky130_fd_sc_hd__a21oi_1
XFILLER_0_30_83 vssd1 vssd1 vccd1 vccd1 sky130_fd_sc_hd__fill_1
XFILLER_0_124_581 vssd1 vssd1 vccd1 vccd1 sky130_fd_sc_hd__decap_6
X_09823_ _03803_ _03811_ _03810_ vssd1 vssd1 vccd1 vccd1 _03930_ sky130_fd_sc_hd__a21oi_1
XTAP_262 vssd1 vccd1 sky130_fd_sc_hd__tapvpwrvgnd_1
XTAP_273 vssd1 vccd1 sky130_fd_sc_hd__tapvpwrvgnd_1
XTAP_284 vssd1 vccd1 sky130_fd_sc_hd__tapvpwrvgnd_1
X_09754_ _03859_ _03860_ _03856_ vssd1 vssd1 vccd1 vccd1 _03862_ sky130_fd_sc_hd__a21o_1
XTAP_295 vssd1 vccd1 sky130_fd_sc_hd__tapvpwrvgnd_1
X_06966_ _01084_ _01088_ _01089_ vssd1 vssd1 vccd1 vccd1 _01091_ sky130_fd_sc_hd__nand3_1
XTAP_2107 vssd1 vccd1 sky130_fd_sc_hd__tapvpwrvgnd_1
X_09685_ _03772_ _03792_ vssd1 vssd1 vccd1 vccd1 _03793_ sky130_fd_sc_hd__xnor2_4
X_06897_ _01019_ _01021_ vssd1 vssd1 vccd1 vccd1 _01022_ sky130_fd_sc_hd__and2b_1
X_08705_ temp1\[10\] _02819_ net540 vssd1 vssd1 vccd1 vccd1 _02820_ sky130_fd_sc_hd__mux2_1
XTAP_2129 vssd1 vccd1 sky130_fd_sc_hd__tapvpwrvgnd_1
XTAP_2118 vssd1 vccd1 sky130_fd_sc_hd__tapvpwrvgnd_1
X_08636_ _02741_ _02749_ vssd1 vssd1 vccd1 vccd1 _02751_ sky130_fd_sc_hd__xnor2_1
XTAP_1406 vssd1 vccd1 sky130_fd_sc_hd__tapvpwrvgnd_1
XFILLER_0_55_91 vssd1 vssd1 vccd1 vccd1 sky130_fd_sc_hd__fill_1
XFILLER_0_77_741 vssd1 vssd1 vccd1 vccd1 sky130_fd_sc_hd__fill_2
XTAP_1439 vssd1 vccd1 sky130_fd_sc_hd__tapvpwrvgnd_1
XTAP_1428 vssd1 vccd1 sky130_fd_sc_hd__tapvpwrvgnd_1
XTAP_1417 vssd1 vccd1 sky130_fd_sc_hd__tapvpwrvgnd_1
X_08567_ _02681_ _02680_ _02679_ vssd1 vssd1 vccd1 vccd1 _02682_ sky130_fd_sc_hd__nand3b_2
X_08498_ _02612_ _02613_ _02596_ vssd1 vssd1 vccd1 vccd1 _02614_ sky130_fd_sc_hd__a21o_1
XFILLER_0_76_295 vssd1 vssd1 vccd1 vccd1 sky130_fd_sc_hd__decap_8
XFILLER_0_18_830 vssd1 vssd1 vccd1 vccd1 sky130_fd_sc_hd__decap_4
X_07518_ _01625_ _01638_ _01641_ vssd1 vssd1 vccd1 vccd1 _01643_ sky130_fd_sc_hd__a21o_1
XFILLER_0_92_755 vssd1 vssd1 vccd1 vccd1 sky130_fd_sc_hd__fill_1
X_07449_ _01532_ _01573_ vssd1 vssd1 vccd1 vccd1 _01574_ sky130_fd_sc_hd__and2_1
XFILLER_0_18_841 vssd1 vssd1 vccd1 vccd1 sky130_fd_sc_hd__fill_1
XFILLER_0_91_265 vssd1 vssd1 vccd1 vccd1 sky130_fd_sc_hd__fill_1
X_10460_ _04543_ _04544_ _04561_ _04562_ vssd1 vssd1 vccd1 vccd1 _04563_ sky130_fd_sc_hd__or4_4
XFILLER_0_45_671 vssd1 vssd1 vccd1 vccd1 sky130_fd_sc_hd__fill_1
X_09119_ _03227_ _03228_ _03229_ vssd1 vssd1 vccd1 vccd1 _03231_ sky130_fd_sc_hd__a21o_1
X_10391_ _04287_ _04295_ _04294_ vssd1 vssd1 vccd1 vccd1 _04495_ sky130_fd_sc_hd__a21bo_1
XFILLER_0_103_765 vssd1 vssd1 vccd1 vccd1 sky130_fd_sc_hd__decap_4
XFILLER_0_102_253 vssd1 vssd1 vccd1 vccd1 sky130_fd_sc_hd__decap_8
X_12130_ _00928_ _06103_ net500 vssd1 vssd1 vccd1 vccd1 _06104_ sky130_fd_sc_hd__mux2_1
XFILLER_0_130_573 vssd1 vssd1 vccd1 vccd1 sky130_fd_sc_hd__fill_2
Xhold480 sub1.b_i\[0\] vssd1 vssd1 vccd1 vccd1 net1695 sky130_fd_sc_hd__dlygate4sd3_1
XFILLER_0_3_3 vssd1 vssd1 vccd1 vccd1 sky130_ef_sc_hd__decap_12
X_12061_ y2my0\[6\] net584 net531 x2mx1\[6\] _06051_ vssd1 vssd1 vccd1 vccd1 _06052_
+ sky130_fd_sc_hd__a221o_1
Xhold491 posy\[8\] vssd1 vssd1 vccd1 vccd1 net1706 sky130_fd_sc_hd__dlygate4sd3_1
X_11012_ _05109_ _05110_ vssd1 vssd1 vccd1 vccd1 _05111_ sky130_fd_sc_hd__xnor2_1
Xfanout960 mul1.a\[25\] vssd1 vssd1 vccd1 vccd1 net960 sky130_fd_sc_hd__clkbuf_2
Xfanout993 net994 vssd1 vssd1 vccd1 vccd1 net993 sky130_fd_sc_hd__clkbuf_4
Xfanout971 net972 vssd1 vssd1 vccd1 vccd1 net971 sky130_fd_sc_hd__clkbuf_4
Xfanout982 net983 vssd1 vssd1 vccd1 vccd1 net982 sky130_fd_sc_hd__buf_2
X_12963_ clknet_leaf_46_clk_i _00349_ net1163 vssd1 vssd1 vccd1 vccd1 y1my2\[16\]
+ sky130_fd_sc_hd__dfrtp_1
XFILLER_0_59_218 vssd1 vssd1 vccd1 vccd1 sky130_fd_sc_hd__decap_6
X_11914_ net115 net620 net594 net83 vssd1 vssd1 vccd1 vccd1 _05940_ sky130_fd_sc_hd__a22o_1
XFILLER_0_129_106 vssd1 vssd1 vccd1 vccd1 sky130_fd_sc_hd__decap_6
XFILLER_0_68_730 vssd1 vssd1 vccd1 vccd1 sky130_ef_sc_hd__decap_12
X_12894_ clknet_leaf_25_clk_i _00280_ vssd1 vssd1 vccd1 vccd1 mul1.a\[29\] sky130_fd_sc_hd__dfxtp_1
XTAP_1951 vssd1 vccd1 sky130_fd_sc_hd__tapvpwrvgnd_1
XTAP_1940 vssd1 vccd1 sky130_fd_sc_hd__tapvpwrvgnd_1
XFILLER_0_67_251 vssd1 vssd1 vccd1 vccd1 sky130_fd_sc_hd__decap_3
X_11845_ temp1\[23\] net616 net609 net201 vssd1 vssd1 vccd1 vccd1 _05883_ sky130_fd_sc_hd__a22o_1
XTAP_1995 vssd1 vccd1 sky130_fd_sc_hd__tapvpwrvgnd_1
XTAP_1984 vssd1 vccd1 sky130_fd_sc_hd__tapvpwrvgnd_1
XTAP_1962 vssd1 vccd1 sky130_fd_sc_hd__tapvpwrvgnd_1
XTAP_1973 vssd1 vccd1 sky130_fd_sc_hd__tapvpwrvgnd_1
XFILLER_0_68_796 vssd1 vssd1 vccd1 vccd1 sky130_fd_sc_hd__fill_1
XFILLER_0_67_273 vssd1 vssd1 vccd1 vccd1 sky130_fd_sc_hd__decap_6
X_11776_ net157 net470 _05824_ vssd1 vssd1 vccd1 vccd1 _05825_ sky130_fd_sc_hd__o21a_1
XFILLER_0_126_813 vssd1 vssd1 vccd1 vccd1 sky130_ef_sc_hd__decap_12
X_10727_ _04821_ _04826_ vssd1 vssd1 vccd1 vccd1 _04828_ sky130_fd_sc_hd__xnor2_2
XFILLER_0_55_468 vssd1 vssd1 vccd1 vccd1 sky130_fd_sc_hd__fill_1
XFILLER_0_125_389 vssd1 vssd1 vccd1 vccd1 sky130_fd_sc_hd__decap_3
XFILLER_0_113_529 vssd1 vssd1 vccd1 vccd1 sky130_ef_sc_hd__decap_12
X_10658_ _04757_ _04758_ vssd1 vssd1 vccd1 vccd1 _04760_ sky130_fd_sc_hd__xor2_1
X_10589_ net844 net936 net933 net851 vssd1 vssd1 vccd1 vccd1 _04691_ sky130_fd_sc_hd__a22o_1
XFILLER_0_50_151 vssd1 vssd1 vccd1 vccd1 sky130_fd_sc_hd__decap_6
XFILLER_0_23_354 vssd1 vssd1 vccd1 vccd1 sky130_fd_sc_hd__fill_1
XFILLER_0_51_685 vssd1 vssd1 vccd1 vccd1 sky130_fd_sc_hd__decap_6
X_12328_ net1675 _00887_ net667 vssd1 vssd1 vccd1 vccd1 _00380_ sky130_fd_sc_hd__mux2_1
XFILLER_0_121_573 vssd1 vssd1 vccd1 vccd1 sky130_ef_sc_hd__decap_12
X_12259_ _00973_ net512 net469 y1my2\[31\] _06192_ vssd1 vssd1 vccd1 vccd1 _06193_
+ sky130_fd_sc_hd__a221o_1
XFILLER_0_76_79 vssd1 vssd1 vccd1 vccd1 sky130_fd_sc_hd__decap_4
Xclkbuf_0_clk_i clk_i vssd1 vssd1 vccd1 vccd1 clknet_0_clk_i sky130_fd_sc_hd__clkbuf_16
X_06820_ net1412 l0\[27\] net645 vssd1 vssd1 vccd1 vccd1 _00094_ sky130_fd_sc_hd__mux2_1
X_06751_ sub1.b_i\[30\] sub1.a_i\[30\] vssd1 vssd1 vccd1 vccd1 _00966_ sky130_fd_sc_hd__and2b_1
XFILLER_0_116_41 vssd1 vssd1 vccd1 vccd1 sky130_ef_sc_hd__decap_12
X_09470_ _03578_ _03579_ vssd1 vssd1 vccd1 vccd1 _03580_ sky130_fd_sc_hd__and2_2
X_06682_ _00904_ _00907_ vssd1 vssd1 vccd1 vccd1 _00908_ sky130_fd_sc_hd__xor2_4
XFILLER_0_116_85 vssd1 vssd1 vccd1 vccd1 sky130_ef_sc_hd__decap_12
X_08421_ _02534_ _02535_ _02395_ _02397_ vssd1 vssd1 vccd1 vccd1 _02538_ sky130_fd_sc_hd__o211a_1
XFILLER_0_25_61 vssd1 vssd1 vccd1 vccd1 sky130_fd_sc_hd__fill_1
XFILLER_0_25_83 vssd1 vssd1 vccd1 vccd1 sky130_fd_sc_hd__fill_2
X_08352_ net822 _02468_ _02467_ vssd1 vssd1 vccd1 vccd1 _02469_ sky130_fd_sc_hd__a21bo_1
XFILLER_0_59_785 vssd1 vssd1 vccd1 vccd1 sky130_fd_sc_hd__decap_3
XFILLER_0_58_273 vssd1 vssd1 vccd1 vccd1 sky130_ef_sc_hd__decap_12
XFILLER_0_18_104 vssd1 vssd1 vccd1 vccd1 sky130_fd_sc_hd__fill_1
XFILLER_0_129_673 vssd1 vssd1 vccd1 vccd1 sky130_fd_sc_hd__fill_2
XFILLER_0_116_301 vssd1 vssd1 vccd1 vccd1 sky130_fd_sc_hd__decap_6
X_08283_ _02399_ _02400_ vssd1 vssd1 vccd1 vccd1 _02401_ sky130_fd_sc_hd__or2_1
X_07303_ _01297_ _01299_ vssd1 vssd1 vccd1 vccd1 _01428_ sky130_fd_sc_hd__xnor2_1
XFILLER_0_128_194 vssd1 vssd1 vccd1 vccd1 sky130_fd_sc_hd__fill_2
XFILLER_0_116_345 vssd1 vssd1 vccd1 vccd1 sky130_ef_sc_hd__decap_12
XFILLER_0_61_416 vssd1 vssd1 vccd1 vccd1 sky130_ef_sc_hd__decap_12
X_07234_ net1049 _01213_ _01214_ _01211_ vssd1 vssd1 vccd1 vccd1 _01359_ sky130_fd_sc_hd__o2bb2a_1
XFILLER_0_33_118 vssd1 vssd1 vccd1 vccd1 sky130_fd_sc_hd__fill_2
XFILLER_0_41_93 vssd1 vssd1 vccd1 vccd1 sky130_fd_sc_hd__decap_4
XFILLER_0_116_389 vssd1 vssd1 vccd1 vccd1 sky130_ef_sc_hd__decap_12
XFILLER_0_104_529 vssd1 vssd1 vccd1 vccd1 sky130_fd_sc_hd__decap_3
XFILLER_0_81_3 vssd1 vssd1 vccd1 vccd1 sky130_ef_sc_hd__decap_12
XFILLER_0_14_365 vssd1 vssd1 vccd1 vccd1 sky130_fd_sc_hd__decap_4
X_07165_ _01288_ _01289_ vssd1 vssd1 vccd1 vccd1 _01290_ sky130_fd_sc_hd__nand2_1
X_07096_ net873 net1073 net1081 net864 vssd1 vssd1 vccd1 vccd1 _01221_ sky130_fd_sc_hd__a22o_1
XFILLER_0_100_757 vssd1 vssd1 vccd1 vccd1 sky130_fd_sc_hd__fill_1
X_09806_ net714 _03912_ _03911_ vssd1 vssd1 vccd1 vccd1 _03913_ sky130_fd_sc_hd__a21bo_1
X_07998_ net1024 net874 net865 net1033 vssd1 vssd1 vccd1 vccd1 _02118_ sky130_fd_sc_hd__a22o_1
X_09737_ _03842_ _03843_ _03844_ vssd1 vssd1 vccd1 vccd1 _03845_ sky130_fd_sc_hd__nand3_2
X_06949_ net919 net1057 net1065 net911 vssd1 vssd1 vccd1 vccd1 _01074_ sky130_fd_sc_hd__a22oi_2
XFILLER_0_69_505 vssd1 vssd1 vccd1 vccd1 sky130_fd_sc_hd__fill_1
X_09668_ _03636_ _03639_ _03637_ vssd1 vssd1 vccd1 vccd1 _03776_ sky130_fd_sc_hd__o21bai_1
XTAP_1214 vssd1 vccd1 sky130_fd_sc_hd__tapvpwrvgnd_1
XTAP_1203 vssd1 vccd1 sky130_fd_sc_hd__tapvpwrvgnd_1
X_08619_ _02587_ _02591_ _02731_ _02732_ vssd1 vssd1 vccd1 vccd1 _02734_ sky130_fd_sc_hd__o211ai_2
XTAP_1247 vssd1 vccd1 sky130_fd_sc_hd__tapvpwrvgnd_1
XTAP_1236 vssd1 vccd1 sky130_fd_sc_hd__tapvpwrvgnd_1
X_09599_ _03706_ _03707_ vssd1 vssd1 vccd1 vccd1 _03708_ sky130_fd_sc_hd__xor2_1
XTAP_1225 vssd1 vccd1 sky130_fd_sc_hd__tapvpwrvgnd_1
XTAP_1269 vssd1 vccd1 sky130_fd_sc_hd__tapvpwrvgnd_1
XTAP_1258 vssd1 vccd1 sky130_fd_sc_hd__tapvpwrvgnd_1
XFILLER_0_49_262 vssd1 vssd1 vccd1 vccd1 sky130_fd_sc_hd__decap_8
X_11630_ _05709_ _05723_ vssd1 vssd1 vccd1 vccd1 _05724_ sky130_fd_sc_hd__xnor2_1
XFILLER_0_126_109 vssd1 vssd1 vccd1 vccd1 sky130_ef_sc_hd__decap_12
XFILLER_0_119_161 vssd1 vssd1 vccd1 vccd1 sky130_fd_sc_hd__decap_6
XFILLER_0_37_446 vssd1 vssd1 vccd1 vccd1 sky130_fd_sc_hd__fill_2
XFILLER_0_37_457 vssd1 vssd1 vccd1 vccd1 sky130_fd_sc_hd__fill_1
X_11561_ _05654_ _05655_ vssd1 vssd1 vccd1 vccd1 _05656_ sky130_fd_sc_hd__xnor2_1
X_10512_ _04613_ _04614_ vssd1 vssd1 vccd1 vccd1 _04615_ sky130_fd_sc_hd__and2b_1
XFILLER_0_80_714 vssd1 vssd1 vccd1 vccd1 sky130_fd_sc_hd__decap_3
XFILLER_0_64_287 vssd1 vssd1 vccd1 vccd1 sky130_fd_sc_hd__decap_4
XFILLER_0_123_827 vssd1 vssd1 vccd1 vccd1 sky130_fd_sc_hd__fill_1
X_11492_ net799 net929 vssd1 vssd1 vccd1 vccd1 _05587_ sky130_fd_sc_hd__nand2_1
X_13231_ net508 vssd1 vssd1 vccd1 vccd1 net287 sky130_fd_sc_hd__clkbuf_1
X_10443_ net817 net958 net953 net826 vssd1 vssd1 vccd1 vccd1 _04546_ sky130_fd_sc_hd__a22o_1
X_13162_ clknet_leaf_12_clk_i _00548_ net1188 vssd1 vssd1 vccd1 vccd1 l0\[23\] sky130_fd_sc_hd__dfrtp_1
X_10374_ _04475_ _04476_ _04477_ vssd1 vssd1 vccd1 vccd1 _04478_ sky130_fd_sc_hd__nand3_1
XFILLER_0_60_493 vssd1 vssd1 vccd1 vccd1 sky130_ef_sc_hd__decap_12
XFILLER_0_32_184 vssd1 vssd1 vccd1 vccd1 sky130_fd_sc_hd__decap_4
XFILLER_0_103_595 vssd1 vssd1 vccd1 vccd1 sky130_fd_sc_hd__decap_3
X_12113_ y2my0\[19\] net589 net533 x2mx1\[19\] _06090_ vssd1 vssd1 vccd1 vccd1 _06091_
+ sky130_fd_sc_hd__a221o_1
X_13093_ clknet_leaf_46_clk_i _00479_ vssd1 vssd1 vccd1 vccd1 temp1\[18\] sky130_fd_sc_hd__dfxtp_1
X_12044_ x0mx2\[2\] net628 net591 y1my2\[2\] vssd1 vssd1 vccd1 vccd1 _06039_ sky130_fd_sc_hd__a22o_1
Xfanout790 net791 vssd1 vssd1 vccd1 vccd1 net790 sky130_fd_sc_hd__clkbuf_2
XFILLER_0_62_15 vssd1 vssd1 vccd1 vccd1 sky130_fd_sc_hd__decap_4
X_12946_ clknet_leaf_19_clk_i _00332_ net1175 vssd1 vssd1 vccd1 vccd1 posy\[8\] sky130_fd_sc_hd__dfrtp_2
XFILLER_0_1_29 vssd1 vssd1 vccd1 vccd1 sky130_fd_sc_hd__decap_3
X_12877_ clknet_leaf_42_clk_i _00263_ vssd1 vssd1 vccd1 vccd1 mul1.a\[12\] sky130_fd_sc_hd__dfxtp_1
XTAP_1770 vssd1 vccd1 sky130_fd_sc_hd__tapvpwrvgnd_1
XFILLER_0_68_582 vssd1 vssd1 vccd1 vccd1 sky130_fd_sc_hd__decap_3
XFILLER_0_8_819 vssd1 vssd1 vccd1 vccd1 sky130_ef_sc_hd__decap_12
X_11828_ net654 _00913_ net475 _05868_ vssd1 vssd1 vccd1 vccd1 _05869_ sky130_fd_sc_hd__a211o_1
XTAP_1792 vssd1 vccd1 sky130_fd_sc_hd__tapvpwrvgnd_1
XTAP_1781 vssd1 vccd1 sky130_fd_sc_hd__tapvpwrvgnd_1
XFILLER_0_56_755 vssd1 vssd1 vccd1 vccd1 sky130_fd_sc_hd__fill_1
XFILLER_0_28_435 vssd1 vssd1 vccd1 vccd1 sky130_fd_sc_hd__fill_2
X_11759_ net1707 _05810_ net479 vssd1 vssd1 vccd1 vccd1 _00196_ sky130_fd_sc_hd__mux2_1
XFILLER_0_83_596 vssd1 vssd1 vccd1 vccd1 sky130_fd_sc_hd__fill_1
XFILLER_0_36_490 vssd1 vssd1 vccd1 vccd1 sky130_fd_sc_hd__decap_3
XFILLER_0_113_337 vssd1 vssd1 vccd1 vccd1 sky130_ef_sc_hd__decap_12
XFILLER_0_102_65 vssd1 vssd1 vccd1 vccd1 sky130_ef_sc_hd__decap_12
XFILLER_0_12_825 vssd1 vssd1 vccd1 vccd1 sky130_fd_sc_hd__decap_8
XFILLER_0_23_173 vssd1 vssd1 vccd1 vccd1 sky130_fd_sc_hd__fill_1
X_08970_ _02934_ _02938_ _03080_ _03081_ vssd1 vssd1 vccd1 vccd1 _03083_ sky130_fd_sc_hd__a211oi_4
X_07921_ _02003_ _02005_ _02038_ _02039_ vssd1 vssd1 vccd1 vccd1 _02042_ sky130_fd_sc_hd__o22ai_2
X_07852_ _01967_ _01972_ vssd1 vssd1 vccd1 vccd1 _01973_ sky130_fd_sc_hd__and2_1
Xinput1 div_mstream_i vssd1 vssd1 vccd1 vccd1 net1 sky130_fd_sc_hd__buf_4
XFILLER_0_127_51 vssd1 vssd1 vccd1 vccd1 sky130_fd_sc_hd__decap_4
X_06803_ net1432 net1409 net643 vssd1 vssd1 vccd1 vccd1 _00077_ sky130_fd_sc_hd__mux2_1
X_09522_ _03629_ _03630_ vssd1 vssd1 vccd1 vccd1 _03631_ sky130_fd_sc_hd__nor2_1
X_07783_ _01899_ _01902_ _01903_ vssd1 vssd1 vccd1 vccd1 _01905_ sky130_fd_sc_hd__or3_1
X_06734_ net1529 _00951_ net635 vssd1 vssd1 vccd1 vccd1 _00030_ sky130_fd_sc_hd__mux2_1
X_09453_ _03502_ _03503_ _03560_ _03561_ vssd1 vssd1 vccd1 vccd1 _03563_ sky130_fd_sc_hd__a2bb2o_1
X_06665_ sub1.a_i\[17\] _00595_ vssd1 vssd1 vccd1 vccd1 _00893_ sky130_fd_sc_hd__nor2_1
X_09384_ _03484_ _03491_ _03492_ vssd1 vssd1 vccd1 vccd1 _03494_ sky130_fd_sc_hd__nand3_1
X_08404_ _02485_ _02518_ _02519_ vssd1 vssd1 vccd1 vccd1 _02521_ sky130_fd_sc_hd__nor3_1
XFILLER_0_59_571 vssd1 vssd1 vccd1 vccd1 sky130_fd_sc_hd__decap_8
XFILLER_0_108_109 vssd1 vssd1 vccd1 vccd1 sky130_ef_sc_hd__decap_12
X_08335_ _02450_ _02451_ _02443_ vssd1 vssd1 vccd1 vccd1 _02452_ sky130_fd_sc_hd__a21o_1
XFILLER_0_74_552 vssd1 vssd1 vccd1 vccd1 sky130_fd_sc_hd__fill_1
XFILLER_0_52_70 vssd1 vssd1 vccd1 vccd1 sky130_fd_sc_hd__fill_1
XFILLER_0_47_744 vssd1 vssd1 vccd1 vccd1 sky130_fd_sc_hd__fill_2
X_06596_ sub1.a_i\[6\] _00592_ vssd1 vssd1 vccd1 vccd1 _00835_ sky130_fd_sc_hd__and2_1
XFILLER_0_7_841 vssd1 vssd1 vccd1 vccd1 sky130_fd_sc_hd__fill_1
XFILLER_0_117_665 vssd1 vssd1 vccd1 vccd1 sky130_fd_sc_hd__decap_6
XFILLER_0_116_153 vssd1 vssd1 vccd1 vccd1 sky130_ef_sc_hd__decap_12
X_08266_ _02350_ _02381_ _02382_ vssd1 vssd1 vccd1 vccd1 _02384_ sky130_fd_sc_hd__nor3_1
XFILLER_0_116_197 vssd1 vssd1 vccd1 vccd1 sky130_ef_sc_hd__decap_12
XFILLER_0_105_838 vssd1 vssd1 vccd1 vccd1 sky130_fd_sc_hd__fill_2
X_08197_ _02314_ _02313_ _02312_ vssd1 vssd1 vccd1 vccd1 _02315_ sky130_fd_sc_hd__nand3b_1
X_07217_ _01340_ _01341_ vssd1 vssd1 vccd1 vccd1 _01342_ sky130_fd_sc_hd__nor2_1
XFILLER_0_14_173 vssd1 vssd1 vccd1 vccd1 sky130_fd_sc_hd__decap_3
X_07148_ _01271_ _01272_ vssd1 vssd1 vccd1 vccd1 _01273_ sky130_fd_sc_hd__nand2_1
XFILLER_0_14_195 vssd1 vssd1 vccd1 vccd1 sky130_fd_sc_hd__fill_1
X_07079_ net906 net1041 vssd1 vssd1 vccd1 vccd1 _01204_ sky130_fd_sc_hd__and2_1
Xoutput360 net360 vssd1 vssd1 vccd1 vccd1 mstream_o[19] sky130_fd_sc_hd__clkbuf_4
XFILLER_0_30_699 vssd1 vssd1 vccd1 vccd1 sky130_fd_sc_hd__fill_1
Xoutput371 net371 vssd1 vssd1 vccd1 vccd1 mstream_o[29] sky130_fd_sc_hd__clkbuf_4
Xfanout1018 mul1.a\[16\] vssd1 vssd1 vccd1 vccd1 net1018 sky130_fd_sc_hd__clkbuf_4
Xfanout1029 net1030 vssd1 vssd1 vccd1 vccd1 net1029 sky130_fd_sc_hd__buf_2
X_10090_ _04182_ _04183_ _04193_ _04194_ vssd1 vssd1 vccd1 vccd1 _04196_ sky130_fd_sc_hd__a22oi_4
Xfanout1007 net1010 vssd1 vssd1 vccd1 vccd1 net1007 sky130_fd_sc_hd__clkbuf_4
Xoutput382 net382 vssd1 vssd1 vccd1 vccd1 mstream_o[39] sky130_fd_sc_hd__clkbuf_4
Xoutput393 net393 vssd1 vssd1 vccd1 vccd1 mstream_o[49] sky130_fd_sc_hd__clkbuf_4
X_12800_ clknet_leaf_23_clk_i _00186_ vssd1 vssd1 vccd1 vccd1 add1.b_i\[31\] sky130_fd_sc_hd__dfxtp_1
XFILLER_0_69_335 vssd1 vssd1 vccd1 vccd1 sky130_fd_sc_hd__fill_1
X_10992_ _05087_ _05090_ vssd1 vssd1 vccd1 vccd1 _05091_ sky130_fd_sc_hd__nand2b_1
XFILLER_0_96_132 vssd1 vssd1 vccd1 vccd1 sky130_fd_sc_hd__decap_8
XFILLER_0_69_357 vssd1 vssd1 vccd1 vccd1 sky130_fd_sc_hd__decap_4
XTAP_1022 vssd1 vccd1 sky130_fd_sc_hd__tapvpwrvgnd_1
XTAP_1011 vssd1 vccd1 sky130_fd_sc_hd__tapvpwrvgnd_1
XTAP_1000 vssd1 vccd1 sky130_fd_sc_hd__tapvpwrvgnd_1
X_12731_ clknet_leaf_26_clk_i _00117_ net1171 vssd1 vssd1 vccd1 vccd1 state\[0\] sky130_fd_sc_hd__dfrtp_1
X_12662_ clknet_leaf_20_clk_i net1394 net1177 vssd1 vssd1 vccd1 vccd1 net389 sky130_fd_sc_hd__dfrtp_1
XTAP_1055 vssd1 vccd1 sky130_fd_sc_hd__tapvpwrvgnd_1
XTAP_1044 vssd1 vccd1 sky130_fd_sc_hd__tapvpwrvgnd_1
XTAP_1033 vssd1 vccd1 sky130_fd_sc_hd__tapvpwrvgnd_1
XFILLER_0_65_552 vssd1 vssd1 vccd1 vccd1 sky130_fd_sc_hd__fill_2
XTAP_1099 vssd1 vccd1 sky130_fd_sc_hd__tapvpwrvgnd_1
XTAP_1088 vssd1 vccd1 sky130_fd_sc_hd__tapvpwrvgnd_1
XTAP_1066 vssd1 vccd1 sky130_fd_sc_hd__tapvpwrvgnd_1
XTAP_1077 vssd1 vccd1 sky130_fd_sc_hd__tapvpwrvgnd_1
X_11613_ _05586_ _05706_ vssd1 vssd1 vccd1 vccd1 _05707_ sky130_fd_sc_hd__xnor2_1
XFILLER_0_37_210 vssd1 vssd1 vccd1 vccd1 sky130_fd_sc_hd__fill_2
XFILLER_0_37_232 vssd1 vssd1 vccd1 vccd1 sky130_fd_sc_hd__fill_1
XFILLER_0_108_643 vssd1 vssd1 vccd1 vccd1 sky130_fd_sc_hd__fill_1
XFILLER_0_92_360 vssd1 vssd1 vccd1 vccd1 sky130_fd_sc_hd__decap_4
XFILLER_0_53_703 vssd1 vssd1 vccd1 vccd1 sky130_fd_sc_hd__fill_2
X_12593_ net1465 net4 net557 vssd1 vssd1 vccd1 vccd1 _00568_ sky130_fd_sc_hd__mux2_1
XFILLER_0_65_596 vssd1 vssd1 vccd1 vccd1 sky130_fd_sc_hd__decap_4
X_11544_ _05632_ _05637_ vssd1 vssd1 vccd1 vccd1 _05639_ sky130_fd_sc_hd__nand2_1
X_11475_ _05492_ _05494_ vssd1 vssd1 vccd1 vccd1 _05570_ sky130_fd_sc_hd__nor2_1
X_10426_ _04424_ _04426_ vssd1 vssd1 vccd1 vccd1 _04529_ sky130_fd_sc_hd__or2_1
XFILLER_0_122_189 vssd1 vssd1 vccd1 vccd1 sky130_fd_sc_hd__decap_6
XFILLER_0_110_329 vssd1 vssd1 vccd1 vccd1 sky130_ef_sc_hd__decap_12
X_13145_ clknet_leaf_14_clk_i _00531_ net1185 vssd1 vssd1 vccd1 vccd1 l0\[6\] sky130_fd_sc_hd__dfrtp_1
X_10357_ _04446_ _04459_ _04460_ vssd1 vssd1 vccd1 vccd1 _04461_ sky130_fd_sc_hd__and3_2
XFILLER_0_21_688 vssd1 vssd1 vccd1 vccd1 sky130_fd_sc_hd__decap_3
XTAP_806 vssd1 vccd1 sky130_fd_sc_hd__tapvpwrvgnd_1
XTAP_817 vssd1 vccd1 sky130_fd_sc_hd__tapvpwrvgnd_1
X_10288_ net1093 net699 net693 net1101 vssd1 vssd1 vccd1 vccd1 _04392_ sky130_fd_sc_hd__o2bb2a_1
X_13076_ clknet_leaf_53_clk_i _00462_ vssd1 vssd1 vccd1 vccd1 temp1\[1\] sky130_fd_sc_hd__dfxtp_2
XTAP_828 vssd1 vccd1 sky130_fd_sc_hd__tapvpwrvgnd_1
XTAP_839 vssd1 vccd1 sky130_fd_sc_hd__tapvpwrvgnd_1
X_12027_ net26 net552 net627 net210 _06024_ vssd1 vssd1 vccd1 vccd1 _06025_ sky130_fd_sc_hd__a221o_1
Xclkbuf_leaf_16_clk_i clknet_3_7__leaf_clk_i vssd1 vssd1 vccd1 vccd1 clknet_leaf_16_clk_i
+ sky130_fd_sc_hd__clkbuf_16
XFILLER_0_73_69 vssd1 vssd1 vccd1 vccd1 sky130_fd_sc_hd__fill_1
X_12929_ clknet_leaf_8_clk_i _00315_ net1193 vssd1 vssd1 vccd1 vccd1 posx\[0\] sky130_fd_sc_hd__dfrtp_1
X_06450_ net546 _00749_ vssd1 vssd1 vccd1 vccd1 net323 sky130_fd_sc_hd__nor2_1
XFILLER_0_75_316 vssd1 vssd1 vccd1 vccd1 sky130_ef_sc_hd__decap_12
XFILLER_0_29_733 vssd1 vssd1 vccd1 vccd1 sky130_fd_sc_hd__fill_1
X_06381_ add1.a_i\[16\] add1.b_i\[16\] vssd1 vssd1 vccd1 vccd1 _00690_ sky130_fd_sc_hd__xnor2_1
X_08120_ net889 net1001 net993 net898 vssd1 vssd1 vccd1 vccd1 _02239_ sky130_fd_sc_hd__a22o_1
XFILLER_0_4_811 vssd1 vssd1 vccd1 vccd1 sky130_fd_sc_hd__fill_1
XFILLER_0_28_287 vssd1 vssd1 vccd1 vccd1 sky130_fd_sc_hd__fill_1
XFILLER_0_114_613 vssd1 vssd1 vccd1 vccd1 sky130_ef_sc_hd__decap_12
X_08051_ _02091_ _02093_ vssd1 vssd1 vccd1 vccd1 _02170_ sky130_fd_sc_hd__or2_1
XFILLER_0_114_657 vssd1 vssd1 vccd1 vccd1 sky130_ef_sc_hd__decap_12
XFILLER_0_98_77 vssd1 vssd1 vccd1 vccd1 sky130_fd_sc_hd__decap_6
XFILLER_0_12_622 vssd1 vssd1 vccd1 vccd1 sky130_fd_sc_hd__fill_2
X_07002_ net855 net1103 _01124_ _01125_ vssd1 vssd1 vccd1 vccd1 _01127_ sky130_fd_sc_hd__o2bb2a_1
XFILLER_0_113_167 vssd1 vssd1 vccd1 vccd1 sky130_fd_sc_hd__fill_1
X_08953_ _03062_ _03065_ vssd1 vssd1 vccd1 vccd1 _03066_ sky130_fd_sc_hd__xor2_2
X_07904_ _02022_ _02023_ _02024_ vssd1 vssd1 vccd1 vccd1 _02025_ sky130_fd_sc_hd__nand3_1
XFILLER_0_44_3 vssd1 vssd1 vccd1 vccd1 sky130_ef_sc_hd__decap_12
X_08884_ net1107 net739 _02993_ _02995_ vssd1 vssd1 vccd1 vccd1 _02997_ sky130_fd_sc_hd__a22oi_1
X_07835_ _01949_ _01950_ _01946_ _01947_ vssd1 vssd1 vccd1 vccd1 _01956_ sky130_fd_sc_hd__o2bb2a_1
XFILLER_0_78_110 vssd1 vssd1 vccd1 vccd1 sky130_ef_sc_hd__decap_12
X_07766_ net1083 net831 _01885_ _01886_ vssd1 vssd1 vccd1 vccd1 _01888_ sky130_fd_sc_hd__nand4_2
X_09505_ net1087 net732 net724 net1094 vssd1 vssd1 vccd1 vccd1 _03614_ sky130_fd_sc_hd__a22o_1
X_06717_ sub1.a_i\[25\] sub1.b_i\[25\] vssd1 vssd1 vccd1 vccd1 _00937_ sky130_fd_sc_hd__and2b_1
XFILLER_0_2_83 vssd1 vssd1 vccd1 vccd1 sky130_fd_sc_hd__fill_1
XFILLER_0_67_839 vssd1 vssd1 vccd1 vccd1 sky130_fd_sc_hd__fill_1
XPHY_116 vssd1 vssd1 vccd1 vccd1 sky130_fd_sc_hd__decap_3
X_09436_ _03543_ _03544_ _03545_ vssd1 vssd1 vccd1 vccd1 _03546_ sky130_fd_sc_hd__nand3_1
X_07697_ net1018 net906 vssd1 vssd1 vccd1 vccd1 _01820_ sky130_fd_sc_hd__and2_1
XPHY_105 vssd1 vssd1 vccd1 vccd1 sky130_fd_sc_hd__decap_3
XPHY_149 vssd1 vssd1 vccd1 vccd1 sky130_fd_sc_hd__decap_3
XPHY_138 vssd1 vssd1 vccd1 vccd1 sky130_fd_sc_hd__decap_3
XFILLER_0_66_338 vssd1 vssd1 vccd1 vccd1 sky130_fd_sc_hd__fill_1
XPHY_127 vssd1 vssd1 vccd1 vccd1 sky130_fd_sc_hd__decap_3
XFILLER_0_59_390 vssd1 vssd1 vccd1 vccd1 sky130_fd_sc_hd__fill_2
X_06648_ sub1.a_i\[14\] sub1.b_i\[14\] vssd1 vssd1 vccd1 vccd1 _00879_ sky130_fd_sc_hd__and2b_1
X_09367_ net1054 net767 _03474_ _03476_ vssd1 vssd1 vccd1 vccd1 _03477_ sky130_fd_sc_hd__and4_1
XFILLER_0_81_319 vssd1 vssd1 vccd1 vccd1 sky130_fd_sc_hd__decap_6
XFILLER_0_47_552 vssd1 vssd1 vccd1 vccd1 sky130_fd_sc_hd__decap_8
X_06579_ sub1.b_i\[3\] sub1.a_i\[3\] vssd1 vssd1 vccd1 vccd1 _00821_ sky130_fd_sc_hd__nand2b_1
X_08318_ net1098 net1107 net763 vssd1 vssd1 vccd1 vccd1 _02435_ sky130_fd_sc_hd__and3_1
X_09298_ _03406_ _03407_ _03250_ net1743 vssd1 vssd1 vccd1 vccd1 _03409_ sky130_fd_sc_hd__a211oi_2
XFILLER_0_74_382 vssd1 vssd1 vccd1 vccd1 sky130_fd_sc_hd__fill_2
XFILLER_0_62_533 vssd1 vssd1 vccd1 vccd1 sky130_fd_sc_hd__decap_3
XANTENNA_50 _01003_ vssd1 vssd1 vccd1 vccd1 sky130_fd_sc_hd__diode_2
XFILLER_0_34_202 vssd1 vssd1 vccd1 vccd1 sky130_fd_sc_hd__decap_8
XFILLER_0_117_473 vssd1 vssd1 vccd1 vccd1 sky130_ef_sc_hd__decap_12
X_08249_ net921 net913 net973 net967 vssd1 vssd1 vccd1 vccd1 _02367_ sky130_fd_sc_hd__nand4_1
XANTENNA_61 v2x[28] vssd1 vssd1 vccd1 vccd1 sky130_fd_sc_hd__diode_2
X_11260_ _05354_ _05355_ vssd1 vssd1 vccd1 vccd1 _05357_ sky130_fd_sc_hd__xor2_1
XFILLER_0_101_841 vssd1 vssd1 vccd1 vccd1 sky130_fd_sc_hd__fill_1
X_10211_ _04024_ _04178_ _04312_ _04313_ vssd1 vssd1 vccd1 vccd1 _04316_ sky130_fd_sc_hd__a22o_1
X_11191_ _05102_ _05104_ _05287_ _05288_ vssd1 vssd1 vccd1 vccd1 _05289_ sky130_fd_sc_hd__a211o_1
X_10142_ net1053 net738 _04117_ _04118_ net752 vssd1 vssd1 vccd1 vccd1 _04247_ sky130_fd_sc_hd__a32o_1
XFILLER_0_100_384 vssd1 vssd1 vccd1 vccd1 sky130_fd_sc_hd__decap_4
X_10073_ _04176_ _04177_ _04025_ vssd1 vssd1 vccd1 vccd1 _04179_ sky130_fd_sc_hd__a21o_1
XFILLER_0_97_441 vssd1 vssd1 vccd1 vccd1 sky130_fd_sc_hd__fill_1
XFILLER_0_85_603 vssd1 vssd1 vccd1 vccd1 sky130_fd_sc_hd__fill_2
X_12714_ clknet_leaf_10_clk_i _00100_ net1192 vssd1 vssd1 vccd1 vccd1 net446 sky130_fd_sc_hd__dfrtp_1
XFILLER_0_97_496 vssd1 vssd1 vccd1 vccd1 sky130_fd_sc_hd__fill_1
X_10975_ _05073_ _05074_ vssd1 vssd1 vccd1 vccd1 _05075_ sky130_fd_sc_hd__or2_1
XPHY_7 vssd1 vssd1 vccd1 vccd1 sky130_fd_sc_hd__decap_3
XFILLER_0_128_727 vssd1 vssd1 vccd1 vccd1 sky130_ef_sc_hd__decap_12
XFILLER_0_38_530 vssd1 vssd1 vccd1 vccd1 sky130_fd_sc_hd__fill_2
X_12645_ clknet_leaf_22_clk_i _00031_ net1170 vssd1 vssd1 vccd1 vccd1 net370 sky130_fd_sc_hd__dfrtp_1
X_12576_ net1452 net21 net561 vssd1 vssd1 vccd1 vccd1 _00552_ sky130_fd_sc_hd__mux2_1
X_11527_ net1020 _00590_ net697 net696 vssd1 vssd1 vccd1 vccd1 _05622_ sky130_fd_sc_hd__nand4_2
XFILLER_0_80_363 vssd1 vssd1 vccd1 vccd1 sky130_fd_sc_hd__fill_1
Xhold309 net340 vssd1 vssd1 vccd1 vccd1 net1524 sky130_fd_sc_hd__dlygate4sd3_1
X_11458_ _05434_ _05436_ _05552_ _05553_ vssd1 vssd1 vccd1 vccd1 _05554_ sky130_fd_sc_hd__a211oi_2
XFILLER_0_1_814 vssd1 vssd1 vccd1 vccd1 sky130_fd_sc_hd__decap_3
X_10409_ _04271_ _04362_ _04361_ vssd1 vssd1 vccd1 vccd1 _04513_ sky130_fd_sc_hd__a21oi_2
XFILLER_0_68_36 vssd1 vssd1 vccd1 vccd1 sky130_fd_sc_hd__decap_6
X_11389_ net930 _05484_ _05483_ vssd1 vssd1 vccd1 vccd1 _05485_ sky130_fd_sc_hd__a21bo_1
X_13128_ clknet_leaf_3_clk_i _00514_ vssd1 vssd1 vccd1 vccd1 det_t\[21\] sky130_fd_sc_hd__dfxtp_1
XTAP_603 vssd1 vccd1 sky130_fd_sc_hd__tapvpwrvgnd_1
XTAP_614 vssd1 vccd1 sky130_fd_sc_hd__tapvpwrvgnd_1
XTAP_625 vssd1 vccd1 sky130_fd_sc_hd__tapvpwrvgnd_1
XTAP_636 vssd1 vccd1 sky130_fd_sc_hd__tapvpwrvgnd_1
XTAP_647 vssd1 vccd1 sky130_fd_sc_hd__tapvpwrvgnd_1
XTAP_658 vssd1 vccd1 sky130_fd_sc_hd__tapvpwrvgnd_1
XTAP_669 vssd1 vccd1 sky130_fd_sc_hd__tapvpwrvgnd_1
X_13059_ clknet_leaf_46_clk_i _00445_ net1164 vssd1 vssd1 vccd1 vccd1 y2my0\[16\]
+ sky130_fd_sc_hd__dfrtp_1
XFILLER_0_108_53 vssd1 vssd1 vccd1 vccd1 sky130_ef_sc_hd__decap_12
XFILLER_0_84_57 vssd1 vssd1 vccd1 vccd1 sky130_fd_sc_hd__fill_1
X_07620_ _01740_ _01741_ _01390_ _01393_ vssd1 vssd1 vccd1 vccd1 _01744_ sky130_fd_sc_hd__o211a_1
XFILLER_0_17_51 vssd1 vssd1 vccd1 vccd1 sky130_fd_sc_hd__decap_4
XFILLER_0_108_97 vssd1 vssd1 vccd1 vccd1 sky130_ef_sc_hd__decap_12
X_07551_ _01341_ _01344_ _01674_ vssd1 vssd1 vccd1 vccd1 _01675_ sky130_fd_sc_hd__o21a_1
X_06502_ det_t\[12\] net527 vssd1 vssd1 vccd1 vccd1 net255 sky130_fd_sc_hd__and2_1
XFILLER_0_124_41 vssd1 vssd1 vccd1 vccd1 sky130_ef_sc_hd__decap_12
XFILLER_0_119_727 vssd1 vssd1 vccd1 vccd1 sky130_fd_sc_hd__fill_1
X_07482_ _01606_ vssd1 vssd1 vccd1 vccd1 _01607_ sky130_fd_sc_hd__inv_2
XFILLER_0_33_50 vssd1 vssd1 vccd1 vccd1 sky130_fd_sc_hd__decap_6
XFILLER_0_124_85 vssd1 vssd1 vccd1 vccd1 sky130_ef_sc_hd__decap_12
X_09221_ _03330_ _03331_ vssd1 vssd1 vccd1 vccd1 _03332_ sky130_fd_sc_hd__nor2_1
XFILLER_0_75_179 vssd1 vssd1 vccd1 vccd1 sky130_fd_sc_hd__decap_4
X_06433_ add1.a_i\[23\] add1.b_i\[23\] vssd1 vssd1 vccd1 vccd1 _00735_ sky130_fd_sc_hd__nand2_1
XFILLER_0_29_552 vssd1 vssd1 vccd1 vccd1 sky130_fd_sc_hd__fill_1
XFILLER_0_56_382 vssd1 vssd1 vccd1 vccd1 sky130_fd_sc_hd__decap_3
X_06364_ _00621_ _00674_ _00620_ vssd1 vssd1 vccd1 vccd1 _00676_ sky130_fd_sc_hd__a21o_1
XFILLER_0_44_522 vssd1 vssd1 vccd1 vccd1 sky130_fd_sc_hd__fill_1
X_09152_ temp1\[13\] _03263_ net541 vssd1 vssd1 vccd1 vccd1 _03264_ sky130_fd_sc_hd__mux2_1
X_08103_ _02213_ _02221_ vssd1 vssd1 vccd1 vccd1 _02222_ sky130_fd_sc_hd__and2_1
XFILLER_0_114_421 vssd1 vssd1 vccd1 vccd1 sky130_ef_sc_hd__decap_12
X_09083_ net843 net995 net988 net852 vssd1 vssd1 vccd1 vccd1 _03195_ sky130_fd_sc_hd__a22o_1
X_06295_ net1151 _00608_ vssd1 vssd1 vccd1 vccd1 _00609_ sky130_fd_sc_hd__nand2_1
XFILLER_0_31_205 vssd1 vssd1 vccd1 vccd1 sky130_fd_sc_hd__fill_2
XFILLER_0_32_728 vssd1 vssd1 vccd1 vccd1 sky130_fd_sc_hd__decap_3
X_08034_ _02093_ _02094_ _02152_ _02153_ vssd1 vssd1 vccd1 vccd1 _02154_ sky130_fd_sc_hd__nor4_1
Xinput81 v0x[30] vssd1 vssd1 vccd1 vccd1 net81 sky130_fd_sc_hd__buf_1
Xinput70 v0x[20] vssd1 vssd1 vccd1 vccd1 net70 sky130_fd_sc_hd__buf_1
XFILLER_0_102_638 vssd1 vssd1 vccd1 vccd1 sky130_fd_sc_hd__decap_6
Xinput92 v0y[11] vssd1 vssd1 vccd1 vccd1 net92 sky130_fd_sc_hd__buf_1
XFILLER_0_110_693 vssd1 vssd1 vccd1 vccd1 sky130_fd_sc_hd__decap_6
X_09985_ _03959_ _03967_ _03966_ vssd1 vssd1 vccd1 vccd1 _04091_ sky130_fd_sc_hd__a21oi_1
X_08936_ _03047_ _03048_ _02898_ _02900_ vssd1 vssd1 vccd1 vccd1 _03049_ sky130_fd_sc_hd__a211oi_2
X_08867_ _02979_ vssd1 vssd1 vccd1 vccd1 _02980_ sky130_fd_sc_hd__inv_2
X_07818_ _01840_ _01842_ _01938_ _01939_ vssd1 vssd1 vccd1 vccd1 _01940_ sky130_fd_sc_hd__a211oi_1
XFILLER_0_74_90 vssd1 vssd1 vccd1 vccd1 sky130_fd_sc_hd__fill_1
X_08798_ net861 net994 _02909_ _02910_ vssd1 vssd1 vccd1 vccd1 _02912_ sky130_fd_sc_hd__o2bb2a_1
XFILLER_0_79_474 vssd1 vssd1 vccd1 vccd1 sky130_fd_sc_hd__decap_8
X_07749_ _01868_ _01869_ vssd1 vssd1 vccd1 vccd1 _01871_ sky130_fd_sc_hd__xnor2_1
X_10760_ net776 net766 net984 net976 vssd1 vssd1 vccd1 vccd1 _04861_ sky130_fd_sc_hd__and4_1
XFILLER_0_109_237 vssd1 vssd1 vccd1 vccd1 sky130_ef_sc_hd__decap_12
X_10691_ _04751_ _04791_ _04792_ vssd1 vssd1 vccd1 vccd1 _04793_ sky130_fd_sc_hd__nor3_2
X_09419_ net867 net962 _03527_ _03528_ vssd1 vssd1 vccd1 vccd1 _03529_ sky130_fd_sc_hd__nand4_2
XFILLER_0_47_393 vssd1 vssd1 vccd1 vccd1 sky130_fd_sc_hd__decap_6
X_12430_ net1718 _06207_ net570 vssd1 vssd1 vccd1 vccd1 _00470_ sky130_fd_sc_hd__mux2_1
XFILLER_0_35_500 vssd1 vssd1 vccd1 vccd1 sky130_fd_sc_hd__decap_4
XFILLER_0_117_281 vssd1 vssd1 vccd1 vccd1 sky130_ef_sc_hd__decap_12
XFILLER_0_22_205 vssd1 vssd1 vccd1 vccd1 sky130_fd_sc_hd__decap_3
X_12361_ net1589 _00892_ net658 vssd1 vssd1 vccd1 vccd1 _00413_ sky130_fd_sc_hd__mux2_1
XFILLER_0_35_588 vssd1 vssd1 vccd1 vccd1 sky130_fd_sc_hd__decap_4
XFILLER_0_120_413 vssd1 vssd1 vccd1 vccd1 sky130_fd_sc_hd__decap_6
XFILLER_0_105_487 vssd1 vssd1 vccd1 vccd1 sky130_ef_sc_hd__decap_12
XFILLER_0_50_558 vssd1 vssd1 vccd1 vccd1 sky130_fd_sc_hd__decap_4
XFILLER_0_15_290 vssd1 vssd1 vccd1 vccd1 sky130_fd_sc_hd__fill_1
X_11312_ net989 net729 net721 net996 vssd1 vssd1 vccd1 vccd1 _05409_ sky130_fd_sc_hd__a22oi_1
X_12292_ net1628 _00867_ net675 vssd1 vssd1 vccd1 vccd1 _00344_ sky130_fd_sc_hd__mux2_1
X_11243_ _04957_ _05339_ vssd1 vssd1 vccd1 vccd1 _05340_ sky130_fd_sc_hd__xnor2_1
XFILLER_0_120_457 vssd1 vssd1 vccd1 vccd1 sky130_ef_sc_hd__decap_12
XFILLER_0_101_671 vssd1 vssd1 vccd1 vccd1 sky130_fd_sc_hd__fill_1
X_11174_ _05270_ _05271_ vssd1 vssd1 vccd1 vccd1 _05272_ sky130_fd_sc_hd__or2_1
XFILLER_0_38_39 vssd1 vssd1 vccd1 vccd1 sky130_fd_sc_hd__decap_3
X_10125_ net1093 net706 _04228_ _04229_ vssd1 vssd1 vccd1 vccd1 _04230_ sky130_fd_sc_hd__nand4_2
X_10056_ net850 net842 net958 net951 vssd1 vssd1 vccd1 vccd1 _04162_ sky130_fd_sc_hd__nand4_4
XFILLER_0_128_513 vssd1 vssd1 vccd1 vccd1 sky130_ef_sc_hd__decap_12
XFILLER_0_85_433 vssd1 vssd1 vccd1 vccd1 sky130_fd_sc_hd__decap_3
XFILLER_0_70_15 vssd1 vssd1 vccd1 vccd1 sky130_fd_sc_hd__decap_6
X_10958_ _05056_ _05057_ _05041_ vssd1 vssd1 vccd1 vccd1 _05058_ sky130_fd_sc_hd__o21ai_1
XFILLER_0_57_113 vssd1 vssd1 vccd1 vccd1 sky130_ef_sc_hd__decap_12
XFILLER_0_73_617 vssd1 vssd1 vccd1 vccd1 sky130_fd_sc_hd__decap_4
XFILLER_0_57_146 vssd1 vssd1 vccd1 vccd1 sky130_fd_sc_hd__decap_6
XFILLER_0_128_557 vssd1 vssd1 vccd1 vccd1 sky130_ef_sc_hd__decap_12
X_12628_ clknet_leaf_47_clk_i _00014_ net1160 vssd1 vssd1 vccd1 vccd1 net352 sky130_fd_sc_hd__dfrtp_2
X_10889_ net775 net765 net975 net969 vssd1 vssd1 vccd1 vccd1 _04989_ sky130_fd_sc_hd__and4_1
XFILLER_0_109_782 vssd1 vssd1 vccd1 vccd1 sky130_fd_sc_hd__fill_2
XFILLER_0_72_149 vssd1 vssd1 vccd1 vccd1 sky130_fd_sc_hd__decap_3
XFILLER_0_26_555 vssd1 vssd1 vccd1 vccd1 sky130_fd_sc_hd__decap_3
X_12559_ net1409 net3 net559 vssd1 vssd1 vccd1 vccd1 _00535_ sky130_fd_sc_hd__mux2_1
XFILLER_0_81_683 vssd1 vssd1 vccd1 vccd1 sky130_fd_sc_hd__fill_1
XFILLER_0_123_251 vssd1 vssd1 vccd1 vccd1 sky130_fd_sc_hd__decap_6
XFILLER_0_102_3 vssd1 vssd1 vccd1 vccd1 sky130_ef_sc_hd__decap_12
XFILLER_0_79_57 vssd1 vssd1 vccd1 vccd1 sky130_fd_sc_hd__decap_4
Xhold117 sub1.b_i\[6\] vssd1 vssd1 vccd1 vccd1 net1332 sky130_fd_sc_hd__dlygate4sd3_1
Xhold106 sub1.b_i\[2\] vssd1 vssd1 vccd1 vccd1 net1321 sky130_fd_sc_hd__dlygate4sd3_1
XFILLER_0_41_547 vssd1 vssd1 vccd1 vccd1 sky130_fd_sc_hd__fill_1
XFILLER_0_41_558 vssd1 vssd1 vccd1 vccd1 sky130_fd_sc_hd__fill_2
XFILLER_0_123_284 vssd1 vssd1 vccd1 vccd1 sky130_fd_sc_hd__decap_4
XFILLER_0_110_65 vssd1 vssd1 vccd1 vccd1 sky130_ef_sc_hd__decap_12
Xhold139 l1\[28\] vssd1 vssd1 vccd1 vccd1 net1354 sky130_fd_sc_hd__dlygate4sd3_1
Xhold128 add1.a_i\[30\] vssd1 vssd1 vccd1 vccd1 net1343 sky130_fd_sc_hd__dlygate4sd3_1
XTAP_400 vssd1 vccd1 sky130_fd_sc_hd__tapvpwrvgnd_1
XTAP_422 vssd1 vccd1 sky130_fd_sc_hd__tapvpwrvgnd_1
XTAP_411 vssd1 vccd1 sky130_fd_sc_hd__tapvpwrvgnd_1
Xfanout608 _00993_ vssd1 vssd1 vccd1 vccd1 net608 sky130_fd_sc_hd__clkbuf_2
XTAP_433 vssd1 vccd1 sky130_fd_sc_hd__tapvpwrvgnd_1
X_09770_ _03875_ _03876_ vssd1 vssd1 vccd1 vccd1 _03878_ sky130_fd_sc_hd__xor2_4
XTAP_444 vssd1 vccd1 sky130_fd_sc_hd__tapvpwrvgnd_1
XTAP_455 vssd1 vccd1 sky130_fd_sc_hd__tapvpwrvgnd_1
XTAP_466 vssd1 vccd1 sky130_fd_sc_hd__tapvpwrvgnd_1
X_06982_ net922 net914 net1041 net1049 vssd1 vssd1 vccd1 vccd1 _01107_ sky130_fd_sc_hd__nand4_1
X_08721_ _02826_ _02834_ vssd1 vssd1 vccd1 vccd1 _02835_ sky130_fd_sc_hd__nand2_1
XTAP_488 vssd1 vccd1 sky130_fd_sc_hd__tapvpwrvgnd_1
XTAP_477 vssd1 vccd1 sky130_fd_sc_hd__tapvpwrvgnd_1
XTAP_499 vssd1 vccd1 sky130_fd_sc_hd__tapvpwrvgnd_1
Xfanout1190 net1191 vssd1 vssd1 vccd1 vccd1 net1190 sky130_fd_sc_hd__clkbuf_4
X_08652_ _02757_ _02765_ vssd1 vssd1 vccd1 vccd1 _02767_ sky130_fd_sc_hd__xor2_2
X_07603_ _01724_ _01725_ _01726_ vssd1 vssd1 vccd1 vccd1 _01727_ sky130_fd_sc_hd__nand3_1
X_08583_ _02553_ _02554_ _02420_ vssd1 vssd1 vccd1 vccd1 _02698_ sky130_fd_sc_hd__and3b_1
X_07534_ _01511_ _01549_ _01550_ _01658_ vssd1 vssd1 vccd1 vccd1 _01659_ sky130_fd_sc_hd__a22o_1
X_07465_ net917 net909 net1112 net1119 vssd1 vssd1 vccd1 vccd1 _01590_ sky130_fd_sc_hd__and4_1
X_06416_ net546 _00720_ vssd1 vssd1 vccd1 vccd1 net318 sky130_fd_sc_hd__nor2_1
X_09204_ net1071 net761 _03310_ _03312_ vssd1 vssd1 vccd1 vccd1 _03315_ sky130_fd_sc_hd__a22o_1
XFILLER_0_72_650 vssd1 vssd1 vccd1 vccd1 sky130_fd_sc_hd__decap_3
X_07396_ _01471_ _01515_ _01520_ vssd1 vssd1 vccd1 vccd1 _01521_ sky130_fd_sc_hd__nand3_1
X_09135_ _03187_ _03188_ _03245_ _03246_ vssd1 vssd1 vccd1 vccd1 _03247_ sky130_fd_sc_hd__nor4_1
X_06347_ add1.a_i\[5\] add1.b_i\[5\] vssd1 vssd1 vccd1 vccd1 _00659_ sky130_fd_sc_hd__xor2_2
XFILLER_0_44_374 vssd1 vssd1 vccd1 vccd1 sky130_fd_sc_hd__decap_6
XFILLER_0_114_251 vssd1 vssd1 vccd1 vccd1 sky130_fd_sc_hd__fill_1
X_09066_ _03169_ _03177_ vssd1 vssd1 vccd1 vccd1 _03178_ sky130_fd_sc_hd__xnor2_1
X_06278_ sub1.b_i\[16\] vssd1 vssd1 vccd1 vccd1 _00594_ sky130_fd_sc_hd__inv_2
X_08017_ _02134_ _02135_ _02136_ vssd1 vssd1 vccd1 vccd1 _02137_ sky130_fd_sc_hd__nand3_2
XFILLER_0_13_794 vssd1 vssd1 vccd1 vccd1 sky130_ef_sc_hd__decap_12
X_09968_ _04072_ _04073_ net1101 net704 vssd1 vssd1 vccd1 vccd1 _04074_ sky130_fd_sc_hd__and4bb_1
XFILLER_0_99_503 vssd1 vssd1 vccd1 vccd1 sky130_fd_sc_hd__fill_1
X_08919_ _03031_ vssd1 vssd1 vccd1 vccd1 _03032_ sky130_fd_sc_hd__inv_2
X_09899_ _03997_ _04003_ _04004_ vssd1 vssd1 vccd1 vccd1 _04006_ sky130_fd_sc_hd__nand3_2
X_11930_ net119 net620 net594 net87 vssd1 vssd1 vccd1 vccd1 _05952_ sky130_fd_sc_hd__a22o_1
X_11861_ net235 net600 net580 net139 _05896_ vssd1 vssd1 vccd1 vccd1 _05897_ sky130_fd_sc_hd__a221o_1
X_10812_ _04762_ _04910_ _04911_ vssd1 vssd1 vccd1 vccd1 _04913_ sky130_fd_sc_hd__nand3_1
X_11792_ net224 net599 net579 net128 _05837_ vssd1 vssd1 vccd1 vccd1 _05838_ sky130_fd_sc_hd__a221o_1
XFILLER_0_39_102 vssd1 vssd1 vccd1 vccd1 sky130_fd_sc_hd__decap_8
XFILLER_0_39_135 vssd1 vssd1 vccd1 vccd1 sky130_fd_sc_hd__decap_3
XFILLER_0_67_477 vssd1 vssd1 vccd1 vccd1 sky130_fd_sc_hd__fill_1
X_10743_ _04840_ _04841_ _04842_ vssd1 vssd1 vccd1 vccd1 _04844_ sky130_fd_sc_hd__a21o_1
XFILLER_0_39_146 vssd1 vssd1 vccd1 vccd1 sky130_fd_sc_hd__decap_4
XFILLER_0_125_505 vssd1 vssd1 vccd1 vccd1 sky130_ef_sc_hd__decap_12
XFILLER_0_94_296 vssd1 vssd1 vccd1 vccd1 sky130_fd_sc_hd__fill_2
XFILLER_0_82_436 vssd1 vssd1 vccd1 vccd1 sky130_fd_sc_hd__decap_4
XFILLER_0_82_425 vssd1 vssd1 vccd1 vccd1 sky130_fd_sc_hd__fill_1
X_10674_ net1045 net719 _04773_ _04774_ vssd1 vssd1 vccd1 vccd1 _04776_ sky130_fd_sc_hd__o2bb2a_1
XFILLER_0_40_29 vssd1 vssd1 vccd1 vccd1 sky130_ef_sc_hd__decap_12
XFILLER_0_23_503 vssd1 vssd1 vccd1 vccd1 sky130_fd_sc_hd__fill_1
X_12413_ _00813_ net612 _01760_ net574 vssd1 vssd1 vccd1 vccd1 _06199_ sky130_fd_sc_hd__a22o_1
XFILLER_0_105_262 vssd1 vssd1 vccd1 vccd1 sky130_ef_sc_hd__decap_12
X_12344_ net1614 _00973_ net672 vssd1 vssd1 vccd1 vccd1 _00396_ sky130_fd_sc_hd__mux2_1
XFILLER_0_23_558 vssd1 vssd1 vccd1 vccd1 sky130_fd_sc_hd__fill_2
XFILLER_0_120_221 vssd1 vssd1 vccd1 vccd1 sky130_ef_sc_hd__decap_12
XFILLER_0_121_777 vssd1 vssd1 vccd1 vccd1 sky130_fd_sc_hd__decap_6
X_12275_ net1324 net53 net689 vssd1 vssd1 vccd1 vccd1 _00329_ sky130_fd_sc_hd__mux2_1
XFILLER_0_120_265 vssd1 vssd1 vccd1 vccd1 sky130_ef_sc_hd__decap_12
X_11226_ _05200_ _05319_ vssd1 vssd1 vccd1 vccd1 _05323_ sky130_fd_sc_hd__nand2_1
X_11157_ _05241_ _05253_ _05254_ vssd1 vssd1 vccd1 vccd1 _05255_ sky130_fd_sc_hd__and3_1
XFILLER_0_4_29 vssd1 vssd1 vccd1 vccd1 sky130_ef_sc_hd__decap_12
X_10108_ _03908_ _04054_ _04053_ vssd1 vssd1 vccd1 vccd1 _04214_ sky130_fd_sc_hd__a21boi_4
X_11088_ _05140_ _05141_ _05184_ _05185_ vssd1 vssd1 vccd1 vccd1 _05187_ sky130_fd_sc_hd__nand4_2
X_10039_ _04144_ vssd1 vssd1 vccd1 vccd1 _04145_ sky130_fd_sc_hd__inv_2
XFILLER_0_105_21 vssd1 vssd1 vccd1 vccd1 sky130_ef_sc_hd__decap_12
XFILLER_0_86_753 vssd1 vssd1 vccd1 vccd1 sky130_fd_sc_hd__decap_3
XFILLER_0_85_252 vssd1 vssd1 vccd1 vccd1 sky130_ef_sc_hd__decap_12
XFILLER_0_14_41 vssd1 vssd1 vccd1 vccd1 sky130_ef_sc_hd__decap_12
XFILLER_0_14_85 vssd1 vssd1 vccd1 vccd1 sky130_ef_sc_hd__decap_12
X_07250_ net922 net1018 net914 net1026 vssd1 vssd1 vccd1 vccd1 _01375_ sky130_fd_sc_hd__a22o_1
XFILLER_0_45_149 vssd1 vssd1 vccd1 vccd1 sky130_fd_sc_hd__fill_2
XFILLER_0_54_661 vssd1 vssd1 vccd1 vccd1 sky130_fd_sc_hd__fill_2
X_07181_ _01290_ _01304_ _01305_ _01103_ vssd1 vssd1 vccd1 vccd1 _01306_ sky130_fd_sc_hd__a211o_1
XFILLER_0_30_62 vssd1 vssd1 vccd1 vccd1 sky130_fd_sc_hd__fill_2
XFILLER_0_112_755 vssd1 vssd1 vccd1 vccd1 sky130_fd_sc_hd__fill_1
X_09822_ _03782_ _03785_ vssd1 vssd1 vccd1 vccd1 _03929_ sky130_fd_sc_hd__nand2_2
X_09753_ _03856_ _03859_ _03860_ vssd1 vssd1 vccd1 vccd1 _03861_ sky130_fd_sc_hd__and3_1
XTAP_263 vssd1 vccd1 sky130_fd_sc_hd__tapvpwrvgnd_1
XTAP_274 vssd1 vccd1 sky130_fd_sc_hd__tapvpwrvgnd_1
X_08704_ _02817_ _02818_ vssd1 vssd1 vccd1 vccd1 _02819_ sky130_fd_sc_hd__nor2_1
XTAP_296 vssd1 vccd1 sky130_fd_sc_hd__tapvpwrvgnd_1
XTAP_285 vssd1 vccd1 sky130_fd_sc_hd__tapvpwrvgnd_1
X_06965_ _01088_ _01089_ _01084_ vssd1 vssd1 vccd1 vccd1 _01090_ sky130_fd_sc_hd__a21o_1
XTAP_2108 vssd1 vccd1 sky130_fd_sc_hd__tapvpwrvgnd_1
X_09684_ _03789_ _03790_ vssd1 vssd1 vccd1 vccd1 _03792_ sky130_fd_sc_hd__xnor2_4
X_06896_ net895 net1081 net1088 net888 vssd1 vssd1 vccd1 vccd1 _01021_ sky130_fd_sc_hd__a22o_1
XTAP_2119 vssd1 vccd1 sky130_fd_sc_hd__tapvpwrvgnd_1
X_08635_ _02741_ _02749_ vssd1 vssd1 vccd1 vccd1 _02750_ sky130_fd_sc_hd__and2_2
XFILLER_0_68_219 vssd1 vssd1 vccd1 vccd1 sky130_fd_sc_hd__decap_3
X_08566_ net1148 net720 vssd1 vssd1 vccd1 vccd1 _02681_ sky130_fd_sc_hd__nand2_1
XFILLER_0_89_580 vssd1 vssd1 vccd1 vccd1 sky130_fd_sc_hd__fill_2
XTAP_1429 vssd1 vccd1 sky130_fd_sc_hd__tapvpwrvgnd_1
XTAP_1418 vssd1 vccd1 sky130_fd_sc_hd__tapvpwrvgnd_1
XTAP_1407 vssd1 vccd1 sky130_fd_sc_hd__tapvpwrvgnd_1
XFILLER_0_77_775 vssd1 vssd1 vccd1 vccd1 sky130_fd_sc_hd__fill_1
XFILLER_0_76_241 vssd1 vssd1 vccd1 vccd1 sky130_fd_sc_hd__decap_8
X_07517_ _01625_ _01638_ _01641_ vssd1 vssd1 vccd1 vccd1 _01642_ sky130_fd_sc_hd__nand3_1
XFILLER_0_37_617 vssd1 vssd1 vccd1 vccd1 sky130_fd_sc_hd__decap_8
X_08497_ _02610_ _02611_ _02597_ vssd1 vssd1 vccd1 vccd1 _02613_ sky130_fd_sc_hd__a21o_1
XFILLER_0_76_274 vssd1 vssd1 vccd1 vccd1 sky130_fd_sc_hd__decap_6
XFILLER_0_71_80 vssd1 vssd1 vccd1 vccd1 sky130_fd_sc_hd__fill_1
X_07448_ net876 net1136 net1144 net866 vssd1 vssd1 vccd1 vccd1 _01573_ sky130_fd_sc_hd__a22o_1
X_07379_ _01497_ _01502_ _01503_ vssd1 vssd1 vccd1 vccd1 _01504_ sky130_fd_sc_hd__nand3_2
XFILLER_0_60_620 vssd1 vssd1 vccd1 vccd1 sky130_fd_sc_hd__decap_4
X_09118_ _03227_ _03228_ _03229_ vssd1 vssd1 vccd1 vccd1 _03230_ sky130_fd_sc_hd__nand3_1
XFILLER_0_44_182 vssd1 vssd1 vccd1 vccd1 sky130_fd_sc_hd__decap_3
X_10390_ _04484_ _04491_ _04492_ vssd1 vssd1 vccd1 vccd1 _04494_ sky130_fd_sc_hd__nand3_1
X_09049_ net1080 net761 _03158_ _03159_ vssd1 vssd1 vccd1 vccd1 _03161_ sky130_fd_sc_hd__o2bb2a_1
XFILLER_0_20_528 vssd1 vssd1 vccd1 vccd1 sky130_fd_sc_hd__fill_1
Xhold470 add1.b_i\[16\] vssd1 vssd1 vccd1 vccd1 net1685 sky130_fd_sc_hd__dlygate4sd3_1
X_12060_ x0mx2\[6\] net628 net590 y1my2\[6\] vssd1 vssd1 vccd1 vccd1 _06051_ sky130_fd_sc_hd__a22o_1
Xhold481 temp1\[5\] vssd1 vssd1 vccd1 vccd1 net1696 sky130_fd_sc_hd__dlygate4sd3_1
Xhold492 sub1.a_i\[9\] vssd1 vssd1 vccd1 vccd1 net1707 sky130_fd_sc_hd__dlygate4sd3_1
X_11011_ net757 net975 vssd1 vssd1 vccd1 vccd1 _05110_ sky130_fd_sc_hd__nand2_1
Xfanout961 net962 vssd1 vssd1 vccd1 vccd1 net961 sky130_fd_sc_hd__buf_2
Xfanout950 net951 vssd1 vssd1 vccd1 vccd1 net950 sky130_fd_sc_hd__clkbuf_2
Xfanout994 net995 vssd1 vssd1 vccd1 vccd1 net994 sky130_fd_sc_hd__buf_2
Xfanout983 mul1.a\[21\] vssd1 vssd1 vccd1 vccd1 net983 sky130_fd_sc_hd__clkbuf_2
Xfanout972 mul1.a\[23\] vssd1 vssd1 vccd1 vccd1 net972 sky130_fd_sc_hd__buf_2
X_12962_ clknet_leaf_45_clk_i _00348_ net1156 vssd1 vssd1 vccd1 vccd1 y1my2\[15\]
+ sky130_fd_sc_hd__dfrtp_1
XFILLER_0_99_366 vssd1 vssd1 vccd1 vccd1 sky130_fd_sc_hd__fill_1
X_11913_ net1321 _05939_ net477 vssd1 vssd1 vccd1 vccd1 _00221_ sky130_fd_sc_hd__mux2_1
X_12893_ clknet_leaf_39_clk_i _00279_ vssd1 vssd1 vccd1 vccd1 mul1.a\[28\] sky130_fd_sc_hd__dfxtp_1
XFILLER_0_68_742 vssd1 vssd1 vccd1 vccd1 sky130_ef_sc_hd__decap_12
X_11844_ net1410 _05882_ net481 vssd1 vssd1 vccd1 vccd1 _00209_ sky130_fd_sc_hd__mux2_1
XTAP_1952 vssd1 vccd1 sky130_fd_sc_hd__tapvpwrvgnd_1
XTAP_1941 vssd1 vccd1 sky130_fd_sc_hd__tapvpwrvgnd_1
XTAP_1930 vssd1 vccd1 sky130_fd_sc_hd__tapvpwrvgnd_1
XFILLER_0_95_561 vssd1 vssd1 vccd1 vccd1 sky130_fd_sc_hd__fill_2
XTAP_1985 vssd1 vccd1 sky130_fd_sc_hd__tapvpwrvgnd_1
XTAP_1963 vssd1 vccd1 sky130_fd_sc_hd__tapvpwrvgnd_1
XTAP_1974 vssd1 vccd1 sky130_fd_sc_hd__tapvpwrvgnd_1
XFILLER_0_95_594 vssd1 vssd1 vccd1 vccd1 sky130_fd_sc_hd__decap_3
X_11775_ net652 _00872_ net474 _05823_ vssd1 vssd1 vccd1 vccd1 _05824_ sky130_fd_sc_hd__a211o_1
XFILLER_0_126_825 vssd1 vssd1 vccd1 vccd1 sky130_fd_sc_hd__decap_8
XTAP_1996 vssd1 vccd1 sky130_fd_sc_hd__tapvpwrvgnd_1
XFILLER_0_67_296 vssd1 vssd1 vccd1 vccd1 sky130_fd_sc_hd__decap_6
X_10726_ _04821_ _04826_ vssd1 vssd1 vccd1 vccd1 _04827_ sky130_fd_sc_hd__nand2_1
XFILLER_0_83_789 vssd1 vssd1 vccd1 vccd1 sky130_fd_sc_hd__fill_1
X_10657_ _04757_ _04758_ vssd1 vssd1 vccd1 vccd1 _04759_ sky130_fd_sc_hd__and2b_1
XFILLER_0_36_672 vssd1 vssd1 vccd1 vccd1 sky130_fd_sc_hd__decap_6
XFILLER_0_106_560 vssd1 vssd1 vccd1 vccd1 sky130_ef_sc_hd__decap_12
XFILLER_0_3_717 vssd1 vssd1 vccd1 vccd1 sky130_fd_sc_hd__fill_2
XFILLER_0_2_205 vssd1 vssd1 vccd1 vccd1 sky130_fd_sc_hd__fill_1
X_10588_ net851 net844 net936 net933 vssd1 vssd1 vccd1 vccd1 _04690_ sky130_fd_sc_hd__and4_1
XFILLER_0_121_541 vssd1 vssd1 vccd1 vccd1 sky130_ef_sc_hd__decap_12
X_12327_ net1672 _00882_ net666 vssd1 vssd1 vccd1 vccd1 _00379_ sky130_fd_sc_hd__mux2_1
XFILLER_0_121_585 vssd1 vssd1 vccd1 vccd1 sky130_ef_sc_hd__decap_12
X_12258_ x2mx1\[31\] net605 net588 temp1\[31\] vssd1 vssd1 vccd1 vccd1 _06192_ sky130_fd_sc_hd__a22o_1
X_11209_ _05264_ _05266_ _05305_ _05306_ vssd1 vssd1 vccd1 vccd1 _05307_ sky130_fd_sc_hd__or4_4
X_12189_ x2mx1\[8\] net602 net583 temp1\[8\] vssd1 vssd1 vccd1 vccd1 _06146_ sky130_fd_sc_hd__a22o_1
X_06750_ net1478 _00965_ net637 vssd1 vssd1 vccd1 vccd1 _00032_ sky130_fd_sc_hd__mux2_1
X_06681_ _00905_ _00906_ vssd1 vssd1 vccd1 vccd1 _00907_ sky130_fd_sc_hd__nor2_2
XFILLER_0_116_53 vssd1 vssd1 vccd1 vccd1 sky130_ef_sc_hd__decap_12
X_08420_ _02395_ _02397_ _02534_ _02535_ vssd1 vssd1 vccd1 vccd1 _02537_ sky130_fd_sc_hd__a211o_1
XFILLER_0_25_51 vssd1 vssd1 vccd1 vccd1 sky130_fd_sc_hd__decap_4
XFILLER_0_116_97 vssd1 vssd1 vccd1 vccd1 sky130_ef_sc_hd__decap_12
XFILLER_0_74_701 vssd1 vssd1 vccd1 vccd1 sky130_fd_sc_hd__fill_1
X_08351_ net1051 net1059 net815 vssd1 vssd1 vccd1 vccd1 _02468_ sky130_fd_sc_hd__and3_1
XFILLER_0_86_583 vssd1 vssd1 vccd1 vccd1 sky130_fd_sc_hd__decap_4
XFILLER_0_58_285 vssd1 vssd1 vccd1 vccd1 sky130_ef_sc_hd__decap_12
XFILLER_0_46_414 vssd1 vssd1 vccd1 vccd1 sky130_fd_sc_hd__decap_6
XFILLER_0_129_685 vssd1 vssd1 vccd1 vccd1 sky130_fd_sc_hd__fill_2
X_08282_ _02062_ _02277_ _02276_ vssd1 vssd1 vccd1 vccd1 _02400_ sky130_fd_sc_hd__o21a_1
XFILLER_0_46_458 vssd1 vssd1 vccd1 vccd1 sky130_fd_sc_hd__fill_2
X_07302_ _01417_ _01420_ _01418_ vssd1 vssd1 vccd1 vccd1 _01427_ sky130_fd_sc_hd__o21ba_1
XFILLER_0_61_428 vssd1 vssd1 vccd1 vccd1 sky130_fd_sc_hd__decap_6
XFILLER_0_61_406 vssd1 vssd1 vccd1 vccd1 sky130_fd_sc_hd__decap_6
X_07233_ _01222_ _01223_ vssd1 vssd1 vccd1 vccd1 _01358_ sky130_fd_sc_hd__nand2_1
XFILLER_0_116_357 vssd1 vssd1 vccd1 vccd1 sky130_fd_sc_hd__decap_6
XFILLER_0_54_491 vssd1 vssd1 vccd1 vccd1 sky130_fd_sc_hd__fill_1
XFILLER_0_14_322 vssd1 vssd1 vccd1 vccd1 sky130_fd_sc_hd__fill_2
XFILLER_0_26_171 vssd1 vssd1 vccd1 vccd1 sky130_ef_sc_hd__decap_12
X_07164_ _01081_ _01082_ vssd1 vssd1 vccd1 vccd1 _01289_ sky130_fd_sc_hd__xnor2_1
XFILLER_0_41_130 vssd1 vssd1 vccd1 vccd1 sky130_fd_sc_hd__decap_3
XFILLER_0_42_642 vssd1 vssd1 vccd1 vccd1 sky130_fd_sc_hd__fill_2
XFILLER_0_74_3 vssd1 vssd1 vccd1 vccd1 sky130_ef_sc_hd__decap_12
X_07095_ net855 net1096 _01163_ _01164_ net1081 vssd1 vssd1 vccd1 vccd1 _01220_ sky130_fd_sc_hd__a32o_1
XFILLER_0_41_163 vssd1 vssd1 vccd1 vccd1 sky130_fd_sc_hd__decap_4
XFILLER_0_2_783 vssd1 vssd1 vccd1 vccd1 sky130_fd_sc_hd__fill_2
X_09805_ net1093 net1100 net711 vssd1 vssd1 vccd1 vccd1 _03912_ sky130_fd_sc_hd__and3_1
X_07997_ net1043 net857 vssd1 vssd1 vccd1 vccd1 _02117_ sky130_fd_sc_hd__nand2_1
X_09736_ _03679_ _03681_ _03680_ vssd1 vssd1 vccd1 vccd1 _03844_ sky130_fd_sc_hd__a21bo_1
X_06948_ _01070_ _01071_ _01069_ vssd1 vssd1 vccd1 vccd1 _01073_ sky130_fd_sc_hd__a21bo_1
X_09667_ _03615_ _03617_ vssd1 vssd1 vccd1 vccd1 _03775_ sky130_fd_sc_hd__nand2_1
X_08618_ _02731_ _02732_ _02587_ _02591_ vssd1 vssd1 vccd1 vccd1 _02733_ sky130_fd_sc_hd__a211o_1
XTAP_1204 vssd1 vccd1 sky130_fd_sc_hd__tapvpwrvgnd_1
X_06879_ _00978_ _00999_ _01005_ _01007_ _00982_ vssd1 vssd1 vccd1 vccd1 _01008_ sky130_fd_sc_hd__o41a_1
XTAP_1248 vssd1 vccd1 sky130_fd_sc_hd__tapvpwrvgnd_1
X_09598_ net883 net945 vssd1 vssd1 vccd1 vccd1 _03707_ sky130_fd_sc_hd__nand2_1
XTAP_1237 vssd1 vccd1 sky130_fd_sc_hd__tapvpwrvgnd_1
XTAP_1226 vssd1 vccd1 sky130_fd_sc_hd__tapvpwrvgnd_1
XTAP_1215 vssd1 vccd1 sky130_fd_sc_hd__tapvpwrvgnd_1
XFILLER_0_49_241 vssd1 vssd1 vccd1 vccd1 sky130_ef_sc_hd__decap_12
X_08549_ _02662_ _02663_ _02528_ _02530_ vssd1 vssd1 vccd1 vccd1 _02665_ sky130_fd_sc_hd__a211o_1
XFILLER_0_65_723 vssd1 vssd1 vccd1 vccd1 sky130_fd_sc_hd__fill_2
XFILLER_0_65_712 vssd1 vssd1 vccd1 vccd1 sky130_fd_sc_hd__fill_1
XTAP_1259 vssd1 vccd1 sky130_fd_sc_hd__tapvpwrvgnd_1
XFILLER_0_108_803 vssd1 vssd1 vccd1 vccd1 sky130_fd_sc_hd__fill_1
X_11560_ _05504_ _05548_ vssd1 vssd1 vccd1 vccd1 _05655_ sky130_fd_sc_hd__nand2b_1
X_10511_ _04386_ _04387_ vssd1 vssd1 vccd1 vccd1 _04614_ sky130_fd_sc_hd__nand2_1
XFILLER_0_18_672 vssd1 vssd1 vccd1 vccd1 sky130_fd_sc_hd__decap_3
XFILLER_0_25_609 vssd1 vssd1 vccd1 vccd1 sky130_fd_sc_hd__decap_4
X_13230_ net507 vssd1 vssd1 vccd1 vccd1 net286 sky130_fd_sc_hd__clkbuf_1
X_11491_ net807 _05330_ _05329_ vssd1 vssd1 vccd1 vccd1 _05586_ sky130_fd_sc_hd__a21o_1
X_10442_ _04431_ _04438_ _04437_ vssd1 vssd1 vccd1 vccd1 _04545_ sky130_fd_sc_hd__a21bo_1
XFILLER_0_60_450 vssd1 vssd1 vccd1 vccd1 sky130_fd_sc_hd__decap_3
XFILLER_0_21_804 vssd1 vssd1 vccd1 vccd1 sky130_fd_sc_hd__fill_2
X_13161_ clknet_leaf_12_clk_i _00547_ net1187 vssd1 vssd1 vccd1 vccd1 l0\[22\] sky130_fd_sc_hd__dfrtp_1
X_10373_ net1014 net760 vssd1 vssd1 vccd1 vccd1 _04477_ sky130_fd_sc_hd__and2_1
X_13092_ clknet_leaf_41_clk_i _00478_ vssd1 vssd1 vccd1 vccd1 temp1\[17\] sky130_fd_sc_hd__dfxtp_1
X_12112_ x0mx2\[19\] net630 net593 y1my2\[19\] vssd1 vssd1 vccd1 vccd1 _06090_ sky130_fd_sc_hd__a22o_1
XFILLER_0_20_369 vssd1 vssd1 vccd1 vccd1 sky130_fd_sc_hd__fill_1
X_12043_ net1142 _06038_ net516 vssd1 vssd1 vccd1 vccd1 _00252_ sky130_fd_sc_hd__mux2_1
Xfanout780 mul1.b\[18\] vssd1 vssd1 vccd1 vccd1 net780 sky130_fd_sc_hd__clkbuf_4
Xfanout791 net794 vssd1 vssd1 vccd1 vccd1 net791 sky130_fd_sc_hd__clkbuf_2
XFILLER_0_87_325 vssd1 vssd1 vccd1 vccd1 sky130_fd_sc_hd__fill_2
XFILLER_0_62_27 vssd1 vssd1 vccd1 vccd1 sky130_fd_sc_hd__fill_1
X_12945_ clknet_leaf_21_clk_i _00331_ net1175 vssd1 vssd1 vccd1 vccd1 posy\[7\] sky130_fd_sc_hd__dfrtp_2
X_12876_ clknet_leaf_43_clk_i _00262_ vssd1 vssd1 vccd1 vccd1 mul1.a\[11\] sky130_fd_sc_hd__dfxtp_2
XTAP_1760 vssd1 vccd1 sky130_fd_sc_hd__tapvpwrvgnd_1
XFILLER_0_56_701 vssd1 vssd1 vccd1 vccd1 sky130_fd_sc_hd__fill_1
X_11827_ net102 net669 _05865_ _05867_ vssd1 vssd1 vccd1 vccd1 _05868_ sky130_fd_sc_hd__a211o_1
XFILLER_0_28_425 vssd1 vssd1 vccd1 vccd1 sky130_fd_sc_hd__fill_1
XTAP_1793 vssd1 vccd1 sky130_fd_sc_hd__tapvpwrvgnd_1
XTAP_1771 vssd1 vccd1 sky130_fd_sc_hd__tapvpwrvgnd_1
XTAP_1782 vssd1 vccd1 sky130_fd_sc_hd__tapvpwrvgnd_1
XFILLER_0_83_531 vssd1 vssd1 vccd1 vccd1 sky130_fd_sc_hd__decap_3
X_11758_ net185 net470 _05809_ vssd1 vssd1 vccd1 vccd1 _05810_ sky130_fd_sc_hd__o21a_1
XFILLER_0_126_633 vssd1 vssd1 vccd1 vccd1 sky130_fd_sc_hd__decap_8
X_10709_ _04808_ _04809_ vssd1 vssd1 vccd1 vccd1 _04811_ sky130_fd_sc_hd__nor2_2
XFILLER_0_71_726 vssd1 vssd1 vccd1 vccd1 sky130_fd_sc_hd__fill_2
XFILLER_0_55_277 vssd1 vssd1 vccd1 vccd1 sky130_fd_sc_hd__decap_3
X_11689_ net1329 _05205_ net539 vssd1 vssd1 vccd1 vccd1 _00181_ sky130_fd_sc_hd__mux2_1
XFILLER_0_43_428 vssd1 vssd1 vccd1 vccd1 sky130_ef_sc_hd__decap_12
XFILLER_0_3_503 vssd1 vssd1 vccd1 vccd1 sky130_fd_sc_hd__fill_1
XFILLER_0_126_699 vssd1 vssd1 vccd1 vccd1 sky130_fd_sc_hd__fill_1
XFILLER_0_113_305 vssd1 vssd1 vccd1 vccd1 sky130_ef_sc_hd__decap_12
XFILLER_0_102_77 vssd1 vssd1 vccd1 vccd1 sky130_fd_sc_hd__decap_6
XFILLER_0_24_642 vssd1 vssd1 vccd1 vccd1 sky130_fd_sc_hd__fill_2
XFILLER_0_113_349 vssd1 vssd1 vccd1 vccd1 sky130_ef_sc_hd__decap_12
XFILLER_0_23_152 vssd1 vssd1 vccd1 vccd1 sky130_ef_sc_hd__decap_12
XFILLER_0_87_57 vssd1 vssd1 vccd1 vccd1 sky130_ef_sc_hd__decap_12
XFILLER_0_121_393 vssd1 vssd1 vccd1 vccd1 sky130_ef_sc_hd__decap_12
X_07920_ _02003_ _02005_ _02038_ _02039_ vssd1 vssd1 vccd1 vccd1 _02041_ sky130_fd_sc_hd__or4_1
XFILLER_0_11_369 vssd1 vssd1 vccd1 vccd1 sky130_fd_sc_hd__decap_3
X_07851_ _01968_ _01971_ vssd1 vssd1 vccd1 vccd1 _01972_ sky130_fd_sc_hd__xor2_1
Xinput2 div_sstream_i[0] vssd1 vssd1 vccd1 vccd1 net2 sky130_fd_sc_hd__clkbuf_8
X_06802_ net1598 net1569 net642 vssd1 vssd1 vccd1 vccd1 _00076_ sky130_fd_sc_hd__mux2_1
X_07782_ _01902_ _01903_ vssd1 vssd1 vccd1 vccd1 _01904_ sky130_fd_sc_hd__nor2_1
X_09521_ _03609_ _03610_ _03627_ _03628_ vssd1 vssd1 vccd1 vccd1 _03630_ sky130_fd_sc_hd__nor4_2
X_06733_ _00949_ _00950_ vssd1 vssd1 vccd1 vccd1 _00951_ sky130_fd_sc_hd__xor2_4
XFILLER_0_78_314 vssd1 vssd1 vccd1 vccd1 sky130_fd_sc_hd__fill_1
X_09452_ _03502_ _03503_ _03560_ _03561_ vssd1 vssd1 vccd1 vccd1 _03562_ sky130_fd_sc_hd__or4bb_4
X_06664_ net1704 _00892_ net634 vssd1 vssd1 vccd1 vccd1 _00019_ sky130_fd_sc_hd__mux2_1
X_09383_ _03491_ _03492_ _03484_ vssd1 vssd1 vccd1 vccd1 _03493_ sky130_fd_sc_hd__a21o_1
X_08403_ _02518_ _02519_ _02485_ vssd1 vssd1 vccd1 vccd1 _02520_ sky130_fd_sc_hd__o21ai_2
X_06595_ sub1.a_i\[6\] _00592_ vssd1 vssd1 vccd1 vccd1 _00834_ sky130_fd_sc_hd__nor2_1
X_08334_ _02448_ _02449_ _02444_ vssd1 vssd1 vccd1 vccd1 _02451_ sky130_fd_sc_hd__a21o_1
XFILLER_0_47_734 vssd1 vssd1 vccd1 vccd1 sky130_fd_sc_hd__fill_1
XFILLER_0_46_222 vssd1 vssd1 vccd1 vccd1 sky130_fd_sc_hd__fill_1
XFILLER_0_116_121 vssd1 vssd1 vccd1 vccd1 sky130_ef_sc_hd__decap_12
XFILLER_0_62_715 vssd1 vssd1 vccd1 vccd1 sky130_ef_sc_hd__decap_12
X_08265_ _02381_ _02382_ _02350_ vssd1 vssd1 vccd1 vccd1 _02383_ sky130_fd_sc_hd__o21ai_2
XFILLER_0_61_225 vssd1 vssd1 vccd1 vccd1 sky130_fd_sc_hd__decap_8
XFILLER_0_46_288 vssd1 vssd1 vccd1 vccd1 sky130_fd_sc_hd__fill_1
XFILLER_0_34_439 vssd1 vssd1 vccd1 vccd1 sky130_fd_sc_hd__decap_4
XFILLER_0_116_165 vssd1 vssd1 vccd1 vccd1 sky130_ef_sc_hd__decap_12
X_08196_ net1098 net781 vssd1 vssd1 vccd1 vccd1 _02314_ sky130_fd_sc_hd__nand2_1
X_07216_ net1113 net820 net813 net1120 vssd1 vssd1 vccd1 vccd1 _01341_ sky130_fd_sc_hd__and4_1
XFILLER_0_14_141 vssd1 vssd1 vccd1 vccd1 sky130_fd_sc_hd__fill_1
XFILLER_0_15_642 vssd1 vssd1 vccd1 vccd1 sky130_fd_sc_hd__decap_6
X_07147_ _01268_ _01270_ _01068_ vssd1 vssd1 vccd1 vccd1 _01272_ sky130_fd_sc_hd__o21ai_1
XFILLER_0_42_472 vssd1 vssd1 vccd1 vccd1 sky130_fd_sc_hd__decap_4
Xoutput350 net350 vssd1 vssd1 vccd1 vccd1 mstream_o[113] sky130_fd_sc_hd__clkbuf_4
XFILLER_0_100_511 vssd1 vssd1 vccd1 vccd1 sky130_fd_sc_hd__decap_3
X_07078_ _01144_ _01146_ _01145_ vssd1 vssd1 vccd1 vccd1 _01203_ sky130_fd_sc_hd__a21bo_1
Xoutput361 net361 vssd1 vssd1 vccd1 vccd1 mstream_o[1] sky130_fd_sc_hd__buf_2
XFILLER_0_100_555 vssd1 vssd1 vccd1 vccd1 sky130_fd_sc_hd__decap_4
Xfanout1008 net1010 vssd1 vssd1 vccd1 vccd1 net1008 sky130_fd_sc_hd__buf_1
Xoutput372 net372 vssd1 vssd1 vccd1 vccd1 mstream_o[2] sky130_fd_sc_hd__clkbuf_4
Xoutput383 net383 vssd1 vssd1 vccd1 vccd1 mstream_o[3] sky130_fd_sc_hd__clkbuf_4
Xoutput394 net394 vssd1 vssd1 vccd1 vccd1 mstream_o[4] sky130_fd_sc_hd__buf_2
Xfanout1019 net1020 vssd1 vssd1 vccd1 vccd1 net1019 sky130_fd_sc_hd__buf_2
XFILLER_0_97_601 vssd1 vssd1 vccd1 vccd1 sky130_ef_sc_hd__decap_12
X_09719_ _03823_ _03824_ _03825_ vssd1 vssd1 vccd1 vccd1 _03827_ sky130_fd_sc_hd__a21o_1
X_10991_ net836 _05088_ _05089_ vssd1 vssd1 vccd1 vccd1 _05090_ sky130_fd_sc_hd__a21oi_1
X_12730_ clknet_leaf_7_clk_i _00116_ net1195 vssd1 vssd1 vccd1 vccd1 net350 sky130_fd_sc_hd__dfrtp_1
XTAP_1012 vssd1 vccd1 sky130_fd_sc_hd__tapvpwrvgnd_1
XTAP_1001 vssd1 vccd1 sky130_fd_sc_hd__tapvpwrvgnd_1
XFILLER_0_97_689 vssd1 vssd1 vccd1 vccd1 sky130_fd_sc_hd__fill_1
XFILLER_0_84_317 vssd1 vssd1 vccd1 vccd1 sky130_fd_sc_hd__fill_1
X_12661_ clknet_leaf_21_clk_i _00047_ net1177 vssd1 vssd1 vccd1 vccd1 net388 sky130_fd_sc_hd__dfrtp_1
XTAP_1056 vssd1 vccd1 sky130_fd_sc_hd__tapvpwrvgnd_1
XTAP_1045 vssd1 vccd1 sky130_fd_sc_hd__tapvpwrvgnd_1
XTAP_1034 vssd1 vccd1 sky130_fd_sc_hd__tapvpwrvgnd_1
XTAP_1023 vssd1 vccd1 sky130_fd_sc_hd__tapvpwrvgnd_1
XFILLER_0_38_701 vssd1 vssd1 vccd1 vccd1 sky130_fd_sc_hd__fill_1
XFILLER_0_127_419 vssd1 vssd1 vccd1 vccd1 sky130_fd_sc_hd__fill_1
XTAP_1089 vssd1 vccd1 sky130_fd_sc_hd__tapvpwrvgnd_1
XTAP_1067 vssd1 vccd1 sky130_fd_sc_hd__tapvpwrvgnd_1
XTAP_1078 vssd1 vccd1 sky130_fd_sc_hd__tapvpwrvgnd_1
X_11612_ _05584_ _05599_ _05597_ vssd1 vssd1 vccd1 vccd1 _05706_ sky130_fd_sc_hd__a21oi_1
XFILLER_0_38_745 vssd1 vssd1 vccd1 vccd1 sky130_fd_sc_hd__decap_3
X_12592_ net1497 net3 net557 vssd1 vssd1 vccd1 vccd1 _00567_ sky130_fd_sc_hd__mux2_1
X_11543_ _05632_ _05637_ vssd1 vssd1 vccd1 vccd1 _05638_ sky130_fd_sc_hd__nor2_1
XFILLER_0_108_699 vssd1 vssd1 vccd1 vccd1 sky130_fd_sc_hd__fill_1
XFILLER_0_52_269 vssd1 vssd1 vccd1 vccd1 sky130_fd_sc_hd__fill_1
X_11474_ _05565_ _05568_ vssd1 vssd1 vccd1 vccd1 _05569_ sky130_fd_sc_hd__xnor2_1
X_10425_ _04396_ _04397_ _04399_ vssd1 vssd1 vccd1 vccd1 _04528_ sky130_fd_sc_hd__a21o_1
XFILLER_0_80_589 vssd1 vssd1 vccd1 vccd1 sky130_ef_sc_hd__decap_12
XFILLER_0_21_612 vssd1 vssd1 vccd1 vccd1 sky130_fd_sc_hd__decap_4
X_13144_ clknet_leaf_14_clk_i _00530_ net1184 vssd1 vssd1 vccd1 vccd1 l0\[5\] sky130_fd_sc_hd__dfrtp_1
XFILLER_0_60_291 vssd1 vssd1 vccd1 vccd1 sky130_fd_sc_hd__fill_2
XFILLER_0_20_111 vssd1 vssd1 vccd1 vccd1 sky130_fd_sc_hd__fill_1
XFILLER_0_103_393 vssd1 vssd1 vccd1 vccd1 sky130_fd_sc_hd__decap_3
X_10356_ _04451_ _04457_ _04458_ vssd1 vssd1 vccd1 vccd1 _04460_ sky130_fd_sc_hd__nand3_2
XFILLER_0_0_539 vssd1 vssd1 vccd1 vccd1 sky130_fd_sc_hd__fill_1
XTAP_807 vssd1 vccd1 sky130_fd_sc_hd__tapvpwrvgnd_1
X_10287_ _04389_ _04390_ vssd1 vssd1 vccd1 vccd1 _04391_ sky130_fd_sc_hd__xnor2_2
X_13075_ clknet_leaf_53_clk_i _00461_ vssd1 vssd1 vccd1 vccd1 temp1\[0\] sky130_fd_sc_hd__dfxtp_1
XTAP_818 vssd1 vccd1 sky130_fd_sc_hd__tapvpwrvgnd_1
XTAP_829 vssd1 vccd1 sky130_fd_sc_hd__tapvpwrvgnd_1
X_12026_ net114 net623 net597 net82 vssd1 vssd1 vccd1 vccd1 _06024_ sky130_fd_sc_hd__a22o_1
Xclkbuf_3_2__f_clk_i clknet_0_clk_i vssd1 vssd1 vccd1 vccd1 clknet_3_2__leaf_clk_i
+ sky130_fd_sc_hd__clkbuf_16
XFILLER_0_73_15 vssd1 vssd1 vccd1 vccd1 sky130_ef_sc_hd__decap_12
XFILLER_0_88_645 vssd1 vssd1 vccd1 vccd1 sky130_fd_sc_hd__decap_4
X_12928_ clknet_leaf_31_clk_i _00314_ vssd1 vssd1 vccd1 vccd1 mul1.b\[31\] sky130_fd_sc_hd__dfxtp_1
XFILLER_0_88_689 vssd1 vssd1 vccd1 vccd1 sky130_fd_sc_hd__decap_8
XFILLER_0_75_328 vssd1 vssd1 vccd1 vccd1 sky130_fd_sc_hd__decap_3
XFILLER_0_118_419 vssd1 vssd1 vccd1 vccd1 sky130_fd_sc_hd__fill_1
XFILLER_0_68_380 vssd1 vssd1 vccd1 vccd1 sky130_fd_sc_hd__decap_3
X_12859_ clknet_leaf_30_clk_i _00245_ vssd1 vssd1 vccd1 vccd1 sub1.b_i\[26\] sky130_fd_sc_hd__dfxtp_1
X_06380_ net545 _00689_ vssd1 vssd1 vccd1 vccd1 net312 sky130_fd_sc_hd__nor2_1
XFILLER_0_90_309 vssd1 vssd1 vccd1 vccd1 sky130_ef_sc_hd__decap_12
XTAP_1590 vssd1 vccd1 sky130_fd_sc_hd__tapvpwrvgnd_1
XFILLER_0_22_41 vssd1 vssd1 vccd1 vccd1 sky130_ef_sc_hd__decap_12
XFILLER_0_28_266 vssd1 vssd1 vccd1 vccd1 sky130_fd_sc_hd__fill_1
XFILLER_0_114_625 vssd1 vssd1 vccd1 vccd1 sky130_ef_sc_hd__decap_12
XFILLER_0_113_113 vssd1 vssd1 vccd1 vccd1 sky130_ef_sc_hd__decap_12
XFILLER_0_71_545 vssd1 vssd1 vccd1 vccd1 sky130_ef_sc_hd__decap_12
XFILLER_0_43_258 vssd1 vssd1 vccd1 vccd1 sky130_fd_sc_hd__decap_3
X_08050_ net1741 _02169_ net522 vssd1 vssd1 vccd1 vccd1 _00128_ sky130_fd_sc_hd__mux2_1
XFILLER_0_114_669 vssd1 vssd1 vccd1 vccd1 sky130_ef_sc_hd__decap_12
X_07001_ _01124_ _01125_ net855 net1103 vssd1 vssd1 vccd1 vccd1 _01126_ sky130_fd_sc_hd__and4bb_1
XFILLER_0_11_111 vssd1 vssd1 vccd1 vccd1 sky130_fd_sc_hd__fill_1
X_08952_ net955 _03064_ _03063_ vssd1 vssd1 vccd1 vccd1 _03065_ sky130_fd_sc_hd__a21bo_1
X_08883_ _02994_ net734 net1107 _02993_ vssd1 vssd1 vccd1 vccd1 _02996_ sky130_fd_sc_hd__and4b_1
X_07903_ net912 net994 net986 net920 vssd1 vssd1 vccd1 vccd1 _02024_ sky130_fd_sc_hd__a22o_1
XFILLER_0_37_3 vssd1 vssd1 vccd1 vccd1 sky130_ef_sc_hd__decap_12
X_07834_ _01758_ _01759_ _01762_ _01954_ vssd1 vssd1 vccd1 vccd1 _01955_ sky130_fd_sc_hd__a31o_1
XFILLER_0_98_409 vssd1 vssd1 vccd1 vccd1 sky130_fd_sc_hd__fill_2
XFILLER_0_79_601 vssd1 vssd1 vccd1 vccd1 sky130_fd_sc_hd__decap_8
X_07765_ net1082 net831 _01885_ _01886_ vssd1 vssd1 vccd1 vccd1 _01887_ sky130_fd_sc_hd__a22o_1
X_09504_ net1080 net746 _03470_ _03471_ net754 vssd1 vssd1 vccd1 vccd1 _03613_ sky130_fd_sc_hd__a32o_1
XFILLER_0_79_667 vssd1 vssd1 vccd1 vccd1 sky130_fd_sc_hd__decap_4
X_07696_ _01815_ _01818_ vssd1 vssd1 vccd1 vccd1 _01819_ sky130_fd_sc_hd__xnor2_2
X_06716_ sub1.b_i\[25\] sub1.a_i\[25\] vssd1 vssd1 vccd1 vccd1 _00936_ sky130_fd_sc_hd__and2b_1
XFILLER_0_39_509 vssd1 vssd1 vccd1 vccd1 sky130_fd_sc_hd__fill_1
XFILLER_0_94_626 vssd1 vssd1 vccd1 vccd1 sky130_fd_sc_hd__fill_1
XFILLER_0_66_317 vssd1 vssd1 vccd1 vccd1 sky130_fd_sc_hd__decap_8
X_09435_ _03378_ _03379_ _03380_ vssd1 vssd1 vccd1 vccd1 _03545_ sky130_fd_sc_hd__a21bo_1
XPHY_106 vssd1 vssd1 vccd1 vccd1 sky130_fd_sc_hd__decap_3
X_06647_ sub1.b_i\[14\] sub1.a_i\[14\] vssd1 vssd1 vccd1 vccd1 _00878_ sky130_fd_sc_hd__and2b_1
XPHY_139 vssd1 vssd1 vccd1 vccd1 sky130_fd_sc_hd__decap_3
XPHY_128 vssd1 vssd1 vccd1 vccd1 sky130_fd_sc_hd__decap_3
XPHY_117 vssd1 vssd1 vccd1 vccd1 sky130_fd_sc_hd__decap_3
XFILLER_0_19_200 vssd1 vssd1 vccd1 vccd1 sky130_fd_sc_hd__fill_2
XFILLER_0_19_233 vssd1 vssd1 vccd1 vccd1 sky130_fd_sc_hd__decap_3
X_09366_ net1039 net1047 net784 net777 vssd1 vssd1 vccd1 vccd1 _03476_ sky130_fd_sc_hd__nand4_1
XFILLER_0_74_350 vssd1 vssd1 vccd1 vccd1 sky130_ef_sc_hd__decap_12
X_06578_ sub1.a_i\[3\] sub1.b_i\[3\] vssd1 vssd1 vccd1 vccd1 _00820_ sky130_fd_sc_hd__nand2b_1
XFILLER_0_117_441 vssd1 vssd1 vccd1 vccd1 sky130_fd_sc_hd__decap_6
X_08317_ net1098 net772 net763 net1106 vssd1 vssd1 vccd1 vccd1 _02434_ sky130_fd_sc_hd__a22o_1
X_09297_ _03250_ _03252_ _03406_ _03407_ vssd1 vssd1 vccd1 vccd1 _03408_ sky130_fd_sc_hd__o211a_1
XANTENNA_40 net53 vssd1 vssd1 vccd1 vccd1 sky130_fd_sc_hd__diode_2
XFILLER_0_117_485 vssd1 vssd1 vccd1 vccd1 sky130_ef_sc_hd__decap_12
XFILLER_0_105_603 vssd1 vssd1 vccd1 vccd1 sky130_fd_sc_hd__fill_2
X_08248_ net913 net973 net967 net921 vssd1 vssd1 vccd1 vccd1 _02366_ sky130_fd_sc_hd__a22o_1
XANTENNA_62 v2y[23] vssd1 vssd1 vccd1 vccd1 sky130_fd_sc_hd__diode_2
XANTENNA_51 v0x[28] vssd1 vssd1 vccd1 vccd1 sky130_fd_sc_hd__diode_2
XFILLER_0_62_589 vssd1 vssd1 vccd1 vccd1 sky130_fd_sc_hd__fill_1
X_08179_ net1147 net734 _02294_ _02295_ vssd1 vssd1 vccd1 vccd1 _02297_ sky130_fd_sc_hd__o2bb2a_1
X_10210_ _04024_ _04178_ _04312_ _04313_ vssd1 vssd1 vccd1 vccd1 _04315_ sky130_fd_sc_hd__a22oi_1
X_11190_ net1011 net717 _05285_ _05286_ vssd1 vssd1 vccd1 vccd1 _05288_ sky130_fd_sc_hd__o2bb2a_1
X_10141_ _04095_ _04097_ vssd1 vssd1 vccd1 vccd1 _04246_ sky130_fd_sc_hd__nand2_1
X_10072_ _04025_ _04176_ _04177_ vssd1 vssd1 vccd1 vccd1 _04178_ sky130_fd_sc_hd__nand3_4
X_10974_ _05071_ _05072_ _04910_ _04913_ vssd1 vssd1 vccd1 vccd1 _05074_ sky130_fd_sc_hd__o211a_1
X_12713_ clknet_leaf_6_clk_i _00099_ net1196 vssd1 vssd1 vccd1 vccd1 net445 sky130_fd_sc_hd__dfrtp_1
XPHY_8 vssd1 vssd1 vccd1 vccd1 sky130_fd_sc_hd__decap_3
XFILLER_0_128_739 vssd1 vssd1 vccd1 vccd1 sky130_ef_sc_hd__decap_12
X_12644_ clknet_leaf_22_clk_i _00030_ net1170 vssd1 vssd1 vccd1 vccd1 net369 sky130_fd_sc_hd__dfrtp_1
X_12575_ net1224 net20 net561 vssd1 vssd1 vccd1 vccd1 _00551_ sky130_fd_sc_hd__mux2_1
XFILLER_0_53_501 vssd1 vssd1 vccd1 vccd1 sky130_fd_sc_hd__decap_3
XFILLER_0_25_225 vssd1 vssd1 vccd1 vccd1 sky130_fd_sc_hd__decap_4
X_11526_ net1020 net697 net696 _00590_ vssd1 vssd1 vccd1 vccd1 _05621_ sky130_fd_sc_hd__a22o_1
XFILLER_0_111_617 vssd1 vssd1 vccd1 vccd1 sky130_ef_sc_hd__decap_12
XFILLER_0_68_15 vssd1 vssd1 vccd1 vccd1 sky130_ef_sc_hd__decap_12
X_11457_ _05550_ _05551_ _05428_ _05430_ vssd1 vssd1 vccd1 vccd1 _05553_ sky130_fd_sc_hd__o211a_1
XFILLER_0_40_228 vssd1 vssd1 vccd1 vccd1 sky130_fd_sc_hd__fill_1
X_10408_ _04510_ _04511_ vssd1 vssd1 vccd1 vccd1 _04512_ sky130_fd_sc_hd__or2_1
X_11388_ net799 net789 net935 vssd1 vssd1 vccd1 vccd1 _05484_ sky130_fd_sc_hd__and3_1
X_13127_ clknet_leaf_3_clk_i _00513_ vssd1 vssd1 vccd1 vccd1 det_t\[20\] sky130_fd_sc_hd__dfxtp_1
X_10339_ _04314_ _04326_ _04327_ _04315_ vssd1 vssd1 vccd1 vccd1 _04443_ sky130_fd_sc_hd__a31o_1
XTAP_604 vssd1 vccd1 sky130_fd_sc_hd__tapvpwrvgnd_1
XTAP_615 vssd1 vccd1 sky130_fd_sc_hd__tapvpwrvgnd_1
XTAP_626 vssd1 vccd1 sky130_fd_sc_hd__tapvpwrvgnd_1
XTAP_637 vssd1 vccd1 sky130_fd_sc_hd__tapvpwrvgnd_1
XTAP_648 vssd1 vccd1 sky130_fd_sc_hd__tapvpwrvgnd_1
X_13058_ clknet_leaf_45_clk_i _00444_ net1164 vssd1 vssd1 vccd1 vccd1 y2my0\[15\]
+ sky130_fd_sc_hd__dfrtp_1
XTAP_659 vssd1 vccd1 sky130_fd_sc_hd__tapvpwrvgnd_1
X_12009_ net1323 _06011_ net482 vssd1 vssd1 vccd1 vccd1 _00245_ sky130_fd_sc_hd__mux2_1
XFILLER_0_108_65 vssd1 vssd1 vccd1 vccd1 sky130_ef_sc_hd__decap_12
X_07550_ _01672_ _01673_ vssd1 vssd1 vccd1 vccd1 _01674_ sky130_fd_sc_hd__xnor2_1
X_06501_ det_t\[11\] net528 vssd1 vssd1 vccd1 vccd1 net254 sky130_fd_sc_hd__and2_1
XFILLER_0_88_475 vssd1 vssd1 vccd1 vccd1 sky130_fd_sc_hd__fill_1
XFILLER_0_124_53 vssd1 vssd1 vccd1 vccd1 sky130_ef_sc_hd__decap_12
X_09220_ _03169_ _03177_ _03176_ vssd1 vssd1 vccd1 vccd1 _03331_ sky130_fd_sc_hd__a21oi_1
X_07481_ _01597_ _01598_ net876 net1145 vssd1 vssd1 vccd1 vccd1 _01606_ sky130_fd_sc_hd__o211a_1
XFILLER_0_124_97 vssd1 vssd1 vccd1 vccd1 sky130_ef_sc_hd__decap_12
X_06432_ add1.a_i\[23\] add1.b_i\[23\] vssd1 vssd1 vccd1 vccd1 _00734_ sky130_fd_sc_hd__nor2_1
XFILLER_0_33_84 vssd1 vssd1 vccd1 vccd1 sky130_fd_sc_hd__decap_6
XFILLER_0_90_139 vssd1 vssd1 vccd1 vccd1 sky130_fd_sc_hd__fill_1
X_09151_ _03113_ _03262_ vssd1 vssd1 vccd1 vccd1 _03263_ sky130_fd_sc_hd__xnor2_4
XFILLER_0_84_670 vssd1 vssd1 vccd1 vccd1 sky130_fd_sc_hd__decap_6
X_06363_ _00621_ _00674_ vssd1 vssd1 vccd1 vccd1 _00675_ sky130_fd_sc_hd__and2_1
X_08102_ _02218_ _02219_ vssd1 vssd1 vccd1 vccd1 _02221_ sky130_fd_sc_hd__xor2_1
X_09082_ _03192_ _03193_ vssd1 vssd1 vccd1 vccd1 _03194_ sky130_fd_sc_hd__xnor2_1
XFILLER_0_114_433 vssd1 vssd1 vccd1 vccd1 sky130_ef_sc_hd__decap_12
X_08033_ _02150_ _02151_ _02038_ _02040_ vssd1 vssd1 vccd1 vccd1 _02153_ sky130_fd_sc_hd__a211oi_1
X_06294_ net1150 _00607_ vssd1 vssd1 vccd1 vccd1 _00608_ sky130_fd_sc_hd__nor2_1
XFILLER_0_114_477 vssd1 vssd1 vccd1 vccd1 sky130_ef_sc_hd__decap_12
Xinput60 v0x[11] vssd1 vssd1 vccd1 vccd1 net60 sky130_fd_sc_hd__buf_1
XFILLER_0_4_686 vssd1 vssd1 vccd1 vccd1 sky130_fd_sc_hd__fill_1
Xinput82 v0x[31] vssd1 vssd1 vccd1 vccd1 net82 sky130_fd_sc_hd__buf_1
Xinput71 v0x[21] vssd1 vssd1 vccd1 vccd1 net71 sky130_fd_sc_hd__buf_1
XFILLER_0_101_105 vssd1 vssd1 vccd1 vccd1 sky130_fd_sc_hd__decap_6
Xinput93 v0y[12] vssd1 vssd1 vccd1 vccd1 net93 sky130_fd_sc_hd__buf_1
XFILLER_0_12_464 vssd1 vssd1 vccd1 vccd1 sky130_fd_sc_hd__fill_2
XFILLER_0_12_475 vssd1 vssd1 vccd1 vccd1 sky130_fd_sc_hd__fill_1
X_09984_ _03938_ _03941_ vssd1 vssd1 vccd1 vccd1 _04090_ sky130_fd_sc_hd__nand2_2
X_08935_ _02914_ _02916_ _03045_ vssd1 vssd1 vccd1 vccd1 _03048_ sky130_fd_sc_hd__or3_1
X_08866_ _02863_ _02865_ _02978_ vssd1 vssd1 vccd1 vccd1 _02979_ sky130_fd_sc_hd__a21oi_2
XFILLER_0_99_729 vssd1 vssd1 vccd1 vccd1 sky130_ef_sc_hd__decap_12
XFILLER_0_99_707 vssd1 vssd1 vccd1 vccd1 sky130_ef_sc_hd__decap_12
XFILLER_0_98_206 vssd1 vssd1 vccd1 vccd1 sky130_fd_sc_hd__fill_2
X_08797_ _02909_ _02910_ net861 net993 vssd1 vssd1 vccd1 vccd1 _02911_ sky130_fd_sc_hd__and4bb_1
X_07817_ _01877_ _01878_ _01936_ _01937_ vssd1 vssd1 vccd1 vccd1 _01939_ sky130_fd_sc_hd__a22oi_2
X_07748_ _01868_ _01869_ vssd1 vssd1 vccd1 vccd1 _01870_ sky130_fd_sc_hd__and2b_1
XFILLER_0_67_604 vssd1 vssd1 vccd1 vccd1 sky130_fd_sc_hd__fill_1
XFILLER_0_66_103 vssd1 vssd1 vccd1 vccd1 sky130_fd_sc_hd__fill_2
X_07679_ _01710_ _01712_ _01800_ vssd1 vssd1 vccd1 vccd1 _01802_ sky130_fd_sc_hd__nand3_1
XFILLER_0_109_205 vssd1 vssd1 vccd1 vccd1 sky130_ef_sc_hd__decap_12
X_10690_ _04789_ _04790_ _04752_ vssd1 vssd1 vccd1 vccd1 _04792_ sky130_fd_sc_hd__a21oi_1
X_09418_ net883 net879 net956 net949 vssd1 vssd1 vccd1 vccd1 _03528_ sky130_fd_sc_hd__nand4_2
XFILLER_0_125_709 vssd1 vssd1 vccd1 vccd1 sky130_ef_sc_hd__decap_12
XFILLER_0_109_249 vssd1 vssd1 vccd1 vccd1 sky130_ef_sc_hd__decap_12
X_09349_ _03289_ _03291_ _03456_ _03457_ vssd1 vssd1 vccd1 vccd1 _03459_ sky130_fd_sc_hd__a211oi_2
XFILLER_0_75_670 vssd1 vssd1 vccd1 vccd1 sky130_fd_sc_hd__fill_2
XFILLER_0_35_523 vssd1 vssd1 vccd1 vccd1 sky130_fd_sc_hd__decap_8
XFILLER_0_124_208 vssd1 vssd1 vccd1 vccd1 sky130_fd_sc_hd__decap_4
X_12360_ net1568 _00887_ net658 vssd1 vssd1 vccd1 vccd1 _00412_ sky130_fd_sc_hd__mux2_1
XFILLER_0_117_293 vssd1 vssd1 vccd1 vccd1 sky130_ef_sc_hd__decap_12
XFILLER_0_90_684 vssd1 vssd1 vccd1 vccd1 sky130_fd_sc_hd__fill_2
XFILLER_0_62_353 vssd1 vssd1 vccd1 vccd1 sky130_fd_sc_hd__decap_4
XFILLER_0_22_217 vssd1 vssd1 vccd1 vccd1 sky130_fd_sc_hd__decap_8
X_11311_ _05225_ _05228_ vssd1 vssd1 vccd1 vccd1 _05408_ sky130_fd_sc_hd__or2_1
Xclkbuf_leaf_15_clk_i clknet_3_7__leaf_clk_i vssd1 vssd1 vccd1 vccd1 clknet_leaf_15_clk_i
+ sky130_fd_sc_hd__clkbuf_16
X_12291_ net1629 _00862_ net675 vssd1 vssd1 vccd1 vccd1 _00343_ sky130_fd_sc_hd__mux2_1
XFILLER_0_105_499 vssd1 vssd1 vccd1 vccd1 sky130_fd_sc_hd__decap_4
X_11242_ _05337_ _05338_ vssd1 vssd1 vccd1 vccd1 _05339_ sky130_fd_sc_hd__nand2b_1
XFILLER_0_120_469 vssd1 vssd1 vccd1 vccd1 sky130_fd_sc_hd__decap_6
X_11173_ net1036 net702 _05268_ _05269_ vssd1 vssd1 vccd1 vccd1 _05271_ sky130_fd_sc_hd__a22oi_1
X_10124_ net1079 net1087 net715 net710 vssd1 vssd1 vccd1 vccd1 _04229_ sky130_fd_sc_hd__nand4_2
X_10055_ net842 net958 net951 net850 vssd1 vssd1 vccd1 vccd1 _04161_ sky130_fd_sc_hd__a22o_1
XFILLER_0_89_239 vssd1 vssd1 vccd1 vccd1 sky130_fd_sc_hd__decap_3
XFILLER_0_58_604 vssd1 vssd1 vccd1 vccd1 sky130_fd_sc_hd__decap_3
X_10957_ _05054_ _05055_ _04926_ _04929_ vssd1 vssd1 vccd1 vccd1 _05057_ sky130_fd_sc_hd__o211a_1
XFILLER_0_58_659 vssd1 vssd1 vccd1 vccd1 sky130_fd_sc_hd__decap_3
XFILLER_0_57_125 vssd1 vssd1 vccd1 vccd1 sky130_fd_sc_hd__fill_2
XFILLER_0_128_525 vssd1 vssd1 vccd1 vccd1 sky130_fd_sc_hd__decap_6
XFILLER_0_57_169 vssd1 vssd1 vccd1 vccd1 sky130_fd_sc_hd__decap_3
XFILLER_0_128_569 vssd1 vssd1 vccd1 vccd1 sky130_ef_sc_hd__decap_12
XFILLER_0_116_709 vssd1 vssd1 vccd1 vccd1 sky130_fd_sc_hd__fill_1
X_12627_ clknet_leaf_47_clk_i _00013_ net1160 vssd1 vssd1 vccd1 vccd1 net346 sky130_fd_sc_hd__dfrtp_2
X_10888_ _04986_ _04987_ vssd1 vssd1 vccd1 vccd1 _04988_ sky130_fd_sc_hd__nand2_1
XFILLER_0_53_342 vssd1 vssd1 vccd1 vccd1 sky130_fd_sc_hd__decap_3
XFILLER_0_108_282 vssd1 vssd1 vccd1 vccd1 sky130_fd_sc_hd__fill_2
X_12558_ net1569 net34 net558 vssd1 vssd1 vccd1 vccd1 _00534_ sky130_fd_sc_hd__mux2_1
XFILLER_0_26_589 vssd1 vssd1 vccd1 vccd1 sky130_ef_sc_hd__decap_12
X_12489_ net1256 net569 _06241_ vssd1 vssd1 vccd1 vccd1 _00495_ sky130_fd_sc_hd__o21a_1
Xhold107 sub1.a_i\[3\] vssd1 vssd1 vccd1 vccd1 net1322 sky130_fd_sc_hd__dlygate4sd3_1
X_11509_ _05570_ _05601_ _05602_ vssd1 vssd1 vccd1 vccd1 _05604_ sky130_fd_sc_hd__nor3_1
XFILLER_0_123_274 vssd1 vssd1 vccd1 vccd1 sky130_fd_sc_hd__fill_2
XFILLER_0_110_77 vssd1 vssd1 vccd1 vccd1 sky130_fd_sc_hd__decap_6
Xhold129 net404 vssd1 vssd1 vccd1 vccd1 net1344 sky130_fd_sc_hd__dlygate4sd3_1
XFILLER_0_0_111 vssd1 vssd1 vccd1 vccd1 sky130_fd_sc_hd__fill_1
Xhold118 net366 vssd1 vssd1 vccd1 vccd1 net1333 sky130_fd_sc_hd__dlygate4sd3_1
XFILLER_0_111_447 vssd1 vssd1 vccd1 vccd1 sky130_fd_sc_hd__fill_1
XFILLER_0_95_57 vssd1 vssd1 vccd1 vccd1 sky130_ef_sc_hd__decap_12
XTAP_423 vssd1 vccd1 sky130_fd_sc_hd__tapvpwrvgnd_1
XTAP_412 vssd1 vccd1 sky130_fd_sc_hd__tapvpwrvgnd_1
XTAP_401 vssd1 vccd1 sky130_fd_sc_hd__tapvpwrvgnd_1
Xfanout609 net610 vssd1 vssd1 vccd1 vccd1 net609 sky130_fd_sc_hd__clkbuf_4
XTAP_434 vssd1 vccd1 sky130_fd_sc_hd__tapvpwrvgnd_1
XTAP_445 vssd1 vccd1 sky130_fd_sc_hd__tapvpwrvgnd_1
XTAP_456 vssd1 vccd1 sky130_fd_sc_hd__tapvpwrvgnd_1
XTAP_467 vssd1 vccd1 sky130_fd_sc_hd__tapvpwrvgnd_1
X_06981_ net922 net1041 net1049 net914 vssd1 vssd1 vccd1 vccd1 _01106_ sky130_fd_sc_hd__a22o_1
X_08720_ _02827_ _02832_ vssd1 vssd1 vccd1 vccd1 _02834_ sky130_fd_sc_hd__xor2_1
XTAP_489 vssd1 vccd1 sky130_fd_sc_hd__tapvpwrvgnd_1
XTAP_478 vssd1 vccd1 sky130_fd_sc_hd__tapvpwrvgnd_1
Xfanout1191 net1192 vssd1 vssd1 vccd1 vccd1 net1191 sky130_fd_sc_hd__clkbuf_4
X_08651_ _02757_ _02765_ vssd1 vssd1 vccd1 vccd1 _02766_ sky130_fd_sc_hd__nand2_1
Xfanout1180 net1181 vssd1 vssd1 vccd1 vccd1 net1180 sky130_fd_sc_hd__buf_2
X_07602_ _01374_ _01375_ _01376_ vssd1 vssd1 vccd1 vccd1 _01726_ sky130_fd_sc_hd__a21bo_1
X_08582_ _02676_ _02695_ vssd1 vssd1 vccd1 vccd1 _02697_ sky130_fd_sc_hd__xor2_1
XFILLER_0_119_503 vssd1 vssd1 vccd1 vccd1 sky130_fd_sc_hd__fill_1
X_07533_ _01585_ _01657_ _01584_ vssd1 vssd1 vccd1 vccd1 _01658_ sky130_fd_sc_hd__o21ai_1
XFILLER_0_48_169 vssd1 vssd1 vccd1 vccd1 sky130_fd_sc_hd__decap_4
X_07464_ net904 net1119 _01558_ _01559_ vssd1 vssd1 vccd1 vccd1 _01589_ sky130_fd_sc_hd__a22o_1
X_09203_ net1071 net761 _03310_ _03312_ vssd1 vssd1 vccd1 vccd1 _03314_ sky130_fd_sc_hd__nand4_1
X_06415_ _00718_ _00719_ vssd1 vssd1 vccd1 vccd1 _00720_ sky130_fd_sc_hd__or2_4
XFILLER_0_9_778 vssd1 vssd1 vccd1 vccd1 sky130_fd_sc_hd__fill_2
XFILLER_0_17_501 vssd1 vssd1 vccd1 vccd1 sky130_fd_sc_hd__decap_3
X_09134_ _03242_ _03244_ _03083_ net489 vssd1 vssd1 vccd1 vccd1 _03246_ sky130_fd_sc_hd__a211oi_2
X_07395_ _01517_ _01518_ _01516_ vssd1 vssd1 vccd1 vccd1 _01520_ sky130_fd_sc_hd__a21bo_1
X_06346_ add1.a_i\[5\] add1.b_i\[5\] _00657_ vssd1 vssd1 vccd1 vccd1 _00658_ sky130_fd_sc_hd__a21oi_1
X_09065_ _03170_ _03175_ vssd1 vssd1 vccd1 vccd1 _03177_ sky130_fd_sc_hd__xor2_1
XFILLER_0_72_695 vssd1 vssd1 vccd1 vccd1 sky130_fd_sc_hd__decap_4
X_06277_ sub1.a_i\[9\] vssd1 vssd1 vccd1 vccd1 _00593_ sky130_fd_sc_hd__inv_2
XFILLER_0_102_425 vssd1 vssd1 vccd1 vccd1 sky130_fd_sc_hd__fill_1
X_08016_ _02022_ _02024_ _02023_ vssd1 vssd1 vccd1 vccd1 _02136_ sky130_fd_sc_hd__a21bo_1
XFILLER_0_8_83 vssd1 vssd1 vccd1 vccd1 sky130_fd_sc_hd__fill_1
XFILLER_0_102_447 vssd1 vssd1 vccd1 vccd1 sky130_fd_sc_hd__decap_6
X_09967_ net1086 net1093 net714 net710 vssd1 vssd1 vccd1 vccd1 _04073_ sky130_fd_sc_hd__and4_1
X_08918_ net1017 net1025 net825 net818 vssd1 vssd1 vccd1 vccd1 _03031_ sky130_fd_sc_hd__and4_1
XFILLER_0_85_90 vssd1 vssd1 vccd1 vccd1 sky130_ef_sc_hd__decap_12
X_09898_ _04003_ _04004_ _03997_ vssd1 vssd1 vccd1 vccd1 _04005_ sky130_fd_sc_hd__a21o_1
XTAP_990 vssd1 vccd1 sky130_fd_sc_hd__tapvpwrvgnd_1
X_08849_ net1444 _02962_ net522 vssd1 vssd1 vccd1 vccd1 _00134_ sky130_fd_sc_hd__mux2_1
XFILLER_0_79_250 vssd1 vssd1 vccd1 vccd1 sky130_ef_sc_hd__decap_12
X_11860_ temp1\[25\] net616 net671 net107 _05895_ vssd1 vssd1 vccd1 vccd1 _05896_
+ sky130_fd_sc_hd__a221o_1
XFILLER_0_95_721 vssd1 vssd1 vccd1 vccd1 sky130_fd_sc_hd__decap_6
X_10811_ _04910_ _04911_ vssd1 vssd1 vccd1 vccd1 _04912_ sky130_fd_sc_hd__nand2_1
X_11791_ temp1\[15\] net614 net665 net96 _05836_ vssd1 vssd1 vccd1 vccd1 _05837_ sky130_fd_sc_hd__a221o_1
XFILLER_0_94_253 vssd1 vssd1 vccd1 vccd1 sky130_fd_sc_hd__decap_4
X_10742_ _04840_ _04841_ _04842_ vssd1 vssd1 vccd1 vccd1 _04843_ sky130_fd_sc_hd__nand3_2
XFILLER_0_39_169 vssd1 vssd1 vccd1 vccd1 sky130_fd_sc_hd__decap_4
XFILLER_0_125_517 vssd1 vssd1 vccd1 vccd1 sky130_ef_sc_hd__decap_12
XFILLER_0_82_448 vssd1 vssd1 vccd1 vccd1 sky130_fd_sc_hd__decap_6
X_10673_ _04773_ _04774_ net1045 net719 vssd1 vssd1 vccd1 vccd1 _04775_ sky130_fd_sc_hd__and4bb_1
XFILLER_0_63_673 vssd1 vssd1 vccd1 vccd1 sky130_fd_sc_hd__decap_3
X_12412_ temp1\[0\] _06198_ net570 vssd1 vssd1 vccd1 vccd1 _00461_ sky130_fd_sc_hd__mux2_1
X_12343_ net1643 _00970_ net673 vssd1 vssd1 vccd1 vccd1 _00395_ sky130_fd_sc_hd__mux2_1
X_12274_ net1585 net52 net689 vssd1 vssd1 vccd1 vccd1 _00328_ sky130_fd_sc_hd__mux2_1
XFILLER_0_105_285 vssd1 vssd1 vccd1 vccd1 sky130_fd_sc_hd__fill_1
XFILLER_0_105_274 vssd1 vssd1 vccd1 vccd1 sky130_fd_sc_hd__decap_6
XFILLER_0_50_345 vssd1 vssd1 vccd1 vccd1 sky130_fd_sc_hd__fill_2
XFILLER_0_120_233 vssd1 vssd1 vccd1 vccd1 sky130_ef_sc_hd__decap_12
X_11225_ net1581 _05322_ net525 vssd1 vssd1 vccd1 vccd1 _00150_ sky130_fd_sc_hd__mux2_1
XFILLER_0_120_277 vssd1 vssd1 vccd1 vccd1 sky130_ef_sc_hd__decap_12
X_11156_ _05125_ _05127_ _05252_ vssd1 vssd1 vccd1 vccd1 _05254_ sky130_fd_sc_hd__nand3_1
X_10107_ _04069_ _04212_ vssd1 vssd1 vccd1 vccd1 _04213_ sky130_fd_sc_hd__xnor2_4
X_11087_ _05140_ _05141_ _05184_ _05185_ vssd1 vssd1 vccd1 vccd1 _05186_ sky130_fd_sc_hd__and4_1
X_10038_ _04141_ _04142_ _04143_ vssd1 vssd1 vccd1 vccd1 _04144_ sky130_fd_sc_hd__nand3_2
XFILLER_0_81_15 vssd1 vssd1 vccd1 vccd1 sky130_ef_sc_hd__decap_12
XFILLER_0_129_801 vssd1 vssd1 vccd1 vccd1 sky130_ef_sc_hd__decap_12
XFILLER_0_105_33 vssd1 vssd1 vccd1 vccd1 sky130_ef_sc_hd__decap_12
XFILLER_0_86_721 vssd1 vssd1 vccd1 vccd1 sky130_ef_sc_hd__decap_12
X_11989_ net1348 _05996_ net484 vssd1 vssd1 vccd1 vccd1 _00240_ sky130_fd_sc_hd__mux2_1
XFILLER_0_14_53 vssd1 vssd1 vccd1 vccd1 sky130_ef_sc_hd__decap_12
XFILLER_0_85_264 vssd1 vssd1 vccd1 vccd1 sky130_fd_sc_hd__fill_1
XFILLER_0_39_670 vssd1 vssd1 vccd1 vccd1 sky130_fd_sc_hd__fill_2
XFILLER_0_14_97 vssd1 vssd1 vccd1 vccd1 sky130_ef_sc_hd__decap_12
X_07180_ _01099_ _01100_ _01101_ vssd1 vssd1 vccd1 vccd1 _01305_ sky130_fd_sc_hd__a21oi_1
XFILLER_0_112_701 vssd1 vssd1 vccd1 vccd1 sky130_ef_sc_hd__decap_12
XFILLER_0_41_301 vssd1 vssd1 vccd1 vccd1 sky130_fd_sc_hd__decap_3
XFILLER_0_30_85 vssd1 vssd1 vccd1 vccd1 sky130_fd_sc_hd__decap_8
XFILLER_0_1_453 vssd1 vssd1 vccd1 vccd1 sky130_fd_sc_hd__fill_2
XFILLER_0_1_475 vssd1 vssd1 vccd1 vccd1 sky130_fd_sc_hd__fill_2
X_09821_ _03764_ _03926_ vssd1 vssd1 vccd1 vccd1 _03928_ sky130_fd_sc_hd__xor2_4
XFILLER_0_10_765 vssd1 vssd1 vccd1 vccd1 sky130_fd_sc_hd__fill_1
X_09752_ net860 net956 _03857_ _03858_ vssd1 vssd1 vccd1 vccd1 _03860_ sky130_fd_sc_hd__a22o_1
XTAP_264 vssd1 vccd1 sky130_fd_sc_hd__tapvpwrvgnd_1
XTAP_275 vssd1 vccd1 sky130_fd_sc_hd__tapvpwrvgnd_1
X_08703_ _02812_ _02814_ _02816_ vssd1 vssd1 vccd1 vccd1 _02818_ sky130_fd_sc_hd__and3_1
XTAP_297 vssd1 vccd1 sky130_fd_sc_hd__tapvpwrvgnd_1
XTAP_286 vssd1 vccd1 sky130_fd_sc_hd__tapvpwrvgnd_1
X_06964_ _01085_ _01086_ _01087_ vssd1 vssd1 vccd1 vccd1 _01089_ sky130_fd_sc_hd__o21ai_1
X_09683_ _03789_ _03790_ vssd1 vssd1 vccd1 vccd1 _03791_ sky130_fd_sc_hd__nor2_1
X_06895_ net880 net1096 vssd1 vssd1 vccd1 vccd1 _01020_ sky130_fd_sc_hd__nand2_1
XTAP_2109 vssd1 vccd1 sky130_fd_sc_hd__tapvpwrvgnd_1
X_08634_ _02746_ _02747_ vssd1 vssd1 vccd1 vccd1 _02749_ sky130_fd_sc_hd__xor2_1
X_08565_ net1131 net1140 net727 net723 vssd1 vssd1 vccd1 vccd1 _02680_ sky130_fd_sc_hd__nand4_2
XTAP_1419 vssd1 vccd1 sky130_fd_sc_hd__tapvpwrvgnd_1
XTAP_1408 vssd1 vccd1 sky130_fd_sc_hd__tapvpwrvgnd_1
XFILLER_0_76_220 vssd1 vssd1 vccd1 vccd1 sky130_fd_sc_hd__fill_1
X_07516_ net905 net1145 _01640_ _01639_ vssd1 vssd1 vccd1 vccd1 _01641_ sky130_fd_sc_hd__a31o_1
X_08496_ _02597_ _02610_ _02611_ vssd1 vssd1 vccd1 vccd1 _02612_ sky130_fd_sc_hd__nand3_2
XFILLER_0_64_426 vssd1 vssd1 vccd1 vccd1 sky130_fd_sc_hd__fill_1
XFILLER_0_92_757 vssd1 vssd1 vccd1 vccd1 sky130_fd_sc_hd__fill_2
XFILLER_0_91_234 vssd1 vssd1 vccd1 vccd1 sky130_fd_sc_hd__decap_6
X_07447_ net881 net1136 _01564_ _01563_ vssd1 vssd1 vccd1 vccd1 _01572_ sky130_fd_sc_hd__a31o_1
XFILLER_0_51_109 vssd1 vssd1 vccd1 vccd1 sky130_fd_sc_hd__decap_3
XFILLER_0_45_673 vssd1 vssd1 vccd1 vccd1 sky130_fd_sc_hd__decap_3
X_07378_ _01439_ _01465_ _01482_ _01495_ vssd1 vssd1 vccd1 vccd1 _01503_ sky130_fd_sc_hd__a211o_1
XFILLER_0_115_561 vssd1 vssd1 vccd1 vccd1 sky130_ef_sc_hd__decap_12
XFILLER_0_72_492 vssd1 vssd1 vccd1 vccd1 sky130_fd_sc_hd__decap_3
X_09117_ _03067_ _03068_ _03069_ vssd1 vssd1 vccd1 vccd1 _03229_ sky130_fd_sc_hd__a21bo_1
X_06329_ _00639_ _00640_ vssd1 vssd1 vccd1 vccd1 _00641_ sky130_fd_sc_hd__nand2_2
X_09048_ _03158_ _03159_ net1080 net761 vssd1 vssd1 vccd1 vccd1 _03160_ sky130_fd_sc_hd__and4bb_1
XFILLER_0_102_200 vssd1 vssd1 vccd1 vccd1 sky130_fd_sc_hd__decap_8
XFILLER_0_130_553 vssd1 vssd1 vccd1 vccd1 sky130_fd_sc_hd__fill_2
XFILLER_0_102_222 vssd1 vssd1 vccd1 vccd1 sky130_ef_sc_hd__decap_12
XFILLER_0_60_698 vssd1 vssd1 vccd1 vccd1 sky130_fd_sc_hd__fill_2
XFILLER_0_130_564 vssd1 vssd1 vccd1 vccd1 sky130_fd_sc_hd__fill_1
Xhold460 x2mx1\[15\] vssd1 vssd1 vccd1 vccd1 net1675 sky130_fd_sc_hd__dlygate4sd3_1
Xhold471 state\[0\] vssd1 vssd1 vccd1 vccd1 net1686 sky130_fd_sc_hd__dlygate4sd3_1
XFILLER_0_102_288 vssd1 vssd1 vccd1 vccd1 sky130_fd_sc_hd__fill_1
Xhold493 add1.b_i\[24\] vssd1 vssd1 vccd1 vccd1 net1708 sky130_fd_sc_hd__dlygate4sd3_1
Xhold482 sub1.a_i\[1\] vssd1 vssd1 vccd1 vccd1 net1697 sky130_fd_sc_hd__dlygate4sd3_1
X_11010_ _05107_ _05108_ vssd1 vssd1 vccd1 vccd1 _05109_ sky130_fd_sc_hd__nand2b_1
Xfanout940 net941 vssd1 vssd1 vccd1 vccd1 net940 sky130_fd_sc_hd__buf_2
Xfanout951 net952 vssd1 vssd1 vccd1 vccd1 net951 sky130_fd_sc_hd__buf_4
Xfanout962 mul1.a\[24\] vssd1 vssd1 vccd1 vccd1 net962 sky130_fd_sc_hd__clkbuf_4
Xfanout995 mul1.a\[19\] vssd1 vssd1 vccd1 vccd1 net995 sky130_fd_sc_hd__buf_4
Xfanout973 net974 vssd1 vssd1 vccd1 vccd1 net973 sky130_fd_sc_hd__buf_2
Xfanout984 net985 vssd1 vssd1 vccd1 vccd1 net984 sky130_fd_sc_hd__clkbuf_4
XFILLER_0_99_345 vssd1 vssd1 vccd1 vccd1 sky130_fd_sc_hd__fill_2
X_12961_ clknet_leaf_46_clk_i _00347_ net1163 vssd1 vssd1 vccd1 vccd1 y1my2\[14\]
+ sky130_fd_sc_hd__dfrtp_1
X_11912_ net144 net659 net502 net240 _05938_ vssd1 vssd1 vccd1 vccd1 _05939_ sky130_fd_sc_hd__a221o_1
X_12892_ clknet_leaf_32_clk_i _00278_ vssd1 vssd1 vccd1 vccd1 mul1.a\[27\] sky130_fd_sc_hd__dfxtp_1
XFILLER_0_99_389 vssd1 vssd1 vccd1 vccd1 sky130_fd_sc_hd__decap_3
X_11843_ net168 net471 _05881_ vssd1 vssd1 vccd1 vccd1 _05882_ sky130_fd_sc_hd__o21a_1
XTAP_1942 vssd1 vccd1 sky130_fd_sc_hd__tapvpwrvgnd_1
XTAP_1931 vssd1 vccd1 sky130_fd_sc_hd__tapvpwrvgnd_1
XTAP_1920 vssd1 vccd1 sky130_fd_sc_hd__tapvpwrvgnd_1
XFILLER_0_68_754 vssd1 vssd1 vccd1 vccd1 sky130_fd_sc_hd__fill_2
XFILLER_0_28_607 vssd1 vssd1 vccd1 vccd1 sky130_fd_sc_hd__decap_8
XTAP_1986 vssd1 vccd1 sky130_fd_sc_hd__tapvpwrvgnd_1
XTAP_1964 vssd1 vccd1 sky130_fd_sc_hd__tapvpwrvgnd_1
XTAP_1975 vssd1 vccd1 sky130_fd_sc_hd__tapvpwrvgnd_1
XTAP_1953 vssd1 vccd1 sky130_fd_sc_hd__tapvpwrvgnd_1
XFILLER_0_67_264 vssd1 vssd1 vccd1 vccd1 sky130_fd_sc_hd__fill_1
XFILLER_0_51_29 vssd1 vssd1 vccd1 vccd1 sky130_ef_sc_hd__decap_12
X_11774_ net221 net599 net579 net125 _05822_ vssd1 vssd1 vccd1 vccd1 _05823_ sky130_fd_sc_hd__a221o_1
XTAP_1997 vssd1 vccd1 sky130_fd_sc_hd__tapvpwrvgnd_1
X_10725_ _04429_ _04825_ vssd1 vssd1 vccd1 vccd1 _04826_ sky130_fd_sc_hd__xnor2_2
XFILLER_0_82_256 vssd1 vssd1 vccd1 vccd1 sky130_fd_sc_hd__decap_3
X_10656_ _04610_ _04611_ vssd1 vssd1 vccd1 vccd1 _04758_ sky130_fd_sc_hd__or2_1
XFILLER_0_35_150 vssd1 vssd1 vccd1 vccd1 sky130_fd_sc_hd__decap_6
XFILLER_0_36_651 vssd1 vssd1 vccd1 vccd1 sky130_fd_sc_hd__decap_8
XFILLER_0_35_183 vssd1 vssd1 vccd1 vccd1 sky130_fd_sc_hd__fill_2
XFILLER_0_106_572 vssd1 vssd1 vccd1 vccd1 sky130_ef_sc_hd__decap_12
X_10587_ _04687_ _04688_ vssd1 vssd1 vccd1 vccd1 _04689_ sky130_fd_sc_hd__nand2_2
XFILLER_0_51_665 vssd1 vssd1 vccd1 vccd1 sky130_fd_sc_hd__decap_6
XFILLER_0_3_729 vssd1 vssd1 vccd1 vccd1 sky130_fd_sc_hd__fill_1
XFILLER_0_23_334 vssd1 vssd1 vccd1 vccd1 sky130_fd_sc_hd__fill_2
XFILLER_0_121_553 vssd1 vssd1 vccd1 vccd1 sky130_fd_sc_hd__decap_6
X_12326_ net1648 _00877_ net666 vssd1 vssd1 vccd1 vccd1 _00378_ sky130_fd_sc_hd__mux2_1
XFILLER_0_76_15 vssd1 vssd1 vccd1 vccd1 sky130_ef_sc_hd__decap_12
XFILLER_0_50_197 vssd1 vssd1 vccd1 vccd1 sky130_fd_sc_hd__decap_8
X_12257_ net698 _06191_ net518 vssd1 vssd1 vccd1 vccd1 _00313_ sky130_fd_sc_hd__mux2_1
XFILLER_0_121_597 vssd1 vssd1 vccd1 vccd1 sky130_ef_sc_hd__decap_12
X_11208_ _05302_ _05304_ _05177_ _05179_ vssd1 vssd1 vccd1 vccd1 _05306_ sky130_fd_sc_hd__a211oi_1
X_12188_ net870 _06145_ net513 vssd1 vssd1 vccd1 vccd1 _00290_ sky130_fd_sc_hd__mux2_1
X_11139_ _05235_ _05236_ vssd1 vssd1 vccd1 vccd1 _05237_ sky130_fd_sc_hd__nand2b_1
X_06680_ sub1.a_i\[19\] sub1.b_i\[19\] vssd1 vssd1 vccd1 vccd1 _00906_ sky130_fd_sc_hd__and2b_1
XFILLER_0_116_65 vssd1 vssd1 vccd1 vccd1 sky130_ef_sc_hd__decap_12
X_08350_ net1051 net821 net815 net1059 vssd1 vssd1 vccd1 vccd1 _02467_ sky130_fd_sc_hd__a22o_1
XFILLER_0_129_642 vssd1 vssd1 vccd1 vccd1 sky130_fd_sc_hd__decap_3
X_07301_ _01287_ _01424_ _01425_ vssd1 vssd1 vccd1 vccd1 _01426_ sky130_fd_sc_hd__nand3_1
XFILLER_0_129_664 vssd1 vssd1 vccd1 vccd1 sky130_fd_sc_hd__fill_2
X_08281_ _02397_ _02398_ vssd1 vssd1 vccd1 vccd1 _02399_ sky130_fd_sc_hd__nand2_2
XFILLER_0_58_297 vssd1 vssd1 vccd1 vccd1 sky130_fd_sc_hd__decap_8
XFILLER_0_129_697 vssd1 vssd1 vccd1 vccd1 sky130_fd_sc_hd__fill_2
X_07232_ _01338_ _01354_ _01355_ vssd1 vssd1 vccd1 vccd1 _01357_ sky130_fd_sc_hd__nor3_1
XFILLER_0_27_673 vssd1 vssd1 vccd1 vccd1 sky130_fd_sc_hd__decap_4
X_07163_ _01281_ _01287_ vssd1 vssd1 vccd1 vccd1 _01288_ sky130_fd_sc_hd__nand2_1
XFILLER_0_26_183 vssd1 vssd1 vccd1 vccd1 sky130_fd_sc_hd__decap_8
XFILLER_0_112_531 vssd1 vssd1 vccd1 vccd1 sky130_fd_sc_hd__fill_1
X_07094_ _01202_ _01216_ _01217_ vssd1 vssd1 vccd1 vccd1 _01219_ sky130_fd_sc_hd__nand3_2
XFILLER_0_41_175 vssd1 vssd1 vccd1 vccd1 sky130_fd_sc_hd__fill_2
XFILLER_0_67_3 vssd1 vssd1 vccd1 vccd1 sky130_ef_sc_hd__decap_12
X_09804_ net1093 net714 net711 net1100 vssd1 vssd1 vccd1 vccd1 _03911_ sky130_fd_sc_hd__a22o_1
XFILLER_0_5_51 vssd1 vssd1 vccd1 vccd1 sky130_fd_sc_hd__decap_4
X_07996_ _02017_ _02019_ _02018_ vssd1 vssd1 vccd1 vccd1 _02116_ sky130_fd_sc_hd__o21ba_1
X_09735_ net833 net977 _03840_ _03841_ vssd1 vssd1 vccd1 vccd1 _03843_ sky130_fd_sc_hd__a22o_1
X_06947_ _01069_ _01070_ _01071_ vssd1 vssd1 vccd1 vccd1 _01072_ sky130_fd_sc_hd__nand3_1
X_09666_ _03640_ _03648_ _03647_ vssd1 vssd1 vccd1 vccd1 _03774_ sky130_fd_sc_hd__a21oi_1
X_08617_ _02729_ _02730_ _02612_ _02615_ vssd1 vssd1 vccd1 vccd1 _02732_ sky130_fd_sc_hd__o211ai_2
XTAP_1205 vssd1 vccd1 sky130_fd_sc_hd__tapvpwrvgnd_1
X_06878_ net685 net626 net605 net661 vssd1 vssd1 vccd1 vccd1 _01007_ sky130_fd_sc_hd__or4_1
X_09597_ net939 _03705_ _03704_ vssd1 vssd1 vccd1 vccd1 _03706_ sky130_fd_sc_hd__a21bo_1
XTAP_1238 vssd1 vccd1 sky130_fd_sc_hd__tapvpwrvgnd_1
XTAP_1227 vssd1 vccd1 sky130_fd_sc_hd__tapvpwrvgnd_1
XTAP_1216 vssd1 vccd1 sky130_fd_sc_hd__tapvpwrvgnd_1
XFILLER_0_77_584 vssd1 vssd1 vccd1 vccd1 sky130_fd_sc_hd__decap_8
X_08548_ _02528_ _02530_ _02662_ _02663_ vssd1 vssd1 vccd1 vccd1 _02664_ sky130_fd_sc_hd__o211ai_2
XTAP_1249 vssd1 vccd1 sky130_fd_sc_hd__tapvpwrvgnd_1
XFILLER_0_92_521 vssd1 vssd1 vccd1 vccd1 sky130_fd_sc_hd__decap_4
X_08479_ _02455_ _02459_ _02592_ _02593_ vssd1 vssd1 vccd1 vccd1 _02595_ sky130_fd_sc_hd__a211oi_2
XFILLER_0_107_325 vssd1 vssd1 vccd1 vccd1 sky130_fd_sc_hd__fill_1
XFILLER_0_92_587 vssd1 vssd1 vccd1 vccd1 sky130_fd_sc_hd__fill_1
X_10510_ _04611_ _04612_ vssd1 vssd1 vccd1 vccd1 _04613_ sky130_fd_sc_hd__or2_1
X_11490_ net930 _05484_ _05485_ _05486_ vssd1 vssd1 vccd1 vccd1 _05585_ sky130_fd_sc_hd__o2bb2ai_1
X_10441_ _04540_ _04541_ _04542_ vssd1 vssd1 vccd1 vccd1 _04544_ sky130_fd_sc_hd__a21oi_1
XFILLER_0_33_632 vssd1 vssd1 vccd1 vccd1 sky130_fd_sc_hd__fill_1
XFILLER_0_115_391 vssd1 vssd1 vccd1 vccd1 sky130_fd_sc_hd__fill_1
XFILLER_0_103_531 vssd1 vssd1 vccd1 vccd1 sky130_fd_sc_hd__decap_4
X_13160_ clknet_leaf_12_clk_i _00546_ net1187 vssd1 vssd1 vccd1 vccd1 l0\[21\] sky130_fd_sc_hd__dfrtp_1
X_10372_ net1005 net779 net999 net769 vssd1 vssd1 vccd1 vccd1 _04476_ sky130_fd_sc_hd__nand4_1
X_12111_ net1004 _06089_ net516 vssd1 vssd1 vccd1 vccd1 _00269_ sky130_fd_sc_hd__mux2_1
XFILLER_0_32_197 vssd1 vssd1 vccd1 vccd1 sky130_fd_sc_hd__fill_1
X_13091_ clknet_leaf_41_clk_i _00477_ vssd1 vssd1 vccd1 vccd1 temp1\[16\] sky130_fd_sc_hd__dfxtp_1
X_12042_ _00813_ _05752_ _06032_ _06037_ vssd1 vssd1 vccd1 vccd1 _06038_ sky130_fd_sc_hd__a31o_1
Xhold290 y2my0\[9\] vssd1 vssd1 vccd1 vccd1 net1505 sky130_fd_sc_hd__dlygate4sd3_1
Xfanout792 net793 vssd1 vssd1 vccd1 vccd1 net792 sky130_fd_sc_hd__clkbuf_4
Xfanout770 net771 vssd1 vssd1 vccd1 vccd1 net770 sky130_fd_sc_hd__clkbuf_4
Xfanout781 mul1.b\[17\] vssd1 vssd1 vccd1 vccd1 net781 sky130_fd_sc_hd__clkbuf_4
X_12944_ clknet_leaf_10_clk_i _00330_ net1192 vssd1 vssd1 vccd1 vccd1 posy\[6\] sky130_fd_sc_hd__dfrtp_1
XFILLER_0_87_348 vssd1 vssd1 vccd1 vccd1 sky130_fd_sc_hd__fill_1
X_12875_ clknet_leaf_43_clk_i _00261_ vssd1 vssd1 vccd1 vccd1 mul1.a\[10\] sky130_fd_sc_hd__dfxtp_2
XTAP_1761 vssd1 vccd1 sky130_fd_sc_hd__tapvpwrvgnd_1
XTAP_1750 vssd1 vccd1 sky130_fd_sc_hd__tapvpwrvgnd_1
X_11826_ net230 net601 net581 net134 _05866_ vssd1 vssd1 vccd1 vccd1 _05867_ sky130_fd_sc_hd__a221o_1
XFILLER_0_126_601 vssd1 vssd1 vccd1 vccd1 sky130_ef_sc_hd__decap_12
XTAP_1794 vssd1 vccd1 sky130_fd_sc_hd__tapvpwrvgnd_1
XTAP_1772 vssd1 vccd1 sky130_fd_sc_hd__tapvpwrvgnd_1
XTAP_1783 vssd1 vccd1 sky130_fd_sc_hd__tapvpwrvgnd_1
XFILLER_0_56_735 vssd1 vssd1 vccd1 vccd1 sky130_fd_sc_hd__fill_2
XFILLER_0_55_223 vssd1 vssd1 vccd1 vccd1 sky130_fd_sc_hd__fill_1
X_11757_ net651 _00855_ net473 _05808_ vssd1 vssd1 vccd1 vccd1 _05809_ sky130_fd_sc_hd__a211o_1
XFILLER_0_126_645 vssd1 vssd1 vccd1 vccd1 sky130_ef_sc_hd__decap_12
XFILLER_0_125_111 vssd1 vssd1 vccd1 vccd1 sky130_fd_sc_hd__fill_1
X_10708_ _04809_ vssd1 vssd1 vccd1 vccd1 _04810_ sky130_fd_sc_hd__inv_2
XFILLER_0_70_215 vssd1 vssd1 vccd1 vccd1 sky130_fd_sc_hd__decap_8
X_11688_ net1607 _05081_ net539 vssd1 vssd1 vccd1 vccd1 _00180_ sky130_fd_sc_hd__mux2_1
XFILLER_0_113_317 vssd1 vssd1 vccd1 vccd1 sky130_ef_sc_hd__decap_12
X_10639_ _04725_ _04737_ _04738_ vssd1 vssd1 vccd1 vccd1 _04741_ sky130_fd_sc_hd__nand3_2
XFILLER_0_23_120 vssd1 vssd1 vccd1 vccd1 sky130_ef_sc_hd__decap_12
XFILLER_0_122_840 vssd1 vssd1 vccd1 vccd1 sky130_fd_sc_hd__fill_2
XFILLER_0_23_164 vssd1 vssd1 vccd1 vccd1 sky130_fd_sc_hd__decap_4
XFILLER_0_24_698 vssd1 vssd1 vccd1 vccd1 sky130_fd_sc_hd__fill_2
XFILLER_0_121_361 vssd1 vssd1 vccd1 vccd1 sky130_ef_sc_hd__decap_12
X_12309_ net1673 _00960_ net680 vssd1 vssd1 vccd1 vccd1 _00361_ sky130_fd_sc_hd__mux2_1
XFILLER_0_87_69 vssd1 vssd1 vccd1 vccd1 sky130_ef_sc_hd__decap_12
X_07850_ net795 _01970_ _01969_ vssd1 vssd1 vccd1 vccd1 _01971_ sky130_fd_sc_hd__a21bo_1
X_06801_ net1539 l0\[8\] net642 vssd1 vssd1 vccd1 vccd1 _00075_ sky130_fd_sc_hd__mux2_1
X_07781_ _01900_ _01901_ net1058 net856 vssd1 vssd1 vccd1 vccd1 _01903_ sky130_fd_sc_hd__and4bb_1
Xinput3 div_sstream_i[10] vssd1 vssd1 vccd1 vccd1 net3 sky130_fd_sc_hd__clkbuf_8
X_09520_ _03609_ _03610_ _03627_ _03628_ vssd1 vssd1 vccd1 vccd1 _03629_ sky130_fd_sc_hd__o22a_1
X_06732_ _00937_ _00943_ _00944_ _00942_ vssd1 vssd1 vccd1 vccd1 _00950_ sky130_fd_sc_hd__o31a_2
XFILLER_0_78_326 vssd1 vssd1 vccd1 vccd1 sky130_fd_sc_hd__fill_1
XFILLER_0_36_95 vssd1 vssd1 vccd1 vccd1 sky130_fd_sc_hd__decap_8
X_09451_ _03558_ _03559_ _03394_ _03397_ vssd1 vssd1 vccd1 vccd1 _03561_ sky130_fd_sc_hd__o211ai_1
X_06663_ _00888_ _00891_ vssd1 vssd1 vccd1 vccd1 _00892_ sky130_fd_sc_hd__xor2_4
X_09382_ _03489_ _03490_ _03485_ vssd1 vssd1 vccd1 vccd1 _03492_ sky130_fd_sc_hd__a21o_1
X_08402_ _02515_ _02516_ _02376_ _02380_ vssd1 vssd1 vccd1 vccd1 _02519_ sky130_fd_sc_hd__o211a_1
X_06594_ net1526 net526 net636 vssd1 vssd1 vccd1 vccd1 _00008_ sky130_fd_sc_hd__mux2_1
X_08333_ _02444_ _02448_ _02449_ vssd1 vssd1 vccd1 vccd1 _02450_ sky130_fd_sc_hd__nand3_1
XFILLER_0_86_392 vssd1 vssd1 vccd1 vccd1 sky130_ef_sc_hd__decap_12
XFILLER_0_19_426 vssd1 vssd1 vccd1 vccd1 sky130_fd_sc_hd__fill_1
X_08264_ _02378_ _02379_ _02256_ _02260_ vssd1 vssd1 vccd1 vccd1 _02382_ sky130_fd_sc_hd__o211a_1
XFILLER_0_116_133 vssd1 vssd1 vccd1 vccd1 sky130_fd_sc_hd__decap_6
XFILLER_0_74_587 vssd1 vssd1 vccd1 vccd1 sky130_fd_sc_hd__fill_1
XFILLER_0_62_727 vssd1 vssd1 vccd1 vccd1 sky130_fd_sc_hd__fill_2
XFILLER_0_116_177 vssd1 vssd1 vccd1 vccd1 sky130_ef_sc_hd__decap_12
X_08195_ net1084 net1091 net796 net786 vssd1 vssd1 vccd1 vccd1 _02313_ sky130_fd_sc_hd__nand4_1
X_07215_ net1113 net820 net813 net1120 vssd1 vssd1 vccd1 vccd1 _01340_ sky130_fd_sc_hd__a22oi_1
X_07146_ _01068_ _01268_ _01270_ vssd1 vssd1 vccd1 vccd1 _01271_ sky130_fd_sc_hd__or3_4
XFILLER_0_14_197 vssd1 vssd1 vccd1 vccd1 sky130_ef_sc_hd__decap_12
X_07077_ _01149_ _01155_ _01150_ vssd1 vssd1 vccd1 vccd1 _01202_ sky130_fd_sc_hd__a21bo_1
Xoutput351 net351 vssd1 vssd1 vccd1 vccd1 mstream_o[114] sky130_fd_sc_hd__clkbuf_4
Xoutput340 net340 vssd1 vssd1 vccd1 vccd1 mstream_o[104] sky130_fd_sc_hd__clkbuf_4
Xoutput362 net362 vssd1 vssd1 vccd1 vccd1 mstream_o[20] sky130_fd_sc_hd__clkbuf_4
XFILLER_0_100_567 vssd1 vssd1 vccd1 vccd1 sky130_fd_sc_hd__fill_1
Xfanout1009 net1010 vssd1 vssd1 vccd1 vccd1 net1009 sky130_fd_sc_hd__buf_2
Xoutput395 net395 vssd1 vssd1 vccd1 vccd1 mstream_o[50] sky130_fd_sc_hd__clkbuf_4
Xoutput373 net373 vssd1 vssd1 vccd1 vccd1 mstream_o[30] sky130_fd_sc_hd__clkbuf_4
Xoutput384 net384 vssd1 vssd1 vccd1 vccd1 mstream_o[40] sky130_fd_sc_hd__clkbuf_4
XFILLER_0_100_589 vssd1 vssd1 vccd1 vccd1 sky130_fd_sc_hd__decap_4
X_09718_ _03823_ _03824_ _03825_ vssd1 vssd1 vccd1 vccd1 _03826_ sky130_fd_sc_hd__nand3_1
X_07979_ _02095_ _02098_ vssd1 vssd1 vccd1 vccd1 _02099_ sky130_fd_sc_hd__xor2_1
XFILLER_0_97_635 vssd1 vssd1 vccd1 vccd1 sky130_fd_sc_hd__fill_2
XFILLER_0_69_315 vssd1 vssd1 vccd1 vccd1 sky130_fd_sc_hd__decap_3
X_10990_ net836 net928 _04969_ vssd1 vssd1 vccd1 vccd1 _05089_ sky130_fd_sc_hd__a21oi_1
X_09649_ net714 _03756_ _03755_ vssd1 vssd1 vccd1 vccd1 _03757_ sky130_fd_sc_hd__a21bo_1
XFILLER_0_97_668 vssd1 vssd1 vccd1 vccd1 sky130_fd_sc_hd__decap_4
XTAP_1013 vssd1 vccd1 sky130_fd_sc_hd__tapvpwrvgnd_1
XTAP_1002 vssd1 vccd1 sky130_fd_sc_hd__tapvpwrvgnd_1
XTAP_1046 vssd1 vccd1 sky130_fd_sc_hd__tapvpwrvgnd_1
X_12660_ clknet_leaf_20_clk_i net1365 net1175 vssd1 vssd1 vccd1 vccd1 net387 sky130_fd_sc_hd__dfrtp_1
XTAP_1035 vssd1 vccd1 sky130_fd_sc_hd__tapvpwrvgnd_1
XTAP_1024 vssd1 vccd1 sky130_fd_sc_hd__tapvpwrvgnd_1
XFILLER_0_108_601 vssd1 vssd1 vccd1 vccd1 sky130_ef_sc_hd__decap_12
XFILLER_0_93_841 vssd1 vssd1 vccd1 vccd1 sky130_fd_sc_hd__fill_1
XTAP_1068 vssd1 vccd1 sky130_fd_sc_hd__tapvpwrvgnd_1
XTAP_1079 vssd1 vccd1 sky130_fd_sc_hd__tapvpwrvgnd_1
XTAP_1057 vssd1 vccd1 sky130_fd_sc_hd__tapvpwrvgnd_1
X_11611_ net990 net712 vssd1 vssd1 vccd1 vccd1 _05705_ sky130_fd_sc_hd__nand2_1
XFILLER_0_37_223 vssd1 vssd1 vccd1 vccd1 sky130_fd_sc_hd__fill_1
XFILLER_0_38_757 vssd1 vssd1 vccd1 vccd1 sky130_fd_sc_hd__decap_4
XFILLER_0_107_111 vssd1 vssd1 vccd1 vccd1 sky130_fd_sc_hd__fill_1
X_12591_ net1594 net34 net554 vssd1 vssd1 vccd1 vccd1 _00566_ sky130_fd_sc_hd__mux2_1
XFILLER_0_37_267 vssd1 vssd1 vccd1 vccd1 sky130_fd_sc_hd__fill_2
XFILLER_0_108_645 vssd1 vssd1 vccd1 vccd1 sky130_ef_sc_hd__decap_12
XFILLER_0_92_373 vssd1 vssd1 vccd1 vccd1 sky130_fd_sc_hd__fill_1
XFILLER_0_9_191 vssd1 vssd1 vccd1 vccd1 sky130_fd_sc_hd__fill_2
X_11542_ _05635_ _05636_ vssd1 vssd1 vccd1 vccd1 _05637_ sky130_fd_sc_hd__xor2_1
XFILLER_0_37_278 vssd1 vssd1 vccd1 vccd1 sky130_fd_sc_hd__fill_2
XFILLER_0_123_615 vssd1 vssd1 vccd1 vccd1 sky130_fd_sc_hd__fill_1
Xwire456 _04652_ vssd1 vssd1 vccd1 vccd1 net456 sky130_fd_sc_hd__clkbuf_1
X_11473_ _04958_ _05567_ vssd1 vssd1 vccd1 vccd1 _05568_ sky130_fd_sc_hd__xnor2_1
XFILLER_0_61_782 vssd1 vssd1 vccd1 vccd1 sky130_fd_sc_hd__fill_2
X_10424_ net1297 _04527_ net524 vssd1 vssd1 vccd1 vccd1 _00144_ sky130_fd_sc_hd__mux2_1
XFILLER_0_110_309 vssd1 vssd1 vccd1 vccd1 sky130_ef_sc_hd__decap_12
X_13143_ clknet_leaf_14_clk_i _00529_ net1185 vssd1 vssd1 vccd1 vccd1 l0\[4\] sky130_fd_sc_hd__dfrtp_1
XFILLER_0_103_361 vssd1 vssd1 vccd1 vccd1 sky130_fd_sc_hd__decap_4
X_10355_ _04457_ _04458_ _04451_ vssd1 vssd1 vccd1 vccd1 _04459_ sky130_fd_sc_hd__a21o_1
XFILLER_0_57_17 vssd1 vssd1 vccd1 vccd1 sky130_fd_sc_hd__fill_1
XFILLER_0_20_156 vssd1 vssd1 vccd1 vccd1 sky130_fd_sc_hd__decap_8
XTAP_808 vssd1 vccd1 sky130_fd_sc_hd__tapvpwrvgnd_1
X_10286_ _04229_ _04230_ vssd1 vssd1 vccd1 vccd1 _04390_ sky130_fd_sc_hd__and2_1
X_13074_ clknet_leaf_28_clk_i _00460_ net1168 vssd1 vssd1 vccd1 vccd1 y2my0\[31\]
+ sky130_fd_sc_hd__dfrtp_1
XTAP_819 vssd1 vccd1 sky130_fd_sc_hd__tapvpwrvgnd_1
X_12025_ net1277 _06023_ net483 vssd1 vssd1 vccd1 vccd1 _00249_ sky130_fd_sc_hd__mux2_1
XFILLER_0_73_27 vssd1 vssd1 vccd1 vccd1 sky130_fd_sc_hd__decap_6
XFILLER_0_87_101 vssd1 vssd1 vccd1 vccd1 sky130_fd_sc_hd__decap_8
X_12927_ clknet_leaf_25_clk_i _00313_ vssd1 vssd1 vccd1 vccd1 mul1.b\[30\] sky130_fd_sc_hd__dfxtp_1
XFILLER_0_87_178 vssd1 vssd1 vccd1 vccd1 sky130_fd_sc_hd__decap_8
X_12858_ clknet_leaf_30_clk_i _00244_ vssd1 vssd1 vccd1 vccd1 sub1.b_i\[25\] sky130_fd_sc_hd__dfxtp_1
XFILLER_0_96_690 vssd1 vssd1 vccd1 vccd1 sky130_fd_sc_hd__decap_8
X_11809_ net1596 _05852_ net481 vssd1 vssd1 vccd1 vccd1 _00204_ sky130_fd_sc_hd__mux2_1
XFILLER_0_113_55 vssd1 vssd1 vccd1 vccd1 sky130_fd_sc_hd__fill_1
XTAP_1591 vssd1 vccd1 sky130_fd_sc_hd__tapvpwrvgnd_1
XTAP_1580 vssd1 vccd1 sky130_fd_sc_hd__tapvpwrvgnd_1
X_12789_ clknet_leaf_40_clk_i _00175_ vssd1 vssd1 vccd1 vccd1 add1.b_i\[20\] sky130_fd_sc_hd__dfxtp_1
XFILLER_0_125_3 vssd1 vssd1 vccd1 vccd1 sky130_ef_sc_hd__decap_12
XFILLER_0_56_587 vssd1 vssd1 vccd1 vccd1 sky130_fd_sc_hd__fill_1
XFILLER_0_43_204 vssd1 vssd1 vccd1 vccd1 sky130_ef_sc_hd__decap_12
XFILLER_0_22_53 vssd1 vssd1 vccd1 vccd1 sky130_ef_sc_hd__decap_12
XFILLER_0_71_557 vssd1 vssd1 vccd1 vccd1 sky130_fd_sc_hd__decap_3
XFILLER_0_114_637 vssd1 vssd1 vccd1 vccd1 sky130_fd_sc_hd__decap_6
XFILLER_0_113_125 vssd1 vssd1 vccd1 vccd1 sky130_ef_sc_hd__decap_12
X_07000_ net872 net863 net1088 net1095 vssd1 vssd1 vccd1 vccd1 _01125_ sky130_fd_sc_hd__and4_1
XFILLER_0_113_169 vssd1 vssd1 vccd1 vccd1 sky130_ef_sc_hd__decap_12
XFILLER_0_122_681 vssd1 vssd1 vccd1 vccd1 sky130_ef_sc_hd__decap_12
X_08951_ net903 net894 net962 vssd1 vssd1 vccd1 vccd1 _03064_ sky130_fd_sc_hd__and3_1
XFILLER_0_11_167 vssd1 vssd1 vccd1 vccd1 sky130_fd_sc_hd__fill_1
XFILLER_0_11_178 vssd1 vssd1 vccd1 vccd1 sky130_fd_sc_hd__decap_8
X_08882_ _02994_ vssd1 vssd1 vccd1 vccd1 _02995_ sky130_fd_sc_hd__inv_2
X_07902_ net920 net912 net994 net986 vssd1 vssd1 vccd1 vccd1 _02023_ sky130_fd_sc_hd__nand4_1
XFILLER_0_47_61 vssd1 vssd1 vccd1 vccd1 sky130_fd_sc_hd__fill_1
X_07833_ _01852_ _01949_ vssd1 vssd1 vccd1 vccd1 _01954_ sky130_fd_sc_hd__nand2_1
XFILLER_0_47_94 vssd1 vssd1 vccd1 vccd1 sky130_fd_sc_hd__fill_1
XFILLER_0_79_635 vssd1 vssd1 vccd1 vccd1 sky130_ef_sc_hd__decap_12
X_07764_ net1066 net1077 net848 net839 vssd1 vssd1 vccd1 vccd1 _01886_ sky130_fd_sc_hd__nand4_2
XFILLER_0_2_41 vssd1 vssd1 vccd1 vccd1 sky130_fd_sc_hd__decap_6
X_09503_ _03448_ _03450_ vssd1 vssd1 vccd1 vccd1 _03612_ sky130_fd_sc_hd__nand2_1
X_07695_ _01816_ _01817_ vssd1 vssd1 vccd1 vccd1 _01818_ sky130_fd_sc_hd__nor2_1
XFILLER_0_2_85 vssd1 vssd1 vccd1 vccd1 sky130_fd_sc_hd__decap_3
X_06715_ net1333 _00935_ net635 vssd1 vssd1 vccd1 vccd1 _00027_ sky130_fd_sc_hd__mux2_1
X_09434_ net915 net932 _03540_ _03542_ vssd1 vssd1 vccd1 vccd1 _03544_ sky130_fd_sc_hd__nand4_1
XPHY_107 vssd1 vssd1 vccd1 vccd1 sky130_fd_sc_hd__decap_3
X_06646_ net1734 _00877_ net633 vssd1 vssd1 vccd1 vccd1 _00016_ sky130_fd_sc_hd__mux2_1
XFILLER_0_75_841 vssd1 vssd1 vccd1 vccd1 sky130_fd_sc_hd__fill_1
XPHY_129 vssd1 vssd1 vccd1 vccd1 sky130_fd_sc_hd__decap_3
XPHY_118 vssd1 vssd1 vccd1 vccd1 sky130_fd_sc_hd__decap_3
XFILLER_0_47_532 vssd1 vssd1 vccd1 vccd1 sky130_fd_sc_hd__fill_1
X_09365_ net1039 net1047 net784 net777 vssd1 vssd1 vccd1 vccd1 _03475_ sky130_fd_sc_hd__and4_1
X_06577_ _00814_ _00815_ _00816_ vssd1 vssd1 vccd1 vccd1 _00819_ sky130_fd_sc_hd__a21bo_2
XANTENNA_41 net57 vssd1 vssd1 vccd1 vccd1 sky130_fd_sc_hd__diode_2
X_08316_ net1114 net755 vssd1 vssd1 vccd1 vccd1 _02433_ sky130_fd_sc_hd__nand2_1
X_09296_ _03303_ _03304_ _03403_ _03404_ vssd1 vssd1 vccd1 vccd1 _03407_ sky130_fd_sc_hd__o22ai_2
XFILLER_0_74_362 vssd1 vssd1 vccd1 vccd1 sky130_fd_sc_hd__fill_2
XANTENNA_30 net10 vssd1 vssd1 vccd1 vccd1 sky130_fd_sc_hd__diode_2
XFILLER_0_19_267 vssd1 vssd1 vccd1 vccd1 sky130_fd_sc_hd__fill_1
XFILLER_0_35_749 vssd1 vssd1 vccd1 vccd1 sky130_fd_sc_hd__fill_2
XFILLER_0_105_615 vssd1 vssd1 vccd1 vccd1 sky130_fd_sc_hd__fill_1
XFILLER_0_62_546 vssd1 vssd1 vccd1 vccd1 sky130_fd_sc_hd__decap_3
X_08247_ net908 net979 vssd1 vssd1 vccd1 vccd1 _02365_ sky130_fd_sc_hd__and2_1
XFILLER_0_6_150 vssd1 vssd1 vccd1 vccd1 sky130_fd_sc_hd__fill_1
XANTENNA_52 v0x[8] vssd1 vssd1 vccd1 vccd1 sky130_fd_sc_hd__diode_2
XANTENNA_63 net10 vssd1 vssd1 vccd1 vccd1 sky130_fd_sc_hd__diode_2
XFILLER_0_117_497 vssd1 vssd1 vccd1 vccd1 sky130_fd_sc_hd__decap_6
X_08178_ _02295_ net734 net1147 _02293_ vssd1 vssd1 vccd1 vccd1 _02296_ sky130_fd_sc_hd__and4b_1
XFILLER_0_30_465 vssd1 vssd1 vccd1 vccd1 sky130_fd_sc_hd__decap_4
X_07129_ _01232_ _01233_ _01251_ _01252_ vssd1 vssd1 vccd1 vccd1 _01254_ sky130_fd_sc_hd__or4bb_1
X_10140_ _04121_ _04129_ _04128_ vssd1 vssd1 vccd1 vccd1 _04245_ sky130_fd_sc_hd__a21o_1
X_10071_ net884 net931 _04174_ _04175_ vssd1 vssd1 vccd1 vccd1 _04177_ sky130_fd_sc_hd__a22o_1
XFILLER_0_69_101 vssd1 vssd1 vccd1 vccd1 sky130_fd_sc_hd__fill_1
Xmax_cap10 _04891_ vssd1 vssd1 vccd1 vccd1 net1751 sky130_fd_sc_hd__buf_1
X_10973_ _04910_ _04913_ _05071_ _05072_ vssd1 vssd1 vccd1 vccd1 _05073_ sky130_fd_sc_hd__a211oi_1
X_12712_ clknet_leaf_9_clk_i _00098_ net1191 vssd1 vssd1 vccd1 vccd1 net444 sky130_fd_sc_hd__dfrtp_1
XPHY_9 vssd1 vssd1 vccd1 vccd1 sky130_fd_sc_hd__decap_3
XFILLER_0_84_137 vssd1 vssd1 vccd1 vccd1 sky130_fd_sc_hd__decap_3
X_12643_ clknet_leaf_27_clk_i _00029_ net1170 vssd1 vssd1 vccd1 vccd1 net368 sky130_fd_sc_hd__dfrtp_1
X_12574_ net1253 net19 net560 vssd1 vssd1 vccd1 vccd1 _00550_ sky130_fd_sc_hd__mux2_1
XFILLER_0_111_9 vssd1 vssd1 vccd1 vccd1 sky130_ef_sc_hd__decap_12
XFILLER_0_4_109 vssd1 vssd1 vccd1 vccd1 sky130_fd_sc_hd__fill_2
X_11525_ _05618_ _05619_ vssd1 vssd1 vccd1 vccd1 _05620_ sky130_fd_sc_hd__nor2_1
XFILLER_0_80_365 vssd1 vssd1 vccd1 vccd1 sky130_fd_sc_hd__decap_4
XFILLER_0_25_259 vssd1 vssd1 vccd1 vccd1 sky130_fd_sc_hd__fill_1
X_11456_ _05428_ _05430_ _05550_ _05551_ vssd1 vssd1 vccd1 vccd1 _05552_ sky130_fd_sc_hd__a211oi_4
XFILLER_0_111_629 vssd1 vssd1 vccd1 vccd1 sky130_ef_sc_hd__decap_12
XFILLER_0_104_681 vssd1 vssd1 vccd1 vccd1 sky130_ef_sc_hd__decap_12
X_10407_ _04426_ _04427_ _04508_ _04509_ vssd1 vssd1 vccd1 vccd1 _04511_ sky130_fd_sc_hd__o22a_1
XFILLER_0_68_27 vssd1 vssd1 vccd1 vccd1 sky130_fd_sc_hd__fill_1
X_11387_ net789 net935 net930 net799 vssd1 vssd1 vccd1 vccd1 _05483_ sky130_fd_sc_hd__a22o_1
X_13126_ clknet_leaf_2_clk_i _00512_ vssd1 vssd1 vccd1 vccd1 det_t\[19\] sky130_fd_sc_hd__dfxtp_1
XFILLER_0_110_139 vssd1 vssd1 vccd1 vccd1 sky130_fd_sc_hd__fill_1
X_10338_ _04439_ _04440_ _04429_ vssd1 vssd1 vccd1 vccd1 _04442_ sky130_fd_sc_hd__a21o_1
XTAP_605 vssd1 vccd1 sky130_fd_sc_hd__tapvpwrvgnd_1
XTAP_616 vssd1 vccd1 sky130_fd_sc_hd__tapvpwrvgnd_1
XTAP_627 vssd1 vccd1 sky130_fd_sc_hd__tapvpwrvgnd_1
XTAP_638 vssd1 vccd1 sky130_fd_sc_hd__tapvpwrvgnd_1
XTAP_649 vssd1 vccd1 sky130_fd_sc_hd__tapvpwrvgnd_1
X_13057_ clknet_leaf_42_clk_i _00443_ net1164 vssd1 vssd1 vccd1 vccd1 y2my0\[14\]
+ sky130_fd_sc_hd__dfrtp_1
X_10269_ _04372_ _04373_ vssd1 vssd1 vccd1 vccd1 _04374_ sky130_fd_sc_hd__or2_1
XFILLER_0_84_15 vssd1 vssd1 vccd1 vccd1 sky130_ef_sc_hd__decap_12
X_12008_ net140 net661 net505 net236 _06010_ vssd1 vssd1 vccd1 vccd1 _06011_ sky130_fd_sc_hd__a221o_1
XFILLER_0_108_77 vssd1 vssd1 vccd1 vccd1 sky130_fd_sc_hd__decap_6
X_06500_ det_t\[10\] net529 vssd1 vssd1 vccd1 vccd1 net253 sky130_fd_sc_hd__and2_1
XFILLER_0_76_605 vssd1 vssd1 vccd1 vccd1 sky130_fd_sc_hd__fill_1
XFILLER_0_48_307 vssd1 vssd1 vccd1 vccd1 sky130_fd_sc_hd__fill_1
X_07480_ _01604_ vssd1 vssd1 vccd1 vccd1 _01605_ sky130_fd_sc_hd__inv_2
XFILLER_0_124_65 vssd1 vssd1 vccd1 vccd1 sky130_ef_sc_hd__decap_12
X_06431_ net546 _00733_ vssd1 vssd1 vccd1 vccd1 net320 sky130_fd_sc_hd__nor2_1
XFILLER_0_119_729 vssd1 vssd1 vccd1 vccd1 sky130_ef_sc_hd__decap_12
XFILLER_0_91_608 vssd1 vssd1 vccd1 vccd1 sky130_fd_sc_hd__decap_3
XFILLER_0_57_841 vssd1 vssd1 vccd1 vccd1 sky130_fd_sc_hd__fill_1
X_09150_ _03103_ _03261_ vssd1 vssd1 vccd1 vccd1 _03262_ sky130_fd_sc_hd__xnor2_4
XFILLER_0_72_811 vssd1 vssd1 vccd1 vccd1 sky130_fd_sc_hd__fill_1
X_06362_ _00624_ _00672_ _00623_ vssd1 vssd1 vccd1 vccd1 _00674_ sky130_fd_sc_hd__a21o_1
XFILLER_0_114_401 vssd1 vssd1 vccd1 vccd1 sky130_ef_sc_hd__decap_12
X_08101_ _02218_ _02219_ vssd1 vssd1 vccd1 vccd1 _02220_ sky130_fd_sc_hd__and2_1
X_09081_ net1025 net810 vssd1 vssd1 vccd1 vccd1 _03193_ sky130_fd_sc_hd__nand2_1
XFILLER_0_71_321 vssd1 vssd1 vccd1 vccd1 sky130_fd_sc_hd__decap_8
XFILLER_0_16_237 vssd1 vssd1 vccd1 vccd1 sky130_fd_sc_hd__decap_3
X_06293_ state\[4\] _00606_ vssd1 vssd1 vccd1 vccd1 _00607_ sky130_fd_sc_hd__or2_1
XFILLER_0_114_445 vssd1 vssd1 vccd1 vccd1 sky130_ef_sc_hd__decap_12
X_08032_ _02038_ _02040_ _02150_ _02151_ vssd1 vssd1 vccd1 vccd1 _02152_ sky130_fd_sc_hd__o211a_1
XFILLER_0_4_621 vssd1 vssd1 vccd1 vccd1 sky130_fd_sc_hd__fill_1
XFILLER_0_4_676 vssd1 vssd1 vccd1 vccd1 sky130_fd_sc_hd__fill_1
Xinput61 v0x[12] vssd1 vssd1 vccd1 vccd1 net61 sky130_fd_sc_hd__buf_1
Xinput72 v0x[22] vssd1 vssd1 vccd1 vccd1 net72 sky130_fd_sc_hd__buf_1
Xinput50 sstream_i[2] vssd1 vssd1 vccd1 vccd1 net50 sky130_fd_sc_hd__buf_4
XFILLER_0_114_489 vssd1 vssd1 vccd1 vccd1 sky130_ef_sc_hd__decap_12
Xinput94 v0y[13] vssd1 vssd1 vccd1 vccd1 net94 sky130_fd_sc_hd__buf_1
Xinput83 v0x[3] vssd1 vssd1 vccd1 vccd1 net83 sky130_fd_sc_hd__buf_1
X_09983_ _03920_ _04087_ vssd1 vssd1 vccd1 vccd1 _04089_ sky130_fd_sc_hd__xor2_4
X_08934_ _02914_ _02916_ _03045_ vssd1 vssd1 vccd1 vccd1 _03047_ sky130_fd_sc_hd__o21ai_1
X_08865_ _02968_ _02976_ vssd1 vssd1 vccd1 vccd1 _02978_ sky130_fd_sc_hd__xnor2_1
XFILLER_0_99_719 vssd1 vssd1 vccd1 vccd1 sky130_fd_sc_hd__decap_8
X_08796_ net877 net869 net987 net980 vssd1 vssd1 vccd1 vccd1 _02910_ sky130_fd_sc_hd__and4_1
X_07816_ _01877_ _01878_ _01936_ _01937_ vssd1 vssd1 vccd1 vccd1 _01938_ sky130_fd_sc_hd__and4_1
XFILLER_0_74_81 vssd1 vssd1 vccd1 vccd1 sky130_fd_sc_hd__decap_3
X_07747_ _01765_ _01773_ _01772_ vssd1 vssd1 vccd1 vccd1 _01869_ sky130_fd_sc_hd__a21o_1
X_07678_ _01710_ _01712_ _01800_ vssd1 vssd1 vccd1 vccd1 _01801_ sky130_fd_sc_hd__a21o_1
XFILLER_0_109_217 vssd1 vssd1 vccd1 vccd1 sky130_fd_sc_hd__decap_6
XFILLER_0_66_159 vssd1 vssd1 vccd1 vccd1 sky130_fd_sc_hd__decap_6
X_09417_ net879 net956 net949 net883 vssd1 vssd1 vccd1 vccd1 _03527_ sky130_fd_sc_hd__a22o_1
X_06629_ _00857_ _00861_ _00856_ vssd1 vssd1 vccd1 vccd1 _00863_ sky130_fd_sc_hd__a21o_2
X_09348_ _03456_ _03457_ _03289_ _03291_ vssd1 vssd1 vccd1 vccd1 _03458_ sky130_fd_sc_hd__o211ai_2
XFILLER_0_117_261 vssd1 vssd1 vccd1 vccd1 sky130_ef_sc_hd__decap_12
XFILLER_0_90_674 vssd1 vssd1 vccd1 vccd1 sky130_fd_sc_hd__fill_2
X_09279_ _03386_ _03387_ _03388_ vssd1 vssd1 vccd1 vccd1 _03390_ sky130_fd_sc_hd__a21o_1
X_11310_ _05285_ _05287_ vssd1 vssd1 vccd1 vccd1 _05407_ sky130_fd_sc_hd__or2_1
XFILLER_0_105_456 vssd1 vssd1 vccd1 vccd1 sky130_fd_sc_hd__decap_8
XFILLER_0_16_793 vssd1 vssd1 vccd1 vccd1 sky130_fd_sc_hd__decap_6
X_12290_ net1631 _00855_ net675 vssd1 vssd1 vccd1 vccd1 _00342_ sky130_fd_sc_hd__mux2_1
X_11241_ _05328_ _05336_ vssd1 vssd1 vccd1 vccd1 _05338_ sky130_fd_sc_hd__nand2_1
X_11172_ net1036 net702 _05268_ _05269_ vssd1 vssd1 vccd1 vccd1 _05270_ sky130_fd_sc_hd__and4_1
XFILLER_0_101_673 vssd1 vssd1 vccd1 vccd1 sky130_ef_sc_hd__decap_12
X_10123_ net1079 mul1.b\[27\] net710 net1086 vssd1 vssd1 vccd1 vccd1 _04228_ sky130_fd_sc_hd__a22o_1
X_10054_ _04158_ _04159_ vssd1 vssd1 vccd1 vccd1 _04160_ sky130_fd_sc_hd__xor2_2
X_10956_ _04926_ _04929_ _05054_ _05055_ vssd1 vssd1 vccd1 vccd1 _05056_ sky130_fd_sc_hd__a211oi_1
XFILLER_0_85_457 vssd1 vssd1 vccd1 vccd1 sky130_ef_sc_hd__decap_12
XFILLER_0_85_446 vssd1 vssd1 vccd1 vccd1 sky130_fd_sc_hd__fill_2
X_10887_ net1003 net735 _04984_ _04985_ vssd1 vssd1 vccd1 vccd1 _04987_ sky130_fd_sc_hd__a22o_1
XFILLER_0_39_841 vssd1 vssd1 vccd1 vccd1 sky130_fd_sc_hd__fill_1
XFILLER_0_72_129 vssd1 vssd1 vccd1 vccd1 sky130_fd_sc_hd__decap_8
X_12626_ clknet_leaf_36_clk_i _00012_ net1162 vssd1 vssd1 vccd1 vccd1 net449 sky130_fd_sc_hd__dfrtp_2
XFILLER_0_108_261 vssd1 vssd1 vccd1 vccd1 sky130_fd_sc_hd__fill_2
XFILLER_0_53_321 vssd1 vssd1 vccd1 vccd1 sky130_fd_sc_hd__fill_1
X_12557_ net1582 net33 net558 vssd1 vssd1 vccd1 vccd1 _00533_ sky130_fd_sc_hd__mux2_1
XFILLER_0_26_568 vssd1 vssd1 vccd1 vccd1 sky130_fd_sc_hd__decap_3
XFILLER_0_41_505 vssd1 vssd1 vccd1 vccd1 sky130_fd_sc_hd__decap_8
X_12488_ _00786_ net568 vssd1 vssd1 vccd1 vccd1 _06241_ sky130_fd_sc_hd__nand2_1
XFILLER_0_123_231 vssd1 vssd1 vccd1 vccd1 sky130_fd_sc_hd__fill_2
Xhold108 sub1.b_i\[26\] vssd1 vssd1 vccd1 vccd1 net1323 sky130_fd_sc_hd__dlygate4sd3_1
X_11508_ _05601_ _05602_ _05570_ vssd1 vssd1 vccd1 vccd1 _05603_ sky130_fd_sc_hd__o21a_1
XFILLER_0_41_527 vssd1 vssd1 vccd1 vccd1 sky130_fd_sc_hd__decap_4
Xhold119 posy\[0\] vssd1 vssd1 vccd1 vccd1 net1334 sky130_fd_sc_hd__dlygate4sd3_1
X_11439_ _05356_ _05359_ _05534_ vssd1 vssd1 vccd1 vccd1 _05535_ sky130_fd_sc_hd__a21oi_2
X_13109_ clknet_leaf_3_clk_i _00495_ vssd1 vssd1 vccd1 vccd1 det_t\[2\] sky130_fd_sc_hd__dfxtp_1
XTAP_424 vssd1 vccd1 sky130_fd_sc_hd__tapvpwrvgnd_1
XTAP_413 vssd1 vccd1 sky130_fd_sc_hd__tapvpwrvgnd_1
XTAP_402 vssd1 vccd1 sky130_fd_sc_hd__tapvpwrvgnd_1
XFILLER_0_95_69 vssd1 vssd1 vccd1 vccd1 sky130_ef_sc_hd__decap_12
XTAP_435 vssd1 vccd1 sky130_fd_sc_hd__tapvpwrvgnd_1
XTAP_446 vssd1 vccd1 sky130_fd_sc_hd__tapvpwrvgnd_1
XTAP_457 vssd1 vccd1 sky130_fd_sc_hd__tapvpwrvgnd_1
X_06980_ _01085_ _01087_ _01086_ vssd1 vssd1 vccd1 vccd1 _01105_ sky130_fd_sc_hd__o21bai_1
XTAP_468 vssd1 vccd1 sky130_fd_sc_hd__tapvpwrvgnd_1
XTAP_479 vssd1 vccd1 sky130_fd_sc_hd__tapvpwrvgnd_1
Xfanout1192 net1196 vssd1 vssd1 vccd1 vccd1 net1192 sky130_fd_sc_hd__buf_4
X_08650_ _02758_ _02763_ vssd1 vssd1 vccd1 vccd1 _02765_ sky130_fd_sc_hd__xnor2_2
Xfanout1181 net36 vssd1 vssd1 vccd1 vccd1 net1181 sky130_fd_sc_hd__buf_4
Xfanout1170 net1171 vssd1 vssd1 vccd1 vccd1 net1170 sky130_fd_sc_hd__clkbuf_4
XFILLER_0_28_85 vssd1 vssd1 vccd1 vccd1 sky130_ef_sc_hd__decap_12
XFILLER_0_89_741 vssd1 vssd1 vccd1 vccd1 sky130_fd_sc_hd__decap_8
X_07601_ _01721_ _01722_ _01723_ vssd1 vssd1 vccd1 vccd1 _01725_ sky130_fd_sc_hd__nand3_1
X_08581_ _02676_ _02695_ vssd1 vssd1 vccd1 vccd1 _02696_ sky130_fd_sc_hd__and2_1
X_07532_ _01652_ _01653_ _01654_ _01655_ _01656_ vssd1 vssd1 vccd1 vccd1 _01657_ sky130_fd_sc_hd__o41a_1
XFILLER_0_76_457 vssd1 vssd1 vccd1 vccd1 sky130_fd_sc_hd__fill_1
X_07463_ _01567_ _01569_ vssd1 vssd1 vccd1 vccd1 _01588_ sky130_fd_sc_hd__xnor2_1
XFILLER_0_119_559 vssd1 vssd1 vccd1 vccd1 sky130_fd_sc_hd__fill_1
X_09202_ net1071 net761 _03310_ _03312_ vssd1 vssd1 vccd1 vccd1 _03313_ sky130_fd_sc_hd__and4_1
X_06414_ _00708_ _00712_ _00717_ vssd1 vssd1 vccd1 vccd1 _00719_ sky130_fd_sc_hd__nor3b_1
XFILLER_0_29_373 vssd1 vssd1 vccd1 vccd1 sky130_fd_sc_hd__fill_2
X_09133_ _03083_ _03086_ _03242_ _03244_ vssd1 vssd1 vccd1 vccd1 _03245_ sky130_fd_sc_hd__o211a_2
X_07394_ _01516_ _01517_ _01518_ vssd1 vssd1 vccd1 vccd1 _01519_ sky130_fd_sc_hd__nand3_1
XFILLER_0_97_3 vssd1 vssd1 vccd1 vccd1 sky130_ef_sc_hd__decap_12
XFILLER_0_72_663 vssd1 vssd1 vccd1 vccd1 sky130_fd_sc_hd__fill_1
X_06345_ add1.a_i\[5\] add1.b_i\[5\] add1.a_i\[4\] add1.b_i\[4\] vssd1 vssd1 vccd1
+ vccd1 _00657_ sky130_fd_sc_hd__o211a_1
XFILLER_0_114_253 vssd1 vssd1 vccd1 vccd1 sky130_ef_sc_hd__decap_12
X_09064_ _03170_ _03175_ vssd1 vssd1 vccd1 vccd1 _03176_ sky130_fd_sc_hd__nor2_1
X_06276_ sub1.b_i\[6\] vssd1 vssd1 vccd1 vccd1 _00592_ sky130_fd_sc_hd__inv_2
XFILLER_0_32_549 vssd1 vssd1 vccd1 vccd1 sky130_fd_sc_hd__fill_1
XFILLER_0_115_798 vssd1 vssd1 vccd1 vccd1 sky130_fd_sc_hd__fill_1
XFILLER_0_102_415 vssd1 vssd1 vccd1 vccd1 sky130_fd_sc_hd__decap_4
X_08015_ _02132_ _02133_ _02131_ vssd1 vssd1 vccd1 vccd1 _02135_ sky130_fd_sc_hd__a21o_1
XFILLER_0_69_81 vssd1 vssd1 vccd1 vccd1 sky130_fd_sc_hd__decap_6
X_09966_ net1086 net714 net710 net1093 vssd1 vssd1 vccd1 vccd1 _04072_ sky130_fd_sc_hd__a22oi_1
X_08917_ net1017 net825 net818 net1025 vssd1 vssd1 vccd1 vccd1 _03030_ sky130_fd_sc_hd__a22o_1
X_09897_ _04001_ _04002_ _03841_ _03842_ vssd1 vssd1 vccd1 vccd1 _04004_ sky130_fd_sc_hd__o211ai_2
XTAP_980 vssd1 vccd1 sky130_fd_sc_hd__tapvpwrvgnd_1
XTAP_991 vssd1 vccd1 sky130_fd_sc_hd__tapvpwrvgnd_1
X_08848_ temp1\[11\] _02961_ net541 vssd1 vssd1 vccd1 vccd1 _02962_ sky130_fd_sc_hd__mux2_1
XFILLER_0_99_538 vssd1 vssd1 vccd1 vccd1 sky130_fd_sc_hd__decap_4
X_08779_ net843 net1008 net1001 net852 vssd1 vssd1 vccd1 vccd1 _02893_ sky130_fd_sc_hd__a22o_1
XFILLER_0_79_262 vssd1 vssd1 vccd1 vccd1 sky130_fd_sc_hd__decap_4
X_10810_ _04759_ _04764_ _04909_ vssd1 vssd1 vccd1 vccd1 _04911_ sky130_fd_sc_hd__or3_1
X_11790_ net64 net674 net608 net192 vssd1 vssd1 vccd1 vccd1 _05836_ sky130_fd_sc_hd__a22o_1
XFILLER_0_39_126 vssd1 vssd1 vccd1 vccd1 sky130_fd_sc_hd__fill_1
X_10741_ net836 net942 _04691_ _04690_ vssd1 vssd1 vccd1 vccd1 _04842_ sky130_fd_sc_hd__a31o_1
XFILLER_0_125_529 vssd1 vssd1 vccd1 vccd1 sky130_ef_sc_hd__decap_12
X_10672_ net1029 net731 net725 net1037 vssd1 vssd1 vccd1 vccd1 _04774_ sky130_fd_sc_hd__a22oi_1
X_12411_ _00810_ net612 _01667_ net574 vssd1 vssd1 vccd1 vccd1 _06198_ sky130_fd_sc_hd__a22o_1
XFILLER_0_118_581 vssd1 vssd1 vccd1 vccd1 sky130_fd_sc_hd__decap_6
XFILLER_0_62_151 vssd1 vssd1 vccd1 vccd1 sky130_fd_sc_hd__fill_2
XFILLER_0_35_354 vssd1 vssd1 vccd1 vccd1 sky130_fd_sc_hd__decap_4
XFILLER_0_106_776 vssd1 vssd1 vccd1 vccd1 sky130_fd_sc_hd__decap_4
XFILLER_0_105_253 vssd1 vssd1 vccd1 vccd1 sky130_fd_sc_hd__decap_6
XFILLER_0_51_836 vssd1 vssd1 vccd1 vccd1 sky130_fd_sc_hd__decap_4
X_12342_ net1634 _00965_ net673 vssd1 vssd1 vccd1 vccd1 _00394_ sky130_fd_sc_hd__mux2_1
X_12273_ net1507 net51 net689 vssd1 vssd1 vccd1 vccd1 _00327_ sky130_fd_sc_hd__mux2_1
XFILLER_0_120_245 vssd1 vssd1 vccd1 vccd1 sky130_fd_sc_hd__decap_6
XFILLER_0_49_29 vssd1 vssd1 vccd1 vccd1 sky130_fd_sc_hd__fill_2
X_11224_ temp1\[27\] _05321_ net542 vssd1 vssd1 vccd1 vccd1 _05322_ sky130_fd_sc_hd__mux2_1
XFILLER_0_31_593 vssd1 vssd1 vccd1 vccd1 sky130_fd_sc_hd__decap_6
XFILLER_0_120_289 vssd1 vssd1 vccd1 vccd1 sky130_ef_sc_hd__decap_12
X_11155_ _05125_ _05127_ _05252_ vssd1 vssd1 vccd1 vccd1 _05253_ sky130_fd_sc_hd__a21o_1
X_10106_ _04209_ _04210_ vssd1 vssd1 vccd1 vccd1 _04212_ sky130_fd_sc_hd__xnor2_4
X_11086_ _05182_ _05183_ _05142_ vssd1 vssd1 vccd1 vccd1 _05185_ sky130_fd_sc_hd__a21o_1
X_10037_ _03970_ _03978_ _03977_ vssd1 vssd1 vccd1 vccd1 _04143_ sky130_fd_sc_hd__a21bo_1
Xinput240 v2y[2] vssd1 vssd1 vccd1 vccd1 net240 sky130_fd_sc_hd__buf_1
XFILLER_0_86_733 vssd1 vssd1 vccd1 vccd1 sky130_ef_sc_hd__decap_12
XFILLER_0_85_210 vssd1 vssd1 vccd1 vccd1 sky130_fd_sc_hd__fill_1
XFILLER_0_81_27 vssd1 vssd1 vccd1 vccd1 sky130_ef_sc_hd__decap_12
X_11988_ net135 net660 net504 net231 _05995_ vssd1 vssd1 vccd1 vccd1 _05996_ sky130_fd_sc_hd__a221o_1
XFILLER_0_129_813 vssd1 vssd1 vccd1 vccd1 sky130_ef_sc_hd__decap_12
XFILLER_0_105_45 vssd1 vssd1 vccd1 vccd1 sky130_fd_sc_hd__decap_8
X_10939_ _05037_ _05038_ vssd1 vssd1 vccd1 vccd1 _05039_ sky130_fd_sc_hd__or2_1
XFILLER_0_14_21 vssd1 vssd1 vccd1 vccd1 sky130_fd_sc_hd__decap_6
XFILLER_0_14_65 vssd1 vssd1 vccd1 vccd1 sky130_ef_sc_hd__decap_12
XFILLER_0_128_356 vssd1 vssd1 vccd1 vccd1 sky130_fd_sc_hd__decap_3
XFILLER_0_73_449 vssd1 vssd1 vccd1 vccd1 sky130_fd_sc_hd__decap_4
XFILLER_0_66_490 vssd1 vssd1 vccd1 vccd1 sky130_ef_sc_hd__decap_12
X_12609_ net1415 net21 net555 vssd1 vssd1 vccd1 vccd1 _00584_ sky130_fd_sc_hd__mux2_1
XFILLER_0_53_140 vssd1 vssd1 vccd1 vccd1 sky130_ef_sc_hd__decap_12
XFILLER_0_26_365 vssd1 vssd1 vccd1 vccd1 sky130_fd_sc_hd__decap_3
XFILLER_0_121_55 vssd1 vssd1 vccd1 vccd1 sky130_fd_sc_hd__fill_1
XFILLER_0_54_696 vssd1 vssd1 vccd1 vccd1 sky130_fd_sc_hd__fill_1
XFILLER_0_112_713 vssd1 vssd1 vccd1 vccd1 sky130_ef_sc_hd__decap_12
XFILLER_0_53_195 vssd1 vssd1 vccd1 vccd1 sky130_fd_sc_hd__fill_2
XFILLER_0_111_223 vssd1 vssd1 vccd1 vccd1 sky130_fd_sc_hd__fill_1
XFILLER_0_10_755 vssd1 vssd1 vccd1 vccd1 sky130_fd_sc_hd__fill_1
X_09820_ _03926_ vssd1 vssd1 vccd1 vccd1 _03927_ sky130_fd_sc_hd__inv_2
X_09751_ net860 net956 _03857_ _03858_ vssd1 vssd1 vccd1 vccd1 _03859_ sky130_fd_sc_hd__nand4_1
XTAP_265 vssd1 vccd1 sky130_fd_sc_hd__tapvpwrvgnd_1
X_06963_ _01085_ _01086_ _01087_ vssd1 vssd1 vccd1 vccd1 _01088_ sky130_fd_sc_hd__or3_1
X_08702_ _02814_ _02816_ _02812_ vssd1 vssd1 vccd1 vccd1 _02817_ sky130_fd_sc_hd__a21oi_1
XTAP_298 vssd1 vccd1 sky130_fd_sc_hd__tapvpwrvgnd_1
XTAP_276 vssd1 vccd1 sky130_fd_sc_hd__tapvpwrvgnd_1
XTAP_287 vssd1 vccd1 sky130_fd_sc_hd__tapvpwrvgnd_1
X_09682_ _03623_ _03626_ vssd1 vssd1 vccd1 vccd1 _03790_ sky130_fd_sc_hd__and2b_2
X_06894_ net895 net887 net1081 net1088 vssd1 vssd1 vccd1 vccd1 _01019_ sky130_fd_sc_hd__and4_1
X_08633_ _02746_ _02747_ vssd1 vssd1 vccd1 vccd1 _02748_ sky130_fd_sc_hd__and2_2
Xclkbuf_leaf_14_clk_i clknet_3_7__leaf_clk_i vssd1 vssd1 vccd1 vccd1 clknet_leaf_14_clk_i
+ sky130_fd_sc_hd__clkbuf_16
X_08564_ net1131 net727 net723 net1140 vssd1 vssd1 vccd1 vccd1 _02679_ sky130_fd_sc_hd__a22o_1
XTAP_1409 vssd1 vccd1 sky130_fd_sc_hd__tapvpwrvgnd_1
XFILLER_0_12_3 vssd1 vssd1 vccd1 vccd1 sky130_ef_sc_hd__decap_12
X_07515_ net918 net1130 net1138 net910 vssd1 vssd1 vccd1 vccd1 _01640_ sky130_fd_sc_hd__a22o_1
X_08495_ _02602_ _02608_ _02609_ vssd1 vssd1 vccd1 vccd1 _02611_ sky130_fd_sc_hd__nand3_2
XFILLER_0_18_811 vssd1 vssd1 vccd1 vccd1 sky130_fd_sc_hd__fill_1
XFILLER_0_91_213 vssd1 vssd1 vccd1 vccd1 sky130_fd_sc_hd__fill_1
Xclkbuf_leaf_29_clk_i clknet_3_5__leaf_clk_i vssd1 vssd1 vccd1 vccd1 clknet_leaf_29_clk_i
+ sky130_fd_sc_hd__clkbuf_16
X_07446_ _01528_ _01555_ _01570_ vssd1 vssd1 vccd1 vccd1 _01571_ sky130_fd_sc_hd__and3_1
XFILLER_0_91_279 vssd1 vssd1 vccd1 vccd1 sky130_fd_sc_hd__fill_1
X_07377_ _01500_ _01501_ vssd1 vssd1 vccd1 vccd1 _01502_ sky130_fd_sc_hd__and2_1
X_09116_ _03224_ _03225_ _03226_ vssd1 vssd1 vccd1 vccd1 _03228_ sky130_fd_sc_hd__nand3_1
X_06328_ add1.a_i\[4\] add1.b_i\[4\] vssd1 vssd1 vccd1 vccd1 _00640_ sky130_fd_sc_hd__or2_1
XFILLER_0_115_573 vssd1 vssd1 vccd1 vccd1 sky130_ef_sc_hd__decap_12
X_09047_ net1063 net1071 net780 net770 vssd1 vssd1 vccd1 vccd1 _03159_ sky130_fd_sc_hd__and4_1
XFILLER_0_44_195 vssd1 vssd1 vccd1 vccd1 sky130_fd_sc_hd__fill_1
XFILLER_0_5_782 vssd1 vssd1 vccd1 vccd1 sky130_fd_sc_hd__fill_2
XFILLER_0_102_234 vssd1 vssd1 vccd1 vccd1 sky130_fd_sc_hd__decap_3
XFILLER_0_20_519 vssd1 vssd1 vccd1 vccd1 sky130_fd_sc_hd__decap_3
XFILLER_0_102_267 vssd1 vssd1 vccd1 vccd1 sky130_fd_sc_hd__decap_3
Xhold450 add1.a_i\[23\] vssd1 vssd1 vccd1 vccd1 net1665 sky130_fd_sc_hd__dlygate4sd3_1
Xhold472 y1my2\[21\] vssd1 vssd1 vccd1 vccd1 net1687 sky130_fd_sc_hd__dlygate4sd3_1
Xhold461 sub1.a_i\[31\] vssd1 vssd1 vccd1 vccd1 net1676 sky130_fd_sc_hd__dlygate4sd3_1
XFILLER_0_130_598 vssd1 vssd1 vccd1 vccd1 sky130_fd_sc_hd__fill_2
Xhold483 mul1.b\[2\] vssd1 vssd1 vccd1 vccd1 net1698 sky130_fd_sc_hd__dlygate4sd3_1
Xhold494 net358 vssd1 vssd1 vccd1 vccd1 net1709 sky130_fd_sc_hd__dlygate4sd3_1
X_09949_ _03752_ _03894_ _03893_ vssd1 vssd1 vccd1 vccd1 _04056_ sky130_fd_sc_hd__a21oi_4
Xfanout952 mul1.a\[26\] vssd1 vssd1 vccd1 vccd1 net952 sky130_fd_sc_hd__clkbuf_2
Xfanout941 mul1.a\[28\] vssd1 vssd1 vccd1 vccd1 net941 sky130_fd_sc_hd__clkbuf_4
Xfanout930 net934 vssd1 vssd1 vccd1 vccd1 net930 sky130_fd_sc_hd__buf_2
Xfanout974 mul1.a\[22\] vssd1 vssd1 vccd1 vccd1 net974 sky130_fd_sc_hd__buf_2
Xfanout985 mul1.a\[21\] vssd1 vssd1 vccd1 vccd1 net985 sky130_fd_sc_hd__clkbuf_4
Xfanout963 net966 vssd1 vssd1 vccd1 vccd1 net963 sky130_fd_sc_hd__buf_2
XFILLER_0_99_335 vssd1 vssd1 vccd1 vccd1 sky130_fd_sc_hd__fill_1
XFILLER_0_99_313 vssd1 vssd1 vccd1 vccd1 sky130_fd_sc_hd__fill_1
Xfanout996 net997 vssd1 vssd1 vccd1 vccd1 net996 sky130_fd_sc_hd__clkbuf_4
X_12960_ clknet_leaf_45_clk_i _00346_ net1157 vssd1 vssd1 vccd1 vccd1 y1my2\[13\]
+ sky130_fd_sc_hd__dfrtp_1
XFILLER_0_99_357 vssd1 vssd1 vccd1 vccd1 sky130_fd_sc_hd__decap_6
XFILLER_0_87_508 vssd1 vssd1 vccd1 vccd1 sky130_fd_sc_hd__decap_8
X_11911_ net24 net549 net624 net208 _05937_ vssd1 vssd1 vccd1 vccd1 _05938_ sky130_fd_sc_hd__a221o_1
X_12891_ clknet_leaf_31_clk_i _00277_ vssd1 vssd1 vccd1 vccd1 mul1.a\[26\] sky130_fd_sc_hd__dfxtp_1
XTAP_1910 vssd1 vccd1 sky130_fd_sc_hd__tapvpwrvgnd_1
XFILLER_0_67_210 vssd1 vssd1 vccd1 vccd1 sky130_fd_sc_hd__decap_8
X_11842_ net654 _00923_ net475 _05880_ vssd1 vssd1 vccd1 vccd1 _05881_ sky130_fd_sc_hd__a211o_1
XTAP_1943 vssd1 vccd1 sky130_fd_sc_hd__tapvpwrvgnd_1
XTAP_1932 vssd1 vccd1 sky130_fd_sc_hd__tapvpwrvgnd_1
XTAP_1921 vssd1 vccd1 sky130_fd_sc_hd__tapvpwrvgnd_1
XTAP_1965 vssd1 vccd1 sky130_fd_sc_hd__tapvpwrvgnd_1
XTAP_1976 vssd1 vccd1 sky130_fd_sc_hd__tapvpwrvgnd_1
XTAP_1954 vssd1 vccd1 sky130_fd_sc_hd__tapvpwrvgnd_1
XFILLER_0_95_585 vssd1 vssd1 vccd1 vccd1 sky130_fd_sc_hd__fill_1
XFILLER_0_83_703 vssd1 vssd1 vccd1 vccd1 sky130_fd_sc_hd__fill_2
X_11773_ temp1\[12\] net614 net665 net93 _05821_ vssd1 vssd1 vccd1 vccd1 _05822_ sky130_fd_sc_hd__a221o_1
XFILLER_0_126_805 vssd1 vssd1 vccd1 vccd1 sky130_fd_sc_hd__decap_6
XTAP_1998 vssd1 vccd1 sky130_fd_sc_hd__tapvpwrvgnd_1
XTAP_1987 vssd1 vccd1 sky130_fd_sc_hd__tapvpwrvgnd_1
X_10724_ _04823_ _04824_ vssd1 vssd1 vccd1 vccd1 _04825_ sky130_fd_sc_hd__nand2_2
XFILLER_0_27_129 vssd1 vssd1 vccd1 vccd1 sky130_fd_sc_hd__decap_6
XFILLER_0_82_246 vssd1 vssd1 vccd1 vccd1 sky130_fd_sc_hd__decap_6
X_10655_ _04755_ _04756_ vssd1 vssd1 vccd1 vccd1 _04757_ sky130_fd_sc_hd__or2_1
XFILLER_0_24_803 vssd1 vssd1 vccd1 vccd1 sky130_fd_sc_hd__fill_1
XFILLER_0_91_780 vssd1 vssd1 vccd1 vccd1 sky130_fd_sc_hd__decap_4
XFILLER_0_63_471 vssd1 vssd1 vccd1 vccd1 sky130_fd_sc_hd__decap_3
XFILLER_0_106_584 vssd1 vssd1 vccd1 vccd1 sky130_fd_sc_hd__decap_4
X_10586_ net808 net959 _04685_ _04686_ vssd1 vssd1 vccd1 vccd1 _04688_ sky130_fd_sc_hd__a22o_1
XFILLER_0_50_132 vssd1 vssd1 vccd1 vccd1 sky130_fd_sc_hd__fill_1
X_12325_ net1611 _00872_ net666 vssd1 vssd1 vccd1 vccd1 _00377_ sky130_fd_sc_hd__mux2_1
XFILLER_0_50_176 vssd1 vssd1 vccd1 vccd1 sky130_fd_sc_hd__fill_1
X_12256_ _00970_ net512 net469 net1619 _06190_ vssd1 vssd1 vccd1 vccd1 _06191_ sky130_fd_sc_hd__a221o_1
XFILLER_0_76_27 vssd1 vssd1 vccd1 vccd1 sky130_fd_sc_hd__fill_1
X_11207_ _05177_ _05179_ _05302_ _05304_ vssd1 vssd1 vccd1 vccd1 _05305_ sky130_fd_sc_hd__o211a_2
X_12187_ _00846_ net509 net466 y1my2\[7\] _06144_ vssd1 vssd1 vccd1 vccd1 _06145_
+ sky130_fd_sc_hd__a221o_1
X_11138_ net757 net975 _05108_ _05107_ vssd1 vssd1 vccd1 vccd1 _05236_ sky130_fd_sc_hd__a31o_1
X_11069_ _05165_ _05166_ _04984_ _04986_ vssd1 vssd1 vccd1 vccd1 _05168_ sky130_fd_sc_hd__o211ai_1
XFILLER_0_116_77 vssd1 vssd1 vccd1 vccd1 sky130_fd_sc_hd__decap_6
XFILLER_0_58_221 vssd1 vssd1 vccd1 vccd1 sky130_fd_sc_hd__fill_1
XFILLER_0_128_120 vssd1 vssd1 vccd1 vccd1 sky130_fd_sc_hd__decap_8
X_07300_ _01281_ _01286_ _01285_ vssd1 vssd1 vccd1 vccd1 _01425_ sky130_fd_sc_hd__a21o_1
XFILLER_0_129_654 vssd1 vssd1 vccd1 vccd1 sky130_fd_sc_hd__fill_1
X_08280_ _02395_ _02396_ _02173_ vssd1 vssd1 vccd1 vccd1 _02398_ sky130_fd_sc_hd__a21o_1
X_07231_ _01354_ _01355_ _01338_ vssd1 vssd1 vccd1 vccd1 _01356_ sky130_fd_sc_hd__o21a_1
XFILLER_0_14_313 vssd1 vssd1 vccd1 vccd1 sky130_fd_sc_hd__decap_3
XFILLER_0_15_825 vssd1 vssd1 vccd1 vccd1 sky130_fd_sc_hd__fill_1
X_07162_ _01281_ _01285_ _01286_ vssd1 vssd1 vccd1 vccd1 _01287_ sky130_fd_sc_hd__nand3_1
XFILLER_0_27_696 vssd1 vssd1 vccd1 vccd1 sky130_fd_sc_hd__decap_6
X_07093_ _01216_ _01217_ _01202_ vssd1 vssd1 vccd1 vccd1 _01218_ sky130_fd_sc_hd__a21o_1
XFILLER_0_41_154 vssd1 vssd1 vccd1 vccd1 sky130_fd_sc_hd__fill_1
XFILLER_0_2_774 vssd1 vssd1 vccd1 vccd1 sky130_fd_sc_hd__fill_1
XFILLER_0_112_587 vssd1 vssd1 vccd1 vccd1 sky130_fd_sc_hd__fill_1
XFILLER_0_100_749 vssd1 vssd1 vccd1 vccd1 sky130_fd_sc_hd__fill_1
X_09803_ _03798_ _03831_ _03830_ vssd1 vssd1 vccd1 vccd1 _03910_ sky130_fd_sc_hd__a21bo_2
X_07995_ _02009_ _02011_ vssd1 vssd1 vccd1 vccd1 _02115_ sky130_fd_sc_hd__or2_1
XFILLER_0_66_60 vssd1 vssd1 vccd1 vccd1 sky130_fd_sc_hd__fill_2
X_09734_ net833 net977 _03840_ _03841_ vssd1 vssd1 vccd1 vccd1 _03842_ sky130_fd_sc_hd__nand4_4
XFILLER_0_66_93 vssd1 vssd1 vccd1 vccd1 sky130_fd_sc_hd__decap_3
X_06946_ net919 net1065 net1073 net911 vssd1 vssd1 vccd1 vccd1 _01071_ sky130_fd_sc_hd__a22o_1
X_09665_ _03619_ _03622_ vssd1 vssd1 vccd1 vccd1 _03773_ sky130_fd_sc_hd__nand2_2
X_06877_ _00598_ _00613_ vssd1 vssd1 vccd1 vccd1 _01006_ sky130_fd_sc_hd__nor2_2
XFILLER_0_96_305 vssd1 vssd1 vccd1 vccd1 sky130_fd_sc_hd__decap_3
X_08616_ _02612_ _02615_ _02729_ _02730_ vssd1 vssd1 vccd1 vccd1 _02731_ sky130_fd_sc_hd__a211o_1
XFILLER_0_82_70 vssd1 vssd1 vccd1 vccd1 sky130_fd_sc_hd__decap_8
X_09596_ net901 net892 net937 vssd1 vssd1 vccd1 vccd1 _03705_ sky130_fd_sc_hd__and3_1
XTAP_1239 vssd1 vccd1 sky130_fd_sc_hd__tapvpwrvgnd_1
XTAP_1228 vssd1 vccd1 sky130_fd_sc_hd__tapvpwrvgnd_1
XTAP_1217 vssd1 vccd1 sky130_fd_sc_hd__tapvpwrvgnd_1
XTAP_1206 vssd1 vccd1 sky130_fd_sc_hd__tapvpwrvgnd_1
X_08547_ _02658_ _02660_ _02560_ vssd1 vssd1 vccd1 vccd1 _02663_ sky130_fd_sc_hd__a21o_1
XFILLER_0_77_552 vssd1 vssd1 vccd1 vccd1 sky130_fd_sc_hd__decap_3
X_08478_ _02592_ _02593_ _02455_ _02459_ vssd1 vssd1 vccd1 vccd1 _02594_ sky130_fd_sc_hd__o211a_1
XFILLER_0_64_213 vssd1 vssd1 vccd1 vccd1 sky130_fd_sc_hd__decap_6
XFILLER_0_37_449 vssd1 vssd1 vccd1 vccd1 sky130_fd_sc_hd__decap_8
X_07429_ _01539_ _01553_ vssd1 vssd1 vccd1 vccd1 _01554_ sky130_fd_sc_hd__or2_1
X_10440_ _04540_ _04541_ _04542_ vssd1 vssd1 vccd1 vccd1 _04543_ sky130_fd_sc_hd__and3_1
XFILLER_0_52_419 vssd1 vssd1 vccd1 vccd1 sky130_fd_sc_hd__fill_1
XFILLER_0_17_151 vssd1 vssd1 vccd1 vccd1 sky130_ef_sc_hd__decap_12
XFILLER_0_122_307 vssd1 vssd1 vccd1 vccd1 sky130_fd_sc_hd__fill_1
X_10371_ net779 net999 net769 net1005 vssd1 vssd1 vccd1 vccd1 _04475_ sky130_fd_sc_hd__a22o_1
XFILLER_0_20_305 vssd1 vssd1 vccd1 vccd1 sky130_fd_sc_hd__decap_3
X_13090_ clknet_leaf_43_clk_i _00476_ vssd1 vssd1 vccd1 vccd1 temp1\[15\] sky130_fd_sc_hd__dfxtp_1
X_12110_ _00903_ _06088_ net501 vssd1 vssd1 vccd1 vccd1 _06089_ sky130_fd_sc_hd__mux2_1
Xhold280 l1\[13\] vssd1 vssd1 vccd1 vccd1 net1495 sky130_fd_sc_hd__dlygate4sd3_1
X_12041_ y2my0\[1\] net585 net531 x2mx1\[1\] _06036_ vssd1 vssd1 vccd1 vccd1 _06037_
+ sky130_fd_sc_hd__a221o_1
Xhold291 y2my0\[8\] vssd1 vssd1 vccd1 vccd1 net1506 sky130_fd_sc_hd__dlygate4sd3_1
Xfanout760 net761 vssd1 vssd1 vccd1 vccd1 net760 sky130_fd_sc_hd__buf_2
Xfanout793 net794 vssd1 vssd1 vccd1 vccd1 net793 sky130_fd_sc_hd__buf_2
Xfanout771 mul1.b\[19\] vssd1 vssd1 vccd1 vccd1 net771 sky130_fd_sc_hd__clkbuf_8
Xfanout782 net785 vssd1 vssd1 vccd1 vccd1 net782 sky130_fd_sc_hd__clkbuf_4
X_12943_ clknet_leaf_6_clk_i _00329_ net1192 vssd1 vssd1 vccd1 vccd1 posy\[5\] sky130_fd_sc_hd__dfrtp_1
X_12874_ clknet_leaf_44_clk_i _00260_ vssd1 vssd1 vccd1 vccd1 mul1.a\[9\] sky130_fd_sc_hd__dfxtp_2
XTAP_1751 vssd1 vccd1 sky130_fd_sc_hd__tapvpwrvgnd_1
XTAP_1740 vssd1 vccd1 sky130_fd_sc_hd__tapvpwrvgnd_1
X_11825_ net42 net687 net678 net70 vssd1 vssd1 vccd1 vccd1 _05866_ sky130_fd_sc_hd__a22o_1
XTAP_1773 vssd1 vccd1 sky130_fd_sc_hd__tapvpwrvgnd_1
XTAP_1784 vssd1 vccd1 sky130_fd_sc_hd__tapvpwrvgnd_1
XTAP_1762 vssd1 vccd1 sky130_fd_sc_hd__tapvpwrvgnd_1
X_11756_ net249 net598 net578 net153 _05807_ vssd1 vssd1 vccd1 vccd1 _05808_ sky130_fd_sc_hd__a221o_1
XFILLER_0_126_613 vssd1 vssd1 vccd1 vccd1 sky130_ef_sc_hd__decap_12
XTAP_1795 vssd1 vccd1 sky130_fd_sc_hd__tapvpwrvgnd_1
X_10707_ _04660_ _04662_ _04806_ _04807_ vssd1 vssd1 vccd1 vccd1 _04809_ sky130_fd_sc_hd__o211a_1
XFILLER_0_126_657 vssd1 vssd1 vccd1 vccd1 sky130_ef_sc_hd__decap_12
X_11687_ net1708 _04952_ net539 vssd1 vssd1 vccd1 vccd1 _00179_ sky130_fd_sc_hd__mux2_1
XFILLER_0_113_329 vssd1 vssd1 vccd1 vccd1 sky130_fd_sc_hd__decap_6
XFILLER_0_70_249 vssd1 vssd1 vccd1 vccd1 sky130_fd_sc_hd__decap_3
X_10638_ _04725_ _04737_ _04738_ vssd1 vssd1 vccd1 vccd1 _04740_ sky130_fd_sc_hd__and3_1
XFILLER_0_3_505 vssd1 vssd1 vccd1 vccd1 sky130_fd_sc_hd__fill_1
XFILLER_0_11_55 vssd1 vssd1 vccd1 vccd1 sky130_fd_sc_hd__fill_1
XFILLER_0_23_132 vssd1 vssd1 vccd1 vccd1 sky130_fd_sc_hd__decap_6
XFILLER_0_87_15 vssd1 vssd1 vccd1 vccd1 sky130_ef_sc_hd__decap_12
X_10569_ temp1\[22\] _04671_ net542 vssd1 vssd1 vccd1 vccd1 _04672_ sky130_fd_sc_hd__mux2_1
XFILLER_0_23_143 vssd1 vssd1 vccd1 vccd1 sky130_fd_sc_hd__decap_6
X_12308_ net1637 _00951_ net680 vssd1 vssd1 vccd1 vccd1 _00360_ sky130_fd_sc_hd__mux2_1
XFILLER_0_121_373 vssd1 vssd1 vccd1 vccd1 sky130_ef_sc_hd__decap_12
X_12239_ net730 _06179_ net517 vssd1 vssd1 vccd1 vccd1 _00307_ sky130_fd_sc_hd__mux2_1
X_06800_ net418 net1236 net643 vssd1 vssd1 vccd1 vccd1 _00074_ sky130_fd_sc_hd__mux2_1
X_07780_ net1058 net856 _01900_ _01901_ vssd1 vssd1 vccd1 vccd1 _01902_ sky130_fd_sc_hd__o2bb2a_1
Xinput4 div_sstream_i[11] vssd1 vssd1 vccd1 vccd1 net4 sky130_fd_sc_hd__clkbuf_8
X_06731_ _00947_ _00948_ vssd1 vssd1 vccd1 vccd1 _00949_ sky130_fd_sc_hd__nand2b_2
X_09450_ _03394_ _03397_ _03558_ _03559_ vssd1 vssd1 vccd1 vccd1 _03560_ sky130_fd_sc_hd__a211o_2
X_08401_ _02376_ _02380_ _02515_ _02516_ vssd1 vssd1 vccd1 vccd1 _02518_ sky130_fd_sc_hd__a211oi_4
X_06662_ _00889_ _00890_ vssd1 vssd1 vccd1 vccd1 _00891_ sky130_fd_sc_hd__nor2_2
X_09381_ _03485_ _03489_ _03490_ vssd1 vssd1 vccd1 vccd1 _03491_ sky130_fd_sc_hd__nand3_1
XFILLER_0_52_51 vssd1 vssd1 vccd1 vccd1 sky130_fd_sc_hd__fill_2
X_06593_ _00831_ _00832_ vssd1 vssd1 vccd1 vccd1 _00833_ sky130_fd_sc_hd__xnor2_1
X_08332_ _02445_ _02446_ _02447_ vssd1 vssd1 vccd1 vccd1 _02449_ sky130_fd_sc_hd__a21bo_1
XFILLER_0_74_511 vssd1 vssd1 vccd1 vccd1 sky130_fd_sc_hd__fill_2
XFILLER_0_59_596 vssd1 vssd1 vccd1 vccd1 sky130_fd_sc_hd__decap_8
X_08263_ _02256_ _02260_ _02378_ _02379_ vssd1 vssd1 vccd1 vccd1 _02381_ sky130_fd_sc_hd__a211oi_4
XFILLER_0_46_246 vssd1 vssd1 vccd1 vccd1 sky130_fd_sc_hd__decap_6
X_07214_ _01220_ _01226_ _01225_ vssd1 vssd1 vccd1 vccd1 _01339_ sky130_fd_sc_hd__a21o_1
X_08194_ net1084 net796 net786 net1091 vssd1 vssd1 vccd1 vccd1 _02312_ sky130_fd_sc_hd__a22o_1
XFILLER_0_14_121 vssd1 vssd1 vccd1 vccd1 sky130_ef_sc_hd__decap_12
XFILLER_0_116_189 vssd1 vssd1 vccd1 vccd1 sky130_fd_sc_hd__decap_6
XFILLER_0_113_841 vssd1 vssd1 vccd1 vccd1 sky130_fd_sc_hd__fill_1
X_07145_ _01266_ _01267_ _01198_ _01201_ vssd1 vssd1 vccd1 vccd1 _01270_ sky130_fd_sc_hd__o211a_1
X_07076_ _01197_ _01199_ _01200_ vssd1 vssd1 vccd1 vccd1 _01201_ sky130_fd_sc_hd__or3_2
Xoutput330 net330 vssd1 vssd1 vccd1 vccd1 div_mstream_o[95] sky130_fd_sc_hd__clkbuf_4
Xoutput341 net341 vssd1 vssd1 vccd1 vccd1 mstream_o[105] sky130_fd_sc_hd__clkbuf_4
Xoutput352 net352 vssd1 vssd1 vccd1 vccd1 mstream_o[11] sky130_fd_sc_hd__buf_2
XFILLER_0_77_81 vssd1 vssd1 vccd1 vccd1 sky130_ef_sc_hd__decap_12
Xoutput363 net363 vssd1 vssd1 vccd1 vccd1 mstream_o[21] sky130_fd_sc_hd__clkbuf_4
Xoutput374 net374 vssd1 vssd1 vccd1 vccd1 mstream_o[31] sky130_fd_sc_hd__clkbuf_4
Xoutput396 net396 vssd1 vssd1 vccd1 vccd1 mstream_o[51] sky130_fd_sc_hd__clkbuf_4
Xoutput385 net385 vssd1 vssd1 vccd1 vccd1 mstream_o[41] sky130_fd_sc_hd__clkbuf_4
X_07978_ net821 _02097_ _02096_ vssd1 vssd1 vccd1 vccd1 _02098_ sky130_fd_sc_hd__a21bo_1
X_09717_ _03651_ _03659_ _03658_ vssd1 vssd1 vccd1 vccd1 _03825_ sky130_fd_sc_hd__a21bo_1
X_06929_ net829 net1135 _01043_ _01044_ vssd1 vssd1 vccd1 vccd1 _01054_ sky130_fd_sc_hd__a22oi_1
X_09648_ net1100 net1108 net711 vssd1 vssd1 vccd1 vccd1 _03756_ sky130_fd_sc_hd__and3_1
XFILLER_0_96_124 vssd1 vssd1 vccd1 vccd1 sky130_fd_sc_hd__decap_3
XTAP_1003 vssd1 vccd1 sky130_fd_sc_hd__tapvpwrvgnd_1
X_09579_ _03678_ _03685_ _03686_ vssd1 vssd1 vccd1 vccd1 _03688_ sky130_fd_sc_hd__nand3_2
XTAP_1047 vssd1 vccd1 sky130_fd_sc_hd__tapvpwrvgnd_1
XTAP_1036 vssd1 vccd1 sky130_fd_sc_hd__tapvpwrvgnd_1
XTAP_1025 vssd1 vccd1 sky130_fd_sc_hd__tapvpwrvgnd_1
XTAP_1014 vssd1 vccd1 sky130_fd_sc_hd__tapvpwrvgnd_1
XFILLER_0_77_393 vssd1 vssd1 vccd1 vccd1 sky130_fd_sc_hd__decap_4
XTAP_1069 vssd1 vccd1 sky130_fd_sc_hd__tapvpwrvgnd_1
XTAP_1058 vssd1 vccd1 sky130_fd_sc_hd__tapvpwrvgnd_1
X_12590_ net1591 net33 net554 vssd1 vssd1 vccd1 vccd1 _00565_ sky130_fd_sc_hd__mux2_1
X_11610_ _05698_ _05703_ vssd1 vssd1 vccd1 vccd1 _05704_ sky130_fd_sc_hd__xnor2_1
XFILLER_0_108_613 vssd1 vssd1 vccd1 vccd1 sky130_ef_sc_hd__decap_12
X_11541_ net990 net717 vssd1 vssd1 vccd1 vccd1 _05636_ sky130_fd_sc_hd__nand2_1
XFILLER_0_108_657 vssd1 vssd1 vccd1 vccd1 sky130_ef_sc_hd__decap_12
XFILLER_0_107_167 vssd1 vssd1 vccd1 vccd1 sky130_fd_sc_hd__fill_1
XFILLER_0_92_396 vssd1 vssd1 vccd1 vccd1 sky130_fd_sc_hd__fill_1
XFILLER_0_52_249 vssd1 vssd1 vccd1 vccd1 sky130_fd_sc_hd__decap_3
X_11472_ _05457_ _05566_ vssd1 vssd1 vccd1 vccd1 _05567_ sky130_fd_sc_hd__xnor2_1
X_10423_ temp1\[21\] _04526_ net542 vssd1 vssd1 vccd1 vccd1 _04527_ sky130_fd_sc_hd__mux2_1
X_13142_ clknet_leaf_16_clk_i _00528_ net1184 vssd1 vssd1 vccd1 vccd1 l0\[3\] sky130_fd_sc_hd__dfrtp_1
X_10354_ _04455_ _04456_ _04340_ _04342_ vssd1 vssd1 vccd1 vccd1 _04458_ sky130_fd_sc_hd__o211ai_2
XFILLER_0_33_485 vssd1 vssd1 vccd1 vccd1 sky130_fd_sc_hd__decap_4
XFILLER_0_21_669 vssd1 vssd1 vccd1 vccd1 sky130_fd_sc_hd__decap_3
X_10285_ _04387_ _04388_ vssd1 vssd1 vccd1 vccd1 _04389_ sky130_fd_sc_hd__nand2_2
X_13073_ clknet_leaf_32_clk_i _00459_ net1173 vssd1 vssd1 vccd1 vccd1 y2my0\[30\]
+ sky130_fd_sc_hd__dfrtp_1
XTAP_809 vssd1 vccd1 sky130_fd_sc_hd__tapvpwrvgnd_1
X_12024_ net145 net662 net505 net241 _06022_ vssd1 vssd1 vccd1 vccd1 _06023_ sky130_fd_sc_hd__a221o_1
Xfanout590 net591 vssd1 vssd1 vccd1 vccd1 net590 sky130_fd_sc_hd__clkbuf_4
XFILLER_0_87_146 vssd1 vssd1 vccd1 vccd1 sky130_fd_sc_hd__fill_1
XFILLER_0_76_809 vssd1 vssd1 vccd1 vccd1 sky130_fd_sc_hd__decap_3
X_12926_ clknet_leaf_25_clk_i _00312_ vssd1 vssd1 vccd1 vccd1 mul1.b\[29\] sky130_fd_sc_hd__dfxtp_1
XFILLER_0_87_157 vssd1 vssd1 vccd1 vccd1 sky130_fd_sc_hd__decap_6
XFILLER_0_75_308 vssd1 vssd1 vccd1 vccd1 sky130_fd_sc_hd__fill_1
X_12857_ clknet_leaf_34_clk_i _00243_ vssd1 vssd1 vccd1 vccd1 sub1.b_i\[24\] sky130_fd_sc_hd__dfxtp_1
X_11808_ net162 net472 _05851_ vssd1 vssd1 vccd1 vccd1 _05852_ sky130_fd_sc_hd__o21a_1
XTAP_1592 vssd1 vccd1 sky130_fd_sc_hd__tapvpwrvgnd_1
XTAP_1581 vssd1 vccd1 sky130_fd_sc_hd__tapvpwrvgnd_1
XTAP_1570 vssd1 vccd1 sky130_fd_sc_hd__tapvpwrvgnd_1
X_12788_ clknet_leaf_40_clk_i _00174_ vssd1 vssd1 vccd1 vccd1 add1.b_i\[19\] sky130_fd_sc_hd__dfxtp_1
XFILLER_0_43_216 vssd1 vssd1 vccd1 vccd1 sky130_fd_sc_hd__decap_8
X_11739_ net246 net598 net578 net150 _05793_ vssd1 vssd1 vccd1 vccd1 _05794_ sky130_fd_sc_hd__a221o_1
XFILLER_0_16_419 vssd1 vssd1 vccd1 vccd1 sky130_fd_sc_hd__fill_1
XFILLER_0_22_65 vssd1 vssd1 vccd1 vccd1 sky130_fd_sc_hd__decap_4
XFILLER_0_43_238 vssd1 vssd1 vccd1 vccd1 sky130_fd_sc_hd__decap_3
XFILLER_0_4_825 vssd1 vssd1 vccd1 vccd1 sky130_fd_sc_hd__fill_2
XFILLER_0_113_137 vssd1 vssd1 vccd1 vccd1 sky130_ef_sc_hd__decap_12
XFILLER_0_11_113 vssd1 vssd1 vccd1 vccd1 sky130_ef_sc_hd__decap_12
XFILLER_0_122_693 vssd1 vssd1 vccd1 vccd1 sky130_fd_sc_hd__decap_6
XFILLER_0_121_181 vssd1 vssd1 vccd1 vccd1 sky130_ef_sc_hd__decap_12
X_08950_ net894 net961 net955 net903 vssd1 vssd1 vccd1 vccd1 _03063_ sky130_fd_sc_hd__a22o_1
X_08881_ net1092 net1099 net749 net741 vssd1 vssd1 vccd1 vccd1 _02994_ sky130_fd_sc_hd__and4_1
X_07901_ net906 net1001 vssd1 vssd1 vccd1 vccd1 _02022_ sky130_fd_sc_hd__and2_1
X_07832_ net1604 _01953_ net522 vssd1 vssd1 vccd1 vccd1 _00126_ sky130_fd_sc_hd__mux2_1
X_09502_ _03473_ _03481_ _03480_ vssd1 vssd1 vccd1 vccd1 _03611_ sky130_fd_sc_hd__a21o_1
X_07763_ net1066 net848 net839 net1074 vssd1 vssd1 vccd1 vccd1 _01885_ sky130_fd_sc_hd__a22o_1
XFILLER_0_79_647 vssd1 vssd1 vccd1 vccd1 sky130_fd_sc_hd__decap_3
X_07694_ net1026 net1032 net899 net890 vssd1 vssd1 vccd1 vccd1 _01817_ sky130_fd_sc_hd__and4_1
X_06714_ _00933_ _00934_ vssd1 vssd1 vccd1 vccd1 _00935_ sky130_fd_sc_hd__nor2_4
X_09433_ net915 net931 _03540_ _03542_ vssd1 vssd1 vccd1 vccd1 _03543_ sky130_fd_sc_hd__a22o_1
X_06645_ _00873_ _00876_ vssd1 vssd1 vccd1 vccd1 _00877_ sky130_fd_sc_hd__xor2_4
X_09364_ net1039 net784 net777 net1047 vssd1 vssd1 vccd1 vccd1 _03474_ sky130_fd_sc_hd__a22o_1
XPHY_119 vssd1 vssd1 vccd1 vccd1 sky130_fd_sc_hd__decap_3
XPHY_108 vssd1 vssd1 vccd1 vccd1 sky130_fd_sc_hd__decap_3
X_08315_ _02430_ _02431_ vssd1 vssd1 vccd1 vccd1 _02432_ sky130_fd_sc_hd__xor2_1
XFILLER_0_59_393 vssd1 vssd1 vccd1 vccd1 sky130_fd_sc_hd__fill_2
X_06576_ net1733 _00818_ net633 vssd1 vssd1 vccd1 vccd1 _00005_ sky130_fd_sc_hd__mux2_1
XFILLER_0_129_281 vssd1 vssd1 vccd1 vccd1 sky130_fd_sc_hd__fill_1
X_09295_ _03303_ _03304_ _03403_ _03404_ vssd1 vssd1 vccd1 vccd1 _03406_ sky130_fd_sc_hd__or4_1
XFILLER_0_62_514 vssd1 vssd1 vccd1 vccd1 sky130_fd_sc_hd__fill_1
XFILLER_0_62_503 vssd1 vssd1 vccd1 vccd1 sky130_fd_sc_hd__decap_6
XANTENNA_20 v1x[7] vssd1 vssd1 vccd1 vccd1 sky130_fd_sc_hd__diode_2
XANTENNA_31 net19 vssd1 vssd1 vccd1 vccd1 sky130_fd_sc_hd__diode_2
XANTENNA_42 net57 vssd1 vssd1 vccd1 vccd1 sky130_fd_sc_hd__diode_2
X_08246_ _02360_ _02363_ vssd1 vssd1 vccd1 vccd1 _02364_ sky130_fd_sc_hd__xor2_2
XANTENNA_53 v0y[28] vssd1 vssd1 vccd1 vccd1 sky130_fd_sc_hd__diode_2
XANTENNA_64 net619 vssd1 vssd1 vccd1 vccd1 sky130_fd_sc_hd__diode_2
X_08177_ net1131 net1139 net748 net740 vssd1 vssd1 vccd1 vccd1 _02295_ sky130_fd_sc_hd__and4_1
XFILLER_0_6_195 vssd1 vssd1 vccd1 vccd1 sky130_fd_sc_hd__fill_1
X_07128_ _01232_ _01233_ _01251_ _01252_ vssd1 vssd1 vccd1 vccd1 _01253_ sky130_fd_sc_hd__and4bb_1
XFILLER_0_113_671 vssd1 vssd1 vccd1 vccd1 sky130_fd_sc_hd__fill_1
XFILLER_0_30_455 vssd1 vssd1 vccd1 vccd1 sky130_fd_sc_hd__fill_1
X_07059_ net820 net1127 net1135 net813 vssd1 vssd1 vccd1 vccd1 _01184_ sky130_fd_sc_hd__a22o_1
X_10070_ net883 net931 _04174_ _04175_ vssd1 vssd1 vccd1 vccd1 _04176_ sky130_fd_sc_hd__nand4_2
Xmax_cap11 net1753 vssd1 vssd1 vccd1 vccd1 net1752 sky130_fd_sc_hd__clkbuf_1
X_10972_ _05069_ _05070_ _04940_ _04942_ vssd1 vssd1 vccd1 vccd1 _05072_ sky130_fd_sc_hd__o211a_1
X_12711_ clknet_leaf_9_clk_i _00097_ net1191 vssd1 vssd1 vccd1 vccd1 net443 sky130_fd_sc_hd__dfrtp_1
XFILLER_0_85_617 vssd1 vssd1 vccd1 vccd1 sky130_fd_sc_hd__decap_4
XFILLER_0_57_319 vssd1 vssd1 vccd1 vccd1 sky130_fd_sc_hd__decap_4
X_12642_ clknet_leaf_27_clk_i _00028_ net1170 vssd1 vssd1 vccd1 vccd1 net367 sky130_fd_sc_hd__dfrtp_1
XFILLER_0_38_511 vssd1 vssd1 vccd1 vccd1 sky130_fd_sc_hd__decap_3
XFILLER_0_38_522 vssd1 vssd1 vccd1 vccd1 sky130_fd_sc_hd__decap_3
XFILLER_0_65_330 vssd1 vssd1 vccd1 vccd1 sky130_fd_sc_hd__decap_6
XFILLER_0_38_544 vssd1 vssd1 vccd1 vccd1 sky130_fd_sc_hd__fill_2
X_12573_ net1380 net18 net560 vssd1 vssd1 vccd1 vccd1 _00549_ sky130_fd_sc_hd__mux2_1
XFILLER_0_53_558 vssd1 vssd1 vccd1 vccd1 sky130_fd_sc_hd__fill_2
X_11524_ _05617_ _05616_ vssd1 vssd1 vccd1 vccd1 _05619_ sky130_fd_sc_hd__and2b_1
X_11455_ _05548_ _05549_ _05384_ _05432_ vssd1 vssd1 vccd1 vccd1 _05551_ sky130_fd_sc_hd__a211oi_2
XFILLER_0_40_208 vssd1 vssd1 vccd1 vccd1 sky130_fd_sc_hd__fill_2
X_10406_ _04426_ _04427_ _04508_ _04509_ vssd1 vssd1 vccd1 vccd1 _04510_ sky130_fd_sc_hd__nor4_1
XFILLER_0_1_828 vssd1 vssd1 vccd1 vccd1 sky130_fd_sc_hd__fill_2
X_11386_ net807 net930 _05330_ _05329_ vssd1 vssd1 vccd1 vccd1 _05482_ sky130_fd_sc_hd__a31o_1
X_13125_ clknet_leaf_4_clk_i _00511_ vssd1 vssd1 vccd1 vccd1 det_t\[18\] sky130_fd_sc_hd__dfxtp_1
XFILLER_0_104_693 vssd1 vssd1 vccd1 vccd1 sky130_fd_sc_hd__decap_6
X_10337_ _04429_ _04439_ _04440_ vssd1 vssd1 vccd1 vccd1 _04441_ sky130_fd_sc_hd__nand3_1
XTAP_606 vssd1 vccd1 sky130_fd_sc_hd__tapvpwrvgnd_1
X_10268_ _04068_ _04216_ _04215_ vssd1 vssd1 vccd1 vccd1 _04373_ sky130_fd_sc_hd__a21oi_4
XTAP_617 vssd1 vccd1 sky130_fd_sc_hd__tapvpwrvgnd_1
XTAP_628 vssd1 vccd1 sky130_fd_sc_hd__tapvpwrvgnd_1
XTAP_639 vssd1 vccd1 sky130_fd_sc_hd__tapvpwrvgnd_1
X_13056_ clknet_leaf_42_clk_i _00442_ net1181 vssd1 vssd1 vccd1 vccd1 y2my0\[13\]
+ sky130_fd_sc_hd__dfrtp_1
XFILLER_0_84_27 vssd1 vssd1 vccd1 vccd1 sky130_fd_sc_hd__fill_1
X_12007_ net20 net552 net626 net204 _06009_ vssd1 vssd1 vccd1 vccd1 _06010_ sky130_fd_sc_hd__a221o_1
X_10199_ _04286_ _04299_ _04301_ vssd1 vssd1 vccd1 vccd1 _04304_ sky130_fd_sc_hd__nand3_2
XFILLER_0_88_477 vssd1 vssd1 vccd1 vccd1 sky130_fd_sc_hd__decap_4
X_12909_ clknet_leaf_45_clk_i _00295_ vssd1 vssd1 vccd1 vccd1 mul1.b\[12\] sky130_fd_sc_hd__dfxtp_4
X_06430_ _00731_ _00732_ vssd1 vssd1 vccd1 vccd1 _00733_ sky130_fd_sc_hd__or2_4
XFILLER_0_124_77 vssd1 vssd1 vccd1 vccd1 sky130_fd_sc_hd__decap_6
XTAP_2090 vssd1 vccd1 sky130_fd_sc_hd__tapvpwrvgnd_1
XFILLER_0_8_427 vssd1 vssd1 vccd1 vccd1 sky130_fd_sc_hd__fill_2
XFILLER_0_127_741 vssd1 vssd1 vccd1 vccd1 sky130_ef_sc_hd__decap_12
XFILLER_0_84_683 vssd1 vssd1 vccd1 vccd1 sky130_ef_sc_hd__decap_12
X_06361_ _00624_ _00672_ vssd1 vssd1 vccd1 vccd1 _00673_ sky130_fd_sc_hd__nand2_2
XFILLER_0_127_785 vssd1 vssd1 vccd1 vccd1 sky130_ef_sc_hd__decap_12
X_09080_ net1009 _03191_ _03190_ vssd1 vssd1 vccd1 vccd1 _03192_ sky130_fd_sc_hd__a21bo_1
X_08100_ _02101_ _02103_ vssd1 vssd1 vccd1 vccd1 _02219_ sky130_fd_sc_hd__or2_1
X_06292_ state\[2\] state\[3\] vssd1 vssd1 vccd1 vccd1 _00606_ sky130_fd_sc_hd__nand2_1
XFILLER_0_114_413 vssd1 vssd1 vccd1 vccd1 sky130_fd_sc_hd__decap_6
Xinput40 sstream_i[11] vssd1 vssd1 vccd1 vccd1 net40 sky130_fd_sc_hd__buf_4
X_08031_ _02112_ _02114_ _02147_ _02148_ vssd1 vssd1 vccd1 vccd1 _02151_ sky130_fd_sc_hd__o22ai_2
XFILLER_0_114_457 vssd1 vssd1 vccd1 vccd1 sky130_ef_sc_hd__decap_12
Xmax_cap521 _03206_ vssd1 vssd1 vccd1 vccd1 net521 sky130_fd_sc_hd__buf_1
XFILLER_0_52_580 vssd1 vssd1 vccd1 vccd1 sky130_fd_sc_hd__fill_1
Xinput62 v0x[13] vssd1 vssd1 vccd1 vccd1 net62 sky130_fd_sc_hd__buf_1
Xinput73 v0x[23] vssd1 vssd1 vccd1 vccd1 net73 sky130_fd_sc_hd__buf_1
Xinput51 sstream_i[3] vssd1 vssd1 vccd1 vccd1 net51 sky130_fd_sc_hd__buf_4
XFILLER_0_24_260 vssd1 vssd1 vccd1 vccd1 sky130_fd_sc_hd__fill_1
XFILLER_0_25_783 vssd1 vssd1 vccd1 vccd1 sky130_fd_sc_hd__fill_1
Xinput95 v0y[14] vssd1 vssd1 vccd1 vccd1 net95 sky130_fd_sc_hd__buf_1
Xinput84 v0x[4] vssd1 vssd1 vccd1 vccd1 net84 sky130_fd_sc_hd__buf_1
X_09982_ _04087_ vssd1 vssd1 vccd1 vccd1 _04088_ sky130_fd_sc_hd__inv_2
X_08933_ _02914_ _02916_ _03045_ vssd1 vssd1 vccd1 vccd1 _03046_ sky130_fd_sc_hd__o21a_1
XFILLER_0_58_72 vssd1 vssd1 vccd1 vccd1 sky130_fd_sc_hd__fill_1
XFILLER_0_42_3 vssd1 vssd1 vccd1 vccd1 sky130_fd_sc_hd__decap_4
X_08864_ _02968_ _02976_ vssd1 vssd1 vccd1 vccd1 _02977_ sky130_fd_sc_hd__nand2_1
X_08795_ net869 net987 net980 net877 vssd1 vssd1 vccd1 vccd1 _02909_ sky130_fd_sc_hd__a22oi_1
X_07815_ _01932_ _01934_ _01836_ net1755 vssd1 vssd1 vccd1 vccd1 _01937_ sky130_fd_sc_hd__a211o_1
X_07746_ _01859_ _01867_ vssd1 vssd1 vccd1 vccd1 _01868_ sky130_fd_sc_hd__xnor2_1
XFILLER_0_67_617 vssd1 vssd1 vccd1 vccd1 sky130_fd_sc_hd__fill_2
X_09416_ _03364_ _03365_ vssd1 vssd1 vccd1 vccd1 _03526_ sky130_fd_sc_hd__nand2_1
X_07677_ _01790_ _01798_ vssd1 vssd1 vccd1 vccd1 _01800_ sky130_fd_sc_hd__xnor2_1
XFILLER_0_59_190 vssd1 vssd1 vccd1 vccd1 sky130_fd_sc_hd__fill_1
X_06628_ net1725 _00862_ net633 vssd1 vssd1 vccd1 vccd1 _00013_ sky130_fd_sc_hd__mux2_1
X_09347_ _03454_ _03455_ _03444_ vssd1 vssd1 vccd1 vccd1 _03457_ sky130_fd_sc_hd__a21boi_2
X_06559_ net685 vssd1 vssd1 vccd1 vccd1 _00806_ sky130_fd_sc_hd__inv_2
XFILLER_0_118_774 vssd1 vssd1 vccd1 vccd1 sky130_ef_sc_hd__decap_12
XFILLER_0_90_642 vssd1 vssd1 vccd1 vccd1 sky130_fd_sc_hd__fill_2
X_09278_ _03386_ _03387_ _03388_ vssd1 vssd1 vccd1 vccd1 _03389_ sky130_fd_sc_hd__nand3_4
XFILLER_0_35_547 vssd1 vssd1 vccd1 vccd1 sky130_ef_sc_hd__decap_12
XFILLER_0_117_273 vssd1 vssd1 vccd1 vccd1 sky130_fd_sc_hd__decap_6
X_08229_ _02344_ _02345_ _02330_ vssd1 vssd1 vccd1 vccd1 _02347_ sky130_fd_sc_hd__a21o_1
XFILLER_0_23_709 vssd1 vssd1 vccd1 vccd1 sky130_fd_sc_hd__fill_1
XFILLER_0_105_446 vssd1 vssd1 vccd1 vccd1 sky130_fd_sc_hd__fill_2
XFILLER_0_62_388 vssd1 vssd1 vccd1 vccd1 sky130_ef_sc_hd__decap_12
X_11240_ _05328_ _05336_ vssd1 vssd1 vccd1 vccd1 _05337_ sky130_fd_sc_hd__nor2_1
X_11171_ net1019 net713 net708 net1027 vssd1 vssd1 vccd1 vccd1 _05269_ sky130_fd_sc_hd__a22o_1
X_10122_ _04116_ _04151_ _04150_ vssd1 vssd1 vccd1 vccd1 _04227_ sky130_fd_sc_hd__a21bo_2
XFILLER_0_101_685 vssd1 vssd1 vccd1 vccd1 sky130_ef_sc_hd__decap_12
XFILLER_0_100_195 vssd1 vssd1 vccd1 vccd1 sky130_fd_sc_hd__fill_1
X_10053_ net811 net984 vssd1 vssd1 vccd1 vccd1 _04159_ sky130_fd_sc_hd__nand2_1
X_10955_ _05052_ _05053_ _04920_ _04923_ vssd1 vssd1 vccd1 vccd1 _05055_ sky130_fd_sc_hd__o211a_1
X_10886_ net1003 net735 _04984_ _04985_ vssd1 vssd1 vccd1 vccd1 _04986_ sky130_fd_sc_hd__nand4_2
XFILLER_0_109_741 vssd1 vssd1 vccd1 vccd1 sky130_ef_sc_hd__decap_12
XFILLER_0_66_661 vssd1 vssd1 vccd1 vccd1 sky130_fd_sc_hd__fill_1
XFILLER_0_54_801 vssd1 vssd1 vccd1 vccd1 sky130_fd_sc_hd__fill_2
X_12625_ clknet_leaf_48_clk_i _00011_ net1159 vssd1 vssd1 vccd1 vccd1 net438 sky130_fd_sc_hd__dfrtp_2
XFILLER_0_38_363 vssd1 vssd1 vccd1 vccd1 sky130_fd_sc_hd__fill_1
XFILLER_0_108_251 vssd1 vssd1 vccd1 vccd1 sky130_fd_sc_hd__fill_1
X_12556_ net1236 net32 net558 vssd1 vssd1 vccd1 vccd1 _00532_ sky130_fd_sc_hd__mux2_1
XFILLER_0_26_547 vssd1 vssd1 vccd1 vccd1 sky130_fd_sc_hd__decap_8
X_11507_ _05456_ _05459_ _05600_ vssd1 vssd1 vccd1 vccd1 _05602_ sky130_fd_sc_hd__and3_1
X_12487_ net1257 net568 _06240_ vssd1 vssd1 vccd1 vccd1 _00494_ sky130_fd_sc_hd__o21a_1
XFILLER_0_124_755 vssd1 vssd1 vccd1 vccd1 sky130_fd_sc_hd__fill_1
XFILLER_0_123_243 vssd1 vssd1 vccd1 vccd1 sky130_fd_sc_hd__fill_1
XFILLER_0_53_388 vssd1 vssd1 vccd1 vccd1 sky130_fd_sc_hd__decap_4
XFILLER_0_41_517 vssd1 vssd1 vccd1 vccd1 sky130_fd_sc_hd__decap_6
XFILLER_0_111_405 vssd1 vssd1 vccd1 vccd1 sky130_ef_sc_hd__decap_12
Xhold109 posy\[5\] vssd1 vssd1 vccd1 vccd1 net1324 sky130_fd_sc_hd__dlygate4sd3_1
X_11438_ _05524_ _05533_ vssd1 vssd1 vccd1 vccd1 _05534_ sky130_fd_sc_hd__xnor2_1
XFILLER_0_111_449 vssd1 vssd1 vccd1 vccd1 sky130_ef_sc_hd__decap_12
XFILLER_0_0_113 vssd1 vssd1 vccd1 vccd1 sky130_fd_sc_hd__fill_1
XFILLER_0_1_658 vssd1 vssd1 vccd1 vccd1 sky130_fd_sc_hd__fill_2
X_11369_ net751 net747 net969 net963 vssd1 vssd1 vccd1 vccd1 _05465_ sky130_fd_sc_hd__and4_1
XFILLER_0_22_786 vssd1 vssd1 vccd1 vccd1 sky130_fd_sc_hd__fill_1
X_13108_ clknet_leaf_2_clk_i _00494_ vssd1 vssd1 vccd1 vccd1 det_t\[1\] sky130_fd_sc_hd__dfxtp_1
XFILLER_0_95_15 vssd1 vssd1 vccd1 vccd1 sky130_ef_sc_hd__decap_12
XTAP_414 vssd1 vccd1 sky130_fd_sc_hd__tapvpwrvgnd_1
XTAP_403 vssd1 vccd1 sky130_fd_sc_hd__tapvpwrvgnd_1
XFILLER_0_0_179 vssd1 vssd1 vccd1 vccd1 sky130_fd_sc_hd__fill_1
XTAP_425 vssd1 vccd1 sky130_fd_sc_hd__tapvpwrvgnd_1
XTAP_436 vssd1 vccd1 sky130_fd_sc_hd__tapvpwrvgnd_1
XTAP_447 vssd1 vccd1 sky130_fd_sc_hd__tapvpwrvgnd_1
XTAP_458 vssd1 vccd1 sky130_fd_sc_hd__tapvpwrvgnd_1
XFILLER_0_119_55 vssd1 vssd1 vccd1 vccd1 sky130_fd_sc_hd__fill_1
XTAP_469 vssd1 vccd1 sky130_fd_sc_hd__tapvpwrvgnd_1
X_13039_ clknet_leaf_25_clk_i _00425_ net1172 vssd1 vssd1 vccd1 vccd1 x0mx2\[28\]
+ sky130_fd_sc_hd__dfrtp_1
Xfanout1182 net1185 vssd1 vssd1 vccd1 vccd1 net1182 sky130_fd_sc_hd__clkbuf_4
Xfanout1160 net1163 vssd1 vssd1 vccd1 vccd1 net1160 sky130_fd_sc_hd__clkbuf_4
Xfanout1171 net1173 vssd1 vssd1 vccd1 vccd1 net1171 sky130_fd_sc_hd__clkbuf_4
XFILLER_0_28_97 vssd1 vssd1 vccd1 vccd1 sky130_ef_sc_hd__decap_12
Xfanout1193 net1194 vssd1 vssd1 vccd1 vccd1 net1193 sky130_fd_sc_hd__clkbuf_4
X_08580_ _02692_ _02694_ vssd1 vssd1 vccd1 vccd1 _02695_ sky130_fd_sc_hd__and2_1
X_07600_ _01722_ _01723_ _01721_ vssd1 vssd1 vccd1 vccd1 _01724_ sky130_fd_sc_hd__a21o_1
XFILLER_0_44_41 vssd1 vssd1 vccd1 vccd1 sky130_fd_sc_hd__decap_4
X_07531_ _01614_ _01616_ _01586_ vssd1 vssd1 vccd1 vccd1 _01656_ sky130_fd_sc_hd__a21o_1
XFILLER_0_49_639 vssd1 vssd1 vccd1 vccd1 sky130_fd_sc_hd__fill_2
XFILLER_0_48_116 vssd1 vssd1 vccd1 vccd1 sky130_fd_sc_hd__decap_8
XFILLER_0_119_505 vssd1 vssd1 vccd1 vccd1 sky130_ef_sc_hd__decap_12
XFILLER_0_48_149 vssd1 vssd1 vccd1 vccd1 sky130_fd_sc_hd__fill_2
X_07462_ _01577_ _01579_ vssd1 vssd1 vccd1 vccd1 _01587_ sky130_fd_sc_hd__xnor2_1
X_09201_ net1054 net1063 net780 net770 vssd1 vssd1 vccd1 vccd1 _03312_ sky130_fd_sc_hd__nand4_1
XFILLER_0_60_40 vssd1 vssd1 vccd1 vccd1 sky130_ef_sc_hd__decap_12
X_06413_ _00708_ _00712_ _00717_ vssd1 vssd1 vccd1 vccd1 _00718_ sky130_fd_sc_hd__o21ba_1
X_07393_ net917 net1097 net1105 net909 vssd1 vssd1 vccd1 vccd1 _01518_ sky130_fd_sc_hd__a22o_1
X_09132_ _03207_ _03208_ _03240_ _03241_ vssd1 vssd1 vccd1 vccd1 _03244_ sky130_fd_sc_hd__or4_1
X_06344_ _00641_ _00655_ _00639_ vssd1 vssd1 vccd1 vccd1 _00656_ sky130_fd_sc_hd__o21a_2
XFILLER_0_114_221 vssd1 vssd1 vccd1 vccd1 sky130_ef_sc_hd__decap_12
X_06275_ net695 vssd1 vssd1 vccd1 vccd1 _00591_ sky130_fd_sc_hd__inv_2
X_09063_ _03173_ _03174_ vssd1 vssd1 vccd1 vccd1 _03175_ sky130_fd_sc_hd__xnor2_1
XFILLER_0_8_41 vssd1 vssd1 vccd1 vccd1 sky130_ef_sc_hd__decap_12
XFILLER_0_130_725 vssd1 vssd1 vccd1 vccd1 sky130_fd_sc_hd__decap_3
XFILLER_0_114_265 vssd1 vssd1 vccd1 vccd1 sky130_ef_sc_hd__decap_12
X_08014_ _02131_ _02132_ _02133_ vssd1 vssd1 vccd1 vccd1 _02134_ sky130_fd_sc_hd__nand3_1
XFILLER_0_8_85 vssd1 vssd1 vccd1 vccd1 sky130_fd_sc_hd__decap_6
X_09965_ _03954_ _03988_ _03986_ vssd1 vssd1 vccd1 vccd1 _04071_ sky130_fd_sc_hd__a21o_2
X_08916_ _02878_ _02881_ _03025_ _03026_ vssd1 vssd1 vccd1 vccd1 _03029_ sky130_fd_sc_hd__o211ai_2
X_09896_ _03841_ _03842_ _04001_ _04002_ vssd1 vssd1 vccd1 vccd1 _04003_ sky130_fd_sc_hd__a211o_2
XTAP_970 vssd1 vccd1 sky130_fd_sc_hd__tapvpwrvgnd_1
X_08847_ _02821_ _02960_ vssd1 vssd1 vccd1 vccd1 _02961_ sky130_fd_sc_hd__xnor2_2
XTAP_981 vssd1 vccd1 sky130_fd_sc_hd__tapvpwrvgnd_1
XTAP_992 vssd1 vccd1 sky130_fd_sc_hd__tapvpwrvgnd_1
X_08778_ net1016 net835 vssd1 vssd1 vccd1 vccd1 _02892_ sky130_fd_sc_hd__nand2_1
XFILLER_0_79_274 vssd1 vssd1 vccd1 vccd1 sky130_fd_sc_hd__decap_6
X_07729_ _01850_ _01851_ vssd1 vssd1 vccd1 vccd1 _01852_ sky130_fd_sc_hd__xnor2_2
X_10740_ _04837_ _04838_ _04839_ vssd1 vssd1 vccd1 vccd1 _04841_ sky130_fd_sc_hd__a21bo_1
X_10671_ net1029 net1037 net731 net725 vssd1 vssd1 vccd1 vccd1 _04773_ sky130_fd_sc_hd__and4_1
X_12410_ net691 net611 net668 net1155 vssd1 vssd1 vccd1 vccd1 _06197_ sky130_fd_sc_hd__o31a_1
XFILLER_0_35_366 vssd1 vssd1 vccd1 vccd1 sky130_fd_sc_hd__decap_4
XFILLER_0_62_185 vssd1 vssd1 vccd1 vccd1 sky130_fd_sc_hd__fill_1
XFILLER_0_51_826 vssd1 vssd1 vccd1 vccd1 sky130_fd_sc_hd__fill_1
X_12341_ net1621 _00960_ net673 vssd1 vssd1 vccd1 vccd1 _00393_ sky130_fd_sc_hd__mux2_1
XFILLER_0_35_388 vssd1 vssd1 vccd1 vccd1 sky130_fd_sc_hd__decap_4
X_12272_ net1351 net50 net689 vssd1 vssd1 vccd1 vccd1 _00326_ sky130_fd_sc_hd__mux2_1
XFILLER_0_49_19 vssd1 vssd1 vccd1 vccd1 sky130_fd_sc_hd__fill_1
X_11223_ _05319_ _05320_ vssd1 vssd1 vccd1 vccd1 _05321_ sky130_fd_sc_hd__xnor2_2
XFILLER_0_50_369 vssd1 vssd1 vccd1 vccd1 sky130_fd_sc_hd__fill_1
XFILLER_0_31_561 vssd1 vssd1 vccd1 vccd1 sky130_fd_sc_hd__decap_4
XFILLER_0_101_493 vssd1 vssd1 vccd1 vccd1 sky130_fd_sc_hd__decap_6
X_11154_ _05242_ _05250_ vssd1 vssd1 vccd1 vccd1 _05252_ sky130_fd_sc_hd__xnor2_1
X_10105_ _04210_ _04209_ vssd1 vssd1 vccd1 vccd1 _04211_ sky130_fd_sc_hd__nand2b_1
X_11085_ _05142_ _05182_ _05183_ vssd1 vssd1 vccd1 vccd1 _05184_ sky130_fd_sc_hd__nand3_4
X_10036_ _04132_ _04139_ _04140_ vssd1 vssd1 vccd1 vccd1 _04142_ sky130_fd_sc_hd__nand3_1
Xinput241 v2y[30] vssd1 vssd1 vccd1 vccd1 net241 sky130_fd_sc_hd__buf_1
Xinput230 v2y[20] vssd1 vssd1 vccd1 vccd1 net230 sky130_fd_sc_hd__buf_1
XFILLER_0_81_39 vssd1 vssd1 vccd1 vccd1 sky130_ef_sc_hd__decap_12
XFILLER_0_58_403 vssd1 vssd1 vccd1 vccd1 sky130_fd_sc_hd__fill_2
X_11987_ net15 net551 net627 net199 _05994_ vssd1 vssd1 vccd1 vccd1 _05995_ sky130_fd_sc_hd__a221o_1
XFILLER_0_129_825 vssd1 vssd1 vccd1 vccd1 sky130_ef_sc_hd__decap_12
XFILLER_0_105_57 vssd1 vssd1 vccd1 vccd1 sky130_ef_sc_hd__decap_12
XFILLER_0_86_745 vssd1 vssd1 vccd1 vccd1 sky130_fd_sc_hd__decap_8
X_10938_ _04902_ _04908_ _05036_ vssd1 vssd1 vccd1 vccd1 _05038_ sky130_fd_sc_hd__nor3_1
XFILLER_0_14_77 vssd1 vssd1 vccd1 vccd1 sky130_fd_sc_hd__decap_6
X_10869_ net853 net844 net928 vssd1 vssd1 vccd1 vccd1 _04969_ sky130_fd_sc_hd__o21a_1
XFILLER_0_6_717 vssd1 vssd1 vccd1 vccd1 sky130_fd_sc_hd__fill_1
X_12608_ net1260 net20 net555 vssd1 vssd1 vccd1 vccd1 _00583_ sky130_fd_sc_hd__mux2_1
XFILLER_0_53_130 vssd1 vssd1 vccd1 vccd1 sky130_fd_sc_hd__fill_2
X_12539_ _00759_ net565 _06266_ vssd1 vssd1 vccd1 vccd1 _00520_ sky130_fd_sc_hd__o21ai_1
XFILLER_0_30_54 vssd1 vssd1 vccd1 vccd1 sky130_fd_sc_hd__decap_8
XFILLER_0_112_725 vssd1 vssd1 vccd1 vccd1 sky130_ef_sc_hd__decap_12
XFILLER_0_100_3 vssd1 vssd1 vccd1 vccd1 sky130_ef_sc_hd__decap_12
XFILLER_0_111_279 vssd1 vssd1 vccd1 vccd1 sky130_fd_sc_hd__fill_1
X_09750_ net878 net868 net951 net945 vssd1 vssd1 vccd1 vccd1 _03858_ sky130_fd_sc_hd__nand4_2
XTAP_266 vssd1 vccd1 sky130_fd_sc_hd__tapvpwrvgnd_1
X_06962_ net905 net1065 vssd1 vssd1 vccd1 vccd1 _01087_ sky130_fd_sc_hd__nand2_1
X_09681_ _03773_ _03788_ vssd1 vssd1 vccd1 vccd1 _03789_ sky130_fd_sc_hd__xnor2_4
X_08701_ _02415_ _02815_ vssd1 vssd1 vccd1 vccd1 _02816_ sky130_fd_sc_hd__or2_1
XTAP_299 vssd1 vccd1 sky130_fd_sc_hd__tapvpwrvgnd_1
XTAP_277 vssd1 vccd1 sky130_fd_sc_hd__tapvpwrvgnd_1
XTAP_288 vssd1 vccd1 sky130_fd_sc_hd__tapvpwrvgnd_1
X_08632_ _02604_ _02606_ vssd1 vssd1 vccd1 vccd1 _02747_ sky130_fd_sc_hd__nand2_1
XFILLER_0_55_62 vssd1 vssd1 vccd1 vccd1 sky130_ef_sc_hd__decap_12
X_06893_ net895 net887 net1088 vssd1 vssd1 vccd1 vccd1 _01018_ sky130_fd_sc_hd__and3_1
XFILLER_0_89_550 vssd1 vssd1 vccd1 vccd1 sky130_fd_sc_hd__fill_2
X_08563_ _02561_ _02564_ _02562_ vssd1 vssd1 vccd1 vccd1 _02678_ sky130_fd_sc_hd__o21bai_2
XFILLER_0_49_425 vssd1 vssd1 vccd1 vccd1 sky130_fd_sc_hd__fill_1
X_08494_ _02608_ _02609_ _02602_ vssd1 vssd1 vccd1 vccd1 _02610_ sky130_fd_sc_hd__a21o_1
X_07514_ net918 net910 net1130 net1138 vssd1 vssd1 vccd1 vccd1 _01639_ sky130_fd_sc_hd__and4_1
XFILLER_0_119_335 vssd1 vssd1 vccd1 vccd1 sky130_fd_sc_hd__fill_1
XFILLER_0_91_203 vssd1 vssd1 vccd1 vccd1 sky130_fd_sc_hd__decap_3
X_07445_ _01567_ _01568_ _01562_ vssd1 vssd1 vccd1 vccd1 _01570_ sky130_fd_sc_hd__a21o_1
XFILLER_0_9_577 vssd1 vssd1 vccd1 vccd1 sky130_fd_sc_hd__fill_2
XFILLER_0_18_834 vssd1 vssd1 vccd1 vccd1 sky130_fd_sc_hd__fill_1
XFILLER_0_44_141 vssd1 vssd1 vccd1 vccd1 sky130_fd_sc_hd__decap_4
X_07376_ _01485_ _01492_ _01499_ vssd1 vssd1 vccd1 vccd1 _01501_ sky130_fd_sc_hd__or3_1
XFILLER_0_115_541 vssd1 vssd1 vccd1 vccd1 sky130_ef_sc_hd__decap_12
X_09115_ _03225_ _03226_ _03224_ vssd1 vssd1 vccd1 vccd1 _03227_ sky130_fd_sc_hd__a21o_1
X_06327_ add1.a_i\[4\] add1.b_i\[4\] vssd1 vssd1 vccd1 vccd1 _00639_ sky130_fd_sc_hd__nand2_1
XFILLER_0_33_837 vssd1 vssd1 vccd1 vccd1 sky130_fd_sc_hd__decap_3
XFILLER_0_115_585 vssd1 vssd1 vccd1 vccd1 sky130_ef_sc_hd__decap_12
X_09046_ net1063 net780 net770 net1071 vssd1 vssd1 vccd1 vccd1 _03158_ sky130_fd_sc_hd__a22oi_1
XFILLER_0_103_725 vssd1 vssd1 vccd1 vccd1 sky130_fd_sc_hd__decap_3
XFILLER_0_60_645 vssd1 vssd1 vccd1 vccd1 sky130_fd_sc_hd__decap_4
XFILLER_0_32_336 vssd1 vssd1 vccd1 vccd1 sky130_fd_sc_hd__decap_3
XFILLER_0_130_544 vssd1 vssd1 vccd1 vccd1 sky130_fd_sc_hd__decap_6
XFILLER_0_130_533 vssd1 vssd1 vccd1 vccd1 sky130_fd_sc_hd__fill_2
XFILLER_0_5_794 vssd1 vssd1 vccd1 vccd1 sky130_fd_sc_hd__fill_1
XFILLER_0_103_769 vssd1 vssd1 vccd1 vccd1 sky130_fd_sc_hd__fill_1
Xhold440 x2mx1\[2\] vssd1 vssd1 vccd1 vccd1 net1655 sky130_fd_sc_hd__dlygate4sd3_1
Xhold462 y1my2\[1\] vssd1 vssd1 vccd1 vccd1 net1677 sky130_fd_sc_hd__dlygate4sd3_1
Xhold451 x2mx1\[6\] vssd1 vssd1 vccd1 vccd1 net1666 sky130_fd_sc_hd__dlygate4sd3_1
Xhold473 y1my2\[15\] vssd1 vssd1 vccd1 vccd1 net1688 sky130_fd_sc_hd__dlygate4sd3_1
Xhold484 add1.a_i\[0\] vssd1 vssd1 vccd1 vccd1 net1699 sky130_fd_sc_hd__dlygate4sd3_1
Xhold495 mul1.a\[29\] vssd1 vssd1 vccd1 vccd1 net1710 sky130_fd_sc_hd__dlygate4sd3_1
X_09948_ _03908_ _04054_ vssd1 vssd1 vccd1 vccd1 _04055_ sky130_fd_sc_hd__xnor2_4
Xfanout931 net932 vssd1 vssd1 vccd1 vccd1 net931 sky130_fd_sc_hd__clkbuf_4
Xfanout942 net943 vssd1 vssd1 vccd1 vccd1 net942 sky130_fd_sc_hd__clkbuf_4
Xfanout920 net921 vssd1 vssd1 vccd1 vccd1 net920 sky130_fd_sc_hd__buf_2
Xfanout986 net988 vssd1 vssd1 vccd1 vccd1 net986 sky130_fd_sc_hd__buf_2
Xfanout964 net966 vssd1 vssd1 vccd1 vccd1 net964 sky130_fd_sc_hd__clkbuf_4
Xfanout953 net954 vssd1 vssd1 vccd1 vccd1 net953 sky130_fd_sc_hd__clkbuf_4
Xfanout975 net978 vssd1 vssd1 vccd1 vccd1 net975 sky130_fd_sc_hd__buf_2
X_09879_ _03850_ _03853_ _03984_ _03985_ vssd1 vssd1 vccd1 vccd1 _03986_ sky130_fd_sc_hd__a211oi_1
Xfanout997 mul1.a\[19\] vssd1 vssd1 vccd1 vccd1 net997 sky130_fd_sc_hd__clkbuf_2
X_11910_ net112 net620 net594 net80 vssd1 vssd1 vccd1 vccd1 _05937_ sky130_fd_sc_hd__a22o_1
X_12890_ clknet_leaf_32_clk_i _00276_ vssd1 vssd1 vccd1 vccd1 mul1.a\[25\] sky130_fd_sc_hd__dfxtp_2
XTAP_1900 vssd1 vccd1 sky130_fd_sc_hd__tapvpwrvgnd_1
X_11841_ net104 net669 _05877_ _05879_ vssd1 vssd1 vccd1 vccd1 _05880_ sky130_fd_sc_hd__a211o_1
XTAP_1933 vssd1 vccd1 sky130_fd_sc_hd__tapvpwrvgnd_1
XTAP_1922 vssd1 vccd1 sky130_fd_sc_hd__tapvpwrvgnd_1
XTAP_1911 vssd1 vccd1 sky130_fd_sc_hd__tapvpwrvgnd_1
XFILLER_0_67_233 vssd1 vssd1 vccd1 vccd1 sky130_fd_sc_hd__fill_1
X_11772_ net61 net674 net608 net189 vssd1 vssd1 vccd1 vccd1 _05821_ sky130_fd_sc_hd__a22o_1
XTAP_1966 vssd1 vccd1 sky130_fd_sc_hd__tapvpwrvgnd_1
XTAP_1977 vssd1 vccd1 sky130_fd_sc_hd__tapvpwrvgnd_1
XTAP_1955 vssd1 vccd1 sky130_fd_sc_hd__tapvpwrvgnd_1
XTAP_1944 vssd1 vccd1 sky130_fd_sc_hd__tapvpwrvgnd_1
X_10723_ _04676_ _04677_ _04822_ vssd1 vssd1 vccd1 vccd1 _04824_ sky130_fd_sc_hd__nand3_2
XTAP_1999 vssd1 vccd1 sky130_fd_sc_hd__tapvpwrvgnd_1
XTAP_1988 vssd1 vccd1 sky130_fd_sc_hd__tapvpwrvgnd_1
XFILLER_0_125_316 vssd1 vssd1 vccd1 vccd1 sky130_fd_sc_hd__fill_1
X_10654_ net1070 net704 _04753_ _04754_ vssd1 vssd1 vccd1 vccd1 _04756_ sky130_fd_sc_hd__o2bb2a_1
XFILLER_0_48_491 vssd1 vssd1 vccd1 vccd1 sky130_ef_sc_hd__decap_12
X_10585_ net807 net959 _04685_ _04686_ vssd1 vssd1 vccd1 vccd1 _04687_ sky130_fd_sc_hd__nand4_2
XFILLER_0_36_686 vssd1 vssd1 vccd1 vccd1 sky130_fd_sc_hd__decap_8
X_12324_ net1646 _00867_ net666 vssd1 vssd1 vccd1 vccd1 _00376_ sky130_fd_sc_hd__mux2_1
XFILLER_0_50_188 vssd1 vssd1 vccd1 vccd1 sky130_fd_sc_hd__decap_8
X_12255_ x2mx1\[30\] net605 net588 temp1\[30\] vssd1 vssd1 vccd1 vccd1 _06190_ sky130_fd_sc_hd__a22o_1
X_11206_ _05300_ _05301_ _05133_ _05136_ vssd1 vssd1 vccd1 vccd1 _05304_ sky130_fd_sc_hd__a211o_1
X_12186_ x2mx1\[7\] net602 net582 temp1\[7\] vssd1 vssd1 vccd1 vccd1 _06144_ sky130_fd_sc_hd__a22o_1
XFILLER_0_31_391 vssd1 vssd1 vccd1 vccd1 sky130_fd_sc_hd__fill_1
X_11137_ _05233_ _05234_ vssd1 vssd1 vccd1 vccd1 _05235_ sky130_fd_sc_hd__xnor2_1
XFILLER_0_92_27 vssd1 vssd1 vccd1 vccd1 sky130_fd_sc_hd__fill_1
X_11068_ _04984_ _04986_ _05165_ _05166_ vssd1 vssd1 vccd1 vccd1 _05167_ sky130_fd_sc_hd__a211o_1
X_10019_ net1028 net759 _04122_ _04124_ vssd1 vssd1 vccd1 vccd1 _04125_ sky130_fd_sc_hd__and4_1
XFILLER_0_86_531 vssd1 vssd1 vccd1 vccd1 sky130_fd_sc_hd__fill_1
XFILLER_0_86_553 vssd1 vssd1 vccd1 vccd1 sky130_fd_sc_hd__fill_1
XFILLER_0_18_119 vssd1 vssd1 vccd1 vccd1 sky130_fd_sc_hd__fill_1
XFILLER_0_39_480 vssd1 vssd1 vccd1 vccd1 sky130_fd_sc_hd__fill_2
X_07230_ _01352_ _01353_ _01339_ vssd1 vssd1 vccd1 vccd1 _01355_ sky130_fd_sc_hd__a21oi_1
X_07161_ _01072_ _01280_ _01279_ vssd1 vssd1 vccd1 vccd1 _01286_ sky130_fd_sc_hd__a21o_1
XFILLER_0_41_97 vssd1 vssd1 vccd1 vccd1 sky130_fd_sc_hd__fill_1
XFILLER_0_112_533 vssd1 vssd1 vccd1 vccd1 sky130_ef_sc_hd__decap_12
X_07092_ _01209_ _01210_ _01215_ vssd1 vssd1 vccd1 vccd1 _01217_ sky130_fd_sc_hd__a21o_1
XFILLER_0_1_252 vssd1 vssd1 vccd1 vccd1 sky130_fd_sc_hd__fill_1
XFILLER_0_10_542 vssd1 vssd1 vccd1 vccd1 sky130_fd_sc_hd__decap_4
X_09802_ _03772_ _03792_ _03791_ vssd1 vssd1 vccd1 vccd1 _03909_ sky130_fd_sc_hd__o21ba_2
XFILLER_0_10_586 vssd1 vssd1 vccd1 vccd1 sky130_fd_sc_hd__fill_2
X_07994_ _02110_ _02111_ _01997_ _01999_ vssd1 vssd1 vccd1 vccd1 _02114_ sky130_fd_sc_hd__a211oi_2
XFILLER_0_66_72 vssd1 vssd1 vccd1 vccd1 sky130_ef_sc_hd__decap_12
X_09733_ net850 net842 net971 mul1.a\[24\] vssd1 vssd1 vccd1 vccd1 _03841_ sky130_fd_sc_hd__nand4_4
X_06945_ net905 net1081 vssd1 vssd1 vccd1 vccd1 _01070_ sky130_fd_sc_hd__and2_1
X_09664_ _03593_ _03770_ vssd1 vssd1 vccd1 vccd1 _03772_ sky130_fd_sc_hd__xor2_4
X_06876_ net600 _01004_ vssd1 vssd1 vccd1 vccd1 _01005_ sky130_fd_sc_hd__or2_1
XFILLER_0_96_317 vssd1 vssd1 vccd1 vccd1 sky130_fd_sc_hd__decap_4
X_08615_ _02727_ _02728_ _02714_ vssd1 vssd1 vccd1 vccd1 _02730_ sky130_fd_sc_hd__nor3b_4
X_09595_ net892 net939 net937 net901 vssd1 vssd1 vccd1 vccd1 _03704_ sky130_fd_sc_hd__a22o_1
XTAP_1229 vssd1 vccd1 sky130_fd_sc_hd__tapvpwrvgnd_1
XTAP_1218 vssd1 vccd1 sky130_fd_sc_hd__tapvpwrvgnd_1
XTAP_1207 vssd1 vccd1 sky130_fd_sc_hd__tapvpwrvgnd_1
X_08546_ _02560_ _02658_ _02660_ vssd1 vssd1 vccd1 vccd1 _02662_ sky130_fd_sc_hd__nand3_1
X_08477_ _02590_ _02591_ _02481_ _02484_ vssd1 vssd1 vccd1 vccd1 _02593_ sky130_fd_sc_hd__o211a_1
XFILLER_0_64_225 vssd1 vssd1 vccd1 vccd1 sky130_fd_sc_hd__decap_3
X_07428_ _01530_ _01538_ _01537_ vssd1 vssd1 vccd1 vccd1 _01553_ sky130_fd_sc_hd__o21a_1
XFILLER_0_123_809 vssd1 vssd1 vccd1 vccd1 sky130_ef_sc_hd__decap_12
XFILLER_0_107_349 vssd1 vssd1 vccd1 vccd1 sky130_fd_sc_hd__fill_1
XFILLER_0_92_589 vssd1 vssd1 vccd1 vccd1 sky130_fd_sc_hd__fill_1
XFILLER_0_17_163 vssd1 vssd1 vccd1 vccd1 sky130_fd_sc_hd__decap_4
X_07359_ _01432_ _01434_ vssd1 vssd1 vccd1 vccd1 _01484_ sky130_fd_sc_hd__xnor2_1
XFILLER_0_18_697 vssd1 vssd1 vccd1 vccd1 sky130_fd_sc_hd__decap_3
XFILLER_0_33_623 vssd1 vssd1 vccd1 vccd1 sky130_fd_sc_hd__fill_1
XFILLER_0_60_442 vssd1 vssd1 vccd1 vccd1 sky130_fd_sc_hd__decap_8
XFILLER_0_115_393 vssd1 vssd1 vccd1 vccd1 sky130_ef_sc_hd__decap_12
X_10370_ _04472_ _04473_ vssd1 vssd1 vccd1 vccd1 _04474_ sky130_fd_sc_hd__xor2_2
XFILLER_0_32_166 vssd1 vssd1 vccd1 vccd1 sky130_fd_sc_hd__decap_4
XFILLER_0_33_678 vssd1 vssd1 vccd1 vccd1 sky130_fd_sc_hd__decap_4
X_09029_ _02975_ _02977_ _03136_ _03138_ vssd1 vssd1 vccd1 vccd1 _03141_ sky130_fd_sc_hd__a211o_1
XFILLER_0_103_577 vssd1 vssd1 vccd1 vccd1 sky130_fd_sc_hd__decap_3
XFILLER_0_20_317 vssd1 vssd1 vccd1 vccd1 sky130_fd_sc_hd__fill_1
XFILLER_0_20_339 vssd1 vssd1 vccd1 vccd1 sky130_fd_sc_hd__fill_1
XFILLER_0_32_188 vssd1 vssd1 vccd1 vccd1 sky130_fd_sc_hd__fill_1
X_12040_ x0mx2\[1\] net628 net590 y1my2\[1\] vssd1 vssd1 vccd1 vccd1 _06036_ sky130_fd_sc_hd__a22o_1
Xhold270 y2my0\[17\] vssd1 vssd1 vccd1 vccd1 net1485 sky130_fd_sc_hd__dlygate4sd3_1
Xhold292 posy\[3\] vssd1 vssd1 vccd1 vccd1 net1507 sky130_fd_sc_hd__dlygate4sd3_1
Xhold281 y2my0\[19\] vssd1 vssd1 vccd1 vccd1 net1496 sky130_fd_sc_hd__dlygate4sd3_1
Xfanout750 net751 vssd1 vssd1 vccd1 vccd1 net750 sky130_fd_sc_hd__clkbuf_4
XFILLER_0_99_111 vssd1 vssd1 vccd1 vccd1 sky130_fd_sc_hd__fill_1
Xfanout772 net773 vssd1 vssd1 vccd1 vccd1 net772 sky130_fd_sc_hd__clkbuf_4
Xfanout761 net762 vssd1 vssd1 vccd1 vccd1 net761 sky130_fd_sc_hd__clkbuf_4
Xfanout783 net785 vssd1 vssd1 vccd1 vccd1 net783 sky130_fd_sc_hd__buf_1
Xfanout794 mul1.b\[16\] vssd1 vssd1 vccd1 vccd1 net794 sky130_fd_sc_hd__clkbuf_4
X_12942_ clknet_leaf_8_clk_i _00328_ net1196 vssd1 vssd1 vccd1 vccd1 posy\[4\] sky130_fd_sc_hd__dfrtp_1
XFILLER_0_99_177 vssd1 vssd1 vccd1 vccd1 sky130_fd_sc_hd__decap_3
XFILLER_0_87_317 vssd1 vssd1 vccd1 vccd1 sky130_fd_sc_hd__decap_8
XFILLER_0_62_19 vssd1 vssd1 vccd1 vccd1 sky130_fd_sc_hd__fill_1
X_12873_ clknet_leaf_44_clk_i _00259_ vssd1 vssd1 vccd1 vccd1 mul1.a\[8\] sky130_fd_sc_hd__dfxtp_2
XTAP_1752 vssd1 vccd1 sky130_fd_sc_hd__tapvpwrvgnd_1
XTAP_1741 vssd1 vccd1 sky130_fd_sc_hd__tapvpwrvgnd_1
XTAP_1730 vssd1 vccd1 sky130_fd_sc_hd__tapvpwrvgnd_1
X_11824_ temp1\[20\] net615 net610 net198 vssd1 vssd1 vccd1 vccd1 _05865_ sky130_fd_sc_hd__a22o_1
XTAP_1774 vssd1 vccd1 sky130_fd_sc_hd__tapvpwrvgnd_1
XTAP_1785 vssd1 vccd1 sky130_fd_sc_hd__tapvpwrvgnd_1
XTAP_1763 vssd1 vccd1 sky130_fd_sc_hd__tapvpwrvgnd_1
XFILLER_0_68_597 vssd1 vssd1 vccd1 vccd1 sky130_fd_sc_hd__decap_3
XFILLER_0_55_225 vssd1 vssd1 vccd1 vccd1 sky130_ef_sc_hd__decap_12
X_11755_ temp1\[9\] net614 net665 net121 _05806_ vssd1 vssd1 vccd1 vccd1 _05807_ sky130_fd_sc_hd__a221o_1
XFILLER_0_126_625 vssd1 vssd1 vccd1 vccd1 sky130_fd_sc_hd__fill_1
XTAP_1796 vssd1 vccd1 sky130_fd_sc_hd__tapvpwrvgnd_1
X_10706_ _04806_ _04807_ _04660_ _04662_ vssd1 vssd1 vccd1 vccd1 _04808_ sky130_fd_sc_hd__a211oi_2
XFILLER_0_126_669 vssd1 vssd1 vccd1 vccd1 sky130_ef_sc_hd__decap_12
XFILLER_0_125_113 vssd1 vssd1 vccd1 vccd1 sky130_ef_sc_hd__decap_12
XFILLER_0_83_589 vssd1 vssd1 vccd1 vccd1 sky130_fd_sc_hd__fill_2
XFILLER_0_71_729 vssd1 vssd1 vccd1 vccd1 sky130_ef_sc_hd__decap_12
XFILLER_0_71_718 vssd1 vssd1 vccd1 vccd1 sky130_fd_sc_hd__decap_8
X_11686_ net1608 _04813_ net539 vssd1 vssd1 vccd1 vccd1 _00178_ sky130_fd_sc_hd__mux2_1
XFILLER_0_24_601 vssd1 vssd1 vccd1 vccd1 sky130_ef_sc_hd__decap_12
X_10637_ _04737_ _04738_ _04725_ vssd1 vssd1 vccd1 vccd1 _04739_ sky130_fd_sc_hd__a21oi_1
XFILLER_0_36_483 vssd1 vssd1 vccd1 vccd1 sky130_fd_sc_hd__fill_2
X_10568_ _04666_ _04670_ vssd1 vssd1 vccd1 vccd1 _04671_ sky130_fd_sc_hd__xor2_4
XFILLER_0_11_89 vssd1 vssd1 vccd1 vccd1 sky130_fd_sc_hd__decap_3
Xclkbuf_leaf_13_clk_i clknet_3_7__leaf_clk_i vssd1 vssd1 vccd1 vccd1 clknet_leaf_13_clk_i
+ sky130_fd_sc_hd__clkbuf_16
XFILLER_0_87_27 vssd1 vssd1 vccd1 vccd1 sky130_ef_sc_hd__decap_12
X_10499_ _04600_ _04601_ _04497_ _04500_ vssd1 vssd1 vccd1 vccd1 _04602_ sky130_fd_sc_hd__a211o_1
X_12307_ net1620 _00946_ net680 vssd1 vssd1 vccd1 vccd1 _00359_ sky130_fd_sc_hd__mux2_1
XFILLER_0_121_385 vssd1 vssd1 vccd1 vccd1 sky130_fd_sc_hd__decap_6
X_12238_ _00935_ net511 net468 y1my2\[24\] _06178_ vssd1 vssd1 vccd1 vccd1 _06179_
+ sky130_fd_sc_hd__a221o_1
Xclkbuf_leaf_28_clk_i clknet_3_5__leaf_clk_i vssd1 vssd1 vccd1 vccd1 clknet_leaf_28_clk_i
+ sky130_fd_sc_hd__clkbuf_16
X_12169_ _00813_ net509 net466 net1677 _06132_ vssd1 vssd1 vccd1 vccd1 _06133_ sky130_fd_sc_hd__a221o_1
Xinput5 div_sstream_i[12] vssd1 vssd1 vccd1 vccd1 net5 sky130_fd_sc_hd__clkbuf_8
XFILLER_0_127_55 vssd1 vssd1 vccd1 vccd1 sky130_fd_sc_hd__fill_1
X_06730_ sub1.b_i\[27\] sub1.a_i\[27\] vssd1 vssd1 vccd1 vccd1 _00948_ sky130_fd_sc_hd__nand2b_1
X_06661_ sub1.a_i\[16\] _00594_ vssd1 vssd1 vccd1 vccd1 _00890_ sky130_fd_sc_hd__and2_1
X_08400_ _02496_ _02513_ _02514_ vssd1 vssd1 vccd1 vccd1 _02517_ sky130_fd_sc_hd__nand3_2
XFILLER_0_59_531 vssd1 vssd1 vccd1 vccd1 sky130_fd_sc_hd__fill_1
X_09380_ _03486_ _03487_ _03488_ vssd1 vssd1 vccd1 vccd1 _03490_ sky130_fd_sc_hd__a21bo_1
X_06592_ _00824_ _00827_ _00826_ vssd1 vssd1 vccd1 vccd1 _00832_ sky130_fd_sc_hd__a21oi_1
X_08331_ _02447_ _02446_ _02445_ vssd1 vssd1 vccd1 vccd1 _02448_ sky130_fd_sc_hd__nand3b_1
XFILLER_0_46_203 vssd1 vssd1 vccd1 vccd1 sky130_fd_sc_hd__decap_6
X_08262_ _02359_ _02376_ _02377_ vssd1 vssd1 vccd1 vccd1 _02380_ sky130_fd_sc_hd__nand3_2
XFILLER_0_129_496 vssd1 vssd1 vccd1 vccd1 sky130_fd_sc_hd__fill_1
X_07213_ _01241_ _01247_ _01240_ vssd1 vssd1 vccd1 vccd1 _01338_ sky130_fd_sc_hd__a21oi_1
X_08193_ net1084 net805 _02210_ _02211_ net821 vssd1 vssd1 vccd1 vccd1 _02311_ sky130_fd_sc_hd__a32o_1
XFILLER_0_54_291 vssd1 vssd1 vccd1 vccd1 sky130_fd_sc_hd__fill_1
XFILLER_0_14_133 vssd1 vssd1 vccd1 vccd1 sky130_fd_sc_hd__decap_6
X_07144_ _01198_ _01201_ _01266_ _01267_ vssd1 vssd1 vccd1 vccd1 _01269_ sky130_fd_sc_hd__a211o_1
XFILLER_0_2_550 vssd1 vssd1 vccd1 vccd1 sky130_fd_sc_hd__fill_1
XFILLER_0_14_188 vssd1 vssd1 vccd1 vccd1 sky130_fd_sc_hd__fill_1
XFILLER_0_30_637 vssd1 vssd1 vccd1 vccd1 sky130_fd_sc_hd__decap_6
X_07075_ _01017_ _01067_ vssd1 vssd1 vccd1 vccd1 _01200_ sky130_fd_sc_hd__xnor2_1
Xoutput331 net530 vssd1 vssd1 vccd1 vccd1 div_mstream_o[96] sky130_fd_sc_hd__clkbuf_4
Xoutput320 net320 vssd1 vssd1 vccd1 vccd1 div_mstream_o[86] sky130_fd_sc_hd__clkbuf_4
Xoutput342 net342 vssd1 vssd1 vccd1 vccd1 mstream_o[106] sky130_fd_sc_hd__clkbuf_4
XFILLER_0_112_363 vssd1 vssd1 vccd1 vccd1 sky130_fd_sc_hd__fill_1
XFILLER_0_2_561 vssd1 vssd1 vccd1 vccd1 sky130_fd_sc_hd__fill_2
Xoutput353 net353 vssd1 vssd1 vccd1 vccd1 mstream_o[12] sky130_fd_sc_hd__clkbuf_4
Xoutput364 net364 vssd1 vssd1 vccd1 vccd1 mstream_o[22] sky130_fd_sc_hd__clkbuf_4
Xoutput375 net375 vssd1 vssd1 vccd1 vccd1 mstream_o[32] sky130_fd_sc_hd__clkbuf_4
Xoutput386 net386 vssd1 vssd1 vccd1 vccd1 mstream_o[42] sky130_fd_sc_hd__clkbuf_4
XFILLER_0_77_93 vssd1 vssd1 vccd1 vccd1 sky130_fd_sc_hd__decap_8
Xoutput397 net397 vssd1 vssd1 vccd1 vccd1 mstream_o[52] sky130_fd_sc_hd__clkbuf_4
XFILLER_0_10_394 vssd1 vssd1 vccd1 vccd1 sky130_fd_sc_hd__fill_2
X_07977_ net1075 net1084 net814 vssd1 vssd1 vccd1 vccd1 _02097_ sky130_fd_sc_hd__and3_1
X_09716_ _03814_ _03821_ _03822_ vssd1 vssd1 vccd1 vccd1 _03824_ sky130_fd_sc_hd__nand3_1
X_06928_ _01029_ _01036_ _01052_ vssd1 vssd1 vccd1 vccd1 _01053_ sky130_fd_sc_hd__a21oi_2
X_09647_ net1100 net714 net711 net1108 vssd1 vssd1 vccd1 vccd1 _03755_ sky130_fd_sc_hd__a22o_1
XTAP_1004 vssd1 vccd1 sky130_fd_sc_hd__tapvpwrvgnd_1
X_06859_ state\[4\] _00616_ vssd1 vssd1 vccd1 vccd1 _00989_ sky130_fd_sc_hd__or2_1
X_09578_ _03685_ _03686_ _03678_ vssd1 vssd1 vccd1 vccd1 _03687_ sky130_fd_sc_hd__a21o_1
XTAP_1037 vssd1 vccd1 sky130_fd_sc_hd__tapvpwrvgnd_1
XTAP_1026 vssd1 vccd1 sky130_fd_sc_hd__tapvpwrvgnd_1
XTAP_1015 vssd1 vccd1 sky130_fd_sc_hd__tapvpwrvgnd_1
X_08529_ _02641_ _02642_ _02643_ vssd1 vssd1 vccd1 vccd1 _02645_ sky130_fd_sc_hd__a21o_1
XTAP_1059 vssd1 vccd1 sky130_fd_sc_hd__tapvpwrvgnd_1
XTAP_1048 vssd1 vccd1 sky130_fd_sc_hd__tapvpwrvgnd_1
XFILLER_0_108_625 vssd1 vssd1 vccd1 vccd1 sky130_ef_sc_hd__decap_12
X_11540_ _05633_ _05634_ vssd1 vssd1 vccd1 vccd1 _05635_ sky130_fd_sc_hd__nor2_1
XFILLER_0_108_669 vssd1 vssd1 vccd1 vccd1 sky130_ef_sc_hd__decap_12
XFILLER_0_107_113 vssd1 vssd1 vccd1 vccd1 sky130_ef_sc_hd__decap_12
XFILLER_0_80_504 vssd1 vssd1 vccd1 vccd1 sky130_fd_sc_hd__fill_1
XFILLER_0_53_729 vssd1 vssd1 vccd1 vccd1 sky130_fd_sc_hd__fill_2
XFILLER_0_52_217 vssd1 vssd1 vccd1 vccd1 sky130_fd_sc_hd__fill_1
XFILLER_0_123_617 vssd1 vssd1 vccd1 vccd1 sky130_ef_sc_hd__decap_12
X_11471_ _05209_ _05454_ _05207_ vssd1 vssd1 vccd1 vccd1 _05566_ sky130_fd_sc_hd__o21ai_1
X_10422_ _04524_ _04525_ vssd1 vssd1 vccd1 vccd1 _04526_ sky130_fd_sc_hd__xnor2_4
XFILLER_0_60_250 vssd1 vssd1 vccd1 vccd1 sky130_fd_sc_hd__fill_2
X_13141_ clknet_leaf_16_clk_i _00527_ net1182 vssd1 vssd1 vccd1 vccd1 l0\[2\] sky130_fd_sc_hd__dfrtp_1
X_10353_ _04340_ _04342_ _04455_ _04456_ vssd1 vssd1 vccd1 vccd1 _04457_ sky130_fd_sc_hd__a211o_1
XFILLER_0_20_103 vssd1 vssd1 vccd1 vccd1 sky130_fd_sc_hd__decap_8
X_13072_ clknet_leaf_26_clk_i _00458_ net1172 vssd1 vssd1 vccd1 vccd1 y2my0\[29\]
+ sky130_fd_sc_hd__dfrtp_1
X_10284_ net1087 net706 _04385_ _04386_ vssd1 vssd1 vccd1 vccd1 _04388_ sky130_fd_sc_hd__a22o_1
X_12023_ net25 net552 net626 net209 _06021_ vssd1 vssd1 vccd1 vccd1 _06022_ sky130_fd_sc_hd__a221o_1
Xfanout580 net581 vssd1 vssd1 vccd1 vccd1 net580 sky130_fd_sc_hd__clkbuf_4
Xfanout591 net593 vssd1 vssd1 vccd1 vccd1 net591 sky130_fd_sc_hd__buf_4
X_12925_ clknet_leaf_25_clk_i _00311_ vssd1 vssd1 vccd1 vccd1 mul1.b\[28\] sky130_fd_sc_hd__dfxtp_2
XTAP_2250 vssd1 vccd1 sky130_fd_sc_hd__tapvpwrvgnd_1
X_12856_ clknet_leaf_34_clk_i _00242_ vssd1 vssd1 vccd1 vccd1 sub1.b_i\[23\] sky130_fd_sc_hd__dfxtp_1
XTAP_1560 vssd1 vccd1 sky130_fd_sc_hd__tapvpwrvgnd_1
XFILLER_0_68_372 vssd1 vssd1 vccd1 vccd1 sky130_fd_sc_hd__decap_8
XFILLER_0_56_512 vssd1 vssd1 vccd1 vccd1 sky130_fd_sc_hd__fill_1
XFILLER_0_8_609 vssd1 vssd1 vccd1 vccd1 sky130_fd_sc_hd__decap_3
X_11807_ net654 _00897_ net475 _05850_ vssd1 vssd1 vccd1 vccd1 _05851_ sky130_fd_sc_hd__a211o_1
XTAP_1593 vssd1 vccd1 sky130_fd_sc_hd__tapvpwrvgnd_1
XTAP_1582 vssd1 vccd1 sky130_fd_sc_hd__tapvpwrvgnd_1
XTAP_1571 vssd1 vccd1 sky130_fd_sc_hd__tapvpwrvgnd_1
XFILLER_0_68_394 vssd1 vssd1 vccd1 vccd1 sky130_fd_sc_hd__decap_3
X_12787_ clknet_leaf_41_clk_i _00173_ vssd1 vssd1 vccd1 vccd1 add1.b_i\[18\] sky130_fd_sc_hd__dfxtp_1
XFILLER_0_28_247 vssd1 vssd1 vccd1 vccd1 sky130_fd_sc_hd__decap_4
XFILLER_0_113_57 vssd1 vssd1 vccd1 vccd1 sky130_ef_sc_hd__decap_12
XFILLER_0_83_353 vssd1 vssd1 vccd1 vccd1 sky130_fd_sc_hd__fill_1
X_11738_ temp1\[6\] net611 net668 net118 _05792_ vssd1 vssd1 vccd1 vccd1 _05793_ sky130_fd_sc_hd__a221o_1
XFILLER_0_126_477 vssd1 vssd1 vccd1 vccd1 sky130_ef_sc_hd__decap_12
X_11669_ net1703 _02284_ net536 vssd1 vssd1 vccd1 vccd1 _00161_ sky130_fd_sc_hd__mux2_1
XFILLER_0_22_88 vssd1 vssd1 vccd1 vccd1 sky130_fd_sc_hd__fill_2
XFILLER_0_113_105 vssd1 vssd1 vccd1 vccd1 sky130_fd_sc_hd__decap_6
XFILLER_0_113_149 vssd1 vssd1 vccd1 vccd1 sky130_ef_sc_hd__decap_12
XFILLER_0_24_475 vssd1 vssd1 vccd1 vccd1 sky130_fd_sc_hd__fill_1
XFILLER_0_51_294 vssd1 vssd1 vccd1 vccd1 sky130_fd_sc_hd__decap_4
XFILLER_0_11_125 vssd1 vssd1 vccd1 vccd1 sky130_ef_sc_hd__decap_12
XFILLER_0_121_193 vssd1 vssd1 vccd1 vccd1 sky130_ef_sc_hd__decap_12
XFILLER_0_11_169 vssd1 vssd1 vccd1 vccd1 sky130_fd_sc_hd__decap_4
X_08880_ net1092 net749 net741 net1099 vssd1 vssd1 vccd1 vccd1 _02993_ sky130_fd_sc_hd__a22o_1
X_07900_ _02017_ _02020_ vssd1 vssd1 vccd1 vccd1 _02021_ sky130_fd_sc_hd__xnor2_2
X_07831_ temp1\[3\] _01952_ net540 vssd1 vssd1 vccd1 vccd1 _01953_ sky130_fd_sc_hd__mux2_1
X_09501_ _03434_ net655 _03607_ _03608_ vssd1 vssd1 vccd1 vccd1 _03610_ sky130_fd_sc_hd__o211a_1
X_07762_ _01880_ _01883_ vssd1 vssd1 vccd1 vccd1 _01884_ sky130_fd_sc_hd__xor2_1
X_07693_ net1026 net899 net890 net1032 vssd1 vssd1 vccd1 vccd1 _01816_ sky130_fd_sc_hd__a22oi_2
X_06713_ _00931_ _00932_ vssd1 vssd1 vccd1 vccd1 _00934_ sky130_fd_sc_hd__and2_1
X_09432_ net923 net926 net696 vssd1 vssd1 vccd1 vccd1 _03542_ sky130_fd_sc_hd__nand3_1
X_06644_ _00874_ _00875_ vssd1 vssd1 vccd1 vccd1 _00876_ sky130_fd_sc_hd__nor2_2
X_09363_ _03469_ _03472_ vssd1 vssd1 vccd1 vccd1 _03473_ sky130_fd_sc_hd__xor2_2
XPHY_109 vssd1 vssd1 vccd1 vccd1 sky130_fd_sc_hd__decap_3
X_06575_ _00814_ _00817_ vssd1 vssd1 vccd1 vccd1 _00818_ sky130_fd_sc_hd__xnor2_4
X_08314_ net1139 net734 vssd1 vssd1 vccd1 vccd1 _02431_ sky130_fd_sc_hd__nand2_1
XFILLER_0_19_225 vssd1 vssd1 vccd1 vccd1 sky130_fd_sc_hd__decap_3
XANTENNA_32 net19 vssd1 vssd1 vccd1 vccd1 sky130_fd_sc_hd__diode_2
X_09294_ _03303_ _03304_ _03403_ _03404_ vssd1 vssd1 vccd1 vccd1 _03405_ sky130_fd_sc_hd__nor4_1
XFILLER_0_90_802 vssd1 vssd1 vccd1 vccd1 sky130_fd_sc_hd__fill_1
XFILLER_0_47_567 vssd1 vssd1 vccd1 vccd1 sky130_fd_sc_hd__decap_6
XANTENNA_21 v1y[24] vssd1 vssd1 vccd1 vccd1 sky130_fd_sc_hd__diode_2
XANTENNA_10 _01006_ vssd1 vssd1 vccd1 vccd1 sky130_fd_sc_hd__diode_2
XFILLER_0_35_729 vssd1 vssd1 vccd1 vccd1 sky130_fd_sc_hd__decap_4
XANTENNA_43 net553 vssd1 vssd1 vccd1 vccd1 sky130_fd_sc_hd__diode_2
XFILLER_0_105_617 vssd1 vssd1 vccd1 vccd1 sky130_ef_sc_hd__decap_12
X_08245_ net986 _02362_ _02361_ vssd1 vssd1 vccd1 vccd1 _02363_ sky130_fd_sc_hd__a21bo_1
XFILLER_0_6_130 vssd1 vssd1 vccd1 vccd1 sky130_fd_sc_hd__fill_2
XANTENNA_54 v1x[13] vssd1 vssd1 vccd1 vccd1 sky130_fd_sc_hd__diode_2
XANTENNA_65 net619 vssd1 vssd1 vccd1 vccd1 sky130_fd_sc_hd__diode_2
X_08176_ _02293_ vssd1 vssd1 vccd1 vccd1 _02294_ sky130_fd_sc_hd__inv_2
X_07127_ _01249_ _01250_ _01182_ _01189_ vssd1 vssd1 vccd1 vccd1 _01252_ sky130_fd_sc_hd__a211o_1
XFILLER_0_100_333 vssd1 vssd1 vccd1 vccd1 sky130_fd_sc_hd__fill_2
X_07058_ _01180_ _01181_ vssd1 vssd1 vccd1 vccd1 _01183_ sky130_fd_sc_hd__xnor2_1
XFILLER_0_100_388 vssd1 vssd1 vccd1 vccd1 sky130_fd_sc_hd__fill_1
X_10971_ _04940_ _04942_ _05069_ _05070_ vssd1 vssd1 vccd1 vccd1 _05071_ sky130_fd_sc_hd__a211oi_2
X_12710_ clknet_leaf_9_clk_i _00096_ net1190 vssd1 vssd1 vccd1 vccd1 net442 sky130_fd_sc_hd__dfrtp_1
XFILLER_0_69_169 vssd1 vssd1 vccd1 vccd1 sky130_fd_sc_hd__fill_1
X_12641_ clknet_leaf_27_clk_i _00027_ net1170 vssd1 vssd1 vccd1 vccd1 net366 sky130_fd_sc_hd__dfrtp_1
X_12572_ net1421 net17 net560 vssd1 vssd1 vccd1 vccd1 _00548_ sky130_fd_sc_hd__mux2_1
XFILLER_0_93_673 vssd1 vssd1 vccd1 vccd1 sky130_fd_sc_hd__decap_4
XFILLER_0_53_526 vssd1 vssd1 vccd1 vccd1 sky130_ef_sc_hd__decap_12
X_11523_ _05616_ _05617_ vssd1 vssd1 vccd1 vccd1 _05618_ sky130_fd_sc_hd__and2b_1
X_11454_ _05384_ _05432_ _05548_ _05549_ vssd1 vssd1 vccd1 vccd1 _05550_ sky130_fd_sc_hd__o211a_2
XFILLER_0_34_751 vssd1 vssd1 vccd1 vccd1 sky130_fd_sc_hd__decap_4
XFILLER_0_123_447 vssd1 vssd1 vccd1 vccd1 sky130_fd_sc_hd__fill_1
XFILLER_0_111_609 vssd1 vssd1 vccd1 vccd1 sky130_fd_sc_hd__decap_6
X_10405_ _04506_ _04507_ _04355_ _04357_ vssd1 vssd1 vccd1 vccd1 _04509_ sky130_fd_sc_hd__o211a_1
XFILLER_0_80_378 vssd1 vssd1 vccd1 vccd1 sky130_fd_sc_hd__fill_1
XFILLER_0_34_773 vssd1 vssd1 vccd1 vccd1 sky130_fd_sc_hd__fill_2
XFILLER_0_68_29 vssd1 vssd1 vccd1 vccd1 sky130_fd_sc_hd__fill_1
X_11385_ net785 net946 _05364_ _05363_ vssd1 vssd1 vccd1 vccd1 _05481_ sky130_fd_sc_hd__a31o_1
X_13124_ clknet_leaf_2_clk_i _00510_ vssd1 vssd1 vccd1 vccd1 det_t\[17\] sky130_fd_sc_hd__dfxtp_1
X_10336_ _04431_ _04437_ _04438_ vssd1 vssd1 vccd1 vccd1 _04440_ sky130_fd_sc_hd__nand3_1
XTAP_607 vssd1 vccd1 sky130_fd_sc_hd__tapvpwrvgnd_1
X_10267_ _04224_ _04370_ vssd1 vssd1 vccd1 vccd1 _04372_ sky130_fd_sc_hd__xnor2_4
XTAP_618 vssd1 vccd1 sky130_fd_sc_hd__tapvpwrvgnd_1
XTAP_629 vssd1 vccd1 sky130_fd_sc_hd__tapvpwrvgnd_1
X_13055_ clknet_leaf_43_clk_i _00441_ net1181 vssd1 vssd1 vccd1 vccd1 y2my0\[12\]
+ sky130_fd_sc_hd__dfrtp_1
X_12006_ net108 net623 net597 net76 vssd1 vssd1 vccd1 vccd1 _06009_ sky130_fd_sc_hd__a22o_1
X_10198_ _04286_ _04299_ _04301_ vssd1 vssd1 vccd1 vccd1 _04303_ sky130_fd_sc_hd__and3_1
XFILLER_0_17_55 vssd1 vssd1 vccd1 vccd1 sky130_fd_sc_hd__fill_1
XFILLER_0_88_456 vssd1 vssd1 vccd1 vccd1 sky130_fd_sc_hd__decap_6
XFILLER_0_48_309 vssd1 vssd1 vccd1 vccd1 sky130_fd_sc_hd__fill_2
X_12908_ clknet_leaf_43_clk_i _00294_ vssd1 vssd1 vccd1 vccd1 mul1.b\[11\] sky130_fd_sc_hd__dfxtp_2
XFILLER_0_119_709 vssd1 vssd1 vccd1 vccd1 sky130_ef_sc_hd__decap_12
XFILLER_0_29_512 vssd1 vssd1 vccd1 vccd1 sky130_fd_sc_hd__decap_3
XTAP_2091 vssd1 vccd1 sky130_fd_sc_hd__tapvpwrvgnd_1
XTAP_2080 vssd1 vccd1 sky130_fd_sc_hd__tapvpwrvgnd_1
XFILLER_0_56_331 vssd1 vssd1 vccd1 vccd1 sky130_fd_sc_hd__fill_1
X_12839_ clknet_leaf_55_clk_i _00225_ vssd1 vssd1 vccd1 vccd1 sub1.b_i\[6\] sky130_fd_sc_hd__dfxtp_1
XFILLER_0_33_65 vssd1 vssd1 vccd1 vccd1 sky130_ef_sc_hd__decap_12
XTAP_1390 vssd1 vccd1 sky130_fd_sc_hd__tapvpwrvgnd_1
XFILLER_0_71_301 vssd1 vssd1 vccd1 vccd1 sky130_fd_sc_hd__fill_1
XFILLER_0_56_375 vssd1 vssd1 vccd1 vccd1 sky130_fd_sc_hd__fill_1
X_06360_ _00627_ _00671_ _00626_ vssd1 vssd1 vccd1 vccd1 _00672_ sky130_fd_sc_hd__a21o_1
XFILLER_0_33_98 vssd1 vssd1 vccd1 vccd1 sky130_fd_sc_hd__decap_8
XFILLER_0_127_753 vssd1 vssd1 vccd1 vccd1 sky130_ef_sc_hd__decap_12
XFILLER_0_84_695 vssd1 vssd1 vccd1 vccd1 sky130_fd_sc_hd__fill_2
XFILLER_0_83_194 vssd1 vssd1 vccd1 vccd1 sky130_fd_sc_hd__decap_4
X_06291_ net688 vssd1 vssd1 vccd1 vccd1 _00605_ sky130_fd_sc_hd__inv_2
Xinput30 div_sstream_i[5] vssd1 vssd1 vccd1 vccd1 net30 sky130_fd_sc_hd__clkbuf_8
XFILLER_0_127_797 vssd1 vssd1 vccd1 vccd1 sky130_ef_sc_hd__decap_12
X_08030_ _02112_ _02114_ _02147_ _02148_ vssd1 vssd1 vccd1 vccd1 _02150_ sky130_fd_sc_hd__or4_1
XFILLER_0_114_469 vssd1 vssd1 vccd1 vccd1 sky130_fd_sc_hd__decap_6
Xinput41 sstream_i[12] vssd1 vssd1 vccd1 vccd1 net41 sky130_fd_sc_hd__buf_4
XFILLER_0_4_656 vssd1 vssd1 vccd1 vccd1 sky130_fd_sc_hd__fill_1
Xinput63 v0x[14] vssd1 vssd1 vccd1 vccd1 net63 sky130_fd_sc_hd__clkbuf_1
Xinput52 sstream_i[4] vssd1 vssd1 vccd1 vccd1 net52 sky130_fd_sc_hd__buf_4
Xinput85 v0x[5] vssd1 vssd1 vccd1 vccd1 net85 sky130_fd_sc_hd__buf_1
Xinput74 v0x[24] vssd1 vssd1 vccd1 vccd1 net74 sky130_fd_sc_hd__buf_1
Xinput96 v0y[15] vssd1 vssd1 vccd1 vccd1 net96 sky130_fd_sc_hd__buf_1
X_09981_ _04085_ _04086_ vssd1 vssd1 vccd1 vccd1 _04087_ sky130_fd_sc_hd__or2_2
X_08932_ _03035_ _03043_ vssd1 vssd1 vccd1 vccd1 _03045_ sky130_fd_sc_hd__xor2_1
X_08863_ _02969_ _02974_ vssd1 vssd1 vccd1 vccd1 _02976_ sky130_fd_sc_hd__xor2_1
XFILLER_0_35_3 vssd1 vssd1 vccd1 vccd1 sky130_ef_sc_hd__decap_12
XFILLER_0_74_61 vssd1 vssd1 vccd1 vccd1 sky130_fd_sc_hd__fill_2
X_08794_ net885 net980 _02769_ _02770_ net967 vssd1 vssd1 vccd1 vccd1 _02908_ sky130_fd_sc_hd__a32o_1
X_07814_ _01836_ net1755 _01932_ _01934_ vssd1 vssd1 vccd1 vccd1 _01936_ sky130_fd_sc_hd__o211ai_2
X_07745_ _01860_ _01865_ vssd1 vssd1 vccd1 vccd1 _01867_ sky130_fd_sc_hd__xor2_1
X_09415_ _03523_ _03524_ vssd1 vssd1 vccd1 vccd1 _03525_ sky130_fd_sc_hd__nand2_1
X_07676_ _01790_ _01798_ vssd1 vssd1 vccd1 vccd1 _01799_ sky130_fd_sc_hd__and2_1
X_06627_ _00858_ _00861_ vssd1 vssd1 vccd1 vccd1 _00862_ sky130_fd_sc_hd__xnor2_4
X_09346_ _03444_ _03454_ _03455_ vssd1 vssd1 vccd1 vccd1 _03456_ sky130_fd_sc_hd__and3b_2
XFILLER_0_75_662 vssd1 vssd1 vccd1 vccd1 sky130_fd_sc_hd__decap_8
X_06558_ _00603_ _00610_ vssd1 vssd1 vccd1 vccd1 _00805_ sky130_fd_sc_hd__nor2_2
X_06489_ net547 net451 vssd1 vssd1 vccd1 vccd1 net330 sky130_fd_sc_hd__nor2_1
XFILLER_0_74_183 vssd1 vssd1 vccd1 vccd1 sky130_fd_sc_hd__decap_3
XFILLER_0_62_334 vssd1 vssd1 vccd1 vccd1 sky130_fd_sc_hd__fill_2
X_09277_ _03223_ _03231_ _03230_ vssd1 vssd1 vccd1 vccd1 _03388_ sky130_fd_sc_hd__a21bo_1
XFILLER_0_47_386 vssd1 vssd1 vccd1 vccd1 sky130_fd_sc_hd__decap_6
XFILLER_0_118_786 vssd1 vssd1 vccd1 vccd1 sky130_fd_sc_hd__fill_1
XFILLER_0_105_403 vssd1 vssd1 vccd1 vccd1 sky130_fd_sc_hd__decap_4
X_08228_ _02330_ _02344_ _02345_ vssd1 vssd1 vccd1 vccd1 _02346_ sky130_fd_sc_hd__nand3_4
XFILLER_0_35_559 vssd1 vssd1 vccd1 vccd1 sky130_fd_sc_hd__fill_1
XFILLER_0_62_378 vssd1 vssd1 vccd1 vccd1 sky130_fd_sc_hd__fill_2
XFILLER_0_15_272 vssd1 vssd1 vccd1 vccd1 sky130_fd_sc_hd__fill_1
X_08159_ _02062_ _02277_ vssd1 vssd1 vccd1 vccd1 _02278_ sky130_fd_sc_hd__xnor2_4
X_11170_ _05267_ vssd1 vssd1 vccd1 vccd1 _05268_ sky130_fd_sc_hd__inv_2
XFILLER_0_100_141 vssd1 vssd1 vccd1 vccd1 sky130_fd_sc_hd__decap_3
X_10121_ _04109_ _04111_ vssd1 vssd1 vccd1 vccd1 _04226_ sky130_fd_sc_hd__nor2_2
X_10052_ net970 _04157_ _04156_ vssd1 vssd1 vccd1 vccd1 _04158_ sky130_fd_sc_hd__a21bo_1
XFILLER_0_89_209 vssd1 vssd1 vccd1 vccd1 sky130_fd_sc_hd__fill_2
X_10954_ _04920_ _04923_ _05052_ _05053_ vssd1 vssd1 vccd1 vccd1 _05054_ sky130_fd_sc_hd__a211oi_2
X_10885_ net990 net751 net742 net997 vssd1 vssd1 vccd1 vccd1 _04985_ sky130_fd_sc_hd__a22o_1
XFILLER_0_66_651 vssd1 vssd1 vccd1 vccd1 sky130_fd_sc_hd__fill_2
X_12624_ clknet_leaf_48_clk_i _00010_ net1159 vssd1 vssd1 vccd1 vccd1 net427 sky130_fd_sc_hd__dfrtp_2
XFILLER_0_124_701 vssd1 vssd1 vccd1 vccd1 sky130_ef_sc_hd__decap_12
XFILLER_0_109_753 vssd1 vssd1 vccd1 vccd1 sky130_fd_sc_hd__fill_2
X_12555_ net1559 net31 net558 vssd1 vssd1 vccd1 vccd1 _00531_ sky130_fd_sc_hd__mux2_1
XFILLER_0_5_409 vssd1 vssd1 vccd1 vccd1 sky130_fd_sc_hd__fill_1
XFILLER_0_123_211 vssd1 vssd1 vccd1 vccd1 sky130_fd_sc_hd__fill_1
XFILLER_0_109_797 vssd1 vssd1 vccd1 vccd1 sky130_fd_sc_hd__fill_2
XFILLER_0_53_367 vssd1 vssd1 vccd1 vccd1 sky130_ef_sc_hd__decap_12
X_11506_ _05456_ _05459_ _05600_ vssd1 vssd1 vccd1 vccd1 _05601_ sky130_fd_sc_hd__a21oi_2
X_12486_ _00784_ net568 vssd1 vssd1 vccd1 vccd1 _06240_ sky130_fd_sc_hd__nand2_1
XFILLER_0_123_222 vssd1 vssd1 vccd1 vccd1 sky130_fd_sc_hd__fill_2
XFILLER_0_111_417 vssd1 vssd1 vccd1 vccd1 sky130_ef_sc_hd__decap_12
XFILLER_0_80_197 vssd1 vssd1 vccd1 vccd1 sky130_fd_sc_hd__fill_2
XFILLER_0_1_615 vssd1 vssd1 vccd1 vccd1 sky130_fd_sc_hd__fill_1
X_11437_ _05531_ _05532_ vssd1 vssd1 vccd1 vccd1 _05533_ sky130_fd_sc_hd__nor2_1
X_11368_ net747 net969 net963 net751 vssd1 vssd1 vccd1 vccd1 _05464_ sky130_fd_sc_hd__a22o_1
X_13107_ clknet_leaf_2_clk_i _00493_ vssd1 vssd1 vccd1 vccd1 det_t\[0\] sky130_fd_sc_hd__dfxtp_1
XFILLER_0_95_27 vssd1 vssd1 vccd1 vccd1 sky130_ef_sc_hd__decap_12
X_10319_ _04400_ _04418_ _04420_ vssd1 vssd1 vccd1 vccd1 _04423_ sky130_fd_sc_hd__or3_1
XTAP_415 vssd1 vccd1 sky130_fd_sc_hd__tapvpwrvgnd_1
XTAP_404 vssd1 vccd1 sky130_fd_sc_hd__tapvpwrvgnd_1
XFILLER_0_0_169 vssd1 vssd1 vccd1 vccd1 sky130_fd_sc_hd__fill_2
XTAP_426 vssd1 vccd1 sky130_fd_sc_hd__tapvpwrvgnd_1
XTAP_437 vssd1 vccd1 sky130_fd_sc_hd__tapvpwrvgnd_1
XTAP_448 vssd1 vccd1 sky130_fd_sc_hd__tapvpwrvgnd_1
X_11299_ net1036 net697 net694 net1045 vssd1 vssd1 vccd1 vccd1 _05396_ sky130_fd_sc_hd__o2bb2a_1
XTAP_459 vssd1 vccd1 sky130_fd_sc_hd__tapvpwrvgnd_1
Xfanout1150 state\[1\] vssd1 vssd1 vccd1 vccd1 net1150 sky130_fd_sc_hd__buf_2
X_13038_ clknet_leaf_31_clk_i _00424_ net1169 vssd1 vssd1 vccd1 vccd1 x0mx2\[27\]
+ sky130_fd_sc_hd__dfrtp_1
Xfanout1183 net1185 vssd1 vssd1 vccd1 vccd1 net1183 sky130_fd_sc_hd__clkbuf_2
Xfanout1161 net1162 vssd1 vssd1 vccd1 vccd1 net1161 sky130_fd_sc_hd__clkbuf_4
Xfanout1172 net1173 vssd1 vssd1 vccd1 vccd1 net1172 sky130_fd_sc_hd__clkbuf_4
Xfanout1194 net1195 vssd1 vssd1 vccd1 vccd1 net1194 sky130_fd_sc_hd__buf_2
XFILLER_0_49_607 vssd1 vssd1 vccd1 vccd1 sky130_fd_sc_hd__fill_1
X_07530_ _01586_ _01614_ vssd1 vssd1 vccd1 vccd1 _01655_ sky130_fd_sc_hd__xnor2_1
XFILLER_0_88_253 vssd1 vssd1 vccd1 vccd1 sky130_fd_sc_hd__fill_2
XFILLER_0_48_106 vssd1 vssd1 vccd1 vccd1 sky130_fd_sc_hd__decap_4
XFILLER_0_119_517 vssd1 vssd1 vccd1 vccd1 sky130_ef_sc_hd__decap_12
XFILLER_0_8_203 vssd1 vssd1 vccd1 vccd1 sky130_fd_sc_hd__fill_2
X_07461_ _01575_ _01582_ vssd1 vssd1 vccd1 vccd1 _01586_ sky130_fd_sc_hd__xnor2_1
X_09200_ net1054 net1063 net780 net770 vssd1 vssd1 vccd1 vccd1 _03311_ sky130_fd_sc_hd__and4_1
X_06412_ _00714_ _00716_ vssd1 vssd1 vccd1 vccd1 _00717_ sky130_fd_sc_hd__nand2_1
X_07392_ net904 net1112 vssd1 vssd1 vccd1 vccd1 _01517_ sky130_fd_sc_hd__and2_1
X_09131_ _03207_ _03208_ _03240_ _03241_ vssd1 vssd1 vccd1 vccd1 _03243_ sky130_fd_sc_hd__nor4_1
XFILLER_0_72_621 vssd1 vssd1 vccd1 vccd1 sky130_fd_sc_hd__decap_4
XFILLER_0_60_52 vssd1 vssd1 vccd1 vccd1 sky130_fd_sc_hd__decap_6
XFILLER_0_56_172 vssd1 vssd1 vccd1 vccd1 sky130_fd_sc_hd__decap_4
X_06343_ _00643_ _00654_ _00642_ vssd1 vssd1 vccd1 vccd1 _00655_ sky130_fd_sc_hd__o21a_2
XFILLER_0_8_269 vssd1 vssd1 vccd1 vccd1 sky130_fd_sc_hd__fill_2
XFILLER_0_127_561 vssd1 vssd1 vccd1 vccd1 sky130_ef_sc_hd__decap_12
X_09062_ net1052 net784 vssd1 vssd1 vccd1 vccd1 _03174_ sky130_fd_sc_hd__and2_1
XFILLER_0_60_85 vssd1 vssd1 vccd1 vccd1 sky130_fd_sc_hd__decap_4
XFILLER_0_114_233 vssd1 vssd1 vccd1 vccd1 sky130_ef_sc_hd__decap_12
X_06274_ net1027 vssd1 vssd1 vccd1 vccd1 _00590_ sky130_fd_sc_hd__inv_2
XFILLER_0_114_277 vssd1 vssd1 vccd1 vccd1 sky130_ef_sc_hd__decap_12
X_08013_ net912 net986 net979 net920 vssd1 vssd1 vccd1 vccd1 _02133_ sky130_fd_sc_hd__a22o_1
XFILLER_0_8_53 vssd1 vssd1 vccd1 vccd1 sky130_ef_sc_hd__decap_12
XFILLER_0_4_475 vssd1 vssd1 vccd1 vccd1 sky130_fd_sc_hd__fill_1
X_09964_ _03928_ _03948_ _03947_ vssd1 vssd1 vccd1 vccd1 _04070_ sky130_fd_sc_hd__o21ba_2
XFILLER_0_0_670 vssd1 vssd1 vccd1 vccd1 sky130_fd_sc_hd__fill_2
X_08915_ _02878_ _02881_ _03025_ _03026_ vssd1 vssd1 vccd1 vccd1 _03028_ sky130_fd_sc_hd__o211a_1
X_09895_ net833 net971 _03998_ _03999_ vssd1 vssd1 vccd1 vccd1 _04002_ sky130_fd_sc_hd__a22oi_2
XTAP_971 vssd1 vccd1 sky130_fd_sc_hd__tapvpwrvgnd_1
XTAP_960 vssd1 vccd1 sky130_fd_sc_hd__tapvpwrvgnd_1
X_08846_ _02808_ _02959_ vssd1 vssd1 vccd1 vccd1 _02960_ sky130_fd_sc_hd__xnor2_2
XTAP_993 vssd1 vccd1 sky130_fd_sc_hd__tapvpwrvgnd_1
XTAP_982 vssd1 vccd1 sky130_fd_sc_hd__tapvpwrvgnd_1
X_08777_ _02887_ _02890_ vssd1 vssd1 vccd1 vccd1 _02891_ sky130_fd_sc_hd__xor2_1
X_07728_ _01403_ _01753_ _01752_ vssd1 vssd1 vccd1 vccd1 _01851_ sky130_fd_sc_hd__a21oi_1
XFILLER_0_94_223 vssd1 vssd1 vccd1 vccd1 sky130_fd_sc_hd__fill_1
XFILLER_0_67_437 vssd1 vssd1 vccd1 vccd1 sky130_fd_sc_hd__fill_1
X_07659_ _01699_ _01702_ _01780_ vssd1 vssd1 vccd1 vccd1 _01782_ sky130_fd_sc_hd__or3_1
XFILLER_0_82_418 vssd1 vssd1 vccd1 vccd1 sky130_fd_sc_hd__fill_2
X_10670_ net1029 net737 _04567_ _04568_ net753 vssd1 vssd1 vccd1 vccd1 _04772_ sky130_fd_sc_hd__a32oi_4
XFILLER_0_48_662 vssd1 vssd1 vccd1 vccd1 sky130_fd_sc_hd__decap_3
X_09329_ _03432_ _03438_ vssd1 vssd1 vccd1 vccd1 _03439_ sky130_fd_sc_hd__nand2_1
XFILLER_0_63_632 vssd1 vssd1 vccd1 vccd1 sky130_fd_sc_hd__fill_2
XFILLER_0_47_150 vssd1 vssd1 vccd1 vccd1 sky130_fd_sc_hd__decap_3
X_12340_ net1642 _00951_ net673 vssd1 vssd1 vccd1 vccd1 _00392_ sky130_fd_sc_hd__mux2_1
X_12271_ net1341 net49 net689 vssd1 vssd1 vccd1 vccd1 _00325_ sky130_fd_sc_hd__mux2_1
X_11222_ _05200_ _05204_ _05199_ vssd1 vssd1 vccd1 vccd1 _05320_ sky130_fd_sc_hd__a21oi_1
XFILLER_0_101_483 vssd1 vssd1 vccd1 vccd1 sky130_fd_sc_hd__decap_4
X_11153_ _05242_ _05250_ vssd1 vssd1 vccd1 vccd1 _05251_ sky130_fd_sc_hd__nand2_1
X_10104_ _03953_ _04050_ _04049_ vssd1 vssd1 vccd1 vccd1 _04210_ sky130_fd_sc_hd__a21oi_2
X_11084_ _05180_ _05181_ _05016_ _05019_ vssd1 vssd1 vccd1 vccd1 _05183_ sky130_fd_sc_hd__a211o_1
Xinput220 v2y[11] vssd1 vssd1 vccd1 vccd1 net220 sky130_fd_sc_hd__buf_1
X_10035_ _04139_ _04140_ _04132_ vssd1 vssd1 vccd1 vccd1 _04141_ sky130_fd_sc_hd__a21o_1
Xinput242 v2y[31] vssd1 vssd1 vccd1 vccd1 net242 sky130_fd_sc_hd__buf_1
Xinput231 v2y[21] vssd1 vssd1 vccd1 vccd1 net231 sky130_fd_sc_hd__buf_1
XFILLER_0_98_573 vssd1 vssd1 vccd1 vccd1 sky130_ef_sc_hd__decap_12
X_11986_ net103 net622 net596 net71 vssd1 vssd1 vccd1 vccd1 _05994_ sky130_fd_sc_hd__a22o_1
XFILLER_0_85_223 vssd1 vssd1 vccd1 vccd1 sky130_fd_sc_hd__fill_1
X_10937_ _04902_ _04908_ _05036_ vssd1 vssd1 vccd1 vccd1 _05037_ sky130_fd_sc_hd__o21a_1
XFILLER_0_58_437 vssd1 vssd1 vccd1 vccd1 sky130_fd_sc_hd__fill_1
XFILLER_0_129_837 vssd1 vssd1 vccd1 vccd1 sky130_fd_sc_hd__decap_3
XFILLER_0_105_69 vssd1 vssd1 vccd1 vccd1 sky130_ef_sc_hd__decap_12
XFILLER_0_85_278 vssd1 vssd1 vccd1 vccd1 sky130_fd_sc_hd__fill_2
XFILLER_0_39_640 vssd1 vssd1 vccd1 vccd1 sky130_fd_sc_hd__decap_8
XFILLER_0_39_662 vssd1 vssd1 vccd1 vccd1 sky130_fd_sc_hd__decap_8
X_12607_ net1376 net19 net555 vssd1 vssd1 vccd1 vccd1 _00582_ sky130_fd_sc_hd__mux2_1
X_10868_ net836 net934 vssd1 vssd1 vccd1 vccd1 _04968_ sky130_fd_sc_hd__nand2_1
XFILLER_0_39_673 vssd1 vssd1 vccd1 vccd1 sky130_fd_sc_hd__fill_1
XFILLER_0_109_561 vssd1 vssd1 vccd1 vccd1 sky130_ef_sc_hd__decap_12
X_10799_ _04898_ _04899_ vssd1 vssd1 vccd1 vccd1 _04900_ sky130_fd_sc_hd__xnor2_1
X_12538_ net1233 net565 vssd1 vssd1 vccd1 vccd1 _06266_ sky130_fd_sc_hd__nand2_1
XFILLER_0_124_531 vssd1 vssd1 vccd1 vccd1 sky130_fd_sc_hd__fill_1
XFILLER_0_121_57 vssd1 vssd1 vccd1 vccd1 sky130_ef_sc_hd__decap_12
X_12469_ temp1\[25\] _06230_ net572 vssd1 vssd1 vccd1 vccd1 _00486_ sky130_fd_sc_hd__mux2_1
XFILLER_0_112_737 vssd1 vssd1 vccd1 vccd1 sky130_ef_sc_hd__decap_12
XFILLER_0_111_225 vssd1 vssd1 vccd1 vccd1 sky130_ef_sc_hd__decap_12
XFILLER_0_22_584 vssd1 vssd1 vccd1 vccd1 sky130_fd_sc_hd__decap_4
XFILLER_0_120_781 vssd1 vssd1 vccd1 vccd1 sky130_ef_sc_hd__decap_12
XFILLER_0_10_757 vssd1 vssd1 vccd1 vccd1 sky130_fd_sc_hd__decap_8
X_06961_ net919 net911 net1049 net1057 vssd1 vssd1 vccd1 vccd1 _01086_ sky130_fd_sc_hd__and4_1
X_09680_ _03786_ _03787_ vssd1 vssd1 vccd1 vccd1 _03788_ sky130_fd_sc_hd__nor2_2
X_08700_ _02541_ _02671_ vssd1 vssd1 vccd1 vccd1 _02815_ sky130_fd_sc_hd__or2_1
XTAP_267 vssd1 vccd1 sky130_fd_sc_hd__tapvpwrvgnd_1
XTAP_278 vssd1 vccd1 sky130_fd_sc_hd__tapvpwrvgnd_1
XTAP_289 vssd1 vccd1 sky130_fd_sc_hd__tapvpwrvgnd_1
X_08631_ _02744_ _02745_ vssd1 vssd1 vccd1 vccd1 _02746_ sky130_fd_sc_hd__nor2_1
X_06892_ net1143 _01016_ vssd1 vssd1 vccd1 vccd1 _01017_ sky130_fd_sc_hd__nand2_1
XFILLER_0_55_85 vssd1 vssd1 vccd1 vccd1 sky130_fd_sc_hd__decap_6
XFILLER_0_55_74 vssd1 vssd1 vccd1 vccd1 sky130_fd_sc_hd__fill_1
X_08562_ _02565_ _02572_ _02571_ vssd1 vssd1 vccd1 vccd1 _02677_ sky130_fd_sc_hd__a21oi_1
XFILLER_0_77_713 vssd1 vssd1 vccd1 vccd1 sky130_ef_sc_hd__decap_12
X_08493_ _02605_ _02606_ _02607_ vssd1 vssd1 vccd1 vccd1 _02609_ sky130_fd_sc_hd__a21o_1
XFILLER_0_76_234 vssd1 vssd1 vccd1 vccd1 sky130_fd_sc_hd__fill_2
X_07513_ net905 net1138 _01622_ _01623_ vssd1 vssd1 vccd1 vccd1 _01638_ sky130_fd_sc_hd__a22o_1
XFILLER_0_64_407 vssd1 vssd1 vccd1 vccd1 sky130_fd_sc_hd__decap_4
X_07444_ _01562_ _01568_ vssd1 vssd1 vccd1 vccd1 _01569_ sky130_fd_sc_hd__nand2b_1
XFILLER_0_17_312 vssd1 vssd1 vccd1 vccd1 sky130_fd_sc_hd__fill_2
XFILLER_0_17_334 vssd1 vssd1 vccd1 vccd1 sky130_fd_sc_hd__fill_2
X_07375_ _01485_ _01492_ _01499_ vssd1 vssd1 vccd1 vccd1 _01500_ sky130_fd_sc_hd__o21ai_1
X_09114_ net923 net915 net939 net937 vssd1 vssd1 vccd1 vccd1 _03226_ sky130_fd_sc_hd__nand4_1
X_06326_ add1.a_i\[6\] add1.b_i\[6\] vssd1 vssd1 vccd1 vccd1 _00638_ sky130_fd_sc_hd__xnor2_1
XFILLER_0_115_553 vssd1 vssd1 vccd1 vccd1 sky130_fd_sc_hd__decap_6
X_09045_ _03155_ _03156_ vssd1 vssd1 vccd1 vccd1 _03157_ sky130_fd_sc_hd__or2_1
XFILLER_0_115_597 vssd1 vssd1 vccd1 vccd1 sky130_ef_sc_hd__decap_12
XFILLER_0_32_359 vssd1 vssd1 vccd1 vccd1 sky130_fd_sc_hd__fill_1
XFILLER_0_130_578 vssd1 vssd1 vccd1 vccd1 sky130_fd_sc_hd__fill_2
Xhold463 y1my2\[23\] vssd1 vssd1 vccd1 vccd1 net1678 sky130_fd_sc_hd__dlygate4sd3_1
Xhold430 x2mx1\[4\] vssd1 vssd1 vccd1 vccd1 net1645 sky130_fd_sc_hd__dlygate4sd3_1
Xhold452 y1my2\[5\] vssd1 vssd1 vccd1 vccd1 net1667 sky130_fd_sc_hd__dlygate4sd3_1
Xhold441 x2mx1\[8\] vssd1 vssd1 vccd1 vccd1 net1656 sky130_fd_sc_hd__dlygate4sd3_1
XFILLER_0_40_381 vssd1 vssd1 vccd1 vccd1 sky130_fd_sc_hd__fill_2
XFILLER_0_130_589 vssd1 vssd1 vccd1 vccd1 sky130_fd_sc_hd__fill_1
Xhold485 sub1.b_i\[9\] vssd1 vssd1 vccd1 vccd1 net1700 sky130_fd_sc_hd__dlygate4sd3_1
Xhold474 x2mx1\[7\] vssd1 vssd1 vccd1 vccd1 net1689 sky130_fd_sc_hd__dlygate4sd3_1
Xhold496 temp1\[1\] vssd1 vssd1 vccd1 vccd1 net1711 sky130_fd_sc_hd__dlygate4sd3_1
X_09947_ _04051_ _04052_ vssd1 vssd1 vccd1 vccd1 _04054_ sky130_fd_sc_hd__xnor2_4
Xfanout921 net922 vssd1 vssd1 vccd1 vccd1 net921 sky130_fd_sc_hd__buf_2
Xfanout932 net933 vssd1 vssd1 vccd1 vccd1 net932 sky130_fd_sc_hd__clkbuf_2
Xfanout910 net911 vssd1 vssd1 vccd1 vccd1 net910 sky130_fd_sc_hd__clkbuf_4
Xfanout943 mul1.a\[28\] vssd1 vssd1 vccd1 vccd1 net943 sky130_fd_sc_hd__clkbuf_2
Xfanout976 net977 vssd1 vssd1 vccd1 vccd1 net976 sky130_fd_sc_hd__buf_2
Xfanout965 net966 vssd1 vssd1 vccd1 vccd1 net965 sky130_fd_sc_hd__clkbuf_2
Xfanout954 mul1.a\[26\] vssd1 vssd1 vccd1 vccd1 net954 sky130_fd_sc_hd__buf_2
XFILLER_0_99_337 vssd1 vssd1 vccd1 vccd1 sky130_fd_sc_hd__decap_8
X_09878_ _03969_ _03982_ _03983_ vssd1 vssd1 vccd1 vccd1 _03985_ sky130_fd_sc_hd__and3_1
Xfanout998 mul1.a\[19\] vssd1 vssd1 vccd1 vccd1 net998 sky130_fd_sc_hd__clkbuf_4
Xfanout987 net988 vssd1 vssd1 vccd1 vccd1 net987 sky130_fd_sc_hd__clkbuf_2
XTAP_790 vssd1 vccd1 sky130_fd_sc_hd__tapvpwrvgnd_1
X_08829_ _02904_ _02905_ _02939_ _02940_ vssd1 vssd1 vccd1 vccd1 _02943_ sky130_fd_sc_hd__or4_1
XTAP_1901 vssd1 vccd1 sky130_fd_sc_hd__tapvpwrvgnd_1
X_11840_ net232 net601 net581 net136 _05878_ vssd1 vssd1 vccd1 vccd1 _05879_ sky130_fd_sc_hd__a221o_1
XTAP_1934 vssd1 vccd1 sky130_fd_sc_hd__tapvpwrvgnd_1
XTAP_1923 vssd1 vccd1 sky130_fd_sc_hd__tapvpwrvgnd_1
XTAP_1912 vssd1 vccd1 sky130_fd_sc_hd__tapvpwrvgnd_1
XFILLER_0_68_757 vssd1 vssd1 vccd1 vccd1 sky130_fd_sc_hd__decap_4
X_11771_ net1280 _05820_ net479 vssd1 vssd1 vccd1 vccd1 _00198_ sky130_fd_sc_hd__mux2_1
XTAP_1967 vssd1 vccd1 sky130_fd_sc_hd__tapvpwrvgnd_1
XTAP_1956 vssd1 vccd1 sky130_fd_sc_hd__tapvpwrvgnd_1
XTAP_1945 vssd1 vccd1 sky130_fd_sc_hd__tapvpwrvgnd_1
XFILLER_0_83_716 vssd1 vssd1 vccd1 vccd1 sky130_ef_sc_hd__decap_12
X_10722_ _04676_ _04677_ _04822_ vssd1 vssd1 vccd1 vccd1 _04823_ sky130_fd_sc_hd__a21o_1
XTAP_1989 vssd1 vccd1 sky130_fd_sc_hd__tapvpwrvgnd_1
XTAP_1978 vssd1 vccd1 sky130_fd_sc_hd__tapvpwrvgnd_1
XFILLER_0_82_237 vssd1 vssd1 vccd1 vccd1 sky130_fd_sc_hd__decap_4
X_10653_ _04753_ _04754_ net1070 net704 vssd1 vssd1 vccd1 vccd1 _04755_ sky130_fd_sc_hd__and4bb_1
XFILLER_0_36_632 vssd1 vssd1 vccd1 vccd1 sky130_ef_sc_hd__decap_12
X_10584_ net816 net953 net947 net824 vssd1 vssd1 vccd1 vccd1 _04686_ sky130_fd_sc_hd__a22o_1
XFILLER_0_63_495 vssd1 vssd1 vccd1 vccd1 sky130_fd_sc_hd__decap_8
XFILLER_0_51_646 vssd1 vssd1 vccd1 vccd1 sky130_fd_sc_hd__fill_2
XFILLER_0_23_337 vssd1 vssd1 vccd1 vccd1 sky130_fd_sc_hd__fill_1
X_12323_ net1668 _00862_ net666 vssd1 vssd1 vccd1 vccd1 _00375_ sky130_fd_sc_hd__mux2_1
X_12254_ net702 _06189_ net518 vssd1 vssd1 vccd1 vccd1 _00312_ sky130_fd_sc_hd__mux2_1
XFILLER_0_76_29 vssd1 vssd1 vccd1 vccd1 sky130_fd_sc_hd__decap_8
X_11205_ _05302_ vssd1 vssd1 vccd1 vccd1 _05303_ sky130_fd_sc_hd__inv_2
X_12185_ net1702 _06143_ net513 vssd1 vssd1 vccd1 vccd1 _00289_ sky130_fd_sc_hd__mux2_1
XFILLER_0_101_291 vssd1 vssd1 vccd1 vccd1 sky130_fd_sc_hd__fill_1
X_11136_ net757 net969 vssd1 vssd1 vccd1 vccd1 _05234_ sky130_fd_sc_hd__nand2_1
X_11067_ net1019 net717 _05163_ _05164_ vssd1 vssd1 vccd1 vccd1 _05166_ sky130_fd_sc_hd__o2bb2a_1
X_10018_ net1021 net1013 net778 net768 vssd1 vssd1 vccd1 vccd1 _04124_ sky130_fd_sc_hd__nand4_1
Xclkbuf_3_5__f_clk_i clknet_0_clk_i vssd1 vssd1 vccd1 vccd1 clknet_3_5__leaf_clk_i
+ sky130_fd_sc_hd__clkbuf_16
XFILLER_0_58_234 vssd1 vssd1 vccd1 vccd1 sky130_fd_sc_hd__fill_1
XFILLER_0_25_55 vssd1 vssd1 vccd1 vccd1 sky130_fd_sc_hd__fill_1
X_11969_ net1352 _05981_ net481 vssd1 vssd1 vccd1 vccd1 _00235_ sky130_fd_sc_hd__mux2_1
XFILLER_0_25_99 vssd1 vssd1 vccd1 vccd1 sky130_ef_sc_hd__decap_12
XFILLER_0_86_587 vssd1 vssd1 vccd1 vccd1 sky130_fd_sc_hd__fill_1
XFILLER_0_73_259 vssd1 vssd1 vccd1 vccd1 sky130_fd_sc_hd__fill_2
XFILLER_0_27_654 vssd1 vssd1 vccd1 vccd1 sky130_fd_sc_hd__fill_2
XFILLER_0_41_43 vssd1 vssd1 vccd1 vccd1 sky130_fd_sc_hd__decap_4
XFILLER_0_109_391 vssd1 vssd1 vccd1 vccd1 sky130_fd_sc_hd__fill_1
X_07160_ _01283_ _01284_ vssd1 vssd1 vccd1 vccd1 _01285_ sky130_fd_sc_hd__xor2_1
XFILLER_0_112_501 vssd1 vssd1 vccd1 vccd1 sky130_ef_sc_hd__decap_12
X_07091_ _01209_ _01210_ _01215_ vssd1 vssd1 vccd1 vccd1 _01216_ sky130_fd_sc_hd__nand3_1
XFILLER_0_26_197 vssd1 vssd1 vccd1 vccd1 sky130_fd_sc_hd__decap_8
XFILLER_0_41_167 vssd1 vssd1 vccd1 vccd1 sky130_fd_sc_hd__fill_1
XFILLER_0_112_545 vssd1 vssd1 vccd1 vccd1 sky130_ef_sc_hd__decap_12
XFILLER_0_100_707 vssd1 vssd1 vccd1 vccd1 sky130_ef_sc_hd__decap_12
XFILLER_0_112_589 vssd1 vssd1 vccd1 vccd1 sky130_ef_sc_hd__decap_12
X_09801_ _03794_ _03796_ vssd1 vssd1 vccd1 vccd1 _03908_ sky130_fd_sc_hd__or2_4
X_09732_ net841 net971 net962 net850 vssd1 vssd1 vccd1 vccd1 _03840_ sky130_fd_sc_hd__a22o_1
X_07993_ _01997_ _01999_ _02110_ _02111_ vssd1 vssd1 vccd1 vccd1 _02113_ sky130_fd_sc_hd__o211ai_2
XFILLER_0_10_598 vssd1 vssd1 vccd1 vccd1 sky130_fd_sc_hd__decap_4
X_06944_ net919 net911 net1065 net1073 vssd1 vssd1 vccd1 vccd1 _01069_ sky130_fd_sc_hd__nand4_2
X_09663_ _03770_ vssd1 vssd1 vccd1 vccd1 _03771_ sky130_fd_sc_hd__inv_2
XFILLER_0_97_819 vssd1 vssd1 vccd1 vccd1 sky130_fd_sc_hd__fill_1
X_06875_ state\[1\] _00604_ _00608_ vssd1 vssd1 vccd1 vccd1 _01004_ sky130_fd_sc_hd__a21o_1
X_08614_ _02727_ _02728_ _02714_ vssd1 vssd1 vccd1 vccd1 _02729_ sky130_fd_sc_hd__o21ba_1
X_09594_ _03694_ _03702_ vssd1 vssd1 vccd1 vccd1 _03703_ sky130_fd_sc_hd__xor2_1
XFILLER_0_89_381 vssd1 vssd1 vccd1 vccd1 sky130_fd_sc_hd__decap_6
X_08545_ _02560_ _02658_ _02660_ vssd1 vssd1 vccd1 vccd1 _02661_ sky130_fd_sc_hd__and3_1
XFILLER_0_77_510 vssd1 vssd1 vccd1 vccd1 sky130_fd_sc_hd__decap_8
XTAP_1219 vssd1 vccd1 sky130_fd_sc_hd__tapvpwrvgnd_1
XTAP_1208 vssd1 vccd1 sky130_fd_sc_hd__tapvpwrvgnd_1
XFILLER_0_119_111 vssd1 vssd1 vccd1 vccd1 sky130_fd_sc_hd__fill_1
X_08476_ _02481_ _02484_ _02590_ _02591_ vssd1 vssd1 vccd1 vccd1 _02592_ sky130_fd_sc_hd__a211oi_2
XFILLER_0_108_829 vssd1 vssd1 vccd1 vccd1 sky130_fd_sc_hd__decap_4
XFILLER_0_64_259 vssd1 vssd1 vccd1 vccd1 sky130_fd_sc_hd__fill_1
X_07427_ _01546_ _01551_ vssd1 vssd1 vccd1 vccd1 _01552_ sky130_fd_sc_hd__or2_1
XFILLER_0_18_654 vssd1 vssd1 vccd1 vccd1 sky130_fd_sc_hd__fill_2
X_07358_ net880 net1118 _01475_ _01474_ vssd1 vssd1 vccd1 vccd1 _01483_ sky130_fd_sc_hd__a31o_1
XFILLER_0_122_309 vssd1 vssd1 vccd1 vccd1 sky130_ef_sc_hd__decap_12
XFILLER_0_73_793 vssd1 vssd1 vccd1 vccd1 sky130_fd_sc_hd__fill_2
XFILLER_0_60_421 vssd1 vssd1 vccd1 vccd1 sky130_fd_sc_hd__decap_6
X_06309_ add1.a_i\[12\] add1.b_i\[12\] vssd1 vssd1 vccd1 vccd1 _00621_ sky130_fd_sc_hd__nand2_1
XFILLER_0_45_495 vssd1 vssd1 vccd1 vccd1 sky130_fd_sc_hd__fill_2
XFILLER_0_115_361 vssd1 vssd1 vccd1 vccd1 sky130_ef_sc_hd__decap_12
X_07289_ _01411_ _01412_ _01410_ vssd1 vssd1 vccd1 vccd1 _01414_ sky130_fd_sc_hd__a21bo_1
XFILLER_0_33_657 vssd1 vssd1 vccd1 vccd1 sky130_fd_sc_hd__fill_1
X_09028_ _02975_ _02977_ _03136_ _03138_ vssd1 vssd1 vccd1 vccd1 _03140_ sky130_fd_sc_hd__a211oi_1
XFILLER_0_103_556 vssd1 vssd1 vccd1 vccd1 sky130_fd_sc_hd__decap_4
Xhold260 net434 vssd1 vssd1 vccd1 vccd1 net1475 sky130_fd_sc_hd__dlygate4sd3_1
Xhold271 y2my0\[16\] vssd1 vssd1 vccd1 vccd1 net1486 sky130_fd_sc_hd__dlygate4sd3_1
XFILLER_0_41_690 vssd1 vssd1 vccd1 vccd1 sky130_fd_sc_hd__decap_4
Xhold293 net433 vssd1 vssd1 vccd1 vccd1 net1508 sky130_fd_sc_hd__dlygate4sd3_1
Xhold282 l1\[10\] vssd1 vssd1 vccd1 vccd1 net1497 sky130_fd_sc_hd__dlygate4sd3_1
Xclkbuf_leaf_9_clk_i clknet_3_6__leaf_clk_i vssd1 vssd1 vccd1 vccd1 clknet_leaf_9_clk_i
+ sky130_fd_sc_hd__clkbuf_16
Xfanout740 net747 vssd1 vssd1 vccd1 vccd1 net740 sky130_fd_sc_hd__clkbuf_4
Xfanout751 mul1.b\[21\] vssd1 vssd1 vccd1 vccd1 net751 sky130_fd_sc_hd__clkbuf_4
Xfanout773 net774 vssd1 vssd1 vccd1 vccd1 net773 sky130_fd_sc_hd__buf_4
Xfanout784 net785 vssd1 vssd1 vccd1 vccd1 net784 sky130_fd_sc_hd__clkbuf_4
Xfanout762 mul1.b\[20\] vssd1 vssd1 vccd1 vccd1 net762 sky130_fd_sc_hd__buf_4
X_12941_ clknet_leaf_9_clk_i _00327_ net1191 vssd1 vssd1 vccd1 vccd1 posy\[3\] sky130_fd_sc_hd__dfrtp_1
XFILLER_0_99_123 vssd1 vssd1 vccd1 vccd1 sky130_ef_sc_hd__decap_12
Xfanout795 net797 vssd1 vssd1 vccd1 vccd1 net795 sky130_fd_sc_hd__clkbuf_4
X_12872_ clknet_leaf_53_clk_i _00258_ vssd1 vssd1 vccd1 vccd1 mul1.a\[7\] sky130_fd_sc_hd__dfxtp_2
X_11823_ net1318 _05864_ net481 vssd1 vssd1 vccd1 vccd1 _00206_ sky130_fd_sc_hd__mux2_1
XTAP_1742 vssd1 vccd1 sky130_fd_sc_hd__tapvpwrvgnd_1
XTAP_1731 vssd1 vccd1 sky130_fd_sc_hd__tapvpwrvgnd_1
XTAP_1720 vssd1 vccd1 sky130_fd_sc_hd__tapvpwrvgnd_1
XTAP_1775 vssd1 vccd1 sky130_fd_sc_hd__tapvpwrvgnd_1
XTAP_1764 vssd1 vccd1 sky130_fd_sc_hd__tapvpwrvgnd_1
XTAP_1753 vssd1 vccd1 sky130_fd_sc_hd__tapvpwrvgnd_1
X_11754_ net89 net674 net607 net217 vssd1 vssd1 vccd1 vccd1 _05806_ sky130_fd_sc_hd__a22o_1
XTAP_1797 vssd1 vccd1 sky130_fd_sc_hd__tapvpwrvgnd_1
XTAP_1786 vssd1 vccd1 sky130_fd_sc_hd__tapvpwrvgnd_1
X_10705_ _04804_ _04805_ _04624_ _04626_ vssd1 vssd1 vccd1 vccd1 _04807_ sky130_fd_sc_hd__a211o_1
X_11685_ net1660 _04671_ net539 vssd1 vssd1 vccd1 vccd1 _00177_ sky130_fd_sc_hd__mux2_1
XFILLER_0_125_125 vssd1 vssd1 vccd1 vccd1 sky130_ef_sc_hd__decap_12
XFILLER_0_102_15 vssd1 vssd1 vccd1 vccd1 sky130_ef_sc_hd__decap_12
X_10636_ _04589_ _04592_ _04736_ vssd1 vssd1 vccd1 vccd1 _04738_ sky130_fd_sc_hd__nand3_1
XFILLER_0_24_613 vssd1 vssd1 vccd1 vccd1 sky130_fd_sc_hd__decap_4
XFILLER_0_125_169 vssd1 vssd1 vccd1 vccd1 sky130_fd_sc_hd__fill_1
XFILLER_0_63_281 vssd1 vssd1 vccd1 vccd1 sky130_ef_sc_hd__decap_12
XFILLER_0_51_432 vssd1 vssd1 vccd1 vccd1 sky130_fd_sc_hd__fill_1
XFILLER_0_11_57 vssd1 vssd1 vccd1 vccd1 sky130_ef_sc_hd__decap_12
XFILLER_0_106_361 vssd1 vssd1 vccd1 vccd1 sky130_fd_sc_hd__decap_3
X_10567_ _04380_ _04669_ _04667_ vssd1 vssd1 vccd1 vccd1 _04670_ sky130_fd_sc_hd__o21ba_2
XFILLER_0_12_808 vssd1 vssd1 vccd1 vccd1 sky130_fd_sc_hd__decap_4
XFILLER_0_87_39 vssd1 vssd1 vccd1 vccd1 sky130_ef_sc_hd__decap_12
X_10498_ _04597_ _04599_ _04461_ _04464_ vssd1 vssd1 vccd1 vccd1 _04601_ sky130_fd_sc_hd__a211o_1
X_12306_ net1640 _00940_ net679 vssd1 vssd1 vccd1 vccd1 _00358_ sky130_fd_sc_hd__mux2_1
X_12237_ x2mx1\[24\] net605 net587 temp1\[24\] vssd1 vssd1 vccd1 vccd1 _06178_ sky130_fd_sc_hd__a22o_1
XFILLER_0_20_841 vssd1 vssd1 vccd1 vccd1 sky130_fd_sc_hd__fill_1
X_12168_ x2mx1\[1\] net602 net584 temp1\[1\] vssd1 vssd1 vccd1 vccd1 _06132_ sky130_fd_sc_hd__a22o_1
X_11119_ _04960_ _05215_ vssd1 vssd1 vccd1 vccd1 _05217_ sky130_fd_sc_hd__xor2_1
X_12099_ net1026 _06080_ net515 vssd1 vssd1 vccd1 vccd1 _00266_ sky130_fd_sc_hd__mux2_1
Xinput6 div_sstream_i[13] vssd1 vssd1 vccd1 vccd1 net6 sky130_fd_sc_hd__clkbuf_8
XFILLER_0_79_819 vssd1 vssd1 vccd1 vccd1 sky130_fd_sc_hd__fill_1
X_06660_ sub1.a_i\[16\] _00594_ vssd1 vssd1 vccd1 vccd1 _00889_ sky130_fd_sc_hd__nor2_1
XFILLER_0_87_841 vssd1 vssd1 vccd1 vccd1 sky130_fd_sc_hd__fill_1
XFILLER_0_47_705 vssd1 vssd1 vccd1 vccd1 sky130_fd_sc_hd__fill_2
X_06591_ _00829_ _00830_ vssd1 vssd1 vccd1 vccd1 _00831_ sky130_fd_sc_hd__nor2_1
XFILLER_0_129_420 vssd1 vssd1 vccd1 vccd1 sky130_fd_sc_hd__fill_2
X_08330_ net1091 net781 vssd1 vssd1 vccd1 vccd1 _02447_ sky130_fd_sc_hd__nand2_1
XFILLER_0_129_486 vssd1 vssd1 vccd1 vccd1 sky130_fd_sc_hd__fill_1
XFILLER_0_129_475 vssd1 vssd1 vccd1 vccd1 sky130_fd_sc_hd__fill_2
XFILLER_0_117_615 vssd1 vssd1 vccd1 vccd1 sky130_fd_sc_hd__fill_1
X_08261_ _02359_ _02376_ _02377_ vssd1 vssd1 vccd1 vccd1 _02379_ sky130_fd_sc_hd__and3_1
XFILLER_0_55_760 vssd1 vssd1 vccd1 vccd1 sky130_fd_sc_hd__fill_1
XFILLER_0_27_462 vssd1 vssd1 vccd1 vccd1 sky130_fd_sc_hd__fill_1
X_07212_ _01335_ _01336_ vssd1 vssd1 vccd1 vccd1 _01337_ sky130_fd_sc_hd__nor2_1
XFILLER_0_104_309 vssd1 vssd1 vccd1 vccd1 sky130_fd_sc_hd__fill_1
X_08192_ net796 _02193_ _02194_ _02195_ vssd1 vssd1 vccd1 vccd1 _02310_ sky130_fd_sc_hd__a22o_1
XFILLER_0_6_345 vssd1 vssd1 vccd1 vccd1 sky130_fd_sc_hd__fill_1
XFILLER_0_27_495 vssd1 vssd1 vccd1 vccd1 sky130_fd_sc_hd__fill_2
XFILLER_0_30_605 vssd1 vssd1 vccd1 vccd1 sky130_ef_sc_hd__decap_12
X_07143_ _01198_ _01201_ _01266_ _01267_ vssd1 vssd1 vccd1 vccd1 _01268_ sky130_fd_sc_hd__a211oi_1
XFILLER_0_42_465 vssd1 vssd1 vccd1 vccd1 sky130_fd_sc_hd__fill_2
Xoutput310 net310 vssd1 vssd1 vccd1 vccd1 div_mstream_o[77] sky130_fd_sc_hd__clkbuf_4
X_07074_ _01195_ _01196_ _01137_ _01141_ vssd1 vssd1 vccd1 vccd1 _01199_ sky130_fd_sc_hd__o211a_1
XFILLER_0_42_487 vssd1 vssd1 vccd1 vccd1 sky130_ef_sc_hd__decap_12
Xoutput321 net321 vssd1 vssd1 vccd1 vccd1 div_mstream_o[87] sky130_fd_sc_hd__clkbuf_4
Xoutput332 net332 vssd1 vssd1 vccd1 vccd1 div_mstream_o[9] sky130_fd_sc_hd__clkbuf_4
Xoutput343 net343 vssd1 vssd1 vccd1 vccd1 mstream_o[107] sky130_fd_sc_hd__clkbuf_4
XFILLER_0_65_3 vssd1 vssd1 vccd1 vccd1 sky130_fd_sc_hd__decap_8
XFILLER_0_11_841 vssd1 vssd1 vccd1 vccd1 sky130_fd_sc_hd__fill_1
XFILLER_0_100_559 vssd1 vssd1 vccd1 vccd1 sky130_fd_sc_hd__fill_1
XFILLER_0_77_50 vssd1 vssd1 vccd1 vccd1 sky130_fd_sc_hd__decap_6
Xoutput387 net387 vssd1 vssd1 vccd1 vccd1 mstream_o[43] sky130_fd_sc_hd__clkbuf_4
Xoutput354 net354 vssd1 vssd1 vccd1 vccd1 mstream_o[13] sky130_fd_sc_hd__clkbuf_4
Xoutput365 net365 vssd1 vssd1 vccd1 vccd1 mstream_o[23] sky130_fd_sc_hd__clkbuf_4
Xoutput376 net376 vssd1 vssd1 vccd1 vccd1 mstream_o[33] sky130_fd_sc_hd__clkbuf_4
Xoutput398 net398 vssd1 vssd1 vccd1 vccd1 mstream_o[53] sky130_fd_sc_hd__clkbuf_4
X_07976_ net1075 net821 net814 net1084 vssd1 vssd1 vccd1 vccd1 _02096_ sky130_fd_sc_hd__a22o_1
X_09715_ _03821_ _03822_ _03814_ vssd1 vssd1 vccd1 vccd1 _03823_ sky130_fd_sc_hd__a21o_1
X_06927_ _01048_ _01050_ vssd1 vssd1 vccd1 vccd1 _01052_ sky130_fd_sc_hd__xor2_1
XFILLER_0_93_93 vssd1 vssd1 vccd1 vccd1 sky130_fd_sc_hd__fill_2
X_09646_ _03635_ _03668_ _03667_ vssd1 vssd1 vccd1 vccd1 _03754_ sky130_fd_sc_hd__a21bo_2
XFILLER_0_96_115 vssd1 vssd1 vccd1 vccd1 sky130_fd_sc_hd__fill_1
X_06858_ state\[4\] _00616_ vssd1 vssd1 vccd1 vccd1 _00988_ sky130_fd_sc_hd__nor2_2
X_09577_ _03682_ _03683_ _03684_ vssd1 vssd1 vccd1 vccd1 _03686_ sky130_fd_sc_hd__a21o_1
X_06789_ net406 net1354 net641 vssd1 vssd1 vccd1 vccd1 _00063_ sky130_fd_sc_hd__mux2_1
XTAP_1038 vssd1 vccd1 sky130_fd_sc_hd__tapvpwrvgnd_1
XTAP_1027 vssd1 vccd1 sky130_fd_sc_hd__tapvpwrvgnd_1
XTAP_1016 vssd1 vccd1 sky130_fd_sc_hd__tapvpwrvgnd_1
XTAP_1005 vssd1 vccd1 sky130_fd_sc_hd__tapvpwrvgnd_1
X_08528_ _02641_ _02642_ _02643_ vssd1 vssd1 vccd1 vccd1 _02644_ sky130_fd_sc_hd__nand3_4
XFILLER_0_65_502 vssd1 vssd1 vccd1 vccd1 sky130_fd_sc_hd__fill_2
XTAP_1049 vssd1 vccd1 sky130_fd_sc_hd__tapvpwrvgnd_1
X_08459_ _02446_ _02448_ vssd1 vssd1 vccd1 vccd1 _02575_ sky130_fd_sc_hd__nand2_1
XFILLER_0_108_637 vssd1 vssd1 vccd1 vccd1 sky130_fd_sc_hd__decap_6
XFILLER_0_107_125 vssd1 vssd1 vccd1 vccd1 sky130_ef_sc_hd__decap_12
XFILLER_0_92_365 vssd1 vssd1 vccd1 vccd1 sky130_fd_sc_hd__decap_8
XFILLER_0_107_169 vssd1 vssd1 vccd1 vccd1 sky130_ef_sc_hd__decap_12
X_11470_ _04958_ _05460_ _04955_ vssd1 vssd1 vccd1 vccd1 _05565_ sky130_fd_sc_hd__o21a_1
XFILLER_0_123_629 vssd1 vssd1 vccd1 vccd1 sky130_ef_sc_hd__decap_12
XFILLER_0_116_681 vssd1 vssd1 vccd1 vccd1 sky130_ef_sc_hd__decap_12
XFILLER_0_104_810 vssd1 vssd1 vccd1 vccd1 sky130_fd_sc_hd__fill_2
X_10421_ _04375_ _04380_ _04374_ vssd1 vssd1 vccd1 vccd1 _04525_ sky130_fd_sc_hd__o21a_1
XFILLER_0_33_443 vssd1 vssd1 vccd1 vccd1 sky130_fd_sc_hd__decap_4
XFILLER_0_122_139 vssd1 vssd1 vccd1 vccd1 sky130_fd_sc_hd__fill_1
X_13140_ clknet_leaf_14_clk_i _00526_ net1183 vssd1 vssd1 vccd1 vccd1 l0\[1\] sky130_fd_sc_hd__dfrtp_1
X_10352_ net834 net953 _04452_ _04453_ vssd1 vssd1 vccd1 vccd1 _04456_ sky130_fd_sc_hd__a22oi_2
X_13071_ clknet_leaf_25_clk_i _00457_ net1172 vssd1 vssd1 vccd1 vccd1 y2my0\[28\]
+ sky130_fd_sc_hd__dfrtp_1
X_10283_ net1087 net706 _04385_ _04386_ vssd1 vssd1 vccd1 vccd1 _04387_ sky130_fd_sc_hd__nand4_1
X_12022_ net113 net623 net597 net81 vssd1 vssd1 vccd1 vccd1 _06021_ sky130_fd_sc_hd__a22o_1
Xfanout581 _05760_ vssd1 vssd1 vccd1 vccd1 net581 sky130_fd_sc_hd__clkbuf_4
Xfanout592 net593 vssd1 vssd1 vccd1 vccd1 net592 sky130_fd_sc_hd__clkbuf_4
Xfanout570 net571 vssd1 vssd1 vccd1 vccd1 net570 sky130_fd_sc_hd__clkbuf_4
X_12924_ clknet_leaf_31_clk_i _00310_ vssd1 vssd1 vccd1 vccd1 mul1.b\[27\] sky130_fd_sc_hd__dfxtp_2
XFILLER_0_88_649 vssd1 vssd1 vccd1 vccd1 sky130_fd_sc_hd__fill_1
XTAP_2251 vssd1 vccd1 sky130_fd_sc_hd__tapvpwrvgnd_1
XTAP_2240 vssd1 vccd1 sky130_fd_sc_hd__tapvpwrvgnd_1
XFILLER_0_69_841 vssd1 vssd1 vccd1 vccd1 sky130_fd_sc_hd__fill_1
X_12855_ clknet_leaf_34_clk_i _00241_ vssd1 vssd1 vccd1 vccd1 sub1.b_i\[22\] sky130_fd_sc_hd__dfxtp_1
XTAP_1550 vssd1 vccd1 sky130_fd_sc_hd__tapvpwrvgnd_1
X_12786_ clknet_leaf_41_clk_i _00172_ vssd1 vssd1 vccd1 vccd1 add1.b_i\[17\] sky130_fd_sc_hd__dfxtp_1
X_11806_ net98 net669 _05847_ _05849_ vssd1 vssd1 vccd1 vccd1 _05850_ sky130_fd_sc_hd__a211o_1
XFILLER_0_28_204 vssd1 vssd1 vccd1 vccd1 sky130_fd_sc_hd__decap_4
XTAP_1594 vssd1 vccd1 sky130_fd_sc_hd__tapvpwrvgnd_1
XTAP_1583 vssd1 vccd1 sky130_fd_sc_hd__tapvpwrvgnd_1
XTAP_1561 vssd1 vccd1 sky130_fd_sc_hd__tapvpwrvgnd_1
XTAP_1572 vssd1 vccd1 sky130_fd_sc_hd__tapvpwrvgnd_1
XPHY_90 vssd1 vssd1 vccd1 vccd1 sky130_fd_sc_hd__decap_3
X_11737_ net86 net677 net607 net214 vssd1 vssd1 vccd1 vccd1 _05792_ sky130_fd_sc_hd__a22o_1
XFILLER_0_113_69 vssd1 vssd1 vccd1 vccd1 sky130_ef_sc_hd__decap_12
XFILLER_0_83_365 vssd1 vssd1 vccd1 vccd1 sky130_ef_sc_hd__decap_12
X_11668_ net1719 _02168_ net536 vssd1 vssd1 vccd1 vccd1 _00160_ sky130_fd_sc_hd__mux2_1
XFILLER_0_126_489 vssd1 vssd1 vccd1 vccd1 sky130_fd_sc_hd__decap_6
XFILLER_0_98_27 vssd1 vssd1 vccd1 vccd1 sky130_fd_sc_hd__fill_1
X_10619_ _04719_ _04720_ vssd1 vssd1 vccd1 vccd1 _04721_ sky130_fd_sc_hd__nand2b_1
X_11599_ _05585_ _05594_ _05592_ vssd1 vssd1 vccd1 vccd1 _05693_ sky130_fd_sc_hd__a21o_1
XFILLER_0_3_337 vssd1 vssd1 vccd1 vccd1 sky130_fd_sc_hd__fill_1
XFILLER_0_121_161 vssd1 vssd1 vccd1 vccd1 sky130_fd_sc_hd__decap_6
XFILLER_0_110_813 vssd1 vssd1 vccd1 vccd1 sky130_fd_sc_hd__decap_4
XFILLER_0_11_137 vssd1 vssd1 vccd1 vccd1 sky130_ef_sc_hd__decap_12
X_07830_ _01949_ _01951_ vssd1 vssd1 vccd1 vccd1 _01952_ sky130_fd_sc_hd__xnor2_2
X_07761_ net822 _01882_ _01881_ vssd1 vssd1 vccd1 vccd1 _01883_ sky130_fd_sc_hd__a21bo_1
XFILLER_0_47_86 vssd1 vssd1 vccd1 vccd1 sky130_fd_sc_hd__decap_8
X_09500_ _03607_ _03608_ _03434_ net655 vssd1 vssd1 vccd1 vccd1 _03609_ sky130_fd_sc_hd__a211oi_1
X_06712_ _00924_ _00926_ _00931_ _00925_ vssd1 vssd1 vccd1 vccd1 _00933_ sky130_fd_sc_hd__a211oi_4
X_07692_ net1042 net882 vssd1 vssd1 vccd1 vccd1 _01815_ sky130_fd_sc_hd__nand2_1
XFILLER_0_63_74 vssd1 vssd1 vccd1 vccd1 sky130_fd_sc_hd__fill_1
X_09431_ net923 net926 net696 vssd1 vssd1 vccd1 vccd1 _03541_ sky130_fd_sc_hd__and3_1
X_06643_ sub1.a_i\[13\] sub1.b_i\[13\] vssd1 vssd1 vccd1 vccd1 _00875_ sky130_fd_sc_hd__and2b_1
X_09362_ net754 _03471_ _03470_ vssd1 vssd1 vccd1 vccd1 _03472_ sky130_fd_sc_hd__a21bo_1
XFILLER_0_93_118 vssd1 vssd1 vccd1 vccd1 sky130_ef_sc_hd__decap_12
XFILLER_0_87_660 vssd1 vssd1 vccd1 vccd1 sky130_ef_sc_hd__decap_12
X_06574_ _00815_ _00816_ vssd1 vssd1 vccd1 vccd1 _00817_ sky130_fd_sc_hd__nand2_2
X_08313_ _02428_ _02429_ vssd1 vssd1 vccd1 vccd1 _02430_ sky130_fd_sc_hd__nor2_1
X_09293_ _03401_ _03402_ _03245_ net1747 vssd1 vssd1 vccd1 vccd1 _03404_ sky130_fd_sc_hd__a211oi_2
XANTENNA_22 v1y[5] vssd1 vssd1 vccd1 vccd1 sky130_fd_sc_hd__diode_2
XANTENNA_11 _05759_ vssd1 vssd1 vccd1 vccd1 sky130_fd_sc_hd__diode_2
X_08244_ net900 net890 net993 vssd1 vssd1 vccd1 vccd1 _02362_ sky130_fd_sc_hd__and3_1
XANTENNA_33 net19 vssd1 vssd1 vccd1 vccd1 sky130_fd_sc_hd__diode_2
XANTENNA_55 v1y[15] vssd1 vssd1 vccd1 vccd1 sky130_fd_sc_hd__diode_2
XANTENNA_44 net553 vssd1 vssd1 vccd1 vccd1 sky130_fd_sc_hd__diode_2
XANTENNA_66 net619 vssd1 vssd1 vccd1 vccd1 sky130_fd_sc_hd__diode_2
XFILLER_0_34_218 vssd1 vssd1 vccd1 vccd1 sky130_fd_sc_hd__fill_2
XFILLER_0_105_629 vssd1 vssd1 vccd1 vccd1 sky130_ef_sc_hd__decap_12
X_08175_ net1131 net748 net740 net1139 vssd1 vssd1 vccd1 vccd1 _02293_ sky130_fd_sc_hd__a22o_1
XFILLER_0_104_139 vssd1 vssd1 vccd1 vccd1 sky130_fd_sc_hd__fill_1
XFILLER_0_43_785 vssd1 vssd1 vccd1 vccd1 sky130_fd_sc_hd__fill_2
XFILLER_0_6_197 vssd1 vssd1 vccd1 vccd1 sky130_fd_sc_hd__fill_1
X_07126_ _01182_ _01189_ _01249_ _01250_ vssd1 vssd1 vccd1 vccd1 _01251_ sky130_fd_sc_hd__o211ai_4
XFILLER_0_113_673 vssd1 vssd1 vccd1 vccd1 sky130_ef_sc_hd__decap_12
XFILLER_0_100_301 vssd1 vssd1 vccd1 vccd1 sky130_fd_sc_hd__decap_4
XFILLER_0_100_312 vssd1 vssd1 vccd1 vccd1 sky130_fd_sc_hd__decap_3
XFILLER_0_2_381 vssd1 vssd1 vccd1 vccd1 sky130_fd_sc_hd__fill_1
X_07057_ _01181_ _01180_ vssd1 vssd1 vccd1 vccd1 _01182_ sky130_fd_sc_hd__and2b_1
XFILLER_0_100_356 vssd1 vssd1 vccd1 vccd1 sky130_fd_sc_hd__decap_3
X_07959_ net1098 net1106 net786 vssd1 vssd1 vccd1 vccd1 _02079_ sky130_fd_sc_hd__and3_1
XFILLER_0_97_435 vssd1 vssd1 vccd1 vccd1 sky130_fd_sc_hd__decap_6
X_10970_ _05067_ _05068_ _04934_ _04936_ vssd1 vssd1 vccd1 vccd1 _05070_ sky130_fd_sc_hd__o211a_1
X_09629_ _03735_ _03736_ _03564_ _03566_ vssd1 vssd1 vccd1 vccd1 _03738_ sky130_fd_sc_hd__o211ai_2
Xclkbuf_leaf_12_clk_i clknet_3_7__leaf_clk_i vssd1 vssd1 vccd1 vccd1 clknet_leaf_12_clk_i
+ sky130_fd_sc_hd__clkbuf_16
X_12640_ clknet_leaf_27_clk_i _00026_ net1170 vssd1 vssd1 vccd1 vccd1 net365 sky130_fd_sc_hd__dfrtp_1
XFILLER_0_38_557 vssd1 vssd1 vccd1 vccd1 sky130_fd_sc_hd__decap_8
X_12571_ net1426 net16 net560 vssd1 vssd1 vccd1 vccd1 _00547_ sky130_fd_sc_hd__mux2_1
XFILLER_0_53_505 vssd1 vssd1 vccd1 vccd1 sky130_fd_sc_hd__fill_1
XFILLER_0_80_324 vssd1 vssd1 vccd1 vccd1 sky130_fd_sc_hd__fill_2
XFILLER_0_53_538 vssd1 vssd1 vccd1 vccd1 sky130_fd_sc_hd__decap_4
XFILLER_0_25_229 vssd1 vssd1 vccd1 vccd1 sky130_fd_sc_hd__fill_1
Xclkbuf_leaf_27_clk_i clknet_3_5__leaf_clk_i vssd1 vssd1 vccd1 vccd1 clknet_leaf_27_clk_i
+ sky130_fd_sc_hd__clkbuf_16
X_11522_ _05507_ _05509_ vssd1 vssd1 vccd1 vccd1 _05617_ sky130_fd_sc_hd__or2_1
XFILLER_0_92_195 vssd1 vssd1 vccd1 vccd1 sky130_fd_sc_hd__fill_1
X_11453_ _05504_ _05505_ _05545_ _05547_ vssd1 vssd1 vccd1 vccd1 _05549_ sky130_fd_sc_hd__o22ai_2
X_10404_ _04355_ _04357_ _04506_ _04507_ vssd1 vssd1 vccd1 vccd1 _04508_ sky130_fd_sc_hd__a211oi_2
XFILLER_0_21_402 vssd1 vssd1 vccd1 vccd1 sky130_fd_sc_hd__decap_4
X_13123_ clknet_leaf_2_clk_i _00509_ vssd1 vssd1 vccd1 vccd1 det_t\[16\] sky130_fd_sc_hd__dfxtp_1
XFILLER_0_110_109 vssd1 vssd1 vccd1 vccd1 sky130_ef_sc_hd__decap_12
XFILLER_0_61_593 vssd1 vssd1 vccd1 vccd1 sky130_fd_sc_hd__decap_4
XFILLER_0_0_318 vssd1 vssd1 vccd1 vccd1 sky130_fd_sc_hd__fill_2
XFILLER_0_1_819 vssd1 vssd1 vccd1 vccd1 sky130_fd_sc_hd__fill_2
X_11384_ _05469_ _05478_ vssd1 vssd1 vccd1 vccd1 _05480_ sky130_fd_sc_hd__xor2_1
X_10335_ _04437_ _04438_ _04431_ vssd1 vssd1 vccd1 vccd1 _04439_ sky130_fd_sc_hd__a21o_1
X_10266_ _04224_ _04370_ vssd1 vssd1 vccd1 vccd1 _04371_ sky130_fd_sc_hd__nand2_1
XTAP_608 vssd1 vccd1 sky130_fd_sc_hd__tapvpwrvgnd_1
XTAP_619 vssd1 vccd1 sky130_fd_sc_hd__tapvpwrvgnd_1
X_13054_ clknet_leaf_43_clk_i _00440_ net1181 vssd1 vssd1 vccd1 vccd1 y2my0\[11\]
+ sky130_fd_sc_hd__dfrtp_1
XFILLER_0_84_29 vssd1 vssd1 vccd1 vccd1 sky130_ef_sc_hd__decap_12
X_12005_ net1279 _06008_ net482 vssd1 vssd1 vccd1 vccd1 _00244_ sky130_fd_sc_hd__mux2_1
X_10197_ _04299_ _04301_ _04286_ vssd1 vssd1 vccd1 vccd1 _04302_ sky130_fd_sc_hd__a21o_1
X_12907_ clknet_leaf_44_clk_i _00293_ vssd1 vssd1 vccd1 vccd1 mul1.b\[10\] sky130_fd_sc_hd__dfxtp_1
XTAP_2070 vssd1 vccd1 sky130_fd_sc_hd__tapvpwrvgnd_1
XFILLER_0_69_671 vssd1 vssd1 vccd1 vccd1 sky130_fd_sc_hd__fill_1
X_12838_ clknet_leaf_55_clk_i _00224_ vssd1 vssd1 vccd1 vccd1 sub1.b_i\[5\] sky130_fd_sc_hd__dfxtp_1
XFILLER_0_29_502 vssd1 vssd1 vccd1 vccd1 sky130_fd_sc_hd__fill_2
XTAP_2092 vssd1 vccd1 sky130_fd_sc_hd__tapvpwrvgnd_1
XTAP_2081 vssd1 vccd1 sky130_fd_sc_hd__tapvpwrvgnd_1
XFILLER_0_118_209 vssd1 vssd1 vccd1 vccd1 sky130_ef_sc_hd__decap_12
XFILLER_0_33_77 vssd1 vssd1 vccd1 vccd1 sky130_fd_sc_hd__decap_4
XTAP_1391 vssd1 vccd1 sky130_fd_sc_hd__tapvpwrvgnd_1
XTAP_1380 vssd1 vccd1 sky130_fd_sc_hd__tapvpwrvgnd_1
X_12769_ clknet_leaf_57_clk_i _00155_ vssd1 vssd1 vccd1 vccd1 add1.b_i\[0\] sky130_fd_sc_hd__dfxtp_1
XFILLER_0_126_253 vssd1 vssd1 vccd1 vccd1 sky130_fd_sc_hd__fill_1
XFILLER_0_123_3 vssd1 vssd1 vccd1 vccd1 sky130_ef_sc_hd__decap_12
XFILLER_0_83_173 vssd1 vssd1 vccd1 vccd1 sky130_fd_sc_hd__fill_1
XFILLER_0_44_549 vssd1 vssd1 vccd1 vccd1 sky130_fd_sc_hd__decap_8
XFILLER_0_44_516 vssd1 vssd1 vccd1 vccd1 sky130_fd_sc_hd__decap_6
X_06290_ _00600_ _00603_ vssd1 vssd1 vccd1 vccd1 net450 sky130_fd_sc_hd__nor2_1
Xinput20 div_sstream_i[26] vssd1 vssd1 vccd1 vccd1 net20 sky130_fd_sc_hd__buf_4
Xinput31 div_sstream_i[6] vssd1 vssd1 vccd1 vccd1 net31 sky130_fd_sc_hd__clkbuf_8
XFILLER_0_71_335 vssd1 vssd1 vccd1 vccd1 sky130_fd_sc_hd__fill_1
Xinput42 sstream_i[13] vssd1 vssd1 vccd1 vccd1 net42 sky130_fd_sc_hd__buf_4
Xinput64 v0x[15] vssd1 vssd1 vccd1 vccd1 net64 sky130_fd_sc_hd__buf_1
XFILLER_0_25_785 vssd1 vssd1 vccd1 vccd1 sky130_fd_sc_hd__fill_1
Xinput53 sstream_i[5] vssd1 vssd1 vccd1 vccd1 net53 sky130_fd_sc_hd__buf_4
XFILLER_0_52_593 vssd1 vssd1 vccd1 vccd1 sky130_fd_sc_hd__fill_1
Xinput86 v0x[6] vssd1 vssd1 vccd1 vccd1 net86 sky130_fd_sc_hd__buf_1
Xinput97 v0y[16] vssd1 vssd1 vccd1 vccd1 net97 sky130_fd_sc_hd__buf_1
Xinput75 v0x[25] vssd1 vssd1 vccd1 vccd1 net75 sky130_fd_sc_hd__buf_1
X_09980_ _03917_ _03922_ _04084_ vssd1 vssd1 vccd1 vccd1 _04086_ sky130_fd_sc_hd__nor3_1
XFILLER_0_0_841 vssd1 vssd1 vccd1 vccd1 sky130_fd_sc_hd__fill_1
XFILLER_0_110_643 vssd1 vssd1 vccd1 vccd1 sky130_fd_sc_hd__fill_1
X_08931_ _03035_ _03043_ vssd1 vssd1 vccd1 vccd1 _03044_ sky130_fd_sc_hd__or2_1
X_08862_ _02969_ _02974_ vssd1 vssd1 vccd1 vccd1 _02975_ sky130_fd_sc_hd__nand2_1
X_07813_ _01836_ net1755 _01932_ _01934_ vssd1 vssd1 vccd1 vccd1 _01935_ sky130_fd_sc_hd__o211a_1
X_08793_ _02760_ _02762_ vssd1 vssd1 vccd1 vccd1 _02907_ sky130_fd_sc_hd__or2_1
X_07744_ _01860_ _01865_ vssd1 vssd1 vccd1 vccd1 _01866_ sky130_fd_sc_hd__and2_1
XFILLER_0_28_3 vssd1 vssd1 vccd1 vccd1 sky130_ef_sc_hd__decap_12
XFILLER_0_79_435 vssd1 vssd1 vccd1 vccd1 sky130_fd_sc_hd__decap_6
X_07675_ _01795_ _01796_ vssd1 vssd1 vccd1 vccd1 _01798_ sky130_fd_sc_hd__xor2_1
X_09414_ _03504_ _03521_ _03522_ vssd1 vssd1 vccd1 vccd1 _03524_ sky130_fd_sc_hd__nand3_2
X_06626_ _00849_ _00851_ _00853_ _00860_ vssd1 vssd1 vccd1 vccd1 _00861_ sky130_fd_sc_hd__a31o_2
X_06557_ net1575 _00804_ net646 vssd1 vssd1 vccd1 vccd1 _00000_ sky130_fd_sc_hd__a21o_1
X_09345_ _03445_ _03452_ _03453_ vssd1 vssd1 vccd1 vccd1 _03455_ sky130_fd_sc_hd__nand3_2
XFILLER_0_90_83 vssd1 vssd1 vccd1 vccd1 sky130_fd_sc_hd__fill_1
XFILLER_0_47_354 vssd1 vssd1 vccd1 vccd1 sky130_fd_sc_hd__fill_1
XFILLER_0_35_505 vssd1 vssd1 vccd1 vccd1 sky130_fd_sc_hd__decap_4
XFILLER_0_90_611 vssd1 vssd1 vccd1 vccd1 sky130_fd_sc_hd__decap_6
XFILLER_0_75_696 vssd1 vssd1 vccd1 vccd1 sky130_fd_sc_hd__decap_3
X_09276_ _03377_ _03384_ _03385_ vssd1 vssd1 vccd1 vccd1 _03387_ sky130_fd_sc_hd__nand3_2
XFILLER_0_47_376 vssd1 vssd1 vccd1 vccd1 sky130_fd_sc_hd__fill_1
X_06488_ _00780_ _00781_ vssd1 vssd1 vccd1 vccd1 _00782_ sky130_fd_sc_hd__xnor2_4
XFILLER_0_105_426 vssd1 vssd1 vccd1 vccd1 sky130_ef_sc_hd__decap_12
X_08227_ _02335_ _02342_ _02343_ vssd1 vssd1 vccd1 vccd1 _02345_ sky130_fd_sc_hd__nand3_2
XFILLER_0_99_81 vssd1 vssd1 vccd1 vccd1 sky130_ef_sc_hd__decap_12
X_08158_ _02274_ _02275_ vssd1 vssd1 vccd1 vccd1 _02277_ sky130_fd_sc_hd__xnor2_4
XFILLER_0_43_582 vssd1 vssd1 vccd1 vccd1 sky130_fd_sc_hd__decap_4
X_08089_ _02175_ _02205_ _02206_ vssd1 vssd1 vccd1 vccd1 _02208_ sky130_fd_sc_hd__nor3_1
X_07109_ net1096 net847 net838 net1104 vssd1 vssd1 vccd1 vccd1 _01234_ sky130_fd_sc_hd__a22o_1
XFILLER_0_100_131 vssd1 vssd1 vccd1 vccd1 sky130_fd_sc_hd__decap_8
X_10120_ _04071_ _04112_ _04114_ vssd1 vssd1 vccd1 vccd1 _04225_ sky130_fd_sc_hd__a21o_2
X_10051_ net827 net819 net976 vssd1 vssd1 vccd1 vccd1 _04157_ sky130_fd_sc_hd__and3_1
X_10953_ _04867_ _04869_ _05051_ vssd1 vssd1 vccd1 vccd1 _05053_ sky130_fd_sc_hd__and3_1
XFILLER_0_97_254 vssd1 vssd1 vccd1 vccd1 sky130_fd_sc_hd__decap_3
X_10884_ net996 net990 net751 net742 vssd1 vssd1 vccd1 vccd1 _04984_ sky130_fd_sc_hd__nand4_2
XFILLER_0_109_721 vssd1 vssd1 vccd1 vccd1 sky130_fd_sc_hd__decap_6
X_12623_ clknet_leaf_33_clk_i _00009_ net1167 vssd1 vssd1 vccd1 vccd1 net416 sky130_fd_sc_hd__dfrtp_1
X_12554_ net1388 net30 net558 vssd1 vssd1 vccd1 vccd1 _00530_ sky130_fd_sc_hd__mux2_1
XFILLER_0_53_313 vssd1 vssd1 vccd1 vccd1 sky130_fd_sc_hd__decap_8
XFILLER_0_124_713 vssd1 vssd1 vccd1 vccd1 sky130_ef_sc_hd__decap_12
X_11505_ _05584_ _05599_ vssd1 vssd1 vccd1 vccd1 _05600_ sky130_fd_sc_hd__xnor2_1
X_12485_ net1232 net562 _06239_ vssd1 vssd1 vccd1 vccd1 _00493_ sky130_fd_sc_hd__a21o_1
XFILLER_0_124_757 vssd1 vssd1 vccd1 vccd1 sky130_ef_sc_hd__decap_12
XFILLER_0_110_15 vssd1 vssd1 vccd1 vccd1 sky130_ef_sc_hd__decap_12
XFILLER_0_53_379 vssd1 vssd1 vccd1 vccd1 sky130_fd_sc_hd__decap_4
XFILLER_0_34_571 vssd1 vssd1 vccd1 vccd1 sky130_ef_sc_hd__decap_12
X_11436_ _05525_ _05530_ vssd1 vssd1 vccd1 vccd1 _05532_ sky130_fd_sc_hd__nor2_1
XFILLER_0_111_429 vssd1 vssd1 vccd1 vccd1 sky130_ef_sc_hd__decap_12
X_11367_ _05461_ _05462_ vssd1 vssd1 vccd1 vccd1 _05463_ sky130_fd_sc_hd__xnor2_1
XFILLER_0_95_39 vssd1 vssd1 vccd1 vccd1 sky130_ef_sc_hd__decap_12
X_10318_ _04400_ _04418_ _04420_ vssd1 vssd1 vccd1 vccd1 _04422_ sky130_fd_sc_hd__nor3_1
XTAP_405 vssd1 vccd1 sky130_fd_sc_hd__tapvpwrvgnd_1
X_13106_ clknet_leaf_24_clk_i _00492_ vssd1 vssd1 vccd1 vccd1 temp1\[31\] sky130_fd_sc_hd__dfxtp_1
Xbary_pipe_m_1198 vssd1 vssd1 vccd1 vccd1 bary_pipe_m_1198/HI div_mstream_o[48] sky130_fd_sc_hd__conb_1
XTAP_427 vssd1 vccd1 sky130_fd_sc_hd__tapvpwrvgnd_1
XTAP_416 vssd1 vccd1 sky130_fd_sc_hd__tapvpwrvgnd_1
XTAP_438 vssd1 vccd1 sky130_fd_sc_hd__tapvpwrvgnd_1
XTAP_449 vssd1 vccd1 sky130_fd_sc_hd__tapvpwrvgnd_1
X_13037_ clknet_leaf_30_clk_i _00423_ net1168 vssd1 vssd1 vccd1 vccd1 x0mx2\[26\]
+ sky130_fd_sc_hd__dfrtp_1
X_11298_ _05392_ _05393_ vssd1 vssd1 vccd1 vccd1 _05395_ sky130_fd_sc_hd__xor2_2
XFILLER_0_119_57 vssd1 vssd1 vccd1 vccd1 sky130_ef_sc_hd__decap_12
Xfanout1140 net1142 vssd1 vssd1 vccd1 vccd1 net1140 sky130_fd_sc_hd__clkbuf_2
X_10249_ _04331_ _04332_ _04350_ _04351_ vssd1 vssd1 vccd1 vccd1 _04354_ sky130_fd_sc_hd__o22ai_2
Xfanout1173 net1181 vssd1 vssd1 vccd1 vccd1 net1173 sky130_fd_sc_hd__clkbuf_4
Xfanout1162 net1163 vssd1 vssd1 vccd1 vccd1 net1162 sky130_fd_sc_hd__clkbuf_2
Xfanout1151 state\[0\] vssd1 vssd1 vccd1 vccd1 net1151 sky130_fd_sc_hd__clkbuf_4
Xfanout1195 net1196 vssd1 vssd1 vccd1 vccd1 net1195 sky130_fd_sc_hd__clkbuf_2
Xfanout1184 net1185 vssd1 vssd1 vccd1 vccd1 net1184 sky130_fd_sc_hd__clkbuf_4
XFILLER_0_14_9 vssd1 vssd1 vccd1 vccd1 sky130_ef_sc_hd__decap_12
XFILLER_0_69_490 vssd1 vssd1 vccd1 vccd1 sky130_fd_sc_hd__decap_4
XFILLER_0_9_727 vssd1 vssd1 vccd1 vccd1 sky130_fd_sc_hd__fill_1
X_07460_ _01552_ _01581_ _01583_ vssd1 vssd1 vccd1 vccd1 _01585_ sky130_fd_sc_hd__and3_1
XFILLER_0_119_529 vssd1 vssd1 vccd1 vccd1 sky130_ef_sc_hd__decap_12
XFILLER_0_57_641 vssd1 vssd1 vccd1 vccd1 sky130_ef_sc_hd__decap_12
X_06411_ add1.a_i\[20\] add1.b_i\[20\] vssd1 vssd1 vccd1 vccd1 _00716_ sky130_fd_sc_hd__or2_1
X_07391_ net917 net909 net1097 net1105 vssd1 vssd1 vccd1 vccd1 _01516_ sky130_fd_sc_hd__nand4_2
XFILLER_0_29_354 vssd1 vssd1 vccd1 vccd1 sky130_fd_sc_hd__fill_2
X_09130_ _03207_ _03208_ _03240_ _03241_ vssd1 vssd1 vccd1 vccd1 _03242_ sky130_fd_sc_hd__o22ai_2
X_06342_ _00646_ _00653_ _00645_ vssd1 vssd1 vccd1 vccd1 _00654_ sky130_fd_sc_hd__o21a_2
XFILLER_0_127_573 vssd1 vssd1 vccd1 vccd1 sky130_ef_sc_hd__decap_12
X_09061_ net802 _03172_ _03171_ vssd1 vssd1 vccd1 vccd1 _03173_ sky130_fd_sc_hd__a21oi_1
XFILLER_0_72_699 vssd1 vssd1 vccd1 vccd1 sky130_fd_sc_hd__fill_1
X_08012_ net920 net912 net986 net979 vssd1 vssd1 vccd1 vccd1 _02132_ sky130_fd_sc_hd__nand4_1
X_06273_ state\[4\] vssd1 vssd1 vccd1 vccd1 _00589_ sky130_fd_sc_hd__inv_2
XFILLER_0_32_508 vssd1 vssd1 vccd1 vccd1 sky130_ef_sc_hd__decap_12
XFILLER_0_114_245 vssd1 vssd1 vccd1 vccd1 sky130_fd_sc_hd__decap_6
XFILLER_0_8_65 vssd1 vssd1 vccd1 vccd1 sky130_ef_sc_hd__decap_12
XFILLER_0_114_289 vssd1 vssd1 vccd1 vccd1 sky130_ef_sc_hd__decap_12
XFILLER_0_40_541 vssd1 vssd1 vccd1 vccd1 sky130_fd_sc_hd__decap_8
X_09963_ _03950_ _03952_ vssd1 vssd1 vccd1 vccd1 _04069_ sky130_fd_sc_hd__or2_4
X_08914_ _03025_ _03026_ _02878_ _02881_ vssd1 vssd1 vccd1 vccd1 _03027_ sky130_fd_sc_hd__a211oi_2
X_09894_ net833 net971 _03998_ _03999_ vssd1 vssd1 vccd1 vccd1 _04001_ sky130_fd_sc_hd__and4_2
XTAP_961 vssd1 vccd1 sky130_fd_sc_hd__tapvpwrvgnd_1
XTAP_950 vssd1 vccd1 sky130_fd_sc_hd__tapvpwrvgnd_1
X_08845_ _02956_ _02957_ vssd1 vssd1 vccd1 vccd1 _02959_ sky130_fd_sc_hd__xor2_2
XTAP_994 vssd1 vccd1 sky130_fd_sc_hd__tapvpwrvgnd_1
XTAP_972 vssd1 vccd1 sky130_fd_sc_hd__tapvpwrvgnd_1
XTAP_983 vssd1 vccd1 sky130_fd_sc_hd__tapvpwrvgnd_1
X_08776_ net825 _02889_ _02888_ vssd1 vssd1 vccd1 vccd1 _02890_ sky130_fd_sc_hd__a21bo_1
X_07727_ _01848_ _01849_ vssd1 vssd1 vccd1 vccd1 _01850_ sky130_fd_sc_hd__and2_1
X_07658_ _01699_ _01702_ _01780_ vssd1 vssd1 vccd1 vccd1 _01781_ sky130_fd_sc_hd__o21ai_2
XFILLER_0_94_257 vssd1 vssd1 vccd1 vccd1 sky130_fd_sc_hd__fill_1
X_07589_ _01703_ _01711_ vssd1 vssd1 vccd1 vccd1 _01713_ sky130_fd_sc_hd__xnor2_1
X_06609_ net1727 _00846_ net633 vssd1 vssd1 vccd1 vccd1 _00010_ sky130_fd_sc_hd__mux2_1
X_09328_ _03437_ vssd1 vssd1 vccd1 vccd1 _03438_ sky130_fd_sc_hd__inv_2
XFILLER_0_75_460 vssd1 vssd1 vccd1 vccd1 sky130_fd_sc_hd__fill_1
XFILLER_0_90_430 vssd1 vssd1 vccd1 vccd1 sky130_fd_sc_hd__fill_2
XFILLER_0_75_493 vssd1 vssd1 vccd1 vccd1 sky130_fd_sc_hd__decap_3
XFILLER_0_63_644 vssd1 vssd1 vccd1 vccd1 sky130_fd_sc_hd__fill_1
XFILLER_0_47_195 vssd1 vssd1 vccd1 vccd1 sky130_fd_sc_hd__decap_4
XFILLER_0_106_757 vssd1 vssd1 vccd1 vccd1 sky130_ef_sc_hd__decap_12
XFILLER_0_105_223 vssd1 vssd1 vccd1 vccd1 sky130_fd_sc_hd__fill_1
X_09259_ _03361_ _03369_ vssd1 vssd1 vccd1 vccd1 _03370_ sky130_fd_sc_hd__xor2_1
XFILLER_0_35_379 vssd1 vssd1 vccd1 vccd1 sky130_fd_sc_hd__fill_1
XFILLER_0_121_727 vssd1 vssd1 vccd1 vccd1 sky130_fd_sc_hd__fill_1
X_12270_ net1334 net38 net691 vssd1 vssd1 vccd1 vccd1 _00324_ sky130_fd_sc_hd__mux2_1
X_11221_ _05317_ _05318_ vssd1 vssd1 vccd1 vccd1 _05319_ sky130_fd_sc_hd__nor2_1
X_11152_ _05243_ _05248_ vssd1 vssd1 vccd1 vccd1 _05250_ sky130_fd_sc_hd__xor2_1
X_10103_ _04115_ _04208_ vssd1 vssd1 vccd1 vccd1 _04209_ sky130_fd_sc_hd__xor2_4
X_11083_ _05016_ _05019_ _05180_ _05181_ vssd1 vssd1 vccd1 vccd1 _05182_ sky130_fd_sc_hd__o211ai_4
Xinput210 v2x[31] vssd1 vssd1 vccd1 vccd1 net210 sky130_fd_sc_hd__buf_1
X_10034_ _04137_ _04138_ _04133_ vssd1 vssd1 vccd1 vccd1 _04140_ sky130_fd_sc_hd__a21o_1
Xinput232 v2y[22] vssd1 vssd1 vccd1 vccd1 net232 sky130_fd_sc_hd__buf_1
Xinput243 v2y[3] vssd1 vssd1 vccd1 vccd1 net243 sky130_fd_sc_hd__buf_1
Xinput221 v2y[12] vssd1 vssd1 vccd1 vccd1 net221 sky130_fd_sc_hd__buf_1
XFILLER_0_98_585 vssd1 vssd1 vccd1 vccd1 sky130_fd_sc_hd__decap_3
XFILLER_0_58_416 vssd1 vssd1 vccd1 vccd1 sky130_fd_sc_hd__decap_4
X_11985_ net1483 _05993_ net484 vssd1 vssd1 vccd1 vccd1 _00239_ sky130_fd_sc_hd__mux2_1
X_10936_ _05031_ _05034_ vssd1 vssd1 vccd1 vccd1 _05036_ sky130_fd_sc_hd__xnor2_1
X_10867_ _04837_ _04840_ vssd1 vssd1 vccd1 vccd1 _04967_ sky130_fd_sc_hd__nand2_1
XPHY_260 vssd1 vssd1 vccd1 vccd1 sky130_fd_sc_hd__decap_3
X_12606_ net1249 net18 net555 vssd1 vssd1 vccd1 vccd1 _00581_ sky130_fd_sc_hd__mux2_1
XFILLER_0_66_460 vssd1 vssd1 vccd1 vccd1 sky130_fd_sc_hd__fill_2
XFILLER_0_109_573 vssd1 vssd1 vccd1 vccd1 sky130_ef_sc_hd__decap_12
X_10798_ net1064 net704 vssd1 vssd1 vccd1 vccd1 _04899_ sky130_fd_sc_hd__nand2_1
X_12537_ net1239 net566 _06265_ vssd1 vssd1 vccd1 vccd1 _00519_ sky130_fd_sc_hd__a21o_1
XFILLER_0_121_69 vssd1 vssd1 vccd1 vccd1 sky130_ef_sc_hd__decap_12
XFILLER_0_53_187 vssd1 vssd1 vccd1 vccd1 sky130_fd_sc_hd__decap_8
X_12468_ _00940_ net617 _05081_ net576 vssd1 vssd1 vccd1 vccd1 _06230_ sky130_fd_sc_hd__a22o_1
XFILLER_0_124_587 vssd1 vssd1 vccd1 vccd1 sky130_fd_sc_hd__fill_1
XFILLER_0_112_749 vssd1 vssd1 vccd1 vccd1 sky130_fd_sc_hd__decap_6
X_11419_ net1027 net697 net694 net1036 vssd1 vssd1 vccd1 vccd1 _05515_ sky130_fd_sc_hd__o2bb2a_1
XFILLER_0_111_237 vssd1 vssd1 vccd1 vccd1 sky130_ef_sc_hd__decap_12
XFILLER_0_1_457 vssd1 vssd1 vccd1 vccd1 sky130_fd_sc_hd__fill_2
X_12399_ net1455 _00923_ net686 vssd1 vssd1 vccd1 vccd1 _00451_ sky130_fd_sc_hd__mux2_1
XFILLER_0_10_747 vssd1 vssd1 vccd1 vccd1 sky130_fd_sc_hd__fill_2
XFILLER_0_120_793 vssd1 vssd1 vccd1 vccd1 sky130_fd_sc_hd__decap_8
X_06960_ net919 net1049 net1057 net911 vssd1 vssd1 vccd1 vccd1 _01085_ sky130_fd_sc_hd__a22oi_2
XTAP_268 vssd1 vccd1 sky130_fd_sc_hd__tapvpwrvgnd_1
XTAP_279 vssd1 vccd1 sky130_fd_sc_hd__tapvpwrvgnd_1
X_06891_ net820 net813 net1135 vssd1 vssd1 vccd1 vccd1 _01016_ sky130_fd_sc_hd__and3_1
X_08630_ _02742_ _02743_ net1025 net835 vssd1 vssd1 vccd1 vccd1 _02745_ sky130_fd_sc_hd__and4bb_1
X_08561_ _02592_ _02595_ vssd1 vssd1 vccd1 vccd1 _02676_ sky130_fd_sc_hd__or2_1
XFILLER_0_77_725 vssd1 vssd1 vccd1 vccd1 sky130_fd_sc_hd__decap_3
X_08492_ _02605_ _02606_ _02607_ vssd1 vssd1 vccd1 vccd1 _02608_ sky130_fd_sc_hd__nand3_1
X_07512_ _01628_ _01630_ vssd1 vssd1 vccd1 vccd1 _01637_ sky130_fd_sc_hd__xnor2_1
X_07443_ _01519_ _01556_ _01557_ _01560_ vssd1 vssd1 vccd1 vccd1 _01568_ sky130_fd_sc_hd__a211o_1
XFILLER_0_119_337 vssd1 vssd1 vccd1 vccd1 sky130_ef_sc_hd__decap_12
X_09113_ net915 net939 net937 net923 vssd1 vssd1 vccd1 vccd1 _03225_ sky130_fd_sc_hd__a22o_1
XFILLER_0_45_644 vssd1 vssd1 vccd1 vccd1 sky130_fd_sc_hd__fill_2
XFILLER_0_44_121 vssd1 vssd1 vccd1 vccd1 sky130_fd_sc_hd__fill_2
X_07374_ _01313_ _01498_ vssd1 vssd1 vccd1 vccd1 _01499_ sky130_fd_sc_hd__nor2_1
XFILLER_0_95_3 vssd1 vssd1 vccd1 vccd1 sky130_ef_sc_hd__decap_12
XFILLER_0_72_474 vssd1 vssd1 vccd1 vccd1 sky130_fd_sc_hd__fill_2
X_06325_ add1.a_i\[7\] add1.b_i\[7\] vssd1 vssd1 vccd1 vccd1 _00637_ sky130_fd_sc_hd__or2_1
X_09044_ net1100 net739 _03152_ _03154_ vssd1 vssd1 vccd1 vccd1 _03156_ sky130_fd_sc_hd__a22oi_1
XFILLER_0_103_705 vssd1 vssd1 vccd1 vccd1 sky130_fd_sc_hd__fill_2
Xhold420 y1my2\[6\] vssd1 vssd1 vccd1 vccd1 net1635 sky130_fd_sc_hd__dlygate4sd3_1
XFILLER_0_130_568 vssd1 vssd1 vccd1 vccd1 sky130_fd_sc_hd__fill_2
XFILLER_0_102_248 vssd1 vssd1 vccd1 vccd1 sky130_fd_sc_hd__decap_4
Xhold442 x2mx1\[3\] vssd1 vssd1 vccd1 vccd1 net1657 sky130_fd_sc_hd__dlygate4sd3_1
Xhold453 x2mx1\[10\] vssd1 vssd1 vccd1 vccd1 net1668 sky130_fd_sc_hd__dlygate4sd3_1
Xhold431 x2mx1\[11\] vssd1 vssd1 vccd1 vccd1 net1646 sky130_fd_sc_hd__dlygate4sd3_1
Xfanout900 mul1.b\[3\] vssd1 vssd1 vccd1 vccd1 net900 sky130_fd_sc_hd__buf_2
Xhold475 y1my2\[16\] vssd1 vssd1 vccd1 vccd1 net1690 sky130_fd_sc_hd__dlygate4sd3_1
Xhold464 y1my2\[12\] vssd1 vssd1 vccd1 vccd1 net1679 sky130_fd_sc_hd__dlygate4sd3_1
Xhold486 temp1\[8\] vssd1 vssd1 vccd1 vccd1 net1701 sky130_fd_sc_hd__dlygate4sd3_1
X_09946_ _04052_ _04051_ vssd1 vssd1 vccd1 vccd1 _04053_ sky130_fd_sc_hd__nand2b_1
Xfanout933 net934 vssd1 vssd1 vccd1 vccd1 net933 sky130_fd_sc_hd__clkbuf_4
Xfanout911 mul1.b\[1\] vssd1 vssd1 vccd1 vccd1 net911 sky130_fd_sc_hd__buf_2
Xhold497 temp1\[4\] vssd1 vssd1 vccd1 vccd1 net1712 sky130_fd_sc_hd__dlygate4sd3_1
Xfanout922 net925 vssd1 vssd1 vccd1 vccd1 net922 sky130_fd_sc_hd__buf_2
Xfanout955 net956 vssd1 vssd1 vccd1 vccd1 net955 sky130_fd_sc_hd__buf_2
Xfanout944 net945 vssd1 vssd1 vccd1 vccd1 net944 sky130_fd_sc_hd__buf_2
Xfanout977 net978 vssd1 vssd1 vccd1 vccd1 net977 sky130_fd_sc_hd__buf_4
Xfanout966 mul1.a\[24\] vssd1 vssd1 vccd1 vccd1 net966 sky130_fd_sc_hd__clkbuf_2
XFILLER_0_99_327 vssd1 vssd1 vccd1 vccd1 sky130_fd_sc_hd__decap_8
X_09877_ _03982_ _03983_ _03969_ vssd1 vssd1 vccd1 vccd1 _03984_ sky130_fd_sc_hd__a21oi_1
Xfanout988 mul1.a\[20\] vssd1 vssd1 vccd1 vccd1 net988 sky130_fd_sc_hd__clkbuf_4
Xfanout999 mul1.a\[19\] vssd1 vssd1 vccd1 vccd1 net999 sky130_fd_sc_hd__buf_2
XTAP_791 vssd1 vccd1 sky130_fd_sc_hd__tapvpwrvgnd_1
XTAP_780 vssd1 vccd1 sky130_fd_sc_hd__tapvpwrvgnd_1
X_08828_ _02904_ _02905_ _02939_ _02940_ vssd1 vssd1 vccd1 vccd1 _02942_ sky130_fd_sc_hd__nor4_1
X_08759_ _02871_ _02872_ vssd1 vssd1 vccd1 vccd1 _02873_ sky130_fd_sc_hd__xnor2_1
XTAP_1924 vssd1 vccd1 sky130_fd_sc_hd__tapvpwrvgnd_1
XTAP_1913 vssd1 vccd1 sky130_fd_sc_hd__tapvpwrvgnd_1
XTAP_1902 vssd1 vccd1 sky130_fd_sc_hd__tapvpwrvgnd_1
X_11770_ net156 net470 _05819_ vssd1 vssd1 vccd1 vccd1 _05820_ sky130_fd_sc_hd__o21a_1
XTAP_1968 vssd1 vccd1 sky130_fd_sc_hd__tapvpwrvgnd_1
XTAP_1957 vssd1 vccd1 sky130_fd_sc_hd__tapvpwrvgnd_1
XTAP_1946 vssd1 vccd1 sky130_fd_sc_hd__tapvpwrvgnd_1
XTAP_1935 vssd1 vccd1 sky130_fd_sc_hd__tapvpwrvgnd_1
X_10721_ _04531_ _04673_ vssd1 vssd1 vccd1 vccd1 _04822_ sky130_fd_sc_hd__nand2_2
XTAP_1979 vssd1 vccd1 sky130_fd_sc_hd__tapvpwrvgnd_1
XFILLER_0_67_279 vssd1 vssd1 vccd1 vccd1 sky130_fd_sc_hd__fill_1
X_10652_ net1053 net1062 net715 net710 vssd1 vssd1 vccd1 vccd1 _04754_ sky130_fd_sc_hd__and4_1
XFILLER_0_35_121 vssd1 vssd1 vccd1 vccd1 sky130_fd_sc_hd__decap_3
XFILLER_0_35_132 vssd1 vssd1 vccd1 vccd1 sky130_fd_sc_hd__fill_1
XFILLER_0_106_521 vssd1 vssd1 vccd1 vccd1 sky130_fd_sc_hd__decap_6
XFILLER_0_63_463 vssd1 vssd1 vccd1 vccd1 sky130_fd_sc_hd__decap_8
X_10583_ net824 net816 net953 net947 vssd1 vssd1 vccd1 vccd1 _04685_ sky130_fd_sc_hd__nand4_2
XFILLER_0_35_165 vssd1 vssd1 vccd1 vccd1 sky130_fd_sc_hd__decap_3
XFILLER_0_91_794 vssd1 vssd1 vccd1 vccd1 sky130_fd_sc_hd__decap_3
X_12322_ net1658 _00855_ net666 vssd1 vssd1 vccd1 vccd1 _00374_ sky130_fd_sc_hd__mux2_1
X_12253_ _00965_ net512 net469 y1my2\[29\] _06188_ vssd1 vssd1 vccd1 vccd1 _06189_
+ sky130_fd_sc_hd__a221o_1
X_11204_ _05133_ _05136_ _05300_ _05301_ vssd1 vssd1 vccd1 vccd1 _05302_ sky130_fd_sc_hd__o211ai_2
X_12184_ _00840_ net509 net466 net1635 _06142_ vssd1 vssd1 vccd1 vccd1 _06143_ sky130_fd_sc_hd__a221o_1
XFILLER_0_31_393 vssd1 vssd1 vccd1 vccd1 sky130_fd_sc_hd__decap_3
X_11135_ _05231_ _05232_ vssd1 vssd1 vccd1 vccd1 _05233_ sky130_fd_sc_hd__nand2b_1
X_11066_ _05163_ _05164_ net1019 net717 vssd1 vssd1 vccd1 vccd1 _05165_ sky130_fd_sc_hd__and4bb_1
X_10017_ net1021 net1013 net778 net768 vssd1 vssd1 vccd1 vccd1 _04123_ sky130_fd_sc_hd__and4_1
XFILLER_0_92_29 vssd1 vssd1 vccd1 vccd1 sky130_ef_sc_hd__decap_12
XFILLER_0_59_703 vssd1 vssd1 vccd1 vccd1 sky130_fd_sc_hd__decap_3
X_11968_ net129 net660 net504 net225 _05980_ vssd1 vssd1 vccd1 vccd1 _05981_ sky130_fd_sc_hd__a221o_1
X_10919_ _04882_ _04886_ _05016_ _05017_ vssd1 vssd1 vccd1 vccd1 _05019_ sky130_fd_sc_hd__a211oi_4
X_11899_ net178 net472 _05928_ vssd1 vssd1 vccd1 vccd1 _05929_ sky130_fd_sc_hd__o21a_1
XFILLER_0_116_307 vssd1 vssd1 vccd1 vccd1 sky130_fd_sc_hd__fill_1
XFILLER_0_27_622 vssd1 vssd1 vccd1 vccd1 sky130_fd_sc_hd__decap_6
XFILLER_0_125_841 vssd1 vssd1 vccd1 vccd1 sky130_fd_sc_hd__fill_1
XFILLER_0_26_154 vssd1 vssd1 vccd1 vccd1 sky130_fd_sc_hd__decap_4
XFILLER_0_27_677 vssd1 vssd1 vccd1 vccd1 sky130_fd_sc_hd__fill_1
XFILLER_0_42_614 vssd1 vssd1 vccd1 vccd1 sky130_fd_sc_hd__decap_4
XFILLER_0_124_351 vssd1 vssd1 vccd1 vccd1 sky130_ef_sc_hd__decap_12
XFILLER_0_54_485 vssd1 vssd1 vccd1 vccd1 sky130_fd_sc_hd__decap_3
X_07090_ _01211_ _01214_ vssd1 vssd1 vccd1 vccd1 _01215_ sky130_fd_sc_hd__xor2_1
XFILLER_0_112_513 vssd1 vssd1 vccd1 vccd1 sky130_ef_sc_hd__decap_12
XFILLER_0_14_349 vssd1 vssd1 vccd1 vccd1 sky130_fd_sc_hd__fill_1
XFILLER_0_41_146 vssd1 vssd1 vccd1 vccd1 sky130_fd_sc_hd__decap_8
XFILLER_0_112_557 vssd1 vssd1 vccd1 vccd1 sky130_ef_sc_hd__decap_12
XFILLER_0_1_243 vssd1 vssd1 vccd1 vccd1 sky130_fd_sc_hd__fill_1
XFILLER_0_100_719 vssd1 vssd1 vccd1 vccd1 sky130_ef_sc_hd__decap_12
XFILLER_0_50_691 vssd1 vssd1 vccd1 vccd1 sky130_fd_sc_hd__decap_8
X_09800_ _03593_ _03771_ _03768_ vssd1 vssd1 vccd1 vccd1 _03907_ sky130_fd_sc_hd__a21o_2
X_07992_ _01997_ _01999_ _02110_ _02111_ vssd1 vssd1 vccd1 vccd1 _02112_ sky130_fd_sc_hd__o211a_1
X_09731_ _03837_ _03838_ vssd1 vssd1 vccd1 vccd1 _03839_ sky130_fd_sc_hd__xor2_1
XFILLER_0_66_52 vssd1 vssd1 vccd1 vccd1 sky130_fd_sc_hd__decap_8
XFILLER_0_5_55 vssd1 vssd1 vccd1 vccd1 sky130_fd_sc_hd__fill_1
X_06943_ _01017_ _01067_ vssd1 vssd1 vccd1 vccd1 _01068_ sky130_fd_sc_hd__or2_1
XFILLER_0_66_85 vssd1 vssd1 vccd1 vccd1 sky130_fd_sc_hd__decap_8
X_09662_ _03768_ _03769_ vssd1 vssd1 vccd1 vccd1 _03770_ sky130_fd_sc_hd__or2_2
X_06874_ net1151 net1150 _00988_ vssd1 vssd1 vccd1 vccd1 _01003_ sky130_fd_sc_hd__and3_2
X_08613_ _02724_ _02725_ _02726_ vssd1 vssd1 vccd1 vccd1 _02728_ sky130_fd_sc_hd__a21oi_2
X_09593_ _03700_ _03701_ vssd1 vssd1 vccd1 vccd1 _03702_ sky130_fd_sc_hd__and2b_1
XFILLER_0_89_371 vssd1 vssd1 vccd1 vccd1 sky130_fd_sc_hd__decap_4
X_08544_ _02656_ _02657_ _02523_ _02525_ vssd1 vssd1 vccd1 vccd1 _02660_ sky130_fd_sc_hd__o211ai_2
XTAP_1209 vssd1 vccd1 sky130_fd_sc_hd__tapvpwrvgnd_1
XFILLER_0_10_3 vssd1 vssd1 vccd1 vccd1 sky130_ef_sc_hd__decap_12
XFILLER_0_77_566 vssd1 vssd1 vccd1 vccd1 sky130_fd_sc_hd__fill_2
X_08475_ _02574_ _02588_ _02589_ vssd1 vssd1 vccd1 vccd1 _02591_ sky130_fd_sc_hd__and3_2
XFILLER_0_119_167 vssd1 vssd1 vccd1 vccd1 sky130_fd_sc_hd__fill_1
XFILLER_0_17_110 vssd1 vssd1 vccd1 vccd1 sky130_fd_sc_hd__fill_2
XFILLER_0_17_121 vssd1 vssd1 vccd1 vccd1 sky130_fd_sc_hd__fill_2
X_07426_ _01540_ _01545_ _01544_ vssd1 vssd1 vccd1 vccd1 _01551_ sky130_fd_sc_hd__o21a_1
XFILLER_0_116_841 vssd1 vssd1 vccd1 vccd1 sky130_fd_sc_hd__fill_1
Xwire619 _00992_ vssd1 vssd1 vccd1 vccd1 net619 sky130_fd_sc_hd__buf_2
X_07357_ _01423_ _01466_ _01481_ vssd1 vssd1 vccd1 vccd1 _01482_ sky130_fd_sc_hd__and3_1
XFILLER_0_73_783 vssd1 vssd1 vccd1 vccd1 sky130_fd_sc_hd__fill_1
X_06308_ _00618_ _00619_ vssd1 vssd1 vccd1 vccd1 _00620_ sky130_fd_sc_hd__nand2_2
XFILLER_0_115_373 vssd1 vssd1 vccd1 vccd1 sky130_ef_sc_hd__decap_12
X_09027_ _03136_ _03138_ _02975_ _02977_ vssd1 vssd1 vccd1 vccd1 _03139_ sky130_fd_sc_hd__o211a_1
X_07288_ _01410_ _01411_ _01412_ vssd1 vssd1 vccd1 vccd1 _01413_ sky130_fd_sc_hd__nand3_1
XFILLER_0_103_535 vssd1 vssd1 vccd1 vccd1 sky130_fd_sc_hd__fill_1
XFILLER_0_60_477 vssd1 vssd1 vccd1 vccd1 sky130_fd_sc_hd__decap_3
Xhold261 net396 vssd1 vssd1 vccd1 vccd1 net1476 sky130_fd_sc_hd__dlygate4sd3_1
Xhold250 l1\[11\] vssd1 vssd1 vccd1 vccd1 net1465 sky130_fd_sc_hd__dlygate4sd3_1
XFILLER_0_13_393 vssd1 vssd1 vccd1 vccd1 sky130_fd_sc_hd__decap_4
Xhold272 x0mx2\[25\] vssd1 vssd1 vccd1 vccd1 net1487 sky130_fd_sc_hd__dlygate4sd3_1
Xhold283 sub1.a_i\[23\] vssd1 vssd1 vccd1 vccd1 net1498 sky130_fd_sc_hd__dlygate4sd3_1
Xhold294 x0mx2\[29\] vssd1 vssd1 vccd1 vccd1 net1509 sky130_fd_sc_hd__dlygate4sd3_1
Xfanout741 net747 vssd1 vssd1 vccd1 vccd1 net741 sky130_fd_sc_hd__clkbuf_2
Xfanout730 net733 vssd1 vssd1 vccd1 vccd1 net730 sky130_fd_sc_hd__clkbuf_2
Xfanout752 net753 vssd1 vssd1 vccd1 vccd1 net752 sky130_fd_sc_hd__clkbuf_4
X_09929_ _04031_ _04032_ _04033_ vssd1 vssd1 vccd1 vccd1 _04036_ sky130_fd_sc_hd__a21oi_1
Xfanout763 net764 vssd1 vssd1 vccd1 vccd1 net763 sky130_fd_sc_hd__clkbuf_4
Xfanout774 mul1.b\[18\] vssd1 vssd1 vccd1 vccd1 net774 sky130_fd_sc_hd__clkbuf_4
Xfanout785 mul1.b\[17\] vssd1 vssd1 vccd1 vccd1 net785 sky130_fd_sc_hd__buf_4
X_12940_ clknet_leaf_10_clk_i _00326_ net1192 vssd1 vssd1 vccd1 vccd1 posy\[2\] sky130_fd_sc_hd__dfrtp_1
XFILLER_0_99_135 vssd1 vssd1 vccd1 vccd1 sky130_fd_sc_hd__decap_4
XFILLER_0_99_113 vssd1 vssd1 vccd1 vccd1 sky130_fd_sc_hd__decap_4
Xfanout796 net797 vssd1 vssd1 vccd1 vccd1 net796 sky130_fd_sc_hd__clkbuf_2
XFILLER_0_99_146 vssd1 vssd1 vccd1 vccd1 sky130_ef_sc_hd__decap_12
X_12871_ clknet_leaf_45_clk_i _00257_ vssd1 vssd1 vccd1 vccd1 mul1.a\[6\] sky130_fd_sc_hd__dfxtp_1
X_11822_ net164 net471 _05863_ vssd1 vssd1 vccd1 vccd1 _05864_ sky130_fd_sc_hd__o21a_1
XTAP_1743 vssd1 vccd1 sky130_fd_sc_hd__tapvpwrvgnd_1
XTAP_1732 vssd1 vccd1 sky130_fd_sc_hd__tapvpwrvgnd_1
XTAP_1721 vssd1 vccd1 sky130_fd_sc_hd__tapvpwrvgnd_1
XTAP_1710 vssd1 vccd1 sky130_fd_sc_hd__tapvpwrvgnd_1
XFILLER_0_95_352 vssd1 vssd1 vccd1 vccd1 sky130_fd_sc_hd__decap_8
XTAP_1776 vssd1 vccd1 sky130_fd_sc_hd__tapvpwrvgnd_1
XTAP_1765 vssd1 vccd1 sky130_fd_sc_hd__tapvpwrvgnd_1
XTAP_1754 vssd1 vccd1 sky130_fd_sc_hd__tapvpwrvgnd_1
XFILLER_0_83_525 vssd1 vssd1 vccd1 vccd1 sky130_fd_sc_hd__decap_3
X_11753_ net1587 _05805_ net478 vssd1 vssd1 vccd1 vccd1 _00195_ sky130_fd_sc_hd__mux2_1
XTAP_1798 vssd1 vccd1 sky130_fd_sc_hd__tapvpwrvgnd_1
XTAP_1787 vssd1 vccd1 sky130_fd_sc_hd__tapvpwrvgnd_1
X_10704_ _04624_ _04626_ _04804_ _04805_ vssd1 vssd1 vccd1 vccd1 _04806_ sky130_fd_sc_hd__o211ai_4
X_11684_ net1295 _04526_ net538 vssd1 vssd1 vccd1 vccd1 _00176_ sky130_fd_sc_hd__mux2_1
XFILLER_0_125_137 vssd1 vssd1 vccd1 vccd1 sky130_ef_sc_hd__decap_12
XFILLER_0_107_841 vssd1 vssd1 vccd1 vccd1 sky130_fd_sc_hd__fill_1
XFILLER_0_102_27 vssd1 vssd1 vccd1 vccd1 sky130_fd_sc_hd__fill_1
XFILLER_0_83_569 vssd1 vssd1 vccd1 vccd1 sky130_ef_sc_hd__decap_12
X_10635_ _04589_ _04592_ _04736_ vssd1 vssd1 vccd1 vccd1 _04737_ sky130_fd_sc_hd__a21o_2
XFILLER_0_122_833 vssd1 vssd1 vccd1 vccd1 sky130_fd_sc_hd__fill_1
XFILLER_0_122_811 vssd1 vssd1 vccd1 vccd1 sky130_fd_sc_hd__fill_1
X_10566_ _04668_ vssd1 vssd1 vccd1 vccd1 _04669_ sky130_fd_sc_hd__inv_2
XFILLER_0_63_293 vssd1 vssd1 vccd1 vccd1 sky130_fd_sc_hd__fill_1
XFILLER_0_11_69 vssd1 vssd1 vccd1 vccd1 sky130_ef_sc_hd__decap_12
X_12305_ net1659 _00935_ net680 vssd1 vssd1 vccd1 vccd1 _00357_ sky130_fd_sc_hd__mux2_1
X_10497_ _04461_ _04464_ _04597_ _04599_ vssd1 vssd1 vccd1 vccd1 _04600_ sky130_fd_sc_hd__o211ai_2
X_12236_ net736 _06177_ net517 vssd1 vssd1 vccd1 vccd1 _00306_ sky130_fd_sc_hd__mux2_1
X_12167_ net918 _06131_ net513 vssd1 vssd1 vccd1 vccd1 _00283_ sky130_fd_sc_hd__mux2_1
X_11118_ _04961_ _05215_ vssd1 vssd1 vccd1 vccd1 _05216_ sky130_fd_sc_hd__nand2_1
X_12098_ _00887_ _06079_ net499 vssd1 vssd1 vccd1 vccd1 _06080_ sky130_fd_sc_hd__mux2_1
Xinput7 div_sstream_i[14] vssd1 vssd1 vccd1 vccd1 net7 sky130_fd_sc_hd__clkbuf_8
XFILLER_0_127_57 vssd1 vssd1 vccd1 vccd1 sky130_ef_sc_hd__decap_12
X_11049_ net1055 net703 _05025_ _05024_ vssd1 vssd1 vccd1 vccd1 _05148_ sky130_fd_sc_hd__a31o_1
XFILLER_0_59_500 vssd1 vssd1 vccd1 vccd1 sky130_fd_sc_hd__fill_1
XFILLER_0_98_190 vssd1 vssd1 vccd1 vccd1 sky130_fd_sc_hd__decap_6
X_06590_ sub1.b_i\[5\] sub1.a_i\[5\] vssd1 vssd1 vccd1 vccd1 _00830_ sky130_fd_sc_hd__and2b_1
XFILLER_0_86_363 vssd1 vssd1 vccd1 vccd1 sky130_fd_sc_hd__fill_1
XFILLER_0_52_43 vssd1 vssd1 vccd1 vccd1 sky130_fd_sc_hd__decap_8
X_08260_ _02376_ _02377_ _02359_ vssd1 vssd1 vccd1 vccd1 _02378_ sky130_fd_sc_hd__a21oi_2
X_08191_ _02298_ _02307_ vssd1 vssd1 vccd1 vccd1 _02309_ sky130_fd_sc_hd__xor2_1
X_07211_ _01249_ _01251_ _01334_ vssd1 vssd1 vccd1 vccd1 _01336_ sky130_fd_sc_hd__and3_1
X_07142_ _01257_ _01258_ _01265_ vssd1 vssd1 vccd1 vccd1 _01267_ sky130_fd_sc_hd__a21oi_1
XFILLER_0_125_671 vssd1 vssd1 vccd1 vccd1 sky130_fd_sc_hd__fill_1
Xoutput300 net300 vssd1 vssd1 vccd1 vccd1 div_mstream_o[68] sky130_fd_sc_hd__clkbuf_4
XFILLER_0_112_321 vssd1 vssd1 vccd1 vccd1 sky130_ef_sc_hd__decap_12
XFILLER_0_30_617 vssd1 vssd1 vccd1 vccd1 sky130_fd_sc_hd__fill_2
X_07073_ _01137_ _01141_ _01195_ _01196_ vssd1 vssd1 vccd1 vccd1 _01198_ sky130_fd_sc_hd__a211o_1
XFILLER_0_42_499 vssd1 vssd1 vccd1 vccd1 sky130_fd_sc_hd__decap_3
Xoutput322 net322 vssd1 vssd1 vccd1 vccd1 div_mstream_o[88] sky130_fd_sc_hd__clkbuf_4
Xoutput333 net553 vssd1 vssd1 vccd1 vccd1 div_sstream_o sky130_fd_sc_hd__clkbuf_4
Xoutput311 net311 vssd1 vssd1 vccd1 vccd1 div_mstream_o[78] sky130_fd_sc_hd__clkbuf_4
Xoutput344 net344 vssd1 vssd1 vccd1 vccd1 mstream_o[108] sky130_fd_sc_hd__clkbuf_4
XFILLER_0_112_365 vssd1 vssd1 vccd1 vccd1 sky130_ef_sc_hd__decap_12
XFILLER_0_10_341 vssd1 vssd1 vccd1 vccd1 sky130_fd_sc_hd__fill_2
Xoutput355 net355 vssd1 vssd1 vccd1 vccd1 mstream_o[14] sky130_fd_sc_hd__clkbuf_4
Xoutput366 net366 vssd1 vssd1 vccd1 vccd1 mstream_o[24] sky130_fd_sc_hd__clkbuf_4
Xoutput377 net377 vssd1 vssd1 vccd1 vccd1 mstream_o[34] sky130_fd_sc_hd__clkbuf_4
Xoutput399 net399 vssd1 vssd1 vccd1 vccd1 mstream_o[54] sky130_fd_sc_hd__clkbuf_4
XFILLER_0_10_385 vssd1 vssd1 vccd1 vccd1 sky130_fd_sc_hd__fill_1
Xoutput388 net388 vssd1 vssd1 vccd1 vccd1 mstream_o[44] sky130_fd_sc_hd__clkbuf_4
X_07975_ net1091 net805 vssd1 vssd1 vccd1 vccd1 _02095_ sky130_fd_sc_hd__nand2_1
X_09714_ _03819_ _03820_ _03815_ vssd1 vssd1 vccd1 vccd1 _03822_ sky130_fd_sc_hd__a21o_1
X_06926_ _01017_ _01048_ _01049_ vssd1 vssd1 vccd1 vccd1 _01051_ sky130_fd_sc_hd__and3_1
X_09645_ _03627_ _03630_ vssd1 vssd1 vccd1 vccd1 _03753_ sky130_fd_sc_hd__nor2_2
X_06857_ net551 net626 vssd1 vssd1 vccd1 vccd1 _00987_ sky130_fd_sc_hd__or2_2
XFILLER_0_96_105 vssd1 vssd1 vccd1 vccd1 sky130_fd_sc_hd__decap_3
X_09576_ _03682_ _03683_ _03684_ vssd1 vssd1 vccd1 vccd1 _03685_ sky130_fd_sc_hd__nand3_2
X_06788_ net1344 l1\[27\] net641 vssd1 vssd1 vccd1 vccd1 _00062_ sky130_fd_sc_hd__mux2_1
XTAP_1028 vssd1 vccd1 sky130_fd_sc_hd__tapvpwrvgnd_1
XTAP_1017 vssd1 vccd1 sky130_fd_sc_hd__tapvpwrvgnd_1
XTAP_1006 vssd1 vccd1 sky130_fd_sc_hd__tapvpwrvgnd_1
X_08527_ _02501_ _02509_ _02508_ vssd1 vssd1 vccd1 vccd1 _02643_ sky130_fd_sc_hd__a21bo_1
XTAP_1039 vssd1 vccd1 sky130_fd_sc_hd__tapvpwrvgnd_1
X_08458_ _02565_ _02573_ vssd1 vssd1 vccd1 vccd1 _02574_ sky130_fd_sc_hd__xnor2_1
XFILLER_0_77_385 vssd1 vssd1 vccd1 vccd1 sky130_fd_sc_hd__fill_1
X_07409_ _01488_ _01490_ vssd1 vssd1 vccd1 vccd1 _01534_ sky130_fd_sc_hd__xnor2_1
XFILLER_0_107_137 vssd1 vssd1 vccd1 vccd1 sky130_ef_sc_hd__decap_12
X_10420_ _04522_ _04523_ vssd1 vssd1 vccd1 vccd1 _04524_ sky130_fd_sc_hd__nor2_2
X_08389_ _02502_ _02503_ _02504_ vssd1 vssd1 vccd1 vccd1 _02506_ sky130_fd_sc_hd__nand3_1
XFILLER_0_33_455 vssd1 vssd1 vccd1 vccd1 sky130_fd_sc_hd__decap_3
XFILLER_0_116_693 vssd1 vssd1 vccd1 vccd1 sky130_fd_sc_hd__decap_6
XFILLER_0_115_181 vssd1 vssd1 vccd1 vccd1 sky130_ef_sc_hd__decap_12
X_10351_ net834 net953 _04452_ _04453_ vssd1 vssd1 vccd1 vccd1 _04455_ sky130_fd_sc_hd__and4_2
X_10282_ net1072 net1079 net715 net711 vssd1 vssd1 vccd1 vccd1 _04386_ sky130_fd_sc_hd__nand4_1
X_13070_ clknet_leaf_26_clk_i _00456_ net1169 vssd1 vssd1 vccd1 vccd1 y2my0\[27\]
+ sky130_fd_sc_hd__dfrtp_1
X_12021_ net1299 _06020_ net483 vssd1 vssd1 vccd1 vccd1 _00248_ sky130_fd_sc_hd__mux2_1
Xfanout560 _06271_ vssd1 vssd1 vccd1 vccd1 net560 sky130_fd_sc_hd__clkbuf_4
Xfanout582 net584 vssd1 vssd1 vccd1 vccd1 net582 sky130_fd_sc_hd__clkbuf_4
Xfanout593 _06029_ vssd1 vssd1 vccd1 vccd1 net593 sky130_fd_sc_hd__clkbuf_4
Xfanout571 net573 vssd1 vssd1 vccd1 vccd1 net571 sky130_fd_sc_hd__buf_4
X_12923_ clknet_leaf_31_clk_i _00309_ vssd1 vssd1 vccd1 vccd1 mul1.b\[26\] sky130_fd_sc_hd__dfxtp_4
XTAP_2252 vssd1 vccd1 sky130_fd_sc_hd__tapvpwrvgnd_1
XTAP_2241 vssd1 vccd1 sky130_fd_sc_hd__tapvpwrvgnd_1
XTAP_2230 vssd1 vccd1 sky130_fd_sc_hd__tapvpwrvgnd_1
X_12854_ clknet_leaf_35_clk_i _00240_ vssd1 vssd1 vccd1 vccd1 sub1.b_i\[21\] sky130_fd_sc_hd__dfxtp_1
XTAP_1551 vssd1 vccd1 sky130_fd_sc_hd__tapvpwrvgnd_1
XTAP_1540 vssd1 vccd1 sky130_fd_sc_hd__tapvpwrvgnd_1
XFILLER_0_83_300 vssd1 vssd1 vccd1 vccd1 sky130_fd_sc_hd__fill_2
X_12785_ clknet_leaf_41_clk_i _00171_ vssd1 vssd1 vccd1 vccd1 add1.b_i\[16\] sky130_fd_sc_hd__dfxtp_1
X_11805_ net226 net601 net581 net130 _05848_ vssd1 vssd1 vccd1 vccd1 _05849_ sky130_fd_sc_hd__a221o_1
XFILLER_0_113_15 vssd1 vssd1 vccd1 vccd1 sky130_ef_sc_hd__decap_12
XTAP_1584 vssd1 vccd1 sky130_fd_sc_hd__tapvpwrvgnd_1
XTAP_1562 vssd1 vccd1 sky130_fd_sc_hd__tapvpwrvgnd_1
XTAP_1573 vssd1 vccd1 sky130_fd_sc_hd__tapvpwrvgnd_1
XFILLER_0_83_322 vssd1 vssd1 vccd1 vccd1 sky130_fd_sc_hd__fill_2
XPHY_91 vssd1 vssd1 vccd1 vccd1 sky130_fd_sc_hd__decap_3
X_11736_ net1309 _05791_ net478 vssd1 vssd1 vccd1 vccd1 _00192_ sky130_fd_sc_hd__mux2_1
XPHY_80 vssd1 vssd1 vccd1 vccd1 sky130_fd_sc_hd__decap_3
XFILLER_0_126_424 vssd1 vssd1 vccd1 vccd1 sky130_ef_sc_hd__decap_12
XTAP_1595 vssd1 vccd1 sky130_fd_sc_hd__tapvpwrvgnd_1
XFILLER_0_83_377 vssd1 vssd1 vccd1 vccd1 sky130_fd_sc_hd__decap_3
XFILLER_0_71_528 vssd1 vssd1 vccd1 vccd1 sky130_fd_sc_hd__decap_4
X_11667_ net1595 _02060_ net536 vssd1 vssd1 vccd1 vccd1 _00159_ sky130_fd_sc_hd__mux2_1
XFILLER_0_107_671 vssd1 vssd1 vccd1 vccd1 sky130_fd_sc_hd__fill_1
X_10618_ _04573_ _04574_ vssd1 vssd1 vccd1 vccd1 _04720_ sky130_fd_sc_hd__nand2_1
XFILLER_0_3_316 vssd1 vssd1 vccd1 vccd1 sky130_fd_sc_hd__fill_1
X_11598_ net762 net952 _05578_ _05577_ vssd1 vssd1 vccd1 vccd1 _05692_ sky130_fd_sc_hd__a31o_1
X_10549_ _04607_ _04608_ _04650_ _04651_ vssd1 vssd1 vccd1 vccd1 _04652_ sky130_fd_sc_hd__nor4_1
XFILLER_0_11_149 vssd1 vssd1 vccd1 vccd1 sky130_ef_sc_hd__decap_12
X_13199_ clknet_leaf_16_clk_i _00585_ net1182 vssd1 vssd1 vccd1 vccd1 l1\[28\] sky130_fd_sc_hd__dfrtp_1
X_12219_ x2mx1\[18\] net604 net585 temp1\[18\] vssd1 vssd1 vccd1 vccd1 _06166_ sky130_fd_sc_hd__a22o_1
XFILLER_0_47_54 vssd1 vssd1 vccd1 vccd1 sky130_fd_sc_hd__fill_2
X_07760_ net1091 net1098 net814 vssd1 vssd1 vccd1 vccd1 _01882_ sky130_fd_sc_hd__and3_1
X_06711_ _00924_ _00926_ _00925_ vssd1 vssd1 vccd1 vccd1 _00932_ sky130_fd_sc_hd__a21o_1
X_09430_ net923 net926 net696 vssd1 vssd1 vccd1 vccd1 _03540_ sky130_fd_sc_hd__a21o_1
X_07691_ _01806_ _01813_ vssd1 vssd1 vccd1 vccd1 _01814_ sky130_fd_sc_hd__xnor2_2
XFILLER_0_2_56 vssd1 vssd1 vccd1 vccd1 sky130_fd_sc_hd__fill_2
X_06642_ sub1.b_i\[13\] sub1.a_i\[13\] vssd1 vssd1 vccd1 vccd1 _00874_ sky130_fd_sc_hd__and2b_1
X_09361_ net1063 net1071 net761 vssd1 vssd1 vccd1 vccd1 _03471_ sky130_fd_sc_hd__and3_1
XFILLER_0_47_514 vssd1 vssd1 vccd1 vccd1 sky130_ef_sc_hd__decap_12
XFILLER_0_47_503 vssd1 vssd1 vccd1 vccd1 sky130_fd_sc_hd__fill_1
X_06573_ sub1.b_i\[2\] sub1.a_i\[2\] vssd1 vssd1 vccd1 vccd1 _00816_ sky130_fd_sc_hd__nand2b_1
XFILLER_0_129_251 vssd1 vssd1 vccd1 vccd1 sky130_fd_sc_hd__fill_1
X_08312_ net1122 net1131 net748 net740 vssd1 vssd1 vccd1 vccd1 _02429_ sky130_fd_sc_hd__and4_1
X_09292_ _03245_ _03247_ _03401_ _03402_ vssd1 vssd1 vccd1 vccd1 _03403_ sky130_fd_sc_hd__o211a_2
XFILLER_0_87_694 vssd1 vssd1 vccd1 vccd1 sky130_fd_sc_hd__decap_3
XFILLER_0_74_322 vssd1 vssd1 vccd1 vccd1 sky130_fd_sc_hd__decap_4
X_08243_ net889 net993 net986 net898 vssd1 vssd1 vccd1 vccd1 _02361_ sky130_fd_sc_hd__a22o_1
XANTENNA_23 v1y[6] vssd1 vssd1 vccd1 vccd1 sky130_fd_sc_hd__diode_2
XANTENNA_12 _05759_ vssd1 vssd1 vccd1 vccd1 sky130_fd_sc_hd__diode_2
XANTENNA_34 net36 vssd1 vssd1 vccd1 vccd1 sky130_fd_sc_hd__diode_2
Xclkbuf_leaf_8_clk_i clknet_3_7__leaf_clk_i vssd1 vssd1 vccd1 vccd1 clknet_leaf_8_clk_i
+ sky130_fd_sc_hd__clkbuf_16
XANTENNA_45 net1077 vssd1 vssd1 vccd1 vccd1 sky130_fd_sc_hd__diode_2
XANTENNA_56 v1y[22] vssd1 vssd1 vccd1 vccd1 sky130_fd_sc_hd__diode_2
XFILLER_0_103_81 vssd1 vssd1 vccd1 vccd1 sky130_ef_sc_hd__decap_12
X_08174_ _02201_ _02204_ vssd1 vssd1 vccd1 vccd1 _02292_ sky130_fd_sc_hd__or2_1
XANTENNA_67 net739 vssd1 vssd1 vccd1 vccd1 sky130_fd_sc_hd__diode_2
XFILLER_0_113_641 vssd1 vssd1 vccd1 vccd1 sky130_ef_sc_hd__decap_12
X_07125_ _01167_ _01169_ _01248_ vssd1 vssd1 vccd1 vccd1 _01250_ sky130_fd_sc_hd__nand3_2
X_07056_ _01038_ _01039_ vssd1 vssd1 vccd1 vccd1 _01181_ sky130_fd_sc_hd__nor2_1
XFILLER_0_42_285 vssd1 vssd1 vccd1 vccd1 sky130_fd_sc_hd__decap_4
XFILLER_0_113_685 vssd1 vssd1 vccd1 vccd1 sky130_ef_sc_hd__decap_12
XFILLER_0_88_83 vssd1 vssd1 vccd1 vccd1 sky130_fd_sc_hd__fill_1
XFILLER_0_2_371 vssd1 vssd1 vccd1 vccd1 sky130_fd_sc_hd__fill_2
XFILLER_0_112_195 vssd1 vssd1 vccd1 vccd1 sky130_fd_sc_hd__fill_1
X_07958_ net1098 net795 net786 net1106 vssd1 vssd1 vccd1 vccd1 _02078_ sky130_fd_sc_hd__a22oi_1
XFILLER_0_97_414 vssd1 vssd1 vccd1 vccd1 sky130_fd_sc_hd__fill_1
X_07889_ net1050 net856 _02008_ _02009_ vssd1 vssd1 vccd1 vccd1 _02010_ sky130_fd_sc_hd__o2bb2a_1
X_06909_ net854 net1118 _01032_ _01030_ vssd1 vssd1 vccd1 vccd1 _01034_ sky130_fd_sc_hd__a31o_1
X_09628_ _03564_ _03566_ _03735_ _03736_ vssd1 vssd1 vccd1 vccd1 _03737_ sky130_fd_sc_hd__a211o_1
X_09559_ _03665_ _03666_ _03521_ _03524_ vssd1 vssd1 vccd1 vccd1 _03668_ sky130_fd_sc_hd__o211ai_2
XFILLER_0_38_503 vssd1 vssd1 vccd1 vccd1 sky130_fd_sc_hd__decap_8
X_12570_ net1403 net15 net560 vssd1 vssd1 vccd1 vccd1 _00546_ sky130_fd_sc_hd__mux2_1
XFILLER_0_38_536 vssd1 vssd1 vccd1 vccd1 sky130_fd_sc_hd__decap_8
XFILLER_0_26_709 vssd1 vssd1 vccd1 vccd1 sky130_fd_sc_hd__fill_2
XFILLER_0_93_697 vssd1 vssd1 vccd1 vccd1 sky130_ef_sc_hd__decap_12
XFILLER_0_92_163 vssd1 vssd1 vccd1 vccd1 sky130_ef_sc_hd__decap_12
X_11521_ _05614_ _05615_ vssd1 vssd1 vccd1 vccd1 _05616_ sky130_fd_sc_hd__xnor2_1
XFILLER_0_123_405 vssd1 vssd1 vccd1 vccd1 sky130_ef_sc_hd__decap_12
X_11452_ _05504_ _05505_ _05545_ _05547_ vssd1 vssd1 vccd1 vccd1 _05548_ sky130_fd_sc_hd__or4_2
XFILLER_0_123_449 vssd1 vssd1 vccd1 vccd1 sky130_ef_sc_hd__decap_12
X_10403_ _04468_ _04469_ _04504_ _04505_ vssd1 vssd1 vccd1 vccd1 _04507_ sky130_fd_sc_hd__a2bb2oi_1
XFILLER_0_80_369 vssd1 vssd1 vccd1 vccd1 sky130_fd_sc_hd__fill_1
XFILLER_0_61_561 vssd1 vssd1 vccd1 vccd1 sky130_fd_sc_hd__decap_8
X_11383_ _05469_ _05478_ vssd1 vssd1 vccd1 vccd1 _05479_ sky130_fd_sc_hd__or2_1
X_13122_ clknet_leaf_2_clk_i _00508_ vssd1 vssd1 vccd1 vccd1 det_t\[15\] sky130_fd_sc_hd__dfxtp_1
X_10334_ _04435_ _04436_ _04432_ vssd1 vssd1 vccd1 vccd1 _04438_ sky130_fd_sc_hd__a21o_1
X_10265_ _04367_ _04368_ vssd1 vssd1 vccd1 vccd1 _04370_ sky130_fd_sc_hd__xor2_4
XTAP_609 vssd1 vccd1 sky130_fd_sc_hd__tapvpwrvgnd_1
X_13053_ clknet_leaf_0_clk_i _00439_ net1158 vssd1 vssd1 vccd1 vccd1 y2my0\[10\] sky130_fd_sc_hd__dfrtp_1
X_10196_ _04296_ _04297_ _04298_ vssd1 vssd1 vccd1 vccd1 _04301_ sky130_fd_sc_hd__a21o_1
X_12004_ net139 net661 net504 net235 _06007_ vssd1 vssd1 vccd1 vccd1 _06008_ sky130_fd_sc_hd__a221o_1
XFILLER_0_108_15 vssd1 vssd1 vccd1 vccd1 sky130_ef_sc_hd__decap_12
XFILLER_0_17_57 vssd1 vssd1 vccd1 vccd1 sky130_ef_sc_hd__decap_12
X_12906_ clknet_leaf_44_clk_i _00292_ vssd1 vssd1 vccd1 vccd1 mul1.b\[9\] sky130_fd_sc_hd__dfxtp_2
XTAP_2060 vssd1 vccd1 sky130_fd_sc_hd__tapvpwrvgnd_1
XFILLER_0_69_650 vssd1 vssd1 vccd1 vccd1 sky130_fd_sc_hd__fill_2
X_12837_ clknet_leaf_55_clk_i _00223_ vssd1 vssd1 vccd1 vccd1 sub1.b_i\[4\] sky130_fd_sc_hd__dfxtp_1
XFILLER_0_127_700 vssd1 vssd1 vccd1 vccd1 sky130_ef_sc_hd__decap_12
XTAP_2093 vssd1 vccd1 sky130_fd_sc_hd__tapvpwrvgnd_1
XTAP_2082 vssd1 vccd1 sky130_fd_sc_hd__tapvpwrvgnd_1
XTAP_2071 vssd1 vccd1 sky130_fd_sc_hd__tapvpwrvgnd_1
XFILLER_0_84_653 vssd1 vssd1 vccd1 vccd1 sky130_fd_sc_hd__decap_3
XFILLER_0_84_642 vssd1 vssd1 vccd1 vccd1 sky130_fd_sc_hd__fill_2
XTAP_1392 vssd1 vccd1 sky130_fd_sc_hd__tapvpwrvgnd_1
XTAP_1370 vssd1 vccd1 sky130_fd_sc_hd__tapvpwrvgnd_1
XTAP_1381 vssd1 vccd1 sky130_fd_sc_hd__tapvpwrvgnd_1
X_12768_ clknet_leaf_23_clk_i _00154_ vssd1 vssd1 vccd1 vccd1 add1.a_i\[31\] sky130_fd_sc_hd__dfxtp_1
X_12699_ clknet_leaf_12_clk_i _00085_ net1187 vssd1 vssd1 vccd1 vccd1 net430 sky130_fd_sc_hd__dfrtp_1
X_11719_ net651 _00818_ net473 net176 _05777_ vssd1 vssd1 vccd1 vccd1 _05778_ sky130_fd_sc_hd__a221o_1
Xinput10 div_sstream_i[17] vssd1 vssd1 vccd1 vccd1 net10 sky130_fd_sc_hd__clkbuf_8
Xinput21 div_sstream_i[27] vssd1 vssd1 vccd1 vccd1 net21 sky130_fd_sc_hd__buf_4
XFILLER_0_116_3 vssd1 vssd1 vccd1 vccd1 sky130_ef_sc_hd__decap_12
XFILLER_0_3_102 vssd1 vssd1 vccd1 vccd1 sky130_fd_sc_hd__fill_2
Xinput32 div_sstream_i[7] vssd1 vssd1 vccd1 vccd1 net32 sky130_fd_sc_hd__clkbuf_8
Xinput43 sstream_i[14] vssd1 vssd1 vccd1 vccd1 net43 sky130_fd_sc_hd__buf_4
Xinput54 sstream_i[6] vssd1 vssd1 vccd1 vccd1 net54 sky130_fd_sc_hd__buf_4
XFILLER_0_40_701 vssd1 vssd1 vccd1 vccd1 sky130_fd_sc_hd__fill_1
Xinput87 v0x[7] vssd1 vssd1 vccd1 vccd1 net87 sky130_fd_sc_hd__buf_1
Xinput98 v0y[17] vssd1 vssd1 vccd1 vccd1 net98 sky130_fd_sc_hd__buf_1
Xinput76 v0x[26] vssd1 vssd1 vccd1 vccd1 net76 sky130_fd_sc_hd__buf_1
Xinput65 v0x[16] vssd1 vssd1 vccd1 vccd1 net65 sky130_fd_sc_hd__buf_1
XFILLER_0_0_820 vssd1 vssd1 vccd1 vccd1 sky130_fd_sc_hd__fill_2
X_08930_ _03040_ _03041_ vssd1 vssd1 vccd1 vccd1 _03043_ sky130_fd_sc_hd__xor2_1
XFILLER_0_110_699 vssd1 vssd1 vccd1 vccd1 sky130_fd_sc_hd__fill_1
X_08861_ _02972_ _02973_ vssd1 vssd1 vccd1 vccd1 _02974_ sky130_fd_sc_hd__xnor2_1
X_07812_ _01896_ _01897_ _01930_ _01931_ vssd1 vssd1 vccd1 vccd1 _01934_ sky130_fd_sc_hd__or4_2
X_08792_ _02748_ _02750_ _02902_ _02903_ vssd1 vssd1 vccd1 vccd1 _02906_ sky130_fd_sc_hd__o211ai_4
XFILLER_0_74_41 vssd1 vssd1 vccd1 vccd1 sky130_fd_sc_hd__fill_1
XFILLER_0_79_414 vssd1 vssd1 vccd1 vccd1 sky130_fd_sc_hd__fill_2
X_07743_ _01861_ _01864_ vssd1 vssd1 vccd1 vccd1 _01865_ sky130_fd_sc_hd__xor2_1
X_07674_ _01795_ _01796_ vssd1 vssd1 vccd1 vccd1 _01797_ sky130_fd_sc_hd__and2_1
X_09413_ _03521_ _03522_ _03504_ vssd1 vssd1 vccd1 vccd1 _03523_ sky130_fd_sc_hd__a21o_1
X_06625_ _00593_ sub1.b_i\[9\] _00859_ sub1.a_i\[8\] vssd1 vssd1 vccd1 vccd1 _00860_
+ sky130_fd_sc_hd__a2bb2o_1
X_09344_ _03452_ _03453_ _03445_ vssd1 vssd1 vccd1 vccd1 _03454_ sky130_fd_sc_hd__a21o_1
XFILLER_0_74_141 vssd1 vssd1 vccd1 vccd1 sky130_fd_sc_hd__fill_1
XFILLER_0_47_333 vssd1 vssd1 vccd1 vccd1 sky130_fd_sc_hd__decap_3
X_06556_ net35 _00802_ vssd1 vssd1 vccd1 vccd1 _00804_ sky130_fd_sc_hd__nand2_2
XFILLER_0_118_755 vssd1 vssd1 vccd1 vccd1 sky130_fd_sc_hd__fill_1
X_09275_ _03384_ _03385_ _03377_ vssd1 vssd1 vccd1 vccd1 _03386_ sky130_fd_sc_hd__a21o_1
XFILLER_0_47_399 vssd1 vssd1 vccd1 vccd1 sky130_fd_sc_hd__fill_1
X_06487_ add1.a_i\[31\] add1.b_i\[31\] vssd1 vssd1 vccd1 vccd1 _00781_ sky130_fd_sc_hd__xor2_2
X_08226_ _02342_ _02343_ _02335_ vssd1 vssd1 vccd1 vccd1 _02344_ sky130_fd_sc_hd__a21o_1
XFILLER_0_105_438 vssd1 vssd1 vccd1 vccd1 sky130_fd_sc_hd__decap_8
X_08157_ _02274_ _02275_ vssd1 vssd1 vccd1 vccd1 _02276_ sky130_fd_sc_hd__or2_1
XFILLER_0_43_561 vssd1 vssd1 vccd1 vccd1 sky130_ef_sc_hd__decap_12
XFILLER_0_31_701 vssd1 vssd1 vccd1 vccd1 sky130_fd_sc_hd__fill_2
XFILLER_0_120_419 vssd1 vssd1 vccd1 vccd1 sky130_fd_sc_hd__fill_1
XFILLER_0_99_93 vssd1 vssd1 vccd1 vccd1 sky130_ef_sc_hd__decap_12
XFILLER_0_31_723 vssd1 vssd1 vccd1 vccd1 sky130_fd_sc_hd__decap_4
X_07108_ _01159_ _01172_ _01229_ _01231_ vssd1 vssd1 vccd1 vccd1 _01233_ sky130_fd_sc_hd__a211oi_4
XFILLER_0_101_633 vssd1 vssd1 vccd1 vccd1 sky130_fd_sc_hd__fill_2
X_08088_ _02205_ _02206_ _02175_ vssd1 vssd1 vccd1 vccd1 _02207_ sky130_fd_sc_hd__o21a_1
XFILLER_0_3_680 vssd1 vssd1 vccd1 vccd1 sky130_fd_sc_hd__fill_1
X_07039_ net872 net863 net1088 vssd1 vssd1 vccd1 vccd1 _01164_ sky130_fd_sc_hd__and3_1
XFILLER_0_101_699 vssd1 vssd1 vccd1 vccd1 sky130_fd_sc_hd__fill_2
XFILLER_0_100_154 vssd1 vssd1 vccd1 vccd1 sky130_ef_sc_hd__decap_12
X_10050_ net819 net976 net970 net827 vssd1 vssd1 vccd1 vccd1 _04156_ sky130_fd_sc_hd__a22o_1
XFILLER_0_98_701 vssd1 vssd1 vccd1 vccd1 sky130_ef_sc_hd__decap_12
XFILLER_0_98_745 vssd1 vssd1 vccd1 vccd1 sky130_fd_sc_hd__decap_3
X_10952_ _04867_ _04869_ _05051_ vssd1 vssd1 vccd1 vccd1 _05052_ sky130_fd_sc_hd__a21oi_2
X_10883_ _04980_ _04981_ vssd1 vssd1 vccd1 vccd1 _04983_ sky130_fd_sc_hd__xor2_1
XFILLER_0_39_823 vssd1 vssd1 vccd1 vccd1 sky130_fd_sc_hd__decap_3
XFILLER_0_66_642 vssd1 vssd1 vccd1 vccd1 sky130_fd_sc_hd__fill_2
X_12622_ clknet_leaf_28_clk_i _00008_ net1169 vssd1 vssd1 vccd1 vccd1 net405 sky130_fd_sc_hd__dfrtp_1
XFILLER_0_108_221 vssd1 vssd1 vccd1 vccd1 sky130_ef_sc_hd__decap_12
X_12553_ net1550 net29 net558 vssd1 vssd1 vccd1 vccd1 _00529_ sky130_fd_sc_hd__mux2_1
XFILLER_0_53_303 vssd1 vssd1 vccd1 vccd1 sky130_fd_sc_hd__fill_2
XFILLER_0_124_725 vssd1 vssd1 vccd1 vccd1 sky130_ef_sc_hd__decap_12
XFILLER_0_19_591 vssd1 vssd1 vccd1 vccd1 sky130_fd_sc_hd__decap_8
X_11504_ _05597_ _05598_ vssd1 vssd1 vccd1 vccd1 _05599_ sky130_fd_sc_hd__nor2_1
X_12484_ _00649_ _00783_ net568 vssd1 vssd1 vccd1 vccd1 _06239_ sky130_fd_sc_hd__and3_1
XFILLER_0_80_177 vssd1 vssd1 vccd1 vccd1 sky130_ef_sc_hd__decap_12
XFILLER_0_124_769 vssd1 vssd1 vccd1 vccd1 sky130_ef_sc_hd__decap_12
XFILLER_0_110_27 vssd1 vssd1 vccd1 vccd1 sky130_fd_sc_hd__fill_1
X_11435_ _05525_ _05530_ vssd1 vssd1 vccd1 vccd1 _05531_ sky130_fd_sc_hd__and2_1
XFILLER_0_34_583 vssd1 vssd1 vccd1 vccd1 sky130_fd_sc_hd__decap_4
XFILLER_0_104_471 vssd1 vssd1 vccd1 vccd1 sky130_fd_sc_hd__decap_4
X_11366_ _04958_ _05339_ _04955_ vssd1 vssd1 vccd1 vccd1 _05462_ sky130_fd_sc_hd__o21a_1
X_10317_ _04418_ _04420_ _04400_ vssd1 vssd1 vccd1 vccd1 _04421_ sky130_fd_sc_hd__o21a_1
XTAP_406 vssd1 vccd1 sky130_fd_sc_hd__tapvpwrvgnd_1
X_13105_ clknet_leaf_24_clk_i _00491_ vssd1 vssd1 vccd1 vccd1 temp1\[30\] sky130_fd_sc_hd__dfxtp_1
X_11297_ _05392_ _05393_ vssd1 vssd1 vccd1 vccd1 _05394_ sky130_fd_sc_hd__and2b_1
Xbary_pipe_m_1199 vssd1 vssd1 vccd1 vccd1 bary_pipe_m_1199/HI div_mstream_o[49] sky130_fd_sc_hd__conb_1
X_10248_ _04331_ _04332_ _04350_ _04351_ vssd1 vssd1 vccd1 vccd1 _04353_ sky130_fd_sc_hd__or4_2
XTAP_428 vssd1 vccd1 sky130_fd_sc_hd__tapvpwrvgnd_1
X_13036_ clknet_leaf_34_clk_i _00422_ net1165 vssd1 vssd1 vccd1 vccd1 x0mx2\[25\]
+ sky130_fd_sc_hd__dfrtp_1
XTAP_417 vssd1 vccd1 sky130_fd_sc_hd__tapvpwrvgnd_1
XTAP_439 vssd1 vccd1 sky130_fd_sc_hd__tapvpwrvgnd_1
XFILLER_0_119_69 vssd1 vssd1 vccd1 vccd1 sky130_ef_sc_hd__decap_12
Xfanout1141 net1142 vssd1 vssd1 vccd1 vccd1 net1141 sky130_fd_sc_hd__buf_2
Xfanout1130 net1134 vssd1 vssd1 vccd1 vccd1 net1130 sky130_fd_sc_hd__buf_4
X_10179_ _04281_ _04282_ _04123_ _04125_ vssd1 vssd1 vccd1 vccd1 _04284_ sky130_fd_sc_hd__a211o_1
Xfanout1152 net1158 vssd1 vssd1 vccd1 vccd1 net1152 sky130_fd_sc_hd__clkbuf_4
Xfanout1163 net1164 vssd1 vssd1 vccd1 vccd1 net1163 sky130_fd_sc_hd__clkbuf_4
Xfanout1174 net1176 vssd1 vssd1 vccd1 vccd1 net1174 sky130_fd_sc_hd__clkbuf_4
Xfanout1196 net1197 vssd1 vssd1 vccd1 vccd1 net1196 sky130_fd_sc_hd__buf_2
Xfanout1185 net1197 vssd1 vssd1 vccd1 vccd1 net1185 sky130_fd_sc_hd__buf_2
XFILLER_0_44_66 vssd1 vssd1 vccd1 vccd1 sky130_fd_sc_hd__decap_4
X_06410_ _00714_ vssd1 vssd1 vccd1 vccd1 _00715_ sky130_fd_sc_hd__inv_2
XFILLER_0_57_653 vssd1 vssd1 vccd1 vccd1 sky130_ef_sc_hd__decap_12
X_07390_ _01468_ _01470_ _01469_ vssd1 vssd1 vccd1 vccd1 _01515_ sky130_fd_sc_hd__a21o_1
XFILLER_0_84_483 vssd1 vssd1 vccd1 vccd1 sky130_fd_sc_hd__decap_3
XFILLER_0_57_686 vssd1 vssd1 vccd1 vccd1 sky130_fd_sc_hd__fill_1
XFILLER_0_45_837 vssd1 vssd1 vccd1 vccd1 sky130_fd_sc_hd__decap_3
X_06341_ _00649_ _00650_ _00648_ vssd1 vssd1 vccd1 vccd1 _00653_ sky130_fd_sc_hd__o21a_2
XFILLER_0_127_585 vssd1 vssd1 vccd1 vccd1 sky130_ef_sc_hd__decap_12
XFILLER_0_115_725 vssd1 vssd1 vccd1 vccd1 sky130_fd_sc_hd__decap_3
X_09060_ net1035 net1044 net793 vssd1 vssd1 vccd1 vccd1 _03172_ sky130_fd_sc_hd__and3_1
X_08011_ net906 net994 vssd1 vssd1 vccd1 vccd1 _02131_ sky130_fd_sc_hd__and2_1
XFILLER_0_69_41 vssd1 vssd1 vccd1 vccd1 sky130_fd_sc_hd__decap_3
XFILLER_0_102_419 vssd1 vssd1 vccd1 vccd1 sky130_fd_sc_hd__fill_1
XFILLER_0_8_77 vssd1 vssd1 vccd1 vccd1 sky130_fd_sc_hd__decap_6
XFILLER_0_4_477 vssd1 vssd1 vccd1 vccd1 sky130_fd_sc_hd__decap_4
X_09962_ _03764_ _03927_ _03924_ vssd1 vssd1 vccd1 vccd1 _04068_ sky130_fd_sc_hd__a21o_2
XFILLER_0_40_575 vssd1 vssd1 vccd1 vccd1 sky130_ef_sc_hd__decap_12
XFILLER_0_110_463 vssd1 vssd1 vccd1 vccd1 sky130_ef_sc_hd__decap_12
X_08913_ _03023_ _03024_ _02902_ _02906_ vssd1 vssd1 vccd1 vccd1 _03026_ sky130_fd_sc_hd__o211ai_4
X_09893_ _03999_ vssd1 vssd1 vccd1 vccd1 _04000_ sky130_fd_sc_hd__inv_2
XTAP_962 vssd1 vccd1 sky130_fd_sc_hd__tapvpwrvgnd_1
XTAP_951 vssd1 vccd1 sky130_fd_sc_hd__tapvpwrvgnd_1
XTAP_940 vssd1 vccd1 sky130_fd_sc_hd__tapvpwrvgnd_1
X_08844_ _02956_ _02957_ vssd1 vssd1 vccd1 vccd1 _02958_ sky130_fd_sc_hd__nor2_2
XTAP_995 vssd1 vccd1 sky130_fd_sc_hd__tapvpwrvgnd_1
XTAP_973 vssd1 vccd1 sky130_fd_sc_hd__tapvpwrvgnd_1
XTAP_984 vssd1 vccd1 sky130_fd_sc_hd__tapvpwrvgnd_1
Xclkbuf_leaf_26_clk_i clknet_3_5__leaf_clk_i vssd1 vssd1 vccd1 vccd1 clknet_leaf_26_clk_i
+ sky130_fd_sc_hd__clkbuf_16
X_08775_ net1025 net1035 net818 vssd1 vssd1 vccd1 vccd1 _02889_ sky130_fd_sc_hd__and3_1
X_07726_ _01846_ _01847_ _01747_ _01749_ vssd1 vssd1 vccd1 vccd1 _01849_ sky130_fd_sc_hd__a211o_1
XFILLER_0_79_266 vssd1 vssd1 vccd1 vccd1 sky130_fd_sc_hd__fill_1
XFILLER_0_94_236 vssd1 vssd1 vccd1 vccd1 sky130_fd_sc_hd__fill_2
X_07657_ _01777_ _01778_ vssd1 vssd1 vccd1 vccd1 _01780_ sky130_fd_sc_hd__xor2_1
XFILLER_0_94_269 vssd1 vssd1 vccd1 vccd1 sky130_fd_sc_hd__fill_1
XFILLER_0_82_409 vssd1 vssd1 vccd1 vccd1 sky130_fd_sc_hd__decap_4
X_07588_ _01703_ _01711_ vssd1 vssd1 vccd1 vccd1 _01712_ sky130_fd_sc_hd__nand2b_1
X_06608_ _00844_ _00845_ vssd1 vssd1 vccd1 vccd1 _00846_ sky130_fd_sc_hd__xnor2_4
X_09327_ _03435_ _03436_ vssd1 vssd1 vccd1 vccd1 _03437_ sky130_fd_sc_hd__or2_1
X_06539_ _00662_ _00664_ vssd1 vssd1 vccd1 vccd1 _00793_ sky130_fd_sc_hd__xor2_4
XFILLER_0_47_163 vssd1 vssd1 vccd1 vccd1 sky130_fd_sc_hd__decap_4
XFILLER_0_47_185 vssd1 vssd1 vccd1 vccd1 sky130_fd_sc_hd__decap_6
X_09258_ _03367_ _03368_ vssd1 vssd1 vccd1 vccd1 _03369_ sky130_fd_sc_hd__and2b_1
XFILLER_0_63_667 vssd1 vssd1 vccd1 vccd1 sky130_fd_sc_hd__decap_4
XFILLER_0_106_769 vssd1 vssd1 vccd1 vccd1 sky130_fd_sc_hd__fill_1
X_09189_ _03281_ _03297_ _03298_ vssd1 vssd1 vccd1 vccd1 _03300_ sky130_fd_sc_hd__nor3_1
X_08209_ _02324_ _02325_ _02224_ _02228_ vssd1 vssd1 vccd1 vccd1 _02327_ sky130_fd_sc_hd__o211ai_2
XFILLER_0_62_177 vssd1 vssd1 vccd1 vccd1 sky130_fd_sc_hd__decap_8
XFILLER_0_50_317 vssd1 vssd1 vccd1 vccd1 sky130_fd_sc_hd__decap_4
X_11220_ _05193_ _05195_ _05315_ _05316_ vssd1 vssd1 vccd1 vccd1 _05318_ sky130_fd_sc_hd__a211oi_1
X_11151_ _05243_ _05248_ vssd1 vssd1 vccd1 vccd1 _05249_ sky130_fd_sc_hd__or2_1
X_10102_ _04205_ _04206_ vssd1 vssd1 vccd1 vccd1 _04208_ sky130_fd_sc_hd__xor2_4
X_11082_ _05177_ _05178_ _05161_ vssd1 vssd1 vccd1 vccd1 _05181_ sky130_fd_sc_hd__o21ai_2
Xinput211 v2x[3] vssd1 vssd1 vccd1 vccd1 net211 sky130_fd_sc_hd__buf_1
Xinput200 v2x[22] vssd1 vssd1 vccd1 vccd1 net200 sky130_fd_sc_hd__buf_1
X_10033_ _04133_ _04137_ _04138_ vssd1 vssd1 vccd1 vccd1 _04139_ sky130_fd_sc_hd__nand3_1
Xinput233 v2y[23] vssd1 vssd1 vccd1 vccd1 net233 sky130_fd_sc_hd__buf_1
Xinput244 v2y[4] vssd1 vssd1 vccd1 vccd1 net244 sky130_fd_sc_hd__buf_1
Xinput222 v2y[13] vssd1 vssd1 vccd1 vccd1 net222 sky130_fd_sc_hd__buf_1
XFILLER_0_98_531 vssd1 vssd1 vccd1 vccd1 sky130_fd_sc_hd__fill_1
X_11984_ net134 net660 net504 net230 _05992_ vssd1 vssd1 vccd1 vccd1 _05993_ sky130_fd_sc_hd__a221o_1
XFILLER_0_85_225 vssd1 vssd1 vccd1 vccd1 sky130_fd_sc_hd__decap_8
X_10935_ _05031_ _05034_ vssd1 vssd1 vccd1 vccd1 _05035_ sky130_fd_sc_hd__and2b_1
X_10866_ _04964_ _04965_ vssd1 vssd1 vccd1 vccd1 _04966_ sky130_fd_sc_hd__xnor2_1
XPHY_261 vssd1 vssd1 vccd1 vccd1 sky130_fd_sc_hd__decap_3
XPHY_250 vssd1 vssd1 vccd1 vccd1 sky130_fd_sc_hd__decap_3
X_12605_ net1362 net17 net555 vssd1 vssd1 vccd1 vccd1 _00580_ sky130_fd_sc_hd__mux2_1
XFILLER_0_38_141 vssd1 vssd1 vccd1 vccd1 sky130_fd_sc_hd__decap_8
XFILLER_0_38_163 vssd1 vssd1 vccd1 vccd1 sky130_fd_sc_hd__decap_4
XFILLER_0_121_15 vssd1 vssd1 vccd1 vccd1 sky130_ef_sc_hd__decap_12
X_10797_ _04896_ _04897_ vssd1 vssd1 vccd1 vccd1 _04898_ sky130_fd_sc_hd__nand2b_1
XFILLER_0_53_111 vssd1 vssd1 vccd1 vccd1 sky130_fd_sc_hd__fill_1
XFILLER_0_5_208 vssd1 vssd1 vccd1 vccd1 sky130_fd_sc_hd__fill_1
X_12536_ _00754_ net566 vssd1 vssd1 vccd1 vccd1 _06265_ sky130_fd_sc_hd__nor2_1
XFILLER_0_124_533 vssd1 vssd1 vccd1 vccd1 sky130_ef_sc_hd__decap_12
XFILLER_0_109_585 vssd1 vssd1 vccd1 vccd1 sky130_ef_sc_hd__decap_12
XFILLER_0_53_177 vssd1 vssd1 vccd1 vccd1 sky130_fd_sc_hd__fill_2
X_12467_ temp1\[24\] _06229_ net572 vssd1 vssd1 vccd1 vccd1 _00485_ sky130_fd_sc_hd__mux2_1
XFILLER_0_111_205 vssd1 vssd1 vccd1 vccd1 sky130_ef_sc_hd__decap_12
X_11418_ _05511_ _05512_ vssd1 vssd1 vccd1 vccd1 _05514_ sky130_fd_sc_hd__xor2_1
XFILLER_0_111_249 vssd1 vssd1 vccd1 vccd1 sky130_ef_sc_hd__decap_12
X_12398_ net1494 _00918_ net686 vssd1 vssd1 vccd1 vccd1 _00450_ sky130_fd_sc_hd__mux2_1
XFILLER_0_22_564 vssd1 vssd1 vccd1 vccd1 sky130_fd_sc_hd__fill_1
X_11349_ _05443_ _05444_ vssd1 vssd1 vccd1 vccd1 _05446_ sky130_fd_sc_hd__nand2_1
XTAP_269 vssd1 vccd1 sky130_fd_sc_hd__tapvpwrvgnd_1
X_13019_ clknet_leaf_44_clk_i _00405_ net1156 vssd1 vssd1 vccd1 vccd1 x0mx2\[8\] sky130_fd_sc_hd__dfrtp_1
X_06890_ state\[0\] _01004_ net600 vssd1 vssd1 vccd1 vccd1 _01015_ sky130_fd_sc_hd__a21o_1
X_08560_ _02286_ _02422_ _02559_ _02558_ vssd1 vssd1 vccd1 vccd1 _02675_ sky130_fd_sc_hd__a31oi_2
X_08491_ _02471_ _02472_ _02473_ vssd1 vssd1 vccd1 vccd1 _02607_ sky130_fd_sc_hd__a21bo_1
X_07511_ _01635_ vssd1 vssd1 vccd1 vccd1 _01636_ sky130_fd_sc_hd__inv_2
XFILLER_0_119_305 vssd1 vssd1 vccd1 vccd1 sky130_ef_sc_hd__decap_12
XFILLER_0_92_707 vssd1 vssd1 vccd1 vccd1 sky130_ef_sc_hd__decap_12
X_07442_ _01565_ _01566_ vssd1 vssd1 vccd1 vccd1 _01567_ sky130_fd_sc_hd__xnor2_1
XFILLER_0_119_349 vssd1 vssd1 vccd1 vccd1 sky130_ef_sc_hd__decap_12
XFILLER_0_18_804 vssd1 vssd1 vccd1 vccd1 sky130_fd_sc_hd__fill_2
X_07373_ net846 net1136 net1144 net837 vssd1 vssd1 vccd1 vccd1 _01498_ sky130_fd_sc_hd__a22oi_1
XFILLER_0_29_163 vssd1 vssd1 vccd1 vccd1 sky130_fd_sc_hd__decap_4
X_09112_ net907 net944 vssd1 vssd1 vccd1 vccd1 _03224_ sky130_fd_sc_hd__and2_1
X_06324_ add1.a_i\[7\] add1.b_i\[7\] vssd1 vssd1 vccd1 vccd1 _00636_ sky130_fd_sc_hd__and2_1
XFILLER_0_44_100 vssd1 vssd1 vccd1 vccd1 sky130_fd_sc_hd__decap_3
X_09043_ _03153_ net739 net1100 _03152_ vssd1 vssd1 vccd1 vccd1 _03155_ sky130_fd_sc_hd__and4b_1
XFILLER_0_88_3 vssd1 vssd1 vccd1 vccd1 sky130_ef_sc_hd__decap_12
XFILLER_0_111_81 vssd1 vssd1 vccd1 vccd1 sky130_ef_sc_hd__decap_12
Xhold410 x2mx1\[22\] vssd1 vssd1 vccd1 vccd1 net1625 sky130_fd_sc_hd__dlygate4sd3_1
XFILLER_0_25_391 vssd1 vssd1 vccd1 vccd1 sky130_fd_sc_hd__fill_1
XFILLER_0_130_558 vssd1 vssd1 vccd1 vccd1 sky130_fd_sc_hd__fill_2
Xhold454 y1my2\[20\] vssd1 vssd1 vccd1 vccd1 net1669 sky130_fd_sc_hd__dlygate4sd3_1
Xhold421 x2mx1\[0\] vssd1 vssd1 vccd1 vccd1 net1636 sky130_fd_sc_hd__dlygate4sd3_1
Xhold432 x2mx1\[1\] vssd1 vssd1 vccd1 vccd1 net1647 sky130_fd_sc_hd__dlygate4sd3_1
Xhold443 x2mx1\[9\] vssd1 vssd1 vccd1 vccd1 net1658 sky130_fd_sc_hd__dlygate4sd3_1
XFILLER_0_111_783 vssd1 vssd1 vccd1 vccd1 sky130_fd_sc_hd__fill_1
Xhold465 y1my2\[3\] vssd1 vssd1 vccd1 vccd1 net1680 sky130_fd_sc_hd__dlygate4sd3_1
Xhold487 mul1.b\[6\] vssd1 vssd1 vccd1 vccd1 net1702 sky130_fd_sc_hd__dlygate4sd3_1
Xhold476 add1.b_i\[0\] vssd1 vssd1 vccd1 vccd1 net1691 sky130_fd_sc_hd__dlygate4sd3_1
XFILLER_0_96_83 vssd1 vssd1 vccd1 vccd1 sky130_fd_sc_hd__fill_1
X_09945_ _03797_ _03890_ _03889_ vssd1 vssd1 vccd1 vccd1 _04052_ sky130_fd_sc_hd__a21oi_2
Xfanout901 net902 vssd1 vssd1 vccd1 vccd1 net901 sky130_fd_sc_hd__buf_2
Xfanout923 net924 vssd1 vssd1 vccd1 vccd1 net923 sky130_fd_sc_hd__clkbuf_4
Xfanout912 net914 vssd1 vssd1 vccd1 vccd1 net912 sky130_fd_sc_hd__buf_2
Xhold498 net394 vssd1 vssd1 vccd1 vccd1 net1713 sky130_fd_sc_hd__dlygate4sd3_1
Xfanout934 mul1.a\[30\] vssd1 vssd1 vccd1 vccd1 net934 sky130_fd_sc_hd__clkbuf_2
X_09876_ _03979_ _03980_ _03981_ vssd1 vssd1 vccd1 vccd1 _03983_ sky130_fd_sc_hd__a21o_1
Xfanout956 mul1.a\[25\] vssd1 vssd1 vccd1 vccd1 net956 sky130_fd_sc_hd__buf_2
Xfanout967 net968 vssd1 vssd1 vccd1 vccd1 net967 sky130_fd_sc_hd__buf_2
Xfanout945 net948 vssd1 vssd1 vccd1 vccd1 net945 sky130_fd_sc_hd__clkbuf_4
XTAP_770 vssd1 vccd1 sky130_fd_sc_hd__tapvpwrvgnd_1
X_08827_ _02904_ _02905_ _02939_ _02940_ vssd1 vssd1 vccd1 vccd1 _02941_ sky130_fd_sc_hd__o22ai_2
Xfanout989 net990 vssd1 vssd1 vccd1 vccd1 net989 sky130_fd_sc_hd__buf_2
Xfanout978 mul1.a\[22\] vssd1 vssd1 vccd1 vccd1 net978 sky130_fd_sc_hd__buf_2
XTAP_792 vssd1 vccd1 sky130_fd_sc_hd__tapvpwrvgnd_1
XTAP_781 vssd1 vccd1 sky130_fd_sc_hd__tapvpwrvgnd_1
X_08758_ net1068 mul1.b\[17\] vssd1 vssd1 vccd1 vccd1 _02872_ sky130_fd_sc_hd__and2_1
XTAP_1925 vssd1 vccd1 sky130_fd_sc_hd__tapvpwrvgnd_1
XTAP_1914 vssd1 vccd1 sky130_fd_sc_hd__tapvpwrvgnd_1
XTAP_1903 vssd1 vccd1 sky130_fd_sc_hd__tapvpwrvgnd_1
X_08689_ _02801_ _02802_ _02659_ _02661_ vssd1 vssd1 vccd1 vccd1 _02804_ sky130_fd_sc_hd__a211oi_1
X_07709_ _01828_ _01829_ _01830_ vssd1 vssd1 vccd1 vccd1 _01832_ sky130_fd_sc_hd__a21o_1
XTAP_1958 vssd1 vccd1 sky130_fd_sc_hd__tapvpwrvgnd_1
XTAP_1947 vssd1 vccd1 sky130_fd_sc_hd__tapvpwrvgnd_1
XTAP_1936 vssd1 vccd1 sky130_fd_sc_hd__tapvpwrvgnd_1
XFILLER_0_67_258 vssd1 vssd1 vccd1 vccd1 sky130_fd_sc_hd__decap_6
X_10720_ _04430_ _04680_ _04428_ vssd1 vssd1 vccd1 vccd1 _04821_ sky130_fd_sc_hd__o21bai_2
XTAP_1969 vssd1 vccd1 sky130_fd_sc_hd__tapvpwrvgnd_1
XFILLER_0_83_729 vssd1 vssd1 vccd1 vccd1 sky130_ef_sc_hd__decap_12
XFILLER_0_82_217 vssd1 vssd1 vccd1 vccd1 sky130_fd_sc_hd__fill_1
X_10651_ net1053 net715 net710 net1062 vssd1 vssd1 vccd1 vccd1 _04753_ sky130_fd_sc_hd__a22oi_1
XFILLER_0_35_111 vssd1 vssd1 vccd1 vccd1 sky130_fd_sc_hd__fill_1
XFILLER_0_106_533 vssd1 vssd1 vccd1 vccd1 sky130_ef_sc_hd__decap_12
X_10582_ _04681_ _04682_ vssd1 vssd1 vccd1 vccd1 _04684_ sky130_fd_sc_hd__xor2_2
XFILLER_0_51_615 vssd1 vssd1 vccd1 vccd1 sky130_fd_sc_hd__fill_1
XFILLER_0_90_261 vssd1 vssd1 vccd1 vccd1 sky130_fd_sc_hd__decap_3
XFILLER_0_50_114 vssd1 vssd1 vccd1 vccd1 sky130_ef_sc_hd__decap_12
X_12321_ net1656 _00852_ net666 vssd1 vssd1 vccd1 vccd1 _00373_ sky130_fd_sc_hd__mux2_1
XFILLER_0_121_503 vssd1 vssd1 vccd1 vccd1 sky130_fd_sc_hd__fill_1
X_12252_ x2mx1\[29\] net606 net588 temp1\[29\] vssd1 vssd1 vccd1 vccd1 _06188_ sky130_fd_sc_hd__a22o_1
X_11203_ _05298_ _05299_ _05283_ vssd1 vssd1 vccd1 vccd1 _05301_ sky130_fd_sc_hd__o21ai_1
X_12183_ x2mx1\[6\] net602 net582 temp1\[6\] vssd1 vssd1 vccd1 vccd1 _06142_ sky130_fd_sc_hd__a22o_1
X_11134_ net766 net966 net960 net775 vssd1 vssd1 vccd1 vccd1 _05232_ sky130_fd_sc_hd__a22o_1
X_11065_ net1004 net729 net721 net1011 vssd1 vssd1 vccd1 vccd1 _05164_ sky130_fd_sc_hd__a22oi_1
X_10016_ net1013 net778 net768 net1021 vssd1 vssd1 vccd1 vccd1 _04122_ sky130_fd_sc_hd__a22o_1
XFILLER_0_116_15 vssd1 vssd1 vccd1 vccd1 sky130_ef_sc_hd__decap_12
XFILLER_0_86_523 vssd1 vssd1 vccd1 vccd1 sky130_fd_sc_hd__decap_8
X_11967_ net9 net551 net627 net193 _05979_ vssd1 vssd1 vccd1 vccd1 _05980_ sky130_fd_sc_hd__a221o_1
XFILLER_0_25_57 vssd1 vssd1 vccd1 vccd1 sky130_fd_sc_hd__decap_4
XFILLER_0_86_545 vssd1 vssd1 vccd1 vccd1 sky130_fd_sc_hd__decap_8
X_10918_ _05016_ _05017_ _04882_ _04886_ vssd1 vssd1 vccd1 vccd1 _05018_ sky130_fd_sc_hd__o211a_1
XFILLER_0_129_658 vssd1 vssd1 vccd1 vccd1 sky130_fd_sc_hd__decap_4
X_11898_ net653 _00973_ net476 _05927_ vssd1 vssd1 vccd1 vccd1 _05928_ sky130_fd_sc_hd__a211o_1
X_10849_ _04946_ _04948_ _04804_ _04806_ vssd1 vssd1 vccd1 vccd1 _04950_ sky130_fd_sc_hd__o211ai_1
X_12519_ _00699_ net563 _06256_ vssd1 vssd1 vccd1 vccd1 _00510_ sky130_fd_sc_hd__o21ai_1
XFILLER_0_109_393 vssd1 vssd1 vccd1 vccd1 sky130_fd_sc_hd__fill_1
XFILLER_0_124_363 vssd1 vssd1 vccd1 vccd1 sky130_fd_sc_hd__fill_1
XFILLER_0_112_525 vssd1 vssd1 vccd1 vccd1 sky130_fd_sc_hd__decap_6
XFILLER_0_112_569 vssd1 vssd1 vccd1 vccd1 sky130_ef_sc_hd__decap_12
X_07991_ _02013_ _02015_ _02109_ vssd1 vssd1 vccd1 vccd1 _02111_ sky130_fd_sc_hd__nand3_2
X_09730_ net809 net998 vssd1 vssd1 vccd1 vccd1 _03838_ sky130_fd_sc_hd__nand2_1
X_06942_ _01053_ _01066_ vssd1 vssd1 vccd1 vccd1 _01067_ sky130_fd_sc_hd__nor2_1
X_09661_ _03602_ _03604_ _03767_ vssd1 vssd1 vccd1 vccd1 _03769_ sky130_fd_sc_hd__nor3_1
X_06873_ last _00802_ net685 _00782_ _01001_ vssd1 vssd1 vccd1 vccd1 _01002_ sky130_fd_sc_hd__a221o_1
X_08612_ _02724_ _02725_ _02726_ vssd1 vssd1 vccd1 vccd1 _02727_ sky130_fd_sc_hd__and3_2
XFILLER_0_82_41 vssd1 vssd1 vccd1 vccd1 sky130_ef_sc_hd__decap_12
X_09592_ _03698_ _03699_ _03695_ vssd1 vssd1 vccd1 vccd1 _03701_ sky130_fd_sc_hd__a21o_1
X_08543_ _02658_ vssd1 vssd1 vccd1 vccd1 _02659_ sky130_fd_sc_hd__inv_2
XFILLER_0_82_96 vssd1 vssd1 vccd1 vccd1 sky130_ef_sc_hd__decap_12
XFILLER_0_119_113 vssd1 vssd1 vccd1 vccd1 sky130_ef_sc_hd__decap_12
X_08474_ _02588_ _02589_ _02574_ vssd1 vssd1 vccd1 vccd1 _02590_ sky130_fd_sc_hd__a21oi_1
X_07425_ _01547_ _01548_ _01543_ vssd1 vssd1 vccd1 vccd1 _01550_ sky130_fd_sc_hd__a21o_1
XFILLER_0_73_773 vssd1 vssd1 vccd1 vccd1 sky130_fd_sc_hd__fill_1
XFILLER_0_45_464 vssd1 vssd1 vccd1 vccd1 sky130_fd_sc_hd__fill_1
XFILLER_0_45_442 vssd1 vssd1 vccd1 vccd1 sky130_fd_sc_hd__decap_6
XFILLER_0_17_144 vssd1 vssd1 vccd1 vccd1 sky130_fd_sc_hd__fill_1
X_07356_ _01478_ _01479_ _01473_ vssd1 vssd1 vccd1 vccd1 _01481_ sky130_fd_sc_hd__a21bo_1
X_06307_ add1.a_i\[13\] add1.b_i\[13\] vssd1 vssd1 vccd1 vccd1 _00619_ sky130_fd_sc_hd__or2_1
XFILLER_0_17_177 vssd1 vssd1 vccd1 vccd1 sky130_ef_sc_hd__decap_12
X_07287_ net925 net1083 net1090 net910 vssd1 vssd1 vccd1 vccd1 _01412_ sky130_fd_sc_hd__a22o_1
XFILLER_0_115_385 vssd1 vssd1 vccd1 vccd1 sky130_fd_sc_hd__decap_6
X_09026_ _03005_ _03008_ _03135_ vssd1 vssd1 vccd1 vccd1 _03138_ sky130_fd_sc_hd__and3_1
XFILLER_0_17_199 vssd1 vssd1 vccd1 vccd1 sky130_fd_sc_hd__fill_1
Xhold262 net444 vssd1 vssd1 vccd1 vccd1 net1477 sky130_fd_sc_hd__dlygate4sd3_1
XFILLER_0_103_569 vssd1 vssd1 vccd1 vccd1 sky130_fd_sc_hd__decap_8
Xhold251 l0\[18\] vssd1 vssd1 vccd1 vccd1 net1466 sky130_fd_sc_hd__dlygate4sd3_1
Xhold240 y2my0\[22\] vssd1 vssd1 vccd1 vccd1 net1455 sky130_fd_sc_hd__dlygate4sd3_1
Xhold273 net347 vssd1 vssd1 vccd1 vccd1 net1488 sky130_fd_sc_hd__dlygate4sd3_1
Xhold284 x0mx2\[1\] vssd1 vssd1 vccd1 vccd1 net1499 sky130_fd_sc_hd__dlygate4sd3_1
Xhold295 x0mx2\[11\] vssd1 vssd1 vccd1 vccd1 net1510 sky130_fd_sc_hd__dlygate4sd3_1
Xfanout720 mul1.b\[26\] vssd1 vssd1 vccd1 vccd1 net720 sky130_fd_sc_hd__clkbuf_4
Xfanout731 net732 vssd1 vssd1 vccd1 vccd1 net731 sky130_fd_sc_hd__buf_4
X_09928_ _04031_ _04032_ _04033_ vssd1 vssd1 vccd1 vccd1 _04035_ sky130_fd_sc_hd__nand3_2
Xfanout742 net743 vssd1 vssd1 vccd1 vccd1 net742 sky130_fd_sc_hd__clkbuf_4
Xfanout764 net771 vssd1 vssd1 vccd1 vccd1 net764 sky130_fd_sc_hd__clkbuf_4
Xfanout753 net754 vssd1 vssd1 vccd1 vccd1 net753 sky130_fd_sc_hd__clkbuf_4
Xfanout775 net776 vssd1 vssd1 vccd1 vccd1 net775 sky130_fd_sc_hd__buf_2
X_09859_ _03805_ _03807_ _03964_ _03965_ vssd1 vssd1 vccd1 vccd1 _03966_ sky130_fd_sc_hd__o211a_1
Xfanout797 mul1.b\[15\] vssd1 vssd1 vccd1 vccd1 net797 sky130_fd_sc_hd__clkbuf_4
Xfanout786 net787 vssd1 vssd1 vccd1 vccd1 net786 sky130_fd_sc_hd__buf_2
XFILLER_0_99_158 vssd1 vssd1 vccd1 vccd1 sky130_fd_sc_hd__decap_3
X_12870_ clknet_leaf_52_clk_i _00256_ vssd1 vssd1 vccd1 vccd1 mul1.a\[5\] sky130_fd_sc_hd__dfxtp_1
XTAP_1700 vssd1 vccd1 sky130_fd_sc_hd__tapvpwrvgnd_1
X_11821_ net654 _00908_ net475 _05862_ vssd1 vssd1 vccd1 vccd1 _05863_ sky130_fd_sc_hd__a211o_1
XTAP_1733 vssd1 vccd1 sky130_fd_sc_hd__tapvpwrvgnd_1
XTAP_1722 vssd1 vccd1 sky130_fd_sc_hd__tapvpwrvgnd_1
XTAP_1711 vssd1 vccd1 sky130_fd_sc_hd__tapvpwrvgnd_1
XTAP_1766 vssd1 vccd1 sky130_fd_sc_hd__tapvpwrvgnd_1
XTAP_1755 vssd1 vccd1 sky130_fd_sc_hd__tapvpwrvgnd_1
XTAP_1744 vssd1 vccd1 sky130_fd_sc_hd__tapvpwrvgnd_1
XFILLER_0_55_217 vssd1 vssd1 vccd1 vccd1 sky130_fd_sc_hd__decap_6
X_11752_ net184 net470 _05804_ vssd1 vssd1 vccd1 vccd1 _05805_ sky130_fd_sc_hd__o21a_1
XTAP_1799 vssd1 vccd1 sky130_fd_sc_hd__tapvpwrvgnd_1
XTAP_1788 vssd1 vccd1 sky130_fd_sc_hd__tapvpwrvgnd_1
XTAP_1777 vssd1 vccd1 sky130_fd_sc_hd__tapvpwrvgnd_1
X_10703_ _04801_ _04802_ _04803_ vssd1 vssd1 vccd1 vccd1 _04805_ sky130_fd_sc_hd__o21ai_2
XFILLER_0_83_559 vssd1 vssd1 vccd1 vccd1 sky130_fd_sc_hd__fill_1
X_11683_ net1281 _04381_ net538 vssd1 vssd1 vccd1 vccd1 _00175_ sky130_fd_sc_hd__mux2_1
XFILLER_0_125_105 vssd1 vssd1 vccd1 vccd1 sky130_fd_sc_hd__decap_6
X_10634_ _04726_ _04734_ vssd1 vssd1 vccd1 vccd1 _04736_ sky130_fd_sc_hd__xnor2_1
XFILLER_0_11_15 vssd1 vssd1 vccd1 vccd1 sky130_ef_sc_hd__decap_12
XFILLER_0_125_149 vssd1 vssd1 vccd1 vccd1 sky130_ef_sc_hd__decap_12
XFILLER_0_64_784 vssd1 vssd1 vccd1 vccd1 sky130_fd_sc_hd__fill_1
X_10565_ _04523_ _04375_ _04521_ vssd1 vssd1 vccd1 vccd1 _04668_ sky130_fd_sc_hd__nor3b_1
X_12304_ net1678 _00928_ net679 vssd1 vssd1 vccd1 vccd1 _00356_ sky130_fd_sc_hd__mux2_1
X_10496_ _04581_ _04595_ _04596_ vssd1 vssd1 vccd1 vccd1 _04599_ sky130_fd_sc_hd__nand3_1
XFILLER_0_51_489 vssd1 vssd1 vccd1 vccd1 sky130_fd_sc_hd__decap_6
XFILLER_0_23_169 vssd1 vssd1 vccd1 vccd1 sky130_fd_sc_hd__decap_4
X_12235_ _00928_ net511 net468 y1my2\[23\] _06176_ vssd1 vssd1 vccd1 vccd1 _06177_
+ sky130_fd_sc_hd__a221o_1
X_12166_ _00810_ net509 net466 net1650 _06130_ vssd1 vssd1 vccd1 vccd1 _06131_ sky130_fd_sc_hd__a221o_1
X_11117_ _05209_ _05214_ vssd1 vssd1 vccd1 vccd1 _05215_ sky130_fd_sc_hd__xor2_1
X_12097_ y2my0\[15\] net585 net532 x2mx1\[15\] _06078_ vssd1 vssd1 vccd1 vccd1 _06079_
+ sky130_fd_sc_hd__a221o_1
Xinput8 div_sstream_i[15] vssd1 vssd1 vccd1 vccd1 net8 sky130_fd_sc_hd__clkbuf_8
X_11048_ _05145_ _05146_ vssd1 vssd1 vccd1 vccd1 _05147_ sky130_fd_sc_hd__xnor2_1
XFILLER_0_127_69 vssd1 vssd1 vccd1 vccd1 sky130_ef_sc_hd__decap_12
XFILLER_0_36_56 vssd1 vssd1 vccd1 vccd1 sky130_fd_sc_hd__decap_6
XFILLER_0_36_78 vssd1 vssd1 vccd1 vccd1 sky130_fd_sc_hd__fill_2
XFILLER_0_59_523 vssd1 vssd1 vccd1 vccd1 sky130_fd_sc_hd__decap_8
X_12999_ clknet_leaf_37_clk_i _00385_ net1161 vssd1 vssd1 vccd1 vccd1 x2mx1\[20\]
+ sky130_fd_sc_hd__dfrtp_1
XFILLER_0_52_66 vssd1 vssd1 vccd1 vccd1 sky130_fd_sc_hd__decap_4
XFILLER_0_117_617 vssd1 vssd1 vccd1 vccd1 sky130_ef_sc_hd__decap_12
X_08190_ _02298_ _02307_ vssd1 vssd1 vccd1 vccd1 _02308_ sky130_fd_sc_hd__or2_1
XFILLER_0_7_837 vssd1 vssd1 vccd1 vccd1 sky130_fd_sc_hd__decap_3
X_07210_ _01249_ _01251_ _01334_ vssd1 vssd1 vccd1 vccd1 _01335_ sky130_fd_sc_hd__a21oi_2
XFILLER_0_82_581 vssd1 vssd1 vccd1 vccd1 sky130_fd_sc_hd__decap_6
XFILLER_0_27_486 vssd1 vssd1 vccd1 vccd1 sky130_fd_sc_hd__fill_2
X_07141_ _01257_ _01258_ _01265_ vssd1 vssd1 vccd1 vccd1 _01266_ sky130_fd_sc_hd__and3_2
XFILLER_0_70_732 vssd1 vssd1 vccd1 vccd1 sky130_ef_sc_hd__decap_12
Xoutput301 net301 vssd1 vssd1 vccd1 vccd1 div_mstream_o[69] sky130_fd_sc_hd__clkbuf_4
XFILLER_0_124_182 vssd1 vssd1 vccd1 vccd1 sky130_fd_sc_hd__decap_3
XFILLER_0_112_333 vssd1 vssd1 vccd1 vccd1 sky130_ef_sc_hd__decap_12
X_07072_ _01137_ _01141_ _01195_ _01196_ vssd1 vssd1 vccd1 vccd1 _01197_ sky130_fd_sc_hd__a211oi_1
Xoutput334 net334 vssd1 vssd1 vccd1 vccd1 init_o sky130_fd_sc_hd__clkbuf_4
Xoutput312 net312 vssd1 vssd1 vccd1 vccd1 div_mstream_o[79] sky130_fd_sc_hd__clkbuf_4
Xoutput323 net323 vssd1 vssd1 vccd1 vccd1 div_mstream_o[89] sky130_fd_sc_hd__clkbuf_4
XFILLER_0_11_821 vssd1 vssd1 vccd1 vccd1 sky130_ef_sc_hd__decap_12
Xoutput345 net345 vssd1 vssd1 vccd1 vccd1 mstream_o[109] sky130_fd_sc_hd__clkbuf_4
XFILLER_0_112_377 vssd1 vssd1 vccd1 vccd1 sky130_ef_sc_hd__decap_12
XFILLER_0_2_586 vssd1 vssd1 vccd1 vccd1 sky130_fd_sc_hd__fill_2
Xoutput356 net356 vssd1 vssd1 vccd1 vccd1 mstream_o[15] sky130_fd_sc_hd__clkbuf_4
Xoutput367 net367 vssd1 vssd1 vccd1 vccd1 mstream_o[25] sky130_fd_sc_hd__clkbuf_4
Xoutput378 net378 vssd1 vssd1 vccd1 vccd1 mstream_o[35] sky130_fd_sc_hd__clkbuf_4
XFILLER_0_77_74 vssd1 vssd1 vccd1 vccd1 sky130_fd_sc_hd__fill_1
Xoutput389 net389 vssd1 vssd1 vccd1 vccd1 mstream_o[45] sky130_fd_sc_hd__clkbuf_4
X_07974_ _02091_ _02092_ _01977_ _01979_ vssd1 vssd1 vccd1 vccd1 _02094_ sky130_fd_sc_hd__o211a_1
XFILLER_0_93_51 vssd1 vssd1 vccd1 vccd1 sky130_fd_sc_hd__decap_4
X_09713_ _03815_ _03819_ _03820_ vssd1 vssd1 vccd1 vccd1 _03821_ sky130_fd_sc_hd__nand3_1
X_06925_ _01017_ _01049_ vssd1 vssd1 vccd1 vccd1 _01050_ sky130_fd_sc_hd__nand2_1
X_09644_ _03591_ _03629_ net487 _03633_ vssd1 vssd1 vccd1 vccd1 _03752_ sky130_fd_sc_hd__o31ai_4
X_06856_ net691 net677 vssd1 vssd1 vccd1 vccd1 _00986_ sky130_fd_sc_hd__or2_2
X_09575_ _03511_ _03512_ _03513_ vssd1 vssd1 vccd1 vccd1 _03684_ sky130_fd_sc_hd__a21bo_1
X_06787_ net403 net1260 net641 vssd1 vssd1 vccd1 vccd1 _00061_ sky130_fd_sc_hd__mux2_1
XTAP_1029 vssd1 vccd1 sky130_fd_sc_hd__tapvpwrvgnd_1
XTAP_1018 vssd1 vccd1 sky130_fd_sc_hd__tapvpwrvgnd_1
XTAP_1007 vssd1 vccd1 sky130_fd_sc_hd__tapvpwrvgnd_1
X_08526_ _02632_ _02639_ _02640_ vssd1 vssd1 vccd1 vccd1 _02642_ sky130_fd_sc_hd__nand3_2
X_08457_ _02571_ _02572_ vssd1 vssd1 vccd1 vccd1 _02573_ sky130_fd_sc_hd__nand2b_1
XFILLER_0_92_334 vssd1 vssd1 vccd1 vccd1 sky130_fd_sc_hd__decap_8
XFILLER_0_37_228 vssd1 vssd1 vccd1 vccd1 sky130_fd_sc_hd__decap_4
XFILLER_0_107_105 vssd1 vssd1 vccd1 vccd1 sky130_fd_sc_hd__decap_6
X_07408_ net880 net1128 _01523_ _01522_ vssd1 vssd1 vccd1 vccd1 _01533_ sky130_fd_sc_hd__a31o_1
XFILLER_0_123_609 vssd1 vssd1 vccd1 vccd1 sky130_fd_sc_hd__decap_6
XFILLER_0_107_149 vssd1 vssd1 vccd1 vccd1 sky130_ef_sc_hd__decap_12
XFILLER_0_80_518 vssd1 vssd1 vccd1 vccd1 sky130_fd_sc_hd__fill_1
XFILLER_0_61_721 vssd1 vssd1 vccd1 vccd1 sky130_fd_sc_hd__decap_6
X_08388_ _02503_ _02504_ _02502_ vssd1 vssd1 vccd1 vccd1 _02505_ sky130_fd_sc_hd__a21o_1
X_07339_ _01447_ _01449_ vssd1 vssd1 vccd1 vccd1 _01464_ sky130_fd_sc_hd__xnor2_1
XFILLER_0_115_193 vssd1 vssd1 vccd1 vccd1 sky130_ef_sc_hd__decap_12
XFILLER_0_103_333 vssd1 vssd1 vccd1 vccd1 sky130_fd_sc_hd__decap_3
X_10350_ _04453_ vssd1 vssd1 vccd1 vccd1 _04454_ sky130_fd_sc_hd__inv_2
XFILLER_0_33_489 vssd1 vssd1 vccd1 vccd1 sky130_fd_sc_hd__fill_1
XFILLER_0_130_141 vssd1 vssd1 vccd1 vccd1 sky130_fd_sc_hd__decap_4
X_09009_ _03119_ _03120_ vssd1 vssd1 vccd1 vccd1 _03121_ sky130_fd_sc_hd__or2_1
X_10281_ net1072 net715 net710 net1079 vssd1 vssd1 vccd1 vccd1 _04385_ sky130_fd_sc_hd__a22o_1
X_12020_ net143 net662 net505 net239 _06019_ vssd1 vssd1 vccd1 vccd1 _06020_ sky130_fd_sc_hd__a221o_1
Xfanout550 net553 vssd1 vssd1 vccd1 vccd1 net550 sky130_fd_sc_hd__clkbuf_2
Xfanout561 _06271_ vssd1 vssd1 vccd1 vccd1 net561 sky130_fd_sc_hd__buf_2
Xfanout583 net584 vssd1 vssd1 vccd1 vccd1 net583 sky130_fd_sc_hd__clkbuf_4
Xfanout572 net573 vssd1 vssd1 vccd1 vccd1 net572 sky130_fd_sc_hd__buf_4
Xfanout594 _05759_ vssd1 vssd1 vccd1 vccd1 net594 sky130_fd_sc_hd__clkbuf_4
X_12922_ clknet_leaf_33_clk_i _00308_ vssd1 vssd1 vccd1 vccd1 mul1.b\[25\] sky130_fd_sc_hd__dfxtp_1
XTAP_2253 vssd1 vccd1 sky130_fd_sc_hd__tapvpwrvgnd_1
XTAP_2242 vssd1 vccd1 sky130_fd_sc_hd__tapvpwrvgnd_1
XTAP_2231 vssd1 vccd1 sky130_fd_sc_hd__tapvpwrvgnd_1
XTAP_2220 vssd1 vccd1 sky130_fd_sc_hd__tapvpwrvgnd_1
XFILLER_0_87_128 vssd1 vssd1 vccd1 vccd1 sky130_ef_sc_hd__decap_12
X_12853_ clknet_leaf_35_clk_i _00239_ vssd1 vssd1 vccd1 vccd1 sub1.b_i\[20\] sky130_fd_sc_hd__dfxtp_1
XTAP_1541 vssd1 vccd1 sky130_fd_sc_hd__tapvpwrvgnd_1
XTAP_1530 vssd1 vccd1 sky130_fd_sc_hd__tapvpwrvgnd_1
XFILLER_0_68_342 vssd1 vssd1 vccd1 vccd1 sky130_fd_sc_hd__decap_3
X_12784_ clknet_leaf_40_clk_i _00170_ vssd1 vssd1 vccd1 vccd1 add1.b_i\[15\] sky130_fd_sc_hd__dfxtp_1
X_11804_ net39 net687 net678 net66 vssd1 vssd1 vccd1 vccd1 _05848_ sky130_fd_sc_hd__a22o_1
XFILLER_0_113_27 vssd1 vssd1 vccd1 vccd1 sky130_ef_sc_hd__decap_12
XTAP_1585 vssd1 vccd1 sky130_fd_sc_hd__tapvpwrvgnd_1
XTAP_1563 vssd1 vccd1 sky130_fd_sc_hd__tapvpwrvgnd_1
XTAP_1574 vssd1 vccd1 sky130_fd_sc_hd__tapvpwrvgnd_1
XTAP_1552 vssd1 vccd1 sky130_fd_sc_hd__tapvpwrvgnd_1
XFILLER_0_83_334 vssd1 vssd1 vccd1 vccd1 sky130_fd_sc_hd__fill_2
XPHY_92 vssd1 vssd1 vccd1 vccd1 sky130_fd_sc_hd__decap_3
X_11735_ net651 _00833_ net473 net181 _05790_ vssd1 vssd1 vccd1 vccd1 _05791_ sky130_fd_sc_hd__a221o_1
XPHY_70 vssd1 vssd1 vccd1 vccd1 sky130_fd_sc_hd__decap_3
XPHY_81 vssd1 vssd1 vccd1 vccd1 sky130_fd_sc_hd__decap_3
XFILLER_0_126_403 vssd1 vssd1 vccd1 vccd1 sky130_ef_sc_hd__decap_12
XTAP_1596 vssd1 vccd1 sky130_fd_sc_hd__tapvpwrvgnd_1
XFILLER_0_126_436 vssd1 vssd1 vccd1 vccd1 sky130_ef_sc_hd__decap_12
XFILLER_0_83_389 vssd1 vssd1 vccd1 vccd1 sky130_fd_sc_hd__decap_3
X_11666_ net1599 _01952_ net536 vssd1 vssd1 vccd1 vccd1 _00158_ sky130_fd_sc_hd__mux2_1
XFILLER_0_22_69 vssd1 vssd1 vccd1 vccd1 sky130_fd_sc_hd__fill_1
XFILLER_0_98_29 vssd1 vssd1 vccd1 vccd1 sky130_ef_sc_hd__decap_12
X_10617_ _04717_ _04718_ vssd1 vssd1 vccd1 vccd1 _04719_ sky130_fd_sc_hd__xnor2_1
XFILLER_0_4_829 vssd1 vssd1 vccd1 vccd1 sky130_fd_sc_hd__fill_2
X_11597_ _05681_ _05690_ vssd1 vssd1 vccd1 vccd1 _05691_ sky130_fd_sc_hd__xnor2_1
X_10548_ _04648_ _04649_ _04419_ _04423_ vssd1 vssd1 vccd1 vccd1 _04651_ sky130_fd_sc_hd__o211a_1
XFILLER_0_51_286 vssd1 vssd1 vccd1 vccd1 sky130_fd_sc_hd__fill_1
X_10479_ _04487_ _04489_ vssd1 vssd1 vccd1 vccd1 _04582_ sky130_fd_sc_hd__nand2_1
X_12218_ net782 _06165_ net516 vssd1 vssd1 vccd1 vccd1 _00300_ sky130_fd_sc_hd__mux2_1
X_13198_ clknet_leaf_15_clk_i _00584_ net1183 vssd1 vssd1 vccd1 vccd1 l1\[27\] sky130_fd_sc_hd__dfrtp_1
X_12149_ y2my0\[28\] net588 net534 x2mx1\[28\] _06117_ vssd1 vssd1 vccd1 vccd1 _06118_
+ sky130_fd_sc_hd__a221o_1
X_06710_ _00929_ _00930_ vssd1 vssd1 vccd1 vccd1 _00931_ sky130_fd_sc_hd__or2_2
X_07690_ _01811_ _01812_ vssd1 vssd1 vccd1 vccd1 _01813_ sky130_fd_sc_hd__nand2b_1
XFILLER_0_59_320 vssd1 vssd1 vccd1 vccd1 sky130_fd_sc_hd__decap_3
X_06641_ _00869_ _00871_ _00868_ vssd1 vssd1 vccd1 vccd1 _00873_ sky130_fd_sc_hd__o21bai_4
X_09360_ net1063 net761 net754 net1071 vssd1 vssd1 vccd1 vccd1 _03470_ sky130_fd_sc_hd__a22o_1
XFILLER_0_87_673 vssd1 vssd1 vccd1 vccd1 sky130_fd_sc_hd__decap_4
X_06572_ sub1.a_i\[2\] sub1.b_i\[2\] vssd1 vssd1 vccd1 vccd1 _00815_ sky130_fd_sc_hd__nand2b_1
X_08311_ net1122 net748 net740 net1131 vssd1 vssd1 vccd1 vccd1 _02428_ sky130_fd_sc_hd__a22oi_1
X_09291_ _03339_ _03340_ _03398_ _03399_ vssd1 vssd1 vccd1 vccd1 _03402_ sky130_fd_sc_hd__o22ai_2
XFILLER_0_86_161 vssd1 vssd1 vccd1 vccd1 sky130_fd_sc_hd__decap_8
XFILLER_0_47_526 vssd1 vssd1 vccd1 vccd1 sky130_fd_sc_hd__decap_6
X_08242_ net882 net1000 vssd1 vssd1 vccd1 vccd1 _02360_ sky130_fd_sc_hd__nand2_1
XANTENNA_13 v0x[25] vssd1 vssd1 vccd1 vccd1 sky130_fd_sc_hd__diode_2
XANTENNA_46 _00794_ vssd1 vssd1 vccd1 vccd1 sky130_fd_sc_hd__diode_2
XFILLER_0_117_447 vssd1 vssd1 vccd1 vccd1 sky130_fd_sc_hd__fill_1
XANTENNA_35 net49 vssd1 vssd1 vccd1 vccd1 sky130_fd_sc_hd__diode_2
XANTENNA_24 v2x[11] vssd1 vssd1 vccd1 vccd1 sky130_fd_sc_hd__diode_2
XANTENNA_57 v1y[26] vssd1 vssd1 vccd1 vccd1 sky130_fd_sc_hd__diode_2
XFILLER_0_103_93 vssd1 vssd1 vccd1 vccd1 sky130_ef_sc_hd__decap_12
X_08173_ _02289_ _02290_ vssd1 vssd1 vccd1 vccd1 _02291_ sky130_fd_sc_hd__and2_1
XANTENNA_68 v0y[25] vssd1 vssd1 vccd1 vccd1 sky130_fd_sc_hd__diode_2
XFILLER_0_42_231 vssd1 vssd1 vccd1 vccd1 sky130_fd_sc_hd__decap_6
X_07124_ _01167_ _01169_ _01248_ vssd1 vssd1 vccd1 vccd1 _01249_ sky130_fd_sc_hd__a21o_2
XFILLER_0_113_653 vssd1 vssd1 vccd1 vccd1 sky130_ef_sc_hd__decap_12
XFILLER_0_112_141 vssd1 vssd1 vccd1 vccd1 sky130_ef_sc_hd__decap_12
XFILLER_0_70_595 vssd1 vssd1 vccd1 vccd1 sky130_fd_sc_hd__fill_1
XFILLER_0_70_3 vssd1 vssd1 vccd1 vccd1 sky130_ef_sc_hd__decap_12
XFILLER_0_30_415 vssd1 vssd1 vccd1 vccd1 sky130_fd_sc_hd__decap_4
X_07055_ _01178_ _01179_ vssd1 vssd1 vccd1 vccd1 _01180_ sky130_fd_sc_hd__nor2_1
XFILLER_0_113_697 vssd1 vssd1 vccd1 vccd1 sky130_ef_sc_hd__decap_12
XFILLER_0_11_673 vssd1 vssd1 vccd1 vccd1 sky130_fd_sc_hd__decap_4
X_07957_ net822 _01988_ _01989_ _01986_ vssd1 vssd1 vccd1 vccd1 _02077_ sky130_fd_sc_hd__o2bb2a_1
X_06908_ _01030_ _01032_ vssd1 vssd1 vccd1 vccd1 _01033_ sky130_fd_sc_hd__and2b_1
Xmax_cap15 _04465_ vssd1 vssd1 vccd1 vccd1 net1756 sky130_fd_sc_hd__clkbuf_1
X_07888_ net1033 net1042 net874 net865 vssd1 vssd1 vccd1 vccd1 _02009_ sky130_fd_sc_hd__and4_1
X_06839_ net1488 net1416 net647 vssd1 vssd1 vccd1 vccd1 _00113_ sky130_fd_sc_hd__mux2_1
X_09627_ _03733_ _03734_ _03634_ vssd1 vssd1 vccd1 vccd1 _03736_ sky130_fd_sc_hd__a21oi_1
X_09558_ _03521_ _03524_ _03665_ _03666_ vssd1 vssd1 vccd1 vccd1 _03667_ sky130_fd_sc_hd__a211o_1
X_08509_ _02618_ _02623_ vssd1 vssd1 vccd1 vccd1 _02625_ sky130_fd_sc_hd__xnor2_2
X_09489_ net707 _03597_ _03596_ vssd1 vssd1 vccd1 vccd1 _03598_ sky130_fd_sc_hd__a21bo_1
XFILLER_0_65_345 vssd1 vssd1 vccd1 vccd1 sky130_fd_sc_hd__decap_3
X_11520_ net1012 net702 vssd1 vssd1 vccd1 vccd1 _05615_ sky130_fd_sc_hd__nand2_1
XFILLER_0_92_175 vssd1 vssd1 vccd1 vccd1 sky130_ef_sc_hd__decap_12
XFILLER_0_80_304 vssd1 vssd1 vccd1 vccd1 sky130_fd_sc_hd__decap_4
XFILLER_0_65_378 vssd1 vssd1 vccd1 vccd1 sky130_fd_sc_hd__decap_8
XFILLER_0_123_417 vssd1 vssd1 vccd1 vccd1 sky130_ef_sc_hd__decap_12
XFILLER_0_92_197 vssd1 vssd1 vccd1 vccd1 sky130_fd_sc_hd__fill_2
X_11451_ _05543_ _05544_ _05423_ _05425_ vssd1 vssd1 vccd1 vccd1 _05547_ sky130_fd_sc_hd__a211oi_1
X_10402_ _04468_ _04469_ _04504_ _04505_ vssd1 vssd1 vccd1 vccd1 _04506_ sky130_fd_sc_hd__and4bb_2
X_11382_ _05475_ _05476_ vssd1 vssd1 vccd1 vccd1 _05478_ sky130_fd_sc_hd__xor2_1
X_13121_ clknet_leaf_2_clk_i _00507_ vssd1 vssd1 vccd1 vccd1 det_t\[14\] sky130_fd_sc_hd__dfxtp_1
X_10333_ _04432_ _04435_ _04436_ vssd1 vssd1 vccd1 vccd1 _04437_ sky130_fd_sc_hd__nand3_1
XFILLER_0_0_309 vssd1 vssd1 vccd1 vccd1 sky130_fd_sc_hd__fill_2
XFILLER_0_103_185 vssd1 vssd1 vccd1 vccd1 sky130_fd_sc_hd__fill_1
X_10264_ _04367_ _04368_ vssd1 vssd1 vccd1 vccd1 _04369_ sky130_fd_sc_hd__or2_1
X_13052_ clknet_leaf_53_clk_i _00438_ net1155 vssd1 vssd1 vccd1 vccd1 y2my0\[9\] sky130_fd_sc_hd__dfrtp_1
X_10195_ _04299_ vssd1 vssd1 vccd1 vccd1 _04300_ sky130_fd_sc_hd__inv_2
X_12003_ net19 net552 net626 net203 _06006_ vssd1 vssd1 vccd1 vccd1 _06007_ sky130_fd_sc_hd__a221o_1
XFILLER_0_108_27 vssd1 vssd1 vccd1 vccd1 sky130_fd_sc_hd__fill_1
XFILLER_0_17_69 vssd1 vssd1 vccd1 vccd1 sky130_ef_sc_hd__decap_12
X_12905_ clknet_leaf_44_clk_i _00291_ vssd1 vssd1 vccd1 vccd1 mul1.b\[8\] sky130_fd_sc_hd__dfxtp_2
XTAP_2061 vssd1 vccd1 sky130_fd_sc_hd__tapvpwrvgnd_1
XTAP_2050 vssd1 vccd1 sky130_fd_sc_hd__tapvpwrvgnd_1
XFILLER_0_75_109 vssd1 vssd1 vccd1 vccd1 sky130_fd_sc_hd__decap_3
XFILLER_0_69_673 vssd1 vssd1 vccd1 vccd1 sky130_fd_sc_hd__decap_4
X_12836_ clknet_leaf_55_clk_i _00222_ vssd1 vssd1 vccd1 vccd1 sub1.b_i\[3\] sky130_fd_sc_hd__dfxtp_1
XFILLER_0_33_13 vssd1 vssd1 vccd1 vccd1 sky130_fd_sc_hd__fill_1
XTAP_2094 vssd1 vccd1 sky130_fd_sc_hd__tapvpwrvgnd_1
XTAP_2083 vssd1 vccd1 sky130_fd_sc_hd__tapvpwrvgnd_1
XTAP_2072 vssd1 vccd1 sky130_fd_sc_hd__tapvpwrvgnd_1
XFILLER_0_33_35 vssd1 vssd1 vccd1 vccd1 sky130_fd_sc_hd__decap_3
XFILLER_0_127_712 vssd1 vssd1 vccd1 vccd1 sky130_ef_sc_hd__decap_12
XTAP_1393 vssd1 vccd1 sky130_fd_sc_hd__tapvpwrvgnd_1
XTAP_1371 vssd1 vccd1 sky130_fd_sc_hd__tapvpwrvgnd_1
XTAP_1382 vssd1 vccd1 sky130_fd_sc_hd__tapvpwrvgnd_1
XTAP_1360 vssd1 vccd1 sky130_fd_sc_hd__tapvpwrvgnd_1
X_12767_ clknet_leaf_23_clk_i _00153_ vssd1 vssd1 vccd1 vccd1 add1.a_i\[30\] sky130_fd_sc_hd__dfxtp_1
X_12698_ clknet_leaf_13_clk_i _00084_ net1187 vssd1 vssd1 vccd1 vccd1 net429 sky130_fd_sc_hd__dfrtp_1
X_11718_ net240 net598 net578 net144 _05776_ vssd1 vssd1 vccd1 vccd1 _05777_ sky130_fd_sc_hd__a221o_1
Xinput22 div_sstream_i[28] vssd1 vssd1 vccd1 vccd1 net22 sky130_fd_sc_hd__buf_4
Xinput11 div_sstream_i[18] vssd1 vssd1 vccd1 vccd1 net11 sky130_fd_sc_hd__clkbuf_8
XFILLER_0_4_604 vssd1 vssd1 vccd1 vccd1 sky130_fd_sc_hd__fill_1
X_11649_ _05731_ _05742_ vssd1 vssd1 vccd1 vccd1 _05743_ sky130_fd_sc_hd__xnor2_1
Xinput33 div_sstream_i[8] vssd1 vssd1 vccd1 vccd1 net33 sky130_fd_sc_hd__clkbuf_8
XFILLER_0_109_3 vssd1 vssd1 vccd1 vccd1 sky130_ef_sc_hd__decap_12
Xinput44 sstream_i[15] vssd1 vssd1 vccd1 vccd1 net44 sky130_fd_sc_hd__buf_4
XFILLER_0_52_551 vssd1 vssd1 vccd1 vccd1 sky130_fd_sc_hd__fill_2
Xinput55 sstream_i[7] vssd1 vssd1 vccd1 vccd1 net55 sky130_fd_sc_hd__clkbuf_1
XFILLER_0_52_584 vssd1 vssd1 vccd1 vccd1 sky130_fd_sc_hd__decap_4
Xinput77 v0x[27] vssd1 vssd1 vccd1 vccd1 net77 sky130_fd_sc_hd__buf_1
XFILLER_0_3_169 vssd1 vssd1 vccd1 vccd1 sky130_fd_sc_hd__fill_2
Xinput88 v0x[8] vssd1 vssd1 vccd1 vccd1 net88 sky130_fd_sc_hd__buf_1
Xinput66 v0x[17] vssd1 vssd1 vccd1 vccd1 net66 sky130_fd_sc_hd__buf_1
XFILLER_0_110_601 vssd1 vssd1 vccd1 vccd1 sky130_ef_sc_hd__decap_12
Xinput99 v0y[18] vssd1 vssd1 vccd1 vccd1 net99 sky130_fd_sc_hd__buf_1
XFILLER_0_0_810 vssd1 vssd1 vccd1 vccd1 sky130_fd_sc_hd__fill_2
XFILLER_0_110_645 vssd1 vssd1 vccd1 vccd1 sky130_ef_sc_hd__decap_12
X_08860_ net1133 net720 vssd1 vssd1 vccd1 vccd1 _02973_ sky130_fd_sc_hd__nand2_1
X_07811_ _01896_ _01897_ _01930_ _01931_ vssd1 vssd1 vccd1 vccd1 _01933_ sky130_fd_sc_hd__nor4_1
XFILLER_0_42_7 vssd1 vssd1 vccd1 vccd1 sky130_fd_sc_hd__fill_1
X_08791_ _02748_ _02750_ _02902_ _02903_ vssd1 vssd1 vccd1 vccd1 _02905_ sky130_fd_sc_hd__o211a_1
X_07742_ net795 _01863_ _01862_ vssd1 vssd1 vccd1 vccd1 _01864_ sky130_fd_sc_hd__a21bo_1
X_07673_ _01690_ _01692_ vssd1 vssd1 vccd1 vccd1 _01796_ sky130_fd_sc_hd__or2_1
XFILLER_0_94_418 vssd1 vssd1 vccd1 vccd1 sky130_fd_sc_hd__fill_2
X_09412_ _03519_ _03520_ _03505_ vssd1 vssd1 vccd1 vccd1 _03522_ sky130_fd_sc_hd__a21o_1
XFILLER_0_48_813 vssd1 vssd1 vccd1 vccd1 sky130_fd_sc_hd__fill_2
X_06624_ _00593_ sub1.b_i\[9\] sub1.b_i\[8\] vssd1 vssd1 vccd1 vccd1 _00859_ sky130_fd_sc_hd__a21oi_1
X_09343_ _03450_ _03451_ _03446_ vssd1 vssd1 vccd1 vccd1 _03453_ sky130_fd_sc_hd__a21o_1
XFILLER_0_90_41 vssd1 vssd1 vccd1 vccd1 sky130_ef_sc_hd__decap_12
XFILLER_0_48_835 vssd1 vssd1 vccd1 vccd1 sky130_fd_sc_hd__fill_1
XFILLER_0_118_701 vssd1 vssd1 vccd1 vccd1 sky130_ef_sc_hd__decap_12
XFILLER_0_90_85 vssd1 vssd1 vccd1 vccd1 sky130_fd_sc_hd__fill_1
X_06555_ _00802_ vssd1 vssd1 vccd1 vccd1 _00803_ sky130_fd_sc_hd__inv_2
XFILLER_0_90_624 vssd1 vssd1 vccd1 vccd1 sky130_fd_sc_hd__decap_4
XFILLER_0_75_676 vssd1 vssd1 vccd1 vccd1 sky130_fd_sc_hd__decap_3
X_09274_ _03381_ _03382_ _03383_ vssd1 vssd1 vccd1 vccd1 _03385_ sky130_fd_sc_hd__a21o_1
X_06486_ _00776_ _00778_ _00775_ vssd1 vssd1 vccd1 vccd1 _00780_ sky130_fd_sc_hd__a21bo_2
X_08225_ _02339_ _02340_ _02341_ vssd1 vssd1 vccd1 vccd1 _02343_ sky130_fd_sc_hd__a21o_1
X_08156_ _02064_ _02157_ _02156_ vssd1 vssd1 vccd1 vccd1 _02275_ sky130_fd_sc_hd__a21oi_2
XFILLER_0_43_573 vssd1 vssd1 vccd1 vccd1 sky130_fd_sc_hd__fill_1
X_07107_ _01229_ _01231_ _01159_ _01172_ vssd1 vssd1 vccd1 vccd1 _01232_ sky130_fd_sc_hd__o211a_1
XFILLER_0_113_461 vssd1 vssd1 vccd1 vccd1 sky130_ef_sc_hd__decap_12
X_08087_ _02203_ _02204_ _02110_ _02113_ vssd1 vssd1 vccd1 vccd1 _02206_ sky130_fd_sc_hd__o211a_1
X_07038_ net872 net1081 net1088 net863 vssd1 vssd1 vccd1 vccd1 _01163_ sky130_fd_sc_hd__a22o_1
XFILLER_0_101_667 vssd1 vssd1 vccd1 vccd1 sky130_fd_sc_hd__decap_4
XFILLER_0_100_166 vssd1 vssd1 vccd1 vccd1 sky130_ef_sc_hd__decap_12
X_08989_ _03100_ _03101_ vssd1 vssd1 vccd1 vccd1 _03102_ sky130_fd_sc_hd__nand2_2
XFILLER_0_98_713 vssd1 vssd1 vccd1 vccd1 sky130_ef_sc_hd__decap_12
XFILLER_0_97_223 vssd1 vssd1 vccd1 vccd1 sky130_fd_sc_hd__fill_1
X_10951_ _05042_ _05049_ vssd1 vssd1 vccd1 vccd1 _05051_ sky130_fd_sc_hd__xnor2_1
X_10882_ _04980_ _04981_ vssd1 vssd1 vccd1 vccd1 _04982_ sky130_fd_sc_hd__nand2b_2
X_12621_ clknet_leaf_36_clk_i _00007_ net1161 vssd1 vssd1 vccd1 vccd1 net394 sky130_fd_sc_hd__dfrtp_2
XFILLER_0_39_835 vssd1 vssd1 vccd1 vccd1 sky130_fd_sc_hd__decap_4
XFILLER_0_108_233 vssd1 vssd1 vccd1 vccd1 sky130_ef_sc_hd__decap_12
X_12552_ net1230 net27 net558 vssd1 vssd1 vccd1 vccd1 _00528_ sky130_fd_sc_hd__mux2_1
XFILLER_0_66_698 vssd1 vssd1 vccd1 vccd1 sky130_fd_sc_hd__fill_2
X_12483_ net1197 _00996_ vssd1 vssd1 vccd1 vccd1 _06238_ sky130_fd_sc_hd__nand2_1
XFILLER_0_109_778 vssd1 vssd1 vccd1 vccd1 sky130_fd_sc_hd__fill_2
X_11503_ _05595_ _05596_ vssd1 vssd1 vccd1 vccd1 _05598_ sky130_fd_sc_hd__and2_1
XFILLER_0_124_737 vssd1 vssd1 vccd1 vccd1 sky130_ef_sc_hd__decap_12
XFILLER_0_123_225 vssd1 vssd1 vccd1 vccd1 sky130_fd_sc_hd__fill_2
XFILLER_0_81_679 vssd1 vssd1 vccd1 vccd1 sky130_fd_sc_hd__decap_4
X_11434_ _05528_ _05529_ vssd1 vssd1 vccd1 vccd1 _05530_ sky130_fd_sc_hd__xnor2_1
XFILLER_0_80_189 vssd1 vssd1 vccd1 vccd1 sky130_fd_sc_hd__fill_1
XFILLER_0_21_223 vssd1 vssd1 vccd1 vccd1 sky130_fd_sc_hd__fill_1
X_11365_ _04958_ _05460_ vssd1 vssd1 vccd1 vccd1 _05461_ sky130_fd_sc_hd__xnor2_1
X_10316_ _04415_ _04417_ _04257_ _04260_ vssd1 vssd1 vccd1 vccd1 _04420_ sky130_fd_sc_hd__a211oi_1
X_13104_ clknet_leaf_24_clk_i _00490_ vssd1 vssd1 vccd1 vccd1 temp1\[29\] sky130_fd_sc_hd__dfxtp_1
X_11296_ _05267_ _05270_ vssd1 vssd1 vccd1 vccd1 _05393_ sky130_fd_sc_hd__or2_1
XFILLER_0_119_15 vssd1 vssd1 vccd1 vccd1 sky130_ef_sc_hd__decap_12
X_10247_ _04331_ _04332_ _04350_ _04351_ vssd1 vssd1 vccd1 vccd1 _04352_ sky130_fd_sc_hd__nor4_1
XTAP_429 vssd1 vccd1 sky130_fd_sc_hd__tapvpwrvgnd_1
XTAP_418 vssd1 vccd1 sky130_fd_sc_hd__tapvpwrvgnd_1
XTAP_407 vssd1 vccd1 sky130_fd_sc_hd__tapvpwrvgnd_1
X_13035_ clknet_leaf_33_clk_i _00421_ net1166 vssd1 vssd1 vccd1 vccd1 x0mx2\[24\]
+ sky130_fd_sc_hd__dfrtp_1
Xfanout1131 net1132 vssd1 vssd1 vccd1 vccd1 net1131 sky130_fd_sc_hd__clkbuf_4
Xfanout1120 net1121 vssd1 vssd1 vccd1 vccd1 net1120 sky130_fd_sc_hd__clkbuf_4
Xclkbuf_leaf_7_clk_i clknet_3_6__leaf_clk_i vssd1 vssd1 vccd1 vccd1 clknet_leaf_7_clk_i
+ sky130_fd_sc_hd__clkbuf_16
X_10178_ _04123_ _04125_ _04281_ _04282_ vssd1 vssd1 vccd1 vccd1 _04283_ sky130_fd_sc_hd__o211a_1
Xfanout1164 net1181 vssd1 vssd1 vccd1 vccd1 net1164 sky130_fd_sc_hd__buf_2
Xfanout1142 mul1.a\[1\] vssd1 vssd1 vccd1 vccd1 net1142 sky130_fd_sc_hd__clkbuf_8
Xfanout1153 net1154 vssd1 vssd1 vccd1 vccd1 net1153 sky130_fd_sc_hd__buf_2
Xfanout1197 net36 vssd1 vssd1 vccd1 vccd1 net1197 sky130_fd_sc_hd__clkbuf_4
Xfanout1186 net1189 vssd1 vssd1 vccd1 vccd1 net1186 sky130_fd_sc_hd__clkbuf_4
Xfanout1175 net1176 vssd1 vssd1 vccd1 vccd1 net1175 sky130_fd_sc_hd__clkbuf_4
XFILLER_0_88_245 vssd1 vssd1 vccd1 vccd1 sky130_fd_sc_hd__fill_2
XFILLER_0_44_45 vssd1 vssd1 vccd1 vccd1 sky130_fd_sc_hd__fill_1
XFILLER_0_76_418 vssd1 vssd1 vccd1 vccd1 sky130_fd_sc_hd__fill_2
X_12819_ clknet_leaf_36_clk_i _00205_ vssd1 vssd1 vccd1 vccd1 sub1.a_i\[18\] sky130_fd_sc_hd__dfxtp_1
XTAP_1190 vssd1 vccd1 sky130_fd_sc_hd__tapvpwrvgnd_1
XFILLER_0_57_665 vssd1 vssd1 vccd1 vccd1 sky130_fd_sc_hd__fill_1
X_06340_ _00648_ _00651_ vssd1 vssd1 vccd1 vccd1 _00652_ sky130_fd_sc_hd__nand2_4
XFILLER_0_115_715 vssd1 vssd1 vccd1 vccd1 sky130_fd_sc_hd__decap_6
XFILLER_0_127_597 vssd1 vssd1 vccd1 vccd1 sky130_ef_sc_hd__decap_12
X_08010_ _02128_ _02129_ vssd1 vssd1 vccd1 vccd1 _02130_ sky130_fd_sc_hd__nor2_1
XFILLER_0_102_409 vssd1 vssd1 vccd1 vccd1 sky130_fd_sc_hd__fill_2
XFILLER_0_80_690 vssd1 vssd1 vccd1 vccd1 sky130_fd_sc_hd__decap_8
XFILLER_0_71_189 vssd1 vssd1 vccd1 vccd1 sky130_fd_sc_hd__decap_8
XFILLER_0_69_64 vssd1 vssd1 vccd1 vccd1 sky130_fd_sc_hd__decap_3
XFILLER_0_100_83 vssd1 vssd1 vccd1 vccd1 sky130_fd_sc_hd__fill_1
X_09961_ _03907_ _04058_ _04057_ vssd1 vssd1 vccd1 vccd1 _04067_ sky130_fd_sc_hd__a21oi_4
XFILLER_0_40_587 vssd1 vssd1 vccd1 vccd1 sky130_fd_sc_hd__fill_1
XFILLER_0_110_475 vssd1 vssd1 vccd1 vccd1 sky130_fd_sc_hd__fill_1
X_08912_ _02902_ _02906_ _03023_ _03024_ vssd1 vssd1 vccd1 vccd1 _03025_ sky130_fd_sc_hd__a211o_2
X_09892_ net850 net842 net964 net958 vssd1 vssd1 vccd1 vccd1 _03999_ sky130_fd_sc_hd__nand4_2
XTAP_952 vssd1 vccd1 sky130_fd_sc_hd__tapvpwrvgnd_1
XTAP_941 vssd1 vccd1 sky130_fd_sc_hd__tapvpwrvgnd_1
XTAP_930 vssd1 vccd1 sky130_fd_sc_hd__tapvpwrvgnd_1
X_08843_ _02803_ _02805_ vssd1 vssd1 vccd1 vccd1 _02957_ sky130_fd_sc_hd__nor2_2
XTAP_996 vssd1 vccd1 sky130_fd_sc_hd__tapvpwrvgnd_1
XTAP_974 vssd1 vccd1 sky130_fd_sc_hd__tapvpwrvgnd_1
XTAP_985 vssd1 vccd1 sky130_fd_sc_hd__tapvpwrvgnd_1
XTAP_963 vssd1 vccd1 sky130_fd_sc_hd__tapvpwrvgnd_1
XFILLER_0_109_81 vssd1 vssd1 vccd1 vccd1 sky130_ef_sc_hd__decap_12
X_08774_ net1025 net825 net818 net1035 vssd1 vssd1 vccd1 vccd1 _02888_ sky130_fd_sc_hd__a22o_1
X_07725_ _01747_ _01749_ _01846_ _01847_ vssd1 vssd1 vccd1 vccd1 _01848_ sky130_fd_sc_hd__o211ai_2
XFILLER_0_95_749 vssd1 vssd1 vccd1 vccd1 sky130_fd_sc_hd__decap_3
XFILLER_0_95_727 vssd1 vssd1 vccd1 vccd1 sky130_fd_sc_hd__fill_1
X_07656_ _01777_ _01778_ vssd1 vssd1 vccd1 vccd1 _01779_ sky130_fd_sc_hd__or2_1
X_07587_ _01704_ _01709_ vssd1 vssd1 vccd1 vccd1 _01711_ sky130_fd_sc_hd__xnor2_1
XFILLER_0_48_643 vssd1 vssd1 vccd1 vccd1 sky130_fd_sc_hd__fill_1
X_06607_ _00836_ _00839_ _00835_ vssd1 vssd1 vccd1 vccd1 _00845_ sky130_fd_sc_hd__a21oi_2
X_06538_ net544 _00792_ vssd1 vssd1 vccd1 vccd1 net303 sky130_fd_sc_hd__nor2_1
XFILLER_0_118_531 vssd1 vssd1 vccd1 vccd1 sky130_fd_sc_hd__fill_1
X_09326_ net1149 net693 _03433_ _03434_ vssd1 vssd1 vccd1 vccd1 _03436_ sky130_fd_sc_hd__o22a_1
XFILLER_0_90_421 vssd1 vssd1 vccd1 vccd1 sky130_fd_sc_hd__fill_2
X_09257_ _03365_ _03366_ _03362_ vssd1 vssd1 vccd1 vccd1 _03368_ sky130_fd_sc_hd__a21o_1
XFILLER_0_106_748 vssd1 vssd1 vccd1 vccd1 sky130_fd_sc_hd__decap_8
XFILLER_0_105_225 vssd1 vssd1 vccd1 vccd1 sky130_ef_sc_hd__decap_12
X_08208_ _02224_ _02228_ _02324_ _02325_ vssd1 vssd1 vccd1 vccd1 _02326_ sky130_fd_sc_hd__a211o_1
X_06469_ add1.a_i\[28\] add1.b_i\[28\] vssd1 vssd1 vccd1 vccd1 _00766_ sky130_fd_sc_hd__nor2_1
X_09188_ _03297_ _03298_ _03281_ vssd1 vssd1 vccd1 vccd1 _03299_ sky130_fd_sc_hd__o21a_1
XFILLER_0_121_729 vssd1 vssd1 vccd1 vccd1 sky130_ef_sc_hd__decap_12
X_08139_ _02256_ _02257_ _02237_ vssd1 vssd1 vccd1 vccd1 _02258_ sky130_fd_sc_hd__a21oi_2
X_11150_ _05246_ _05247_ vssd1 vssd1 vccd1 vccd1 _05248_ sky130_fd_sc_hd__or2_1
XFILLER_0_101_453 vssd1 vssd1 vccd1 vccd1 sky130_fd_sc_hd__decap_3
X_10101_ _04205_ _04206_ vssd1 vssd1 vccd1 vccd1 _04207_ sky130_fd_sc_hd__nor2_1
X_11081_ _05161_ _05177_ _05178_ vssd1 vssd1 vccd1 vccd1 _05180_ sky130_fd_sc_hd__or3_2
Xinput201 v2x[23] vssd1 vssd1 vccd1 vccd1 net201 sky130_fd_sc_hd__buf_1
X_10032_ _04134_ _04135_ _04136_ vssd1 vssd1 vccd1 vccd1 _04138_ sky130_fd_sc_hd__a21bo_1
Xinput245 v2y[5] vssd1 vssd1 vccd1 vccd1 net245 sky130_fd_sc_hd__buf_1
Xinput212 v2x[4] vssd1 vssd1 vccd1 vccd1 net212 sky130_fd_sc_hd__buf_1
Xinput234 v2y[24] vssd1 vssd1 vccd1 vccd1 net234 sky130_fd_sc_hd__buf_1
Xinput223 v2y[14] vssd1 vssd1 vccd1 vccd1 net223 sky130_fd_sc_hd__buf_1
X_11983_ net14 net551 net627 net198 _05991_ vssd1 vssd1 vccd1 vccd1 _05992_ sky130_fd_sc_hd__a221o_1
X_10934_ _05032_ _05033_ vssd1 vssd1 vccd1 vccd1 _05034_ sky130_fd_sc_hd__nor2_1
XFILLER_0_58_429 vssd1 vssd1 vccd1 vccd1 sky130_fd_sc_hd__fill_1
X_10865_ net807 net945 vssd1 vssd1 vccd1 vccd1 _04965_ sky130_fd_sc_hd__nand2_1
XPHY_251 vssd1 vssd1 vccd1 vccd1 sky130_fd_sc_hd__decap_3
XPHY_240 vssd1 vssd1 vccd1 vccd1 sky130_fd_sc_hd__decap_3
XFILLER_0_109_520 vssd1 vssd1 vccd1 vccd1 sky130_fd_sc_hd__fill_1
XFILLER_0_66_451 vssd1 vssd1 vccd1 vccd1 sky130_fd_sc_hd__decap_6
X_12604_ net1220 net16 net555 vssd1 vssd1 vccd1 vccd1 _00579_ sky130_fd_sc_hd__mux2_1
XFILLER_0_54_602 vssd1 vssd1 vccd1 vccd1 sky130_fd_sc_hd__decap_6
X_12535_ _00749_ net569 _06264_ vssd1 vssd1 vccd1 vccd1 _00518_ sky130_fd_sc_hd__a21oi_1
XFILLER_0_124_501 vssd1 vssd1 vccd1 vccd1 sky130_ef_sc_hd__decap_12
XFILLER_0_121_27 vssd1 vssd1 vccd1 vccd1 sky130_ef_sc_hd__decap_12
XFILLER_0_109_542 vssd1 vssd1 vccd1 vccd1 sky130_fd_sc_hd__decap_4
X_10796_ net1045 net715 net710 net1055 vssd1 vssd1 vccd1 vccd1 _04897_ sky130_fd_sc_hd__a22o_1
XFILLER_0_38_175 vssd1 vssd1 vccd1 vccd1 sky130_fd_sc_hd__decap_6
XFILLER_0_109_597 vssd1 vssd1 vccd1 vccd1 sky130_ef_sc_hd__decap_12
XFILLER_0_124_545 vssd1 vssd1 vccd1 vccd1 sky130_ef_sc_hd__decap_12
X_12466_ _00935_ net617 _04952_ net576 _06195_ vssd1 vssd1 vccd1 vccd1 _06229_ sky130_fd_sc_hd__a221o_1
XFILLER_0_124_589 vssd1 vssd1 vccd1 vccd1 sky130_ef_sc_hd__decap_12
XFILLER_0_111_217 vssd1 vssd1 vccd1 vccd1 sky130_fd_sc_hd__decap_6
X_12397_ net1397 _00913_ net684 vssd1 vssd1 vccd1 vccd1 _00449_ sky130_fd_sc_hd__mux2_1
X_11417_ _05509_ _05510_ _05512_ vssd1 vssd1 vccd1 vccd1 _05513_ sky130_fd_sc_hd__or3b_1
XFILLER_0_104_280 vssd1 vssd1 vccd1 vccd1 sky130_fd_sc_hd__decap_4
X_11348_ _05443_ _05444_ vssd1 vssd1 vccd1 vccd1 _05445_ sky130_fd_sc_hd__or2_1
XFILLER_0_10_705 vssd1 vssd1 vccd1 vccd1 sky130_fd_sc_hd__decap_6
XFILLER_0_10_738 vssd1 vssd1 vccd1 vccd1 sky130_fd_sc_hd__fill_2
X_11279_ _05216_ _05218_ _05373_ _05375_ vssd1 vssd1 vccd1 vccd1 _05376_ sky130_fd_sc_hd__a211oi_4
X_13018_ clknet_leaf_53_clk_i _00404_ net1154 vssd1 vssd1 vccd1 vccd1 x0mx2\[7\] sky130_fd_sc_hd__dfrtp_1
XFILLER_0_55_55 vssd1 vssd1 vccd1 vccd1 sky130_fd_sc_hd__fill_1
X_07510_ _01618_ _01634_ vssd1 vssd1 vccd1 vccd1 _01635_ sky130_fd_sc_hd__nor2_1
X_08490_ net1034 net832 _02603_ _02604_ vssd1 vssd1 vccd1 vccd1 _02606_ sky130_fd_sc_hd__nand4_1
XFILLER_0_119_317 vssd1 vssd1 vccd1 vccd1 sky130_ef_sc_hd__decap_12
XFILLER_0_71_65 vssd1 vssd1 vccd1 vccd1 sky130_fd_sc_hd__fill_1
XFILLER_0_71_32 vssd1 vssd1 vccd1 vccd1 sky130_ef_sc_hd__decap_12
X_07441_ net881 net1136 vssd1 vssd1 vccd1 vccd1 _01566_ sky130_fd_sc_hd__nand2_1
XFILLER_0_92_719 vssd1 vssd1 vccd1 vccd1 sky130_ef_sc_hd__decap_12
XFILLER_0_57_440 vssd1 vssd1 vccd1 vccd1 sky130_fd_sc_hd__fill_2
X_07372_ _01482_ _01495_ _01439_ _01465_ vssd1 vssd1 vccd1 vccd1 _01497_ sky130_fd_sc_hd__o211ai_2
XFILLER_0_72_421 vssd1 vssd1 vccd1 vccd1 sky130_ef_sc_hd__decap_12
X_09111_ _03219_ _03222_ vssd1 vssd1 vccd1 vccd1 _03223_ sky130_fd_sc_hd__xor2_1
X_06323_ _00633_ _00634_ vssd1 vssd1 vccd1 vccd1 _00635_ sky130_fd_sc_hd__nand2_2
XFILLER_0_29_186 vssd1 vssd1 vccd1 vccd1 sky130_fd_sc_hd__fill_1
X_09042_ _03153_ vssd1 vssd1 vccd1 vccd1 _03154_ sky130_fd_sc_hd__inv_2
XFILLER_0_60_649 vssd1 vssd1 vccd1 vccd1 sky130_fd_sc_hd__fill_1
XFILLER_0_130_526 vssd1 vssd1 vccd1 vccd1 sky130_fd_sc_hd__decap_3
XFILLER_0_103_729 vssd1 vssd1 vccd1 vccd1 sky130_ef_sc_hd__decap_12
Xhold400 add1.a_i\[9\] vssd1 vssd1 vccd1 vccd1 net1615 sky130_fd_sc_hd__dlygate4sd3_1
Xhold411 add1.a_i\[26\] vssd1 vssd1 vccd1 vccd1 net1626 sky130_fd_sc_hd__dlygate4sd3_1
XFILLER_0_41_841 vssd1 vssd1 vccd1 vccd1 sky130_fd_sc_hd__fill_1
XFILLER_0_111_93 vssd1 vssd1 vccd1 vccd1 sky130_ef_sc_hd__decap_12
Xhold444 y1my2\[24\] vssd1 vssd1 vccd1 vccd1 net1659 sky130_fd_sc_hd__dlygate4sd3_1
Xhold422 y1my2\[27\] vssd1 vssd1 vccd1 vccd1 net1637 sky130_fd_sc_hd__dlygate4sd3_1
Xhold433 x2mx1\[13\] vssd1 vssd1 vccd1 vccd1 net1648 sky130_fd_sc_hd__dlygate4sd3_1
XFILLER_0_40_362 vssd1 vssd1 vccd1 vccd1 sky130_fd_sc_hd__fill_2
Xhold477 add1.a_i\[22\] vssd1 vssd1 vccd1 vccd1 net1692 sky130_fd_sc_hd__dlygate4sd3_1
Xhold455 y1my2\[4\] vssd1 vssd1 vccd1 vccd1 net1670 sky130_fd_sc_hd__dlygate4sd3_1
Xhold466 y1my2\[7\] vssd1 vssd1 vccd1 vccd1 net1681 sky130_fd_sc_hd__dlygate4sd3_1
X_09944_ _03953_ _04050_ vssd1 vssd1 vccd1 vccd1 _04051_ sky130_fd_sc_hd__xor2_4
Xfanout902 net903 vssd1 vssd1 vccd1 vccd1 net902 sky130_fd_sc_hd__clkbuf_2
Xfanout913 net914 vssd1 vssd1 vccd1 vccd1 net913 sky130_fd_sc_hd__buf_2
Xfanout924 net925 vssd1 vssd1 vccd1 vccd1 net924 sky130_fd_sc_hd__buf_2
Xhold488 add1.b_i\[6\] vssd1 vssd1 vccd1 vccd1 net1703 sky130_fd_sc_hd__dlygate4sd3_1
Xhold499 net449 vssd1 vssd1 vccd1 vccd1 net1714 sky130_fd_sc_hd__dlygate4sd3_1
X_09875_ _03979_ _03980_ _03981_ vssd1 vssd1 vccd1 vccd1 _03982_ sky130_fd_sc_hd__nand3_1
Xfanout968 mul1.a\[23\] vssd1 vssd1 vccd1 vccd1 net968 sky130_fd_sc_hd__clkbuf_4
Xfanout957 net960 vssd1 vssd1 vccd1 vccd1 net957 sky130_fd_sc_hd__buf_2
Xfanout946 net948 vssd1 vssd1 vccd1 vccd1 net946 sky130_fd_sc_hd__buf_2
XTAP_760 vssd1 vccd1 sky130_fd_sc_hd__tapvpwrvgnd_1
Xfanout935 net938 vssd1 vssd1 vccd1 vccd1 net935 sky130_fd_sc_hd__buf_2
XFILLER_0_99_307 vssd1 vssd1 vccd1 vccd1 sky130_fd_sc_hd__decap_6
X_08826_ _02936_ _02937_ _02784_ _02788_ vssd1 vssd1 vccd1 vccd1 _02940_ sky130_fd_sc_hd__o211a_1
Xfanout979 net981 vssd1 vssd1 vccd1 vccd1 net979 sky130_fd_sc_hd__buf_2
XTAP_771 vssd1 vccd1 sky130_fd_sc_hd__tapvpwrvgnd_1
XTAP_793 vssd1 vccd1 sky130_fd_sc_hd__tapvpwrvgnd_1
XTAP_782 vssd1 vccd1 sky130_fd_sc_hd__tapvpwrvgnd_1
X_08757_ net797 _02870_ _02869_ vssd1 vssd1 vccd1 vccd1 _02871_ sky130_fd_sc_hd__a21oi_1
XTAP_1915 vssd1 vccd1 sky130_fd_sc_hd__tapvpwrvgnd_1
XTAP_1904 vssd1 vccd1 sky130_fd_sc_hd__tapvpwrvgnd_1
XFILLER_0_95_502 vssd1 vssd1 vccd1 vccd1 sky130_fd_sc_hd__fill_2
X_08688_ _02659_ _02661_ _02801_ _02802_ vssd1 vssd1 vccd1 vccd1 _02803_ sky130_fd_sc_hd__o211a_1
X_07708_ _01828_ _01829_ _01830_ vssd1 vssd1 vccd1 vccd1 _01831_ sky130_fd_sc_hd__nand3_4
XTAP_1959 vssd1 vccd1 sky130_fd_sc_hd__tapvpwrvgnd_1
XTAP_1948 vssd1 vccd1 sky130_fd_sc_hd__tapvpwrvgnd_1
XTAP_1937 vssd1 vccd1 sky130_fd_sc_hd__tapvpwrvgnd_1
XTAP_1926 vssd1 vccd1 sky130_fd_sc_hd__tapvpwrvgnd_1
X_07639_ _01406_ _01754_ vssd1 vssd1 vccd1 vccd1 _01762_ sky130_fd_sc_hd__or2_1
X_10650_ _04600_ _04603_ vssd1 vssd1 vccd1 vccd1 _04752_ sky130_fd_sc_hd__nand2_1
XFILLER_0_91_741 vssd1 vssd1 vccd1 vccd1 sky130_fd_sc_hd__decap_8
X_09309_ _03417_ _03419_ vssd1 vssd1 vccd1 vccd1 _03420_ sky130_fd_sc_hd__xor2_4
XFILLER_0_75_281 vssd1 vssd1 vccd1 vccd1 sky130_fd_sc_hd__fill_1
XFILLER_0_48_473 vssd1 vssd1 vccd1 vccd1 sky130_fd_sc_hd__decap_3
XFILLER_0_35_101 vssd1 vssd1 vccd1 vccd1 sky130_fd_sc_hd__decap_3
X_10581_ _04681_ _04682_ vssd1 vssd1 vccd1 vccd1 _04683_ sky130_fd_sc_hd__nand2_1
XFILLER_0_35_156 vssd1 vssd1 vccd1 vccd1 sky130_fd_sc_hd__fill_1
XFILLER_0_106_545 vssd1 vssd1 vccd1 vccd1 sky130_fd_sc_hd__decap_4
X_12320_ net1689 _00846_ net666 vssd1 vssd1 vccd1 vccd1 _00372_ sky130_fd_sc_hd__mux2_1
XFILLER_0_50_126 vssd1 vssd1 vccd1 vccd1 sky130_fd_sc_hd__decap_6
X_12251_ net708 _06187_ net518 vssd1 vssd1 vccd1 vccd1 _00311_ sky130_fd_sc_hd__mux2_1
XFILLER_0_121_559 vssd1 vssd1 vccd1 vccd1 sky130_fd_sc_hd__fill_1
X_11202_ _05283_ _05298_ _05299_ vssd1 vssd1 vccd1 vccd1 _05300_ sky130_fd_sc_hd__or3_1
X_12182_ net886 _06141_ net513 vssd1 vssd1 vccd1 vccd1 _00288_ sky130_fd_sc_hd__mux2_1
X_11133_ net775 net766 net963 net957 vssd1 vssd1 vccd1 vccd1 _05231_ sky130_fd_sc_hd__and4_1
X_11064_ net1011 net1004 net729 net721 vssd1 vssd1 vccd1 vccd1 _05163_ sky130_fd_sc_hd__and4_1
X_10015_ _04119_ _04120_ vssd1 vssd1 vccd1 vccd1 _04121_ sky130_fd_sc_hd__xor2_2
XFILLER_0_99_841 vssd1 vssd1 vccd1 vccd1 sky130_fd_sc_hd__fill_1
XFILLER_0_116_27 vssd1 vssd1 vccd1 vccd1 sky130_fd_sc_hd__fill_1
XFILLER_0_58_215 vssd1 vssd1 vccd1 vccd1 sky130_fd_sc_hd__fill_1
X_11966_ net97 net622 net596 net65 vssd1 vssd1 vccd1 vccd1 _05979_ sky130_fd_sc_hd__a22o_1
XFILLER_0_129_626 vssd1 vssd1 vccd1 vccd1 sky130_ef_sc_hd__decap_12
XFILLER_0_129_615 vssd1 vssd1 vccd1 vccd1 sky130_fd_sc_hd__fill_1
Xclkbuf_leaf_10_clk_i clknet_3_6__leaf_clk_i vssd1 vssd1 vccd1 vccd1 clknet_leaf_10_clk_i
+ sky130_fd_sc_hd__clkbuf_16
XFILLER_0_86_557 vssd1 vssd1 vccd1 vccd1 sky130_fd_sc_hd__fill_2
XFILLER_0_58_226 vssd1 vssd1 vccd1 vccd1 sky130_fd_sc_hd__decap_8
X_10917_ _05013_ _05015_ _04847_ _04850_ vssd1 vssd1 vccd1 vccd1 _05017_ sky130_fd_sc_hd__o211a_1
XFILLER_0_129_648 vssd1 vssd1 vccd1 vccd1 sky130_fd_sc_hd__decap_6
XFILLER_0_128_136 vssd1 vssd1 vccd1 vccd1 sky130_fd_sc_hd__decap_4
X_11897_ net242 net601 net581 net146 _05926_ vssd1 vssd1 vccd1 vccd1 _05927_ sky130_fd_sc_hd__a221o_1
XFILLER_0_116_309 vssd1 vssd1 vccd1 vccd1 sky130_ef_sc_hd__decap_12
X_10848_ _04804_ _04806_ _04946_ _04948_ vssd1 vssd1 vccd1 vccd1 _04949_ sky130_fd_sc_hd__a211o_1
XFILLER_0_41_35 vssd1 vssd1 vccd1 vccd1 sky130_fd_sc_hd__fill_1
XFILLER_0_41_57 vssd1 vssd1 vccd1 vccd1 sky130_fd_sc_hd__fill_2
XFILLER_0_125_821 vssd1 vssd1 vccd1 vccd1 sky130_fd_sc_hd__decap_6
X_10779_ _04872_ _04879_ vssd1 vssd1 vccd1 vccd1 _04880_ sky130_fd_sc_hd__nand2_1
X_12518_ net1246 net563 vssd1 vssd1 vccd1 vccd1 _06256_ sky130_fd_sc_hd__nand2_1
XFILLER_0_81_273 vssd1 vssd1 vccd1 vccd1 sky130_fd_sc_hd__fill_1
Xclkbuf_leaf_25_clk_i clknet_3_5__leaf_clk_i vssd1 vssd1 vccd1 vccd1 clknet_leaf_25_clk_i
+ sky130_fd_sc_hd__clkbuf_16
XFILLER_0_23_841 vssd1 vssd1 vccd1 vccd1 sky130_fd_sc_hd__fill_1
X_12449_ net50 net687 _00903_ net615 vssd1 vssd1 vccd1 vccd1 _06218_ sky130_fd_sc_hd__a22o_1
XFILLER_0_1_256 vssd1 vssd1 vccd1 vccd1 sky130_fd_sc_hd__fill_1
XFILLER_0_120_581 vssd1 vssd1 vccd1 vccd1 sky130_fd_sc_hd__decap_6
X_07990_ _02013_ _02015_ _02109_ vssd1 vssd1 vccd1 vccd1 _02110_ sky130_fd_sc_hd__a21o_2
XFILLER_0_5_57 vssd1 vssd1 vccd1 vccd1 sky130_ef_sc_hd__decap_12
X_06941_ _01061_ _01064_ _01065_ _01053_ vssd1 vssd1 vccd1 vccd1 _01066_ sky130_fd_sc_hd__a211oi_2
X_09660_ _03602_ _03604_ _03767_ vssd1 vssd1 vccd1 vccd1 _03768_ sky130_fd_sc_hd__o21a_1
X_08611_ _02575_ _02583_ _02582_ vssd1 vssd1 vccd1 vccd1 _02726_ sky130_fd_sc_hd__a21bo_1
X_06872_ _00997_ _00999_ _01000_ vssd1 vssd1 vccd1 vccd1 _01001_ sky130_fd_sc_hd__or3_1
X_09591_ _03695_ _03698_ _03699_ vssd1 vssd1 vccd1 vccd1 _03700_ sky130_fd_sc_hd__and3_1
XFILLER_0_82_53 vssd1 vssd1 vccd1 vccd1 sky130_fd_sc_hd__fill_2
X_08542_ _02523_ _02525_ _02656_ _02657_ vssd1 vssd1 vccd1 vccd1 _02658_ sky130_fd_sc_hd__a211o_1
XFILLER_0_49_215 vssd1 vssd1 vccd1 vccd1 sky130_fd_sc_hd__fill_1
X_08473_ _02584_ _02585_ _02586_ vssd1 vssd1 vccd1 vccd1 _02589_ sky130_fd_sc_hd__a21o_1
XFILLER_0_77_535 vssd1 vssd1 vccd1 vccd1 sky130_ef_sc_hd__decap_12
XFILLER_0_119_125 vssd1 vssd1 vccd1 vccd1 sky130_ef_sc_hd__decap_12
X_07424_ _01543_ _01548_ _01547_ vssd1 vssd1 vccd1 vccd1 _01549_ sky130_fd_sc_hd__a21bo_1
XFILLER_0_119_169 vssd1 vssd1 vccd1 vccd1 sky130_ef_sc_hd__decap_12
XFILLER_0_128_692 vssd1 vssd1 vccd1 vccd1 sky130_fd_sc_hd__decap_4
XFILLER_0_116_821 vssd1 vssd1 vccd1 vccd1 sky130_fd_sc_hd__decap_4
X_07355_ _01473_ _01478_ _01479_ vssd1 vssd1 vccd1 vccd1 _01480_ sky130_fd_sc_hd__nand3_1
X_06306_ add1.a_i\[13\] add1.b_i\[13\] vssd1 vssd1 vccd1 vccd1 _00618_ sky130_fd_sc_hd__nand2_1
XFILLER_0_17_167 vssd1 vssd1 vccd1 vccd1 sky130_fd_sc_hd__fill_1
X_07286_ net904 net1097 vssd1 vssd1 vccd1 vccd1 _01411_ sky130_fd_sc_hd__and2_1
X_09025_ _03136_ vssd1 vssd1 vccd1 vccd1 _03137_ sky130_fd_sc_hd__inv_2
XFILLER_0_32_137 vssd1 vssd1 vccd1 vccd1 sky130_fd_sc_hd__decap_3
XFILLER_0_32_148 vssd1 vssd1 vccd1 vccd1 sky130_fd_sc_hd__decap_8
XFILLER_0_33_649 vssd1 vssd1 vccd1 vccd1 sky130_fd_sc_hd__fill_1
Xhold252 l0\[20\] vssd1 vssd1 vccd1 vccd1 net1467 sky130_fd_sc_hd__dlygate4sd3_1
Xhold230 net407 vssd1 vssd1 vccd1 vccd1 net1445 sky130_fd_sc_hd__dlygate4sd3_1
Xhold241 sub1.a_i\[0\] vssd1 vssd1 vccd1 vccd1 net1456 sky130_fd_sc_hd__dlygate4sd3_1
Xhold274 net344 vssd1 vssd1 vccd1 vccd1 net1489 sky130_fd_sc_hd__dlygate4sd3_1
Xhold285 l1\[12\] vssd1 vssd1 vccd1 vccd1 net1500 sky130_fd_sc_hd__dlygate4sd3_1
Xhold263 net371 vssd1 vssd1 vccd1 vccd1 net1478 sky130_fd_sc_hd__dlygate4sd3_1
Xhold296 y2my0\[29\] vssd1 vssd1 vccd1 vccd1 net1511 sky130_fd_sc_hd__dlygate4sd3_1
Xfanout732 net733 vssd1 vssd1 vccd1 vccd1 net732 sky130_fd_sc_hd__buf_4
Xfanout710 net711 vssd1 vssd1 vccd1 vccd1 net710 sky130_fd_sc_hd__clkbuf_4
X_09927_ _04031_ _04032_ _04033_ vssd1 vssd1 vccd1 vccd1 _04034_ sky130_fd_sc_hd__and3_1
Xfanout721 net722 vssd1 vssd1 vccd1 vccd1 net721 sky130_fd_sc_hd__buf_2
Xfanout754 mul1.b\[21\] vssd1 vssd1 vccd1 vccd1 net754 sky130_fd_sc_hd__clkbuf_4
Xfanout765 net766 vssd1 vssd1 vccd1 vccd1 net765 sky130_fd_sc_hd__clkbuf_4
Xfanout776 mul1.b\[18\] vssd1 vssd1 vccd1 vccd1 net776 sky130_fd_sc_hd__buf_2
Xfanout743 net747 vssd1 vssd1 vccd1 vccd1 net743 sky130_fd_sc_hd__clkbuf_2
X_09858_ net1038 net759 _03960_ _03962_ vssd1 vssd1 vccd1 vccd1 _03965_ sky130_fd_sc_hd__a22o_1
Xfanout787 net788 vssd1 vssd1 vccd1 vccd1 net787 sky130_fd_sc_hd__clkbuf_4
XTAP_590 vssd1 vccd1 sky130_fd_sc_hd__tapvpwrvgnd_1
Xfanout798 mul1.b\[15\] vssd1 vssd1 vccd1 vccd1 net798 sky130_fd_sc_hd__buf_2
X_09789_ _03895_ _03896_ vssd1 vssd1 vccd1 vccd1 _03897_ sky130_fd_sc_hd__nor2_1
X_08809_ net907 net955 vssd1 vssd1 vccd1 vccd1 _02923_ sky130_fd_sc_hd__and2_1
XFILLER_0_96_811 vssd1 vssd1 vccd1 vccd1 sky130_fd_sc_hd__fill_1
X_11820_ net100 net669 _05859_ _05861_ vssd1 vssd1 vccd1 vccd1 _05862_ sky130_fd_sc_hd__a211o_1
XTAP_1734 vssd1 vccd1 sky130_fd_sc_hd__tapvpwrvgnd_1
XTAP_1723 vssd1 vccd1 sky130_fd_sc_hd__tapvpwrvgnd_1
XTAP_1712 vssd1 vccd1 sky130_fd_sc_hd__tapvpwrvgnd_1
XFILLER_0_95_343 vssd1 vssd1 vccd1 vccd1 sky130_fd_sc_hd__fill_1
XFILLER_0_95_321 vssd1 vssd1 vccd1 vccd1 sky130_fd_sc_hd__fill_1
XTAP_1701 vssd1 vccd1 sky130_fd_sc_hd__tapvpwrvgnd_1
X_11751_ net651 _00852_ net473 _05803_ vssd1 vssd1 vccd1 vccd1 _05804_ sky130_fd_sc_hd__a211o_1
XTAP_1767 vssd1 vccd1 sky130_fd_sc_hd__tapvpwrvgnd_1
XTAP_1756 vssd1 vccd1 sky130_fd_sc_hd__tapvpwrvgnd_1
XTAP_1745 vssd1 vccd1 sky130_fd_sc_hd__tapvpwrvgnd_1
X_10702_ _04801_ _04802_ _04803_ vssd1 vssd1 vccd1 vccd1 _04804_ sky130_fd_sc_hd__or3_2
XFILLER_0_83_505 vssd1 vssd1 vccd1 vccd1 sky130_ef_sc_hd__decap_12
XTAP_1789 vssd1 vccd1 sky130_fd_sc_hd__tapvpwrvgnd_1
XTAP_1778 vssd1 vccd1 sky130_fd_sc_hd__tapvpwrvgnd_1
X_11682_ net1285 _04222_ net538 vssd1 vssd1 vccd1 vccd1 _00174_ sky130_fd_sc_hd__mux2_1
XFILLER_0_126_629 vssd1 vssd1 vccd1 vccd1 sky130_fd_sc_hd__fill_1
X_10633_ _04726_ _04734_ vssd1 vssd1 vccd1 vccd1 _04735_ sky130_fd_sc_hd__nand2_1
XFILLER_0_102_29 vssd1 vssd1 vccd1 vccd1 sky130_ef_sc_hd__decap_12
X_10564_ _04374_ _04521_ _04523_ vssd1 vssd1 vccd1 vccd1 _04667_ sky130_fd_sc_hd__a21oi_1
XFILLER_0_11_27 vssd1 vssd1 vccd1 vccd1 sky130_ef_sc_hd__decap_12
XFILLER_0_122_813 vssd1 vssd1 vccd1 vccd1 sky130_fd_sc_hd__fill_2
X_12303_ net1662 _00923_ net681 vssd1 vssd1 vccd1 vccd1 _00355_ sky130_fd_sc_hd__mux2_1
X_10495_ _04581_ _04595_ _04596_ vssd1 vssd1 vccd1 vccd1 _04598_ sky130_fd_sc_hd__and3_1
XFILLER_0_51_468 vssd1 vssd1 vccd1 vccd1 sky130_fd_sc_hd__fill_1
X_12234_ x2mx1\[23\] net606 net589 temp1\[23\] vssd1 vssd1 vccd1 vccd1 _06176_ sky130_fd_sc_hd__a22o_1
XFILLER_0_20_811 vssd1 vssd1 vccd1 vccd1 sky130_fd_sc_hd__fill_1
X_12165_ x2mx1\[0\] net602 net582 temp1\[0\] vssd1 vssd1 vccd1 vccd1 _06130_ sky130_fd_sc_hd__a22o_1
X_11116_ _05212_ _05213_ vssd1 vssd1 vccd1 vccd1 _05214_ sky130_fd_sc_hd__xnor2_1
XFILLER_0_127_15 vssd1 vssd1 vccd1 vccd1 sky130_ef_sc_hd__decap_12
X_12096_ x0mx2\[15\] net629 net591 y1my2\[15\] vssd1 vssd1 vccd1 vccd1 _06078_ sky130_fd_sc_hd__a22o_1
X_11047_ net1045 net703 vssd1 vssd1 vccd1 vccd1 _05146_ sky130_fd_sc_hd__nand2_1
Xinput9 div_sstream_i[16] vssd1 vssd1 vccd1 vccd1 net9 sky130_fd_sc_hd__clkbuf_8
XFILLER_0_99_671 vssd1 vssd1 vccd1 vccd1 sky130_fd_sc_hd__fill_1
XFILLER_0_86_321 vssd1 vssd1 vccd1 vccd1 sky130_fd_sc_hd__decap_4
X_12998_ clknet_leaf_37_clk_i _00384_ net1161 vssd1 vssd1 vccd1 vccd1 x2mx1\[19\]
+ sky130_fd_sc_hd__dfrtp_1
XFILLER_0_86_376 vssd1 vssd1 vccd1 vccd1 sky130_fd_sc_hd__fill_2
XFILLER_0_59_579 vssd1 vssd1 vccd1 vccd1 sky130_fd_sc_hd__decap_3
X_11949_ net1276 _05966_ net479 vssd1 vssd1 vccd1 vccd1 _00230_ sky130_fd_sc_hd__mux2_1
XFILLER_0_117_629 vssd1 vssd1 vccd1 vccd1 sky130_ef_sc_hd__decap_12
XFILLER_0_39_281 vssd1 vssd1 vccd1 vccd1 sky130_fd_sc_hd__decap_4
XFILLER_0_116_139 vssd1 vssd1 vccd1 vccd1 sky130_fd_sc_hd__fill_1
X_07140_ _01263_ _01264_ vssd1 vssd1 vccd1 vccd1 _01265_ sky130_fd_sc_hd__nor2_1
XFILLER_0_125_673 vssd1 vssd1 vccd1 vccd1 sky130_ef_sc_hd__decap_12
XFILLER_0_82_593 vssd1 vssd1 vccd1 vccd1 sky130_fd_sc_hd__fill_1
XFILLER_0_70_744 vssd1 vssd1 vccd1 vccd1 sky130_fd_sc_hd__decap_6
XFILLER_0_124_194 vssd1 vssd1 vccd1 vccd1 sky130_fd_sc_hd__fill_2
XFILLER_0_112_301 vssd1 vssd1 vccd1 vccd1 sky130_fd_sc_hd__decap_6
X_07071_ _01174_ _01175_ _01193_ _01194_ vssd1 vssd1 vccd1 vccd1 _01196_ sky130_fd_sc_hd__a2bb2oi_1
Xoutput313 net313 vssd1 vssd1 vccd1 vccd1 div_mstream_o[7] sky130_fd_sc_hd__clkbuf_4
Xoutput302 net302 vssd1 vssd1 vccd1 vccd1 div_mstream_o[6] sky130_fd_sc_hd__clkbuf_4
Xoutput324 net324 vssd1 vssd1 vccd1 vccd1 div_mstream_o[8] sky130_fd_sc_hd__clkbuf_4
XFILLER_0_112_345 vssd1 vssd1 vccd1 vccd1 sky130_ef_sc_hd__decap_12
Xoutput335 net335 vssd1 vssd1 vccd1 vccd1 mstream_o[0] sky130_fd_sc_hd__clkbuf_4
XFILLER_0_11_833 vssd1 vssd1 vccd1 vccd1 sky130_fd_sc_hd__fill_1
XFILLER_0_112_389 vssd1 vssd1 vccd1 vccd1 sky130_ef_sc_hd__decap_12
Xoutput357 net357 vssd1 vssd1 vccd1 vccd1 mstream_o[16] sky130_fd_sc_hd__clkbuf_4
Xoutput346 net346 vssd1 vssd1 vccd1 vccd1 mstream_o[10] sky130_fd_sc_hd__clkbuf_4
Xoutput368 net368 vssd1 vssd1 vccd1 vccd1 mstream_o[26] sky130_fd_sc_hd__clkbuf_4
Xoutput379 net379 vssd1 vssd1 vccd1 vccd1 mstream_o[36] sky130_fd_sc_hd__clkbuf_4
X_09712_ _03816_ _03817_ _03818_ vssd1 vssd1 vccd1 vccd1 _03820_ sky130_fd_sc_hd__a21bo_1
X_07973_ _01977_ _01979_ _02091_ _02092_ vssd1 vssd1 vccd1 vccd1 _02093_ sky130_fd_sc_hd__a211oi_2
X_06924_ net820 net1135 net1143 net813 vssd1 vssd1 vccd1 vccd1 _01049_ sky130_fd_sc_hd__a22o_1
X_09643_ _03606_ _03610_ vssd1 vssd1 vccd1 vccd1 _03751_ sky130_fd_sc_hd__or2_2
X_06855_ _00600_ _00613_ vssd1 vssd1 vccd1 vccd1 _00985_ sky130_fd_sc_hd__nor2_4
XFILLER_0_117_81 vssd1 vssd1 vccd1 vccd1 sky130_ef_sc_hd__decap_12
X_09574_ _03679_ _03680_ _03681_ vssd1 vssd1 vccd1 vccd1 _03683_ sky130_fd_sc_hd__a21o_1
X_06786_ net1406 net1376 net641 vssd1 vssd1 vccd1 vccd1 _00060_ sky130_fd_sc_hd__mux2_1
X_08525_ _02639_ _02640_ _02632_ vssd1 vssd1 vccd1 vccd1 _02641_ sky130_fd_sc_hd__a21o_1
XTAP_1019 vssd1 vccd1 sky130_fd_sc_hd__tapvpwrvgnd_1
XTAP_1008 vssd1 vccd1 sky130_fd_sc_hd__tapvpwrvgnd_1
XFILLER_0_77_354 vssd1 vssd1 vccd1 vccd1 sky130_fd_sc_hd__fill_2
XFILLER_0_65_505 vssd1 vssd1 vccd1 vccd1 sky130_fd_sc_hd__decap_4
X_08456_ _02568_ _02569_ _02570_ vssd1 vssd1 vccd1 vccd1 _02572_ sky130_fd_sc_hd__a21o_1
XFILLER_0_65_516 vssd1 vssd1 vccd1 vccd1 sky130_fd_sc_hd__decap_6
XFILLER_0_9_142 vssd1 vssd1 vccd1 vccd1 sky130_fd_sc_hd__decap_3
X_08387_ net921 net913 net967 net961 vssd1 vssd1 vccd1 vccd1 _02504_ sky130_fd_sc_hd__nand4_1
XFILLER_0_46_752 vssd1 vssd1 vccd1 vccd1 sky130_fd_sc_hd__decap_4
XFILLER_0_9_153 vssd1 vssd1 vccd1 vccd1 sky130_ef_sc_hd__decap_12
X_07407_ _01531_ vssd1 vssd1 vccd1 vccd1 _01532_ sky130_fd_sc_hd__inv_2
X_07338_ _01453_ _01454_ _01445_ vssd1 vssd1 vccd1 vccd1 _01463_ sky130_fd_sc_hd__a21o_1
XFILLER_0_33_413 vssd1 vssd1 vccd1 vccd1 sky130_fd_sc_hd__decap_4
XFILLER_0_122_109 vssd1 vssd1 vccd1 vccd1 sky130_ef_sc_hd__decap_12
XFILLER_0_115_161 vssd1 vssd1 vccd1 vccd1 sky130_fd_sc_hd__decap_6
XFILLER_0_103_301 vssd1 vssd1 vccd1 vccd1 sky130_ef_sc_hd__decap_12
X_07269_ _01233_ _01253_ _01392_ _01393_ vssd1 vssd1 vccd1 vccd1 _01394_ sky130_fd_sc_hd__o211ai_4
X_09008_ net1148 net705 _03116_ _03118_ vssd1 vssd1 vccd1 vccd1 _03120_ sky130_fd_sc_hd__a22oi_1
X_10280_ _04227_ _04266_ _04267_ _04270_ vssd1 vssd1 vccd1 vccd1 _04384_ sky130_fd_sc_hd__a31o_1
Xfanout551 net553 vssd1 vssd1 vccd1 vccd1 net551 sky130_fd_sc_hd__clkbuf_4
Xfanout540 net541 vssd1 vssd1 vccd1 vccd1 net540 sky130_fd_sc_hd__clkbuf_4
Xfanout562 net564 vssd1 vssd1 vccd1 vccd1 net562 sky130_fd_sc_hd__buf_2
Xfanout584 net586 vssd1 vssd1 vccd1 vccd1 net584 sky130_fd_sc_hd__clkbuf_4
Xfanout573 _06197_ vssd1 vssd1 vccd1 vccd1 net573 sky130_fd_sc_hd__clkbuf_4
Xfanout595 _05759_ vssd1 vssd1 vccd1 vccd1 net595 sky130_fd_sc_hd__clkbuf_2
X_12921_ clknet_leaf_31_clk_i _00307_ vssd1 vssd1 vccd1 vccd1 mul1.b\[24\] sky130_fd_sc_hd__dfxtp_1
XTAP_2210 vssd1 vccd1 sky130_fd_sc_hd__tapvpwrvgnd_1
XFILLER_0_69_811 vssd1 vssd1 vccd1 vccd1 sky130_fd_sc_hd__decap_4
XTAP_2243 vssd1 vccd1 sky130_fd_sc_hd__tapvpwrvgnd_1
XTAP_2232 vssd1 vccd1 sky130_fd_sc_hd__tapvpwrvgnd_1
XTAP_2221 vssd1 vccd1 sky130_fd_sc_hd__tapvpwrvgnd_1
X_12852_ clknet_leaf_35_clk_i _00238_ vssd1 vssd1 vccd1 vccd1 sub1.b_i\[19\] sky130_fd_sc_hd__dfxtp_1
XTAP_2254 vssd1 vccd1 sky130_fd_sc_hd__tapvpwrvgnd_1
XTAP_1542 vssd1 vccd1 sky130_fd_sc_hd__tapvpwrvgnd_1
XTAP_1531 vssd1 vccd1 sky130_fd_sc_hd__tapvpwrvgnd_1
XTAP_1520 vssd1 vccd1 sky130_fd_sc_hd__tapvpwrvgnd_1
X_12783_ clknet_leaf_1_clk_i _00169_ vssd1 vssd1 vccd1 vccd1 add1.b_i\[14\] sky130_fd_sc_hd__dfxtp_1
X_11803_ temp1\[17\] net615 net610 net194 vssd1 vssd1 vccd1 vccd1 _05847_ sky130_fd_sc_hd__a22o_1
XTAP_1564 vssd1 vccd1 sky130_fd_sc_hd__tapvpwrvgnd_1
XTAP_1575 vssd1 vccd1 sky130_fd_sc_hd__tapvpwrvgnd_1
XTAP_1553 vssd1 vccd1 sky130_fd_sc_hd__tapvpwrvgnd_1
X_11734_ net245 net598 net578 net149 _05789_ vssd1 vssd1 vccd1 vccd1 _05790_ sky130_fd_sc_hd__a221o_1
XFILLER_0_22_15 vssd1 vssd1 vccd1 vccd1 sky130_ef_sc_hd__decap_12
XPHY_60 vssd1 vssd1 vccd1 vccd1 sky130_fd_sc_hd__decap_3
XPHY_71 vssd1 vssd1 vccd1 vccd1 sky130_fd_sc_hd__decap_3
XPHY_82 vssd1 vssd1 vccd1 vccd1 sky130_fd_sc_hd__decap_3
XFILLER_0_126_415 vssd1 vssd1 vccd1 vccd1 sky130_fd_sc_hd__decap_4
XFILLER_0_113_39 vssd1 vssd1 vccd1 vccd1 sky130_ef_sc_hd__decap_12
XTAP_1597 vssd1 vccd1 sky130_fd_sc_hd__tapvpwrvgnd_1
XTAP_1586 vssd1 vccd1 sky130_fd_sc_hd__tapvpwrvgnd_1
XPHY_93 vssd1 vssd1 vccd1 vccd1 sky130_fd_sc_hd__decap_3
X_11665_ net1618 _01853_ net536 vssd1 vssd1 vccd1 vccd1 _00157_ sky130_fd_sc_hd__mux2_1
XFILLER_0_126_448 vssd1 vssd1 vccd1 vccd1 sky130_ef_sc_hd__decap_12
X_10616_ net999 net760 vssd1 vssd1 vccd1 vccd1 _04718_ sky130_fd_sc_hd__nand2_1
XFILLER_0_107_673 vssd1 vssd1 vccd1 vccd1 sky130_ef_sc_hd__decap_12
X_11596_ _05684_ _05689_ vssd1 vssd1 vccd1 vccd1 _05690_ sky130_fd_sc_hd__xnor2_1
X_10547_ _04419_ _04423_ _04648_ _04649_ vssd1 vssd1 vccd1 vccd1 _04650_ sky130_fd_sc_hd__a211oi_2
XFILLER_0_122_643 vssd1 vssd1 vccd1 vccd1 sky130_fd_sc_hd__fill_1
XFILLER_0_106_194 vssd1 vssd1 vccd1 vccd1 sky130_fd_sc_hd__fill_2
X_10478_ _04571_ _04579_ vssd1 vssd1 vccd1 vccd1 _04581_ sky130_fd_sc_hd__xor2_1
XFILLER_0_51_298 vssd1 vssd1 vccd1 vccd1 sky130_fd_sc_hd__fill_1
XFILLER_0_11_107 vssd1 vssd1 vccd1 vccd1 sky130_fd_sc_hd__decap_4
XFILLER_0_110_838 vssd1 vssd1 vccd1 vccd1 sky130_fd_sc_hd__decap_4
X_12217_ _00897_ net510 net467 y1my2\[17\] _06164_ vssd1 vssd1 vccd1 vccd1 _06165_
+ sky130_fd_sc_hd__a221o_1
X_13197_ clknet_leaf_16_clk_i _00583_ net1178 vssd1 vssd1 vccd1 vccd1 l1\[26\] sky130_fd_sc_hd__dfrtp_1
X_12148_ x0mx2\[28\] net631 net592 y1my2\[28\] vssd1 vssd1 vccd1 vccd1 _06117_ sky130_fd_sc_hd__a22o_1
X_12079_ net1069 _06065_ net514 vssd1 vssd1 vccd1 vccd1 _00261_ sky130_fd_sc_hd__mux2_1
XFILLER_0_63_11 vssd1 vssd1 vccd1 vccd1 sky130_fd_sc_hd__decap_3
X_06640_ net1731 _00872_ net633 vssd1 vssd1 vccd1 vccd1 _00015_ sky130_fd_sc_hd__mux2_1
XFILLER_0_78_129 vssd1 vssd1 vccd1 vccd1 sky130_fd_sc_hd__fill_2
XFILLER_0_59_343 vssd1 vssd1 vccd1 vccd1 sky130_fd_sc_hd__fill_1
X_06571_ _00808_ _00812_ _00811_ vssd1 vssd1 vccd1 vccd1 _00814_ sky130_fd_sc_hd__a21o_2
X_09290_ _03339_ _03340_ _03398_ _03399_ vssd1 vssd1 vccd1 vccd1 _03401_ sky130_fd_sc_hd__or4_1
XFILLER_0_86_184 vssd1 vssd1 vccd1 vccd1 sky130_fd_sc_hd__decap_4
X_08310_ _02425_ _02426_ vssd1 vssd1 vccd1 vccd1 _02427_ sky130_fd_sc_hd__nor2_1
XFILLER_0_86_195 vssd1 vssd1 vccd1 vccd1 sky130_fd_sc_hd__fill_1
X_08241_ _02351_ _02358_ vssd1 vssd1 vccd1 vccd1 _02359_ sky130_fd_sc_hd__xnor2_2
XANTENNA_14 v0y[23] vssd1 vssd1 vccd1 vccd1 sky130_fd_sc_hd__diode_2
XANTENNA_47 _00794_ vssd1 vssd1 vccd1 vccd1 sky130_fd_sc_hd__diode_2
XANTENNA_36 net49 vssd1 vssd1 vccd1 vccd1 sky130_fd_sc_hd__diode_2
XFILLER_0_55_571 vssd1 vssd1 vccd1 vccd1 sky130_fd_sc_hd__decap_3
XANTENNA_25 v2x[23] vssd1 vssd1 vccd1 vccd1 sky130_fd_sc_hd__diode_2
XFILLER_0_15_402 vssd1 vssd1 vccd1 vccd1 sky130_fd_sc_hd__decap_4
XFILLER_0_104_109 vssd1 vssd1 vccd1 vccd1 sky130_ef_sc_hd__decap_12
X_08172_ _02205_ _02208_ _02288_ vssd1 vssd1 vccd1 vccd1 _02290_ sky130_fd_sc_hd__or3_1
XFILLER_0_43_755 vssd1 vssd1 vccd1 vccd1 sky130_fd_sc_hd__decap_4
XANTENNA_69 net553 vssd1 vssd1 vccd1 vccd1 sky130_fd_sc_hd__diode_2
XANTENNA_58 v1y[28] vssd1 vssd1 vccd1 vccd1 sky130_fd_sc_hd__diode_2
X_07123_ _01241_ _01247_ vssd1 vssd1 vccd1 vccd1 _01248_ sky130_fd_sc_hd__xnor2_1
XFILLER_0_113_665 vssd1 vssd1 vccd1 vccd1 sky130_fd_sc_hd__decap_6
XFILLER_0_88_41 vssd1 vssd1 vccd1 vccd1 sky130_ef_sc_hd__decap_12
XFILLER_0_3_841 vssd1 vssd1 vccd1 vccd1 sky130_fd_sc_hd__fill_1
X_07054_ net829 net1120 _01176_ _01177_ vssd1 vssd1 vccd1 vccd1 _01179_ sky130_fd_sc_hd__o2bb2a_1
XFILLER_0_112_153 vssd1 vssd1 vccd1 vccd1 sky130_ef_sc_hd__decap_12
XFILLER_0_88_85 vssd1 vssd1 vccd1 vccd1 sky130_fd_sc_hd__decap_4
XFILLER_0_63_3 vssd1 vssd1 vccd1 vccd1 sky130_fd_sc_hd__decap_8
XFILLER_0_2_351 vssd1 vssd1 vccd1 vccd1 sky130_fd_sc_hd__fill_2
XFILLER_0_112_197 vssd1 vssd1 vccd1 vccd1 sky130_ef_sc_hd__decap_12
XFILLER_0_100_348 vssd1 vssd1 vccd1 vccd1 sky130_fd_sc_hd__decap_8
XFILLER_0_10_195 vssd1 vssd1 vccd1 vccd1 sky130_fd_sc_hd__fill_1
X_07956_ net795 _01970_ _01971_ _01968_ vssd1 vssd1 vccd1 vccd1 _02076_ sky130_fd_sc_hd__o2bb2ai_1
X_06907_ net871 net1103 net1111 net862 vssd1 vssd1 vccd1 vccd1 _01032_ sky130_fd_sc_hd__a22o_1
Xmax_cap16 _04200_ vssd1 vssd1 vccd1 vccd1 net1757 sky130_fd_sc_hd__clkbuf_1
X_07887_ net1033 net874 net865 net1042 vssd1 vssd1 vccd1 vccd1 _02008_ sky130_fd_sc_hd__a22oi_1
X_06838_ net345 net1216 net646 vssd1 vssd1 vccd1 vccd1 _00112_ sky130_fd_sc_hd__mux2_1
X_09626_ _03634_ _03733_ _03734_ vssd1 vssd1 vccd1 vccd1 _03735_ sky130_fd_sc_hd__and3_1
XFILLER_0_78_630 vssd1 vssd1 vccd1 vccd1 sky130_ef_sc_hd__decap_12
X_09557_ _03650_ _03663_ _03664_ vssd1 vssd1 vccd1 vccd1 _03666_ sky130_fd_sc_hd__and3_1
X_06769_ net384 net1591 net640 vssd1 vssd1 vccd1 vccd1 _00043_ sky130_fd_sc_hd__mux2_1
X_09488_ net1108 net1116 net714 vssd1 vssd1 vccd1 vccd1 _03597_ sky130_fd_sc_hd__and3_1
XFILLER_0_77_173 vssd1 vssd1 vccd1 vccd1 sky130_fd_sc_hd__decap_3
X_08508_ _02618_ _02621_ _02622_ vssd1 vssd1 vccd1 vccd1 _02624_ sky130_fd_sc_hd__or3_1
X_08439_ _02553_ _02554_ vssd1 vssd1 vccd1 vccd1 _02555_ sky130_fd_sc_hd__nand2b_1
XFILLER_0_93_677 vssd1 vssd1 vccd1 vccd1 sky130_fd_sc_hd__fill_1
XFILLER_0_81_828 vssd1 vssd1 vccd1 vccd1 sky130_fd_sc_hd__decap_3
XFILLER_0_34_711 vssd1 vssd1 vccd1 vccd1 sky130_fd_sc_hd__decap_4
XFILLER_0_92_187 vssd1 vssd1 vccd1 vccd1 sky130_fd_sc_hd__decap_8
XFILLER_0_80_349 vssd1 vssd1 vccd1 vccd1 sky130_fd_sc_hd__fill_1
XFILLER_0_46_593 vssd1 vssd1 vccd1 vccd1 sky130_fd_sc_hd__fill_1
XFILLER_0_46_582 vssd1 vssd1 vccd1 vccd1 sky130_fd_sc_hd__decap_6
X_11450_ _05545_ vssd1 vssd1 vccd1 vccd1 _05546_ sky130_fd_sc_hd__inv_2
XFILLER_0_123_429 vssd1 vssd1 vccd1 vccd1 sky130_ef_sc_hd__decap_12
X_10401_ _04300_ _04303_ _04502_ _04503_ vssd1 vssd1 vccd1 vccd1 _04505_ sky130_fd_sc_hd__o211ai_4
X_11381_ _05473_ _05474_ _05476_ vssd1 vssd1 vccd1 vccd1 _05477_ sky130_fd_sc_hd__or3b_1
XFILLER_0_34_755 vssd1 vssd1 vccd1 vccd1 sky130_fd_sc_hd__fill_1
X_13120_ clknet_leaf_2_clk_i _00506_ vssd1 vssd1 vccd1 vccd1 det_t\[13\] sky130_fd_sc_hd__dfxtp_1
XFILLER_0_104_643 vssd1 vssd1 vccd1 vccd1 sky130_fd_sc_hd__fill_1
X_10332_ net859 net936 _04433_ _04434_ vssd1 vssd1 vccd1 vccd1 _04436_ sky130_fd_sc_hd__a22o_1
XFILLER_0_21_427 vssd1 vssd1 vccd1 vccd1 sky130_fd_sc_hd__fill_1
X_13051_ clknet_leaf_45_clk_i _00437_ net1156 vssd1 vssd1 vccd1 vccd1 y2my0\[8\] sky130_fd_sc_hd__dfrtp_1
X_10263_ _04069_ _04212_ _04211_ vssd1 vssd1 vccd1 vccd1 _04368_ sky130_fd_sc_hd__a21boi_4
X_12002_ net107 net623 net597 net75 vssd1 vssd1 vccd1 vccd1 _06006_ sky130_fd_sc_hd__a22o_1
X_10194_ _04296_ _04297_ _04298_ vssd1 vssd1 vccd1 vccd1 _04299_ sky130_fd_sc_hd__nand3_2
XFILLER_0_17_15 vssd1 vssd1 vccd1 vccd1 sky130_ef_sc_hd__decap_12
XFILLER_0_88_405 vssd1 vssd1 vccd1 vccd1 sky130_fd_sc_hd__decap_3
X_12904_ clknet_leaf_53_clk_i _00290_ vssd1 vssd1 vccd1 vccd1 mul1.b\[7\] sky130_fd_sc_hd__dfxtp_1
XFILLER_0_124_27 vssd1 vssd1 vccd1 vccd1 sky130_fd_sc_hd__fill_1
XTAP_2051 vssd1 vccd1 sky130_fd_sc_hd__tapvpwrvgnd_1
XTAP_2040 vssd1 vccd1 sky130_fd_sc_hd__tapvpwrvgnd_1
XFILLER_0_69_663 vssd1 vssd1 vccd1 vccd1 sky130_fd_sc_hd__decap_8
X_12835_ clknet_leaf_56_clk_i _00221_ vssd1 vssd1 vccd1 vccd1 sub1.b_i\[2\] sky130_fd_sc_hd__dfxtp_1
XTAP_2095 vssd1 vccd1 sky130_fd_sc_hd__tapvpwrvgnd_1
XTAP_2084 vssd1 vccd1 sky130_fd_sc_hd__tapvpwrvgnd_1
XTAP_2073 vssd1 vccd1 sky130_fd_sc_hd__tapvpwrvgnd_1
XTAP_2062 vssd1 vccd1 sky130_fd_sc_hd__tapvpwrvgnd_1
XTAP_1350 vssd1 vccd1 sky130_fd_sc_hd__tapvpwrvgnd_1
XFILLER_0_127_724 vssd1 vssd1 vccd1 vccd1 sky130_fd_sc_hd__decap_4
XTAP_1383 vssd1 vccd1 sky130_fd_sc_hd__tapvpwrvgnd_1
XTAP_1361 vssd1 vccd1 sky130_fd_sc_hd__tapvpwrvgnd_1
XTAP_1372 vssd1 vccd1 sky130_fd_sc_hd__tapvpwrvgnd_1
X_12766_ clknet_leaf_23_clk_i _00152_ vssd1 vssd1 vccd1 vccd1 add1.a_i\[29\] sky130_fd_sc_hd__dfxtp_1
X_12697_ clknet_leaf_12_clk_i _00083_ net1187 vssd1 vssd1 vccd1 vccd1 net428 sky130_fd_sc_hd__dfrtp_1
XFILLER_0_83_165 vssd1 vssd1 vccd1 vccd1 sky130_fd_sc_hd__decap_3
XTAP_1394 vssd1 vccd1 sky130_fd_sc_hd__tapvpwrvgnd_1
X_11717_ _05774_ _05775_ vssd1 vssd1 vccd1 vccd1 _05776_ sky130_fd_sc_hd__or2_1
Xinput12 div_sstream_i[19] vssd1 vssd1 vccd1 vccd1 net12 sky130_fd_sc_hd__clkbuf_8
XFILLER_0_127_768 vssd1 vssd1 vccd1 vccd1 sky130_ef_sc_hd__decap_12
XFILLER_0_83_198 vssd1 vssd1 vccd1 vccd1 sky130_fd_sc_hd__fill_1
X_11648_ _05734_ _05741_ vssd1 vssd1 vccd1 vccd1 _05742_ sky130_fd_sc_hd__xnor2_1
XFILLER_0_37_593 vssd1 vssd1 vccd1 vccd1 sky130_fd_sc_hd__fill_1
Xinput23 div_sstream_i[29] vssd1 vssd1 vccd1 vccd1 net23 sky130_fd_sc_hd__buf_4
Xinput34 div_sstream_i[9] vssd1 vssd1 vccd1 vccd1 net34 sky130_fd_sc_hd__clkbuf_8
Xinput45 sstream_i[16] vssd1 vssd1 vccd1 vccd1 net45 sky130_fd_sc_hd__buf_4
XFILLER_0_24_243 vssd1 vssd1 vccd1 vccd1 sky130_fd_sc_hd__decap_3
X_11579_ _05668_ _05670_ _05667_ vssd1 vssd1 vccd1 vccd1 _05673_ sky130_fd_sc_hd__o21a_1
XFILLER_0_52_574 vssd1 vssd1 vccd1 vccd1 sky130_fd_sc_hd__decap_6
Xinput56 sstream_i[8] vssd1 vssd1 vccd1 vccd1 net56 sky130_fd_sc_hd__clkbuf_1
Xinput89 v0x[9] vssd1 vssd1 vccd1 vccd1 net89 sky130_fd_sc_hd__buf_1
XFILLER_0_3_137 vssd1 vssd1 vccd1 vccd1 sky130_fd_sc_hd__fill_1
Xinput67 v0x[18] vssd1 vssd1 vccd1 vccd1 net67 sky130_fd_sc_hd__buf_1
Xinput78 v0x[28] vssd1 vssd1 vccd1 vccd1 net78 sky130_fd_sc_hd__buf_1
XFILLER_0_40_714 vssd1 vssd1 vccd1 vccd1 sky130_fd_sc_hd__fill_2
XFILLER_0_110_613 vssd1 vssd1 vccd1 vccd1 sky130_ef_sc_hd__decap_12
XFILLER_0_24_298 vssd1 vssd1 vccd1 vccd1 sky130_fd_sc_hd__fill_2
XFILLER_0_110_657 vssd1 vssd1 vccd1 vccd1 sky130_ef_sc_hd__decap_12
X_08790_ _02902_ _02903_ _02748_ _02750_ vssd1 vssd1 vccd1 vccd1 _02904_ sky130_fd_sc_hd__a211oi_2
X_07810_ _01896_ _01897_ _01930_ _01931_ vssd1 vssd1 vccd1 vccd1 _01932_ sky130_fd_sc_hd__o22ai_2
X_07741_ net1115 net1123 net786 vssd1 vssd1 vccd1 vccd1 _01863_ sky130_fd_sc_hd__and3_1
XFILLER_0_74_98 vssd1 vssd1 vccd1 vccd1 sky130_fd_sc_hd__decap_3
X_07672_ _01791_ _01794_ vssd1 vssd1 vccd1 vccd1 _01795_ sky130_fd_sc_hd__xor2_1
X_09411_ _03505_ _03519_ _03520_ vssd1 vssd1 vccd1 vccd1 _03521_ sky130_fd_sc_hd__nand3_2
X_06623_ _00856_ _00857_ vssd1 vssd1 vccd1 vccd1 _00858_ sky130_fd_sc_hd__nand2b_2
X_09342_ _03446_ _03450_ _03451_ vssd1 vssd1 vccd1 vccd1 _03452_ sky130_fd_sc_hd__nand3_2
XFILLER_0_90_53 vssd1 vssd1 vccd1 vccd1 sky130_ef_sc_hd__decap_12
XFILLER_0_75_611 vssd1 vssd1 vccd1 vccd1 sky130_fd_sc_hd__decap_4
X_06554_ _00611_ _00616_ vssd1 vssd1 vccd1 vccd1 _00802_ sky130_fd_sc_hd__nor2_2
XFILLER_0_118_713 vssd1 vssd1 vccd1 vccd1 sky130_ef_sc_hd__decap_12
XFILLER_0_74_132 vssd1 vssd1 vccd1 vccd1 sky130_fd_sc_hd__decap_8
X_06485_ net547 _00779_ vssd1 vssd1 vccd1 vccd1 net329 sky130_fd_sc_hd__nor2_1
XFILLER_0_117_223 vssd1 vssd1 vccd1 vccd1 sky130_fd_sc_hd__fill_1
XFILLER_0_62_305 vssd1 vssd1 vccd1 vccd1 sky130_fd_sc_hd__decap_3
X_09273_ _03381_ _03382_ _03383_ vssd1 vssd1 vccd1 vccd1 _03384_ sky130_fd_sc_hd__nand3_1
XFILLER_0_105_407 vssd1 vssd1 vccd1 vccd1 sky130_fd_sc_hd__fill_1
X_08224_ _02339_ _02340_ _02341_ vssd1 vssd1 vccd1 vccd1 _02342_ sky130_fd_sc_hd__nand3_1
XFILLER_0_28_582 vssd1 vssd1 vccd1 vccd1 sky130_fd_sc_hd__decap_6
XFILLER_0_99_51 vssd1 vssd1 vccd1 vccd1 sky130_fd_sc_hd__decap_4
X_08155_ _02272_ _02273_ vssd1 vssd1 vccd1 vccd1 _02274_ sky130_fd_sc_hd__or2_2
X_07106_ _01218_ _01219_ _01228_ vssd1 vssd1 vccd1 vccd1 _01231_ sky130_fd_sc_hd__a21oi_2
XFILLER_0_113_473 vssd1 vssd1 vccd1 vccd1 sky130_ef_sc_hd__decap_12
XFILLER_0_101_613 vssd1 vssd1 vccd1 vccd1 sky130_fd_sc_hd__decap_3
X_08086_ _02110_ _02113_ _02203_ _02204_ vssd1 vssd1 vccd1 vccd1 _02205_ sky130_fd_sc_hd__a211oi_2
XFILLER_0_30_235 vssd1 vssd1 vccd1 vccd1 sky130_fd_sc_hd__fill_1
X_07037_ net855 net1096 vssd1 vssd1 vccd1 vccd1 _01162_ sky130_fd_sc_hd__nand2_1
X_08988_ _03098_ _03099_ _02964_ vssd1 vssd1 vccd1 vccd1 _03101_ sky130_fd_sc_hd__o21ai_1
XFILLER_0_98_725 vssd1 vssd1 vccd1 vccd1 sky130_ef_sc_hd__decap_12
X_07939_ _02058_ _02059_ vssd1 vssd1 vccd1 vccd1 _02060_ sky130_fd_sc_hd__and2_1
XFILLER_0_97_213 vssd1 vssd1 vccd1 vccd1 sky130_fd_sc_hd__fill_2
X_10950_ _05042_ _05049_ vssd1 vssd1 vccd1 vccd1 _05050_ sky130_fd_sc_hd__nand2_1
XFILLER_0_3_90 vssd1 vssd1 vccd1 vccd1 sky130_fd_sc_hd__fill_1
X_09609_ _03708_ _03715_ _03716_ vssd1 vssd1 vccd1 vccd1 _03718_ sky130_fd_sc_hd__nand3_1
X_10881_ _04828_ _04849_ _04851_ _04827_ vssd1 vssd1 vccd1 vccd1 _04981_ sky130_fd_sc_hd__o31ai_2
XFILLER_0_97_279 vssd1 vssd1 vccd1 vccd1 sky130_fd_sc_hd__fill_1
XFILLER_0_78_482 vssd1 vssd1 vccd1 vccd1 sky130_fd_sc_hd__fill_1
X_12620_ clknet_leaf_49_clk_i _00006_ net1159 vssd1 vssd1 vccd1 vccd1 net383 sky130_fd_sc_hd__dfrtp_2
XFILLER_0_81_603 vssd1 vssd1 vccd1 vccd1 sky130_ef_sc_hd__decap_12
X_12551_ net1337 net24 net558 vssd1 vssd1 vccd1 vccd1 _00527_ sky130_fd_sc_hd__mux2_1
X_12482_ net1197 _00996_ vssd1 vssd1 vccd1 vccd1 _06237_ sky130_fd_sc_hd__and2_1
XFILLER_0_108_245 vssd1 vssd1 vccd1 vccd1 sky130_fd_sc_hd__decap_6
X_11502_ _05595_ _05596_ vssd1 vssd1 vccd1 vccd1 _05597_ sky130_fd_sc_hd__nor2_1
XFILLER_0_124_749 vssd1 vssd1 vccd1 vccd1 sky130_fd_sc_hd__decap_6
XFILLER_0_46_390 vssd1 vssd1 vccd1 vccd1 sky130_fd_sc_hd__fill_1
X_11433_ net996 net717 vssd1 vssd1 vccd1 vccd1 _05529_ sky130_fd_sc_hd__nand2_1
XFILLER_0_110_29 vssd1 vssd1 vccd1 vccd1 sky130_ef_sc_hd__decap_12
XFILLER_0_61_393 vssd1 vssd1 vccd1 vccd1 sky130_fd_sc_hd__decap_8
X_11364_ _05458_ _05459_ vssd1 vssd1 vccd1 vccd1 _05460_ sky130_fd_sc_hd__nand2_1
X_10315_ _04418_ vssd1 vssd1 vccd1 vccd1 _04419_ sky130_fd_sc_hd__inv_2
X_13103_ clknet_leaf_24_clk_i _00489_ vssd1 vssd1 vccd1 vccd1 temp1\[28\] sky130_fd_sc_hd__dfxtp_1
X_11295_ _05390_ _05391_ vssd1 vssd1 vccd1 vccd1 _05392_ sky130_fd_sc_hd__xnor2_2
XFILLER_0_119_27 vssd1 vssd1 vccd1 vccd1 sky130_ef_sc_hd__decap_12
X_10246_ _04165_ _04168_ _04348_ _04349_ vssd1 vssd1 vccd1 vccd1 _04351_ sky130_fd_sc_hd__a211oi_4
XTAP_419 vssd1 vccd1 sky130_fd_sc_hd__tapvpwrvgnd_1
XTAP_408 vssd1 vccd1 sky130_fd_sc_hd__tapvpwrvgnd_1
X_13034_ clknet_leaf_33_clk_i _00420_ net1165 vssd1 vssd1 vccd1 vccd1 x0mx2\[23\]
+ sky130_fd_sc_hd__dfrtp_1
Xfanout1132 net1134 vssd1 vssd1 vccd1 vccd1 net1132 sky130_fd_sc_hd__clkbuf_4
Xfanout1121 mul1.a\[3\] vssd1 vssd1 vccd1 vccd1 net1121 sky130_fd_sc_hd__buf_4
Xfanout1110 mul1.a\[5\] vssd1 vssd1 vccd1 vccd1 net1110 sky130_fd_sc_hd__clkbuf_4
XFILLER_0_100_690 vssd1 vssd1 vccd1 vccd1 sky130_fd_sc_hd__decap_8
X_10177_ net1021 net760 _04277_ _04279_ vssd1 vssd1 vccd1 vccd1 _04282_ sky130_fd_sc_hd__a22o_1
Xfanout1165 net1166 vssd1 vssd1 vccd1 vccd1 net1165 sky130_fd_sc_hd__clkbuf_4
Xfanout1154 net1158 vssd1 vssd1 vccd1 vccd1 net1154 sky130_fd_sc_hd__clkbuf_4
Xfanout1143 net1144 vssd1 vssd1 vccd1 vccd1 net1143 sky130_fd_sc_hd__buf_2
XFILLER_0_28_58 vssd1 vssd1 vccd1 vccd1 sky130_fd_sc_hd__fill_2
Xfanout1187 net1189 vssd1 vssd1 vccd1 vccd1 net1187 sky130_fd_sc_hd__clkbuf_4
XFILLER_0_89_703 vssd1 vssd1 vccd1 vccd1 sky130_ef_sc_hd__decap_12
Xfanout1176 net1181 vssd1 vssd1 vccd1 vccd1 net1176 sky130_fd_sc_hd__buf_2
XFILLER_0_44_24 vssd1 vssd1 vccd1 vccd1 sky130_fd_sc_hd__decap_4
X_12818_ clknet_leaf_49_clk_i _00204_ vssd1 vssd1 vccd1 vccd1 sub1.a_i\[17\] sky130_fd_sc_hd__dfxtp_1
XFILLER_0_29_335 vssd1 vssd1 vccd1 vccd1 sky130_fd_sc_hd__fill_1
XFILLER_0_127_521 vssd1 vssd1 vccd1 vccd1 sky130_ef_sc_hd__decap_12
XFILLER_0_84_452 vssd1 vssd1 vccd1 vccd1 sky130_fd_sc_hd__fill_1
XTAP_1191 vssd1 vccd1 sky130_fd_sc_hd__tapvpwrvgnd_1
XTAP_1180 vssd1 vccd1 sky130_fd_sc_hd__tapvpwrvgnd_1
X_12749_ clknet_leaf_1_clk_i _00135_ vssd1 vssd1 vccd1 vccd1 add1.a_i\[12\] sky130_fd_sc_hd__dfxtp_1
XFILLER_0_121_3 vssd1 vssd1 vccd1 vccd1 sky130_ef_sc_hd__decap_12
XFILLER_0_84_496 vssd1 vssd1 vccd1 vccd1 sky130_fd_sc_hd__decap_3
XFILLER_0_71_113 vssd1 vssd1 vccd1 vccd1 sky130_fd_sc_hd__fill_2
XFILLER_0_52_360 vssd1 vssd1 vccd1 vccd1 sky130_fd_sc_hd__decap_4
XFILLER_0_12_235 vssd1 vssd1 vccd1 vccd1 sky130_fd_sc_hd__fill_2
XFILLER_0_110_421 vssd1 vssd1 vccd1 vccd1 sky130_fd_sc_hd__decap_8
X_09960_ net1382 _04066_ net524 vssd1 vssd1 vccd1 vccd1 _00141_ sky130_fd_sc_hd__mux2_1
X_08911_ _03009_ _03022_ vssd1 vssd1 vccd1 vccd1 _03024_ sky130_fd_sc_hd__and2_2
XFILLER_0_85_53 vssd1 vssd1 vccd1 vccd1 sky130_fd_sc_hd__decap_3
X_09891_ net842 net964 net958 net850 vssd1 vssd1 vccd1 vccd1 _03998_ sky130_fd_sc_hd__a22o_1
XTAP_953 vssd1 vccd1 sky130_fd_sc_hd__tapvpwrvgnd_1
XTAP_942 vssd1 vccd1 sky130_fd_sc_hd__tapvpwrvgnd_1
XTAP_931 vssd1 vccd1 sky130_fd_sc_hd__tapvpwrvgnd_1
XTAP_920 vssd1 vccd1 sky130_fd_sc_hd__tapvpwrvgnd_1
X_08842_ _02822_ _02955_ vssd1 vssd1 vccd1 vccd1 _02956_ sky130_fd_sc_hd__xnor2_2
XFILLER_0_85_86 vssd1 vssd1 vccd1 vccd1 sky130_fd_sc_hd__fill_1
XTAP_975 vssd1 vccd1 sky130_fd_sc_hd__tapvpwrvgnd_1
XTAP_986 vssd1 vccd1 sky130_fd_sc_hd__tapvpwrvgnd_1
XTAP_964 vssd1 vccd1 sky130_fd_sc_hd__tapvpwrvgnd_1
XFILLER_0_109_93 vssd1 vssd1 vccd1 vccd1 sky130_ef_sc_hd__decap_12
X_08773_ net1044 net810 vssd1 vssd1 vccd1 vccd1 _02887_ sky130_fd_sc_hd__nand2_1
XTAP_997 vssd1 vccd1 sky130_fd_sc_hd__tapvpwrvgnd_1
X_07724_ _01844_ _01845_ _01764_ vssd1 vssd1 vccd1 vccd1 _01847_ sky130_fd_sc_hd__o21ai_1
XFILLER_0_26_3 vssd1 vssd1 vccd1 vccd1 sky130_ef_sc_hd__decap_12
XFILLER_0_79_235 vssd1 vssd1 vccd1 vccd1 sky130_fd_sc_hd__fill_1
X_07655_ net1146 net774 vssd1 vssd1 vccd1 vccd1 _01778_ sky130_fd_sc_hd__nand2_1
X_06606_ _00841_ _00843_ vssd1 vssd1 vccd1 vccd1 _00844_ sky130_fd_sc_hd__nor2_2
XFILLER_0_125_81 vssd1 vssd1 vccd1 vccd1 sky130_ef_sc_hd__decap_12
X_07586_ _01704_ _01709_ vssd1 vssd1 vccd1 vccd1 _01710_ sky130_fd_sc_hd__nand2b_1
XFILLER_0_48_622 vssd1 vssd1 vccd1 vccd1 sky130_fd_sc_hd__decap_6
XFILLER_0_47_121 vssd1 vssd1 vccd1 vccd1 sky130_fd_sc_hd__fill_1
X_09325_ net1149 net693 _03433_ _03434_ vssd1 vssd1 vccd1 vccd1 _03435_ sky130_fd_sc_hd__nor4_1
X_06537_ _00661_ _00791_ vssd1 vssd1 vccd1 vccd1 _00792_ sky130_fd_sc_hd__or2_4
X_09256_ _03362_ _03365_ _03366_ vssd1 vssd1 vccd1 vccd1 _03367_ sky130_fd_sc_hd__and3_1
X_06468_ _00742_ _00761_ _00764_ vssd1 vssd1 vccd1 vccd1 _00765_ sky130_fd_sc_hd__a21oi_4
XFILLER_0_118_587 vssd1 vssd1 vccd1 vccd1 sky130_fd_sc_hd__fill_1
X_08207_ _02309_ _02323_ vssd1 vssd1 vccd1 vccd1 _02325_ sky130_fd_sc_hd__and2_2
XFILLER_0_105_237 vssd1 vssd1 vccd1 vccd1 sky130_fd_sc_hd__decap_4
X_09187_ _03295_ _03296_ _03137_ _03141_ vssd1 vssd1 vccd1 vccd1 _03298_ sky130_fd_sc_hd__o211a_1
X_06399_ _00703_ _00704_ _00702_ vssd1 vssd1 vccd1 vccd1 _00706_ sky130_fd_sc_hd__nor3b_1
XFILLER_0_31_511 vssd1 vssd1 vccd1 vccd1 sky130_ef_sc_hd__decap_12
X_08138_ _02253_ _02254_ _02255_ vssd1 vssd1 vccd1 vccd1 _02257_ sky130_fd_sc_hd__a21o_1
XFILLER_0_31_544 vssd1 vssd1 vccd1 vccd1 sky130_fd_sc_hd__decap_8
XFILLER_0_113_281 vssd1 vssd1 vccd1 vccd1 sky130_ef_sc_hd__decap_12
X_08069_ _02185_ _02186_ vssd1 vssd1 vccd1 vccd1 _02188_ sky130_fd_sc_hd__xor2_2
X_10100_ _03990_ _04046_ _04045_ vssd1 vssd1 vccd1 vccd1 _04206_ sky130_fd_sc_hd__a21boi_4
X_11080_ _05161_ _05177_ _05178_ vssd1 vssd1 vccd1 vccd1 _05179_ sky130_fd_sc_hd__nor3_1
XFILLER_0_101_487 vssd1 vssd1 vccd1 vccd1 sky130_fd_sc_hd__fill_1
X_10031_ _04136_ _04135_ _04134_ vssd1 vssd1 vccd1 vccd1 _04137_ sky130_fd_sc_hd__nand3b_1
Xinput202 v2x[24] vssd1 vssd1 vccd1 vccd1 net202 sky130_fd_sc_hd__buf_1
Xinput235 v2y[25] vssd1 vssd1 vccd1 vccd1 net235 sky130_fd_sc_hd__buf_1
Xinput213 v2x[5] vssd1 vssd1 vccd1 vccd1 net213 sky130_fd_sc_hd__buf_1
Xinput224 v2y[15] vssd1 vssd1 vccd1 vccd1 net224 sky130_fd_sc_hd__clkbuf_1
Xinput246 v2y[6] vssd1 vssd1 vccd1 vccd1 net246 sky130_fd_sc_hd__buf_1
X_11982_ net102 net622 net596 net70 vssd1 vssd1 vccd1 vccd1 _05991_ sky130_fd_sc_hd__a22o_1
X_10933_ net1072 net698 mul1.b\[31\] net1064 vssd1 vssd1 vccd1 vccd1 _05033_ sky130_fd_sc_hd__and4b_2
XFILLER_0_14_27 vssd1 vssd1 vccd1 vccd1 sky130_fd_sc_hd__fill_1
XFILLER_0_128_307 vssd1 vssd1 vccd1 vccd1 sky130_fd_sc_hd__fill_1
X_10864_ _04962_ _04963_ vssd1 vssd1 vccd1 vccd1 _04964_ sky130_fd_sc_hd__nand2b_1
XFILLER_0_38_121 vssd1 vssd1 vccd1 vccd1 sky130_fd_sc_hd__fill_2
XFILLER_0_128_329 vssd1 vssd1 vccd1 vccd1 sky130_fd_sc_hd__decap_3
XPHY_252 vssd1 vssd1 vccd1 vccd1 sky130_fd_sc_hd__decap_3
XPHY_241 vssd1 vssd1 vccd1 vccd1 sky130_fd_sc_hd__decap_3
XPHY_230 vssd1 vssd1 vccd1 vccd1 sky130_fd_sc_hd__decap_3
X_10795_ net1045 net1055 net715 net708 vssd1 vssd1 vccd1 vccd1 _04896_ sky130_fd_sc_hd__and4_1
X_12603_ net1358 net15 net555 vssd1 vssd1 vccd1 vccd1 _00578_ sky130_fd_sc_hd__mux2_1
X_12534_ net1252 net569 vssd1 vssd1 vccd1 vccd1 _06264_ sky130_fd_sc_hd__nor2_1
XFILLER_0_93_260 vssd1 vssd1 vccd1 vccd1 sky130_fd_sc_hd__decap_6
XFILLER_0_124_513 vssd1 vssd1 vccd1 vccd1 sky130_ef_sc_hd__decap_12
XFILLER_0_121_39 vssd1 vssd1 vccd1 vccd1 sky130_ef_sc_hd__decap_12
XFILLER_0_30_15 vssd1 vssd1 vccd1 vccd1 sky130_fd_sc_hd__decap_6
XFILLER_0_124_557 vssd1 vssd1 vccd1 vccd1 sky130_ef_sc_hd__decap_12
XFILLER_0_81_499 vssd1 vssd1 vccd1 vccd1 sky130_fd_sc_hd__decap_4
XFILLER_0_81_477 vssd1 vssd1 vccd1 vccd1 sky130_ef_sc_hd__decap_12
X_12465_ temp1\[23\] _06228_ net572 vssd1 vssd1 vccd1 vccd1 _00484_ sky130_fd_sc_hd__mux2_1
XFILLER_0_22_500 vssd1 vssd1 vccd1 vccd1 sky130_fd_sc_hd__fill_1
X_12396_ net1496 _00908_ net684 vssd1 vssd1 vccd1 vccd1 _00448_ sky130_fd_sc_hd__mux2_1
XFILLER_0_22_533 vssd1 vssd1 vccd1 vccd1 sky130_ef_sc_hd__decap_12
X_11416_ net1027 net702 _05389_ _05388_ vssd1 vssd1 vccd1 vccd1 _05512_ sky130_fd_sc_hd__a31o_1
XFILLER_0_105_782 vssd1 vssd1 vccd1 vccd1 sky130_fd_sc_hd__fill_2
X_11347_ _05313_ _05315_ vssd1 vssd1 vccd1 vccd1 _05444_ sky130_fd_sc_hd__nor2_1
XFILLER_0_10_728 vssd1 vssd1 vccd1 vccd1 sky130_fd_sc_hd__fill_2
X_11278_ _05371_ _05372_ _05360_ vssd1 vssd1 vccd1 vccd1 _05375_ sky130_fd_sc_hd__a21oi_2
X_10229_ net817 net970 net964 net826 vssd1 vssd1 vccd1 vccd1 _04334_ sky130_fd_sc_hd__a22o_1
X_13017_ clknet_leaf_52_clk_i _00403_ net1153 vssd1 vssd1 vccd1 vccd1 x0mx2\[6\] sky130_fd_sc_hd__dfrtp_1
Xhold1 posx\[4\] vssd1 vssd1 vccd1 vccd1 net1216 sky130_fd_sc_hd__buf_1
XFILLER_0_77_706 vssd1 vssd1 vccd1 vccd1 sky130_fd_sc_hd__decap_4
XFILLER_0_71_44 vssd1 vssd1 vccd1 vccd1 sky130_ef_sc_hd__decap_12
X_07440_ _01563_ _01564_ vssd1 vssd1 vccd1 vccd1 _01565_ sky130_fd_sc_hd__and2b_1
XFILLER_0_128_841 vssd1 vssd1 vccd1 vccd1 sky130_fd_sc_hd__fill_1
XFILLER_0_119_329 vssd1 vssd1 vccd1 vccd1 sky130_fd_sc_hd__decap_6
XFILLER_0_18_817 vssd1 vssd1 vccd1 vccd1 sky130_fd_sc_hd__fill_1
X_07371_ _01482_ _01493_ _01494_ vssd1 vssd1 vccd1 vccd1 _01496_ sky130_fd_sc_hd__or3_1
XFILLER_0_29_154 vssd1 vssd1 vccd1 vccd1 sky130_fd_sc_hd__fill_1
XFILLER_0_85_783 vssd1 vssd1 vccd1 vccd1 sky130_fd_sc_hd__fill_1
X_09110_ net949 _03221_ _03220_ vssd1 vssd1 vccd1 vccd1 _03222_ sky130_fd_sc_hd__a21bo_1
XFILLER_0_57_474 vssd1 vssd1 vccd1 vccd1 sky130_fd_sc_hd__decap_3
X_06322_ add1.a_i\[8\] add1.b_i\[8\] vssd1 vssd1 vccd1 vccd1 _00634_ sky130_fd_sc_hd__or2_1
X_09041_ net1085 net1092 net749 net741 vssd1 vssd1 vccd1 vccd1 _03153_ sky130_fd_sc_hd__and4_1
XFILLER_0_72_466 vssd1 vssd1 vccd1 vccd1 sky130_fd_sc_hd__decap_8
XFILLER_0_72_433 vssd1 vssd1 vccd1 vccd1 sky130_fd_sc_hd__fill_2
XFILLER_0_5_711 vssd1 vssd1 vccd1 vccd1 sky130_fd_sc_hd__fill_1
XFILLER_0_72_477 vssd1 vssd1 vccd1 vccd1 sky130_fd_sc_hd__fill_1
XFILLER_0_60_628 vssd1 vssd1 vccd1 vccd1 sky130_fd_sc_hd__decap_4
Xhold401 y1my2\[31\] vssd1 vssd1 vccd1 vccd1 net1616 sky130_fd_sc_hd__dlygate4sd3_1
XFILLER_0_102_218 vssd1 vssd1 vccd1 vccd1 sky130_fd_sc_hd__fill_1
Xhold445 add1.b_i\[22\] vssd1 vssd1 vccd1 vccd1 net1660 sky130_fd_sc_hd__dlygate4sd3_1
Xhold412 y1my2\[18\] vssd1 vssd1 vccd1 vccd1 net1627 sky130_fd_sc_hd__dlygate4sd3_1
Xhold423 add1.a_i\[1\] vssd1 vssd1 vccd1 vccd1 net1638 sky130_fd_sc_hd__dlygate4sd3_1
Xhold434 add1.a_i\[20\] vssd1 vssd1 vccd1 vccd1 net1649 sky130_fd_sc_hd__dlygate4sd3_1
XFILLER_0_111_741 vssd1 vssd1 vccd1 vccd1 sky130_ef_sc_hd__decap_12
XFILLER_0_96_41 vssd1 vssd1 vccd1 vccd1 sky130_ef_sc_hd__decap_12
Xhold478 add1.a_i\[25\] vssd1 vssd1 vccd1 vccd1 net1693 sky130_fd_sc_hd__dlygate4sd3_1
Xhold456 x2mx1\[5\] vssd1 vssd1 vccd1 vccd1 net1671 sky130_fd_sc_hd__dlygate4sd3_1
Xhold467 y1my2\[29\] vssd1 vssd1 vccd1 vccd1 net1682 sky130_fd_sc_hd__dlygate4sd3_1
XFILLER_0_110_251 vssd1 vssd1 vccd1 vccd1 sky130_fd_sc_hd__fill_1
XFILLER_0_96_85 vssd1 vssd1 vccd1 vccd1 sky130_ef_sc_hd__decap_12
X_09943_ _04047_ _04048_ vssd1 vssd1 vccd1 vccd1 _04050_ sky130_fd_sc_hd__xor2_4
Xfanout903 mul1.b\[3\] vssd1 vssd1 vccd1 vccd1 net903 sky130_fd_sc_hd__buf_2
Xfanout925 mul1.b\[0\] vssd1 vssd1 vccd1 vccd1 net925 sky130_fd_sc_hd__clkbuf_4
Xhold489 net357 vssd1 vssd1 vccd1 vccd1 net1704 sky130_fd_sc_hd__dlygate4sd3_1
Xfanout914 mul1.b\[1\] vssd1 vssd1 vccd1 vccd1 net914 sky130_fd_sc_hd__clkbuf_4
X_09874_ _03814_ _03822_ _03821_ vssd1 vssd1 vccd1 vccd1 _03981_ sky130_fd_sc_hd__a21bo_1
Xfanout958 net959 vssd1 vssd1 vccd1 vccd1 net958 sky130_fd_sc_hd__clkbuf_4
Xfanout936 net938 vssd1 vssd1 vccd1 vccd1 net936 sky130_fd_sc_hd__clkbuf_4
Xfanout947 net948 vssd1 vssd1 vccd1 vccd1 net947 sky130_fd_sc_hd__buf_4
XTAP_750 vssd1 vccd1 sky130_fd_sc_hd__tapvpwrvgnd_1
XTAP_761 vssd1 vccd1 sky130_fd_sc_hd__tapvpwrvgnd_1
X_08825_ _02784_ _02788_ _02936_ _02937_ vssd1 vssd1 vccd1 vccd1 _02939_ sky130_fd_sc_hd__a211oi_4
Xfanout969 net972 vssd1 vssd1 vccd1 vccd1 net969 sky130_fd_sc_hd__clkbuf_4
XTAP_772 vssd1 vccd1 sky130_fd_sc_hd__tapvpwrvgnd_1
XTAP_794 vssd1 vccd1 sky130_fd_sc_hd__tapvpwrvgnd_1
XTAP_783 vssd1 vccd1 sky130_fd_sc_hd__tapvpwrvgnd_1
X_08756_ net1052 net1060 net787 vssd1 vssd1 vccd1 vccd1 _02870_ sky130_fd_sc_hd__and3_1
XTAP_1916 vssd1 vccd1 sky130_fd_sc_hd__tapvpwrvgnd_1
XTAP_1905 vssd1 vccd1 sky130_fd_sc_hd__tapvpwrvgnd_1
X_08687_ _02799_ _02800_ _02699_ vssd1 vssd1 vccd1 vccd1 _02802_ sky130_fd_sc_hd__a21o_1
X_07707_ _01720_ _01728_ _01727_ vssd1 vssd1 vccd1 vccd1 _01830_ sky130_fd_sc_hd__a21bo_1
XTAP_1949 vssd1 vccd1 sky130_fd_sc_hd__tapvpwrvgnd_1
XTAP_1938 vssd1 vccd1 sky130_fd_sc_hd__tapvpwrvgnd_1
XTAP_1927 vssd1 vccd1 sky130_fd_sc_hd__tapvpwrvgnd_1
X_07638_ net1638 _01761_ net523 vssd1 vssd1 vccd1 vccd1 _00124_ sky130_fd_sc_hd__mux2_1
X_07569_ _01691_ _01692_ vssd1 vssd1 vccd1 vccd1 _01693_ sky130_fd_sc_hd__nor2_1
XFILLER_0_119_841 vssd1 vssd1 vccd1 vccd1 sky130_fd_sc_hd__fill_1
X_09308_ _03106_ _03110_ _03262_ _03418_ vssd1 vssd1 vccd1 vccd1 _03419_ sky130_fd_sc_hd__o31a_2
XFILLER_0_48_485 vssd1 vssd1 vccd1 vccd1 sky130_fd_sc_hd__decap_3
XFILLER_0_35_113 vssd1 vssd1 vccd1 vccd1 sky130_fd_sc_hd__fill_2
X_10580_ _04428_ _04540_ vssd1 vssd1 vccd1 vccd1 _04682_ sky130_fd_sc_hd__nand2b_1
Xclkbuf_leaf_6_clk_i clknet_3_6__leaf_clk_i vssd1 vssd1 vccd1 vccd1 clknet_leaf_6_clk_i
+ sky130_fd_sc_hd__clkbuf_16
X_09239_ net835 net995 vssd1 vssd1 vccd1 vccd1 _03350_ sky130_fd_sc_hd__and2_1
XFILLER_0_63_488 vssd1 vssd1 vccd1 vccd1 sky130_fd_sc_hd__fill_1
XFILLER_0_121_505 vssd1 vssd1 vccd1 vccd1 sky130_ef_sc_hd__decap_12
X_12250_ _00960_ net511 net468 y1my2\[28\] _06186_ vssd1 vssd1 vccd1 vccd1 _06187_
+ sky130_fd_sc_hd__a221o_1
X_11201_ _05296_ _05297_ _05173_ _05175_ vssd1 vssd1 vccd1 vccd1 _05299_ sky130_fd_sc_hd__o211a_1
X_12181_ net526 net509 net466 y1my2\[5\] _06140_ vssd1 vssd1 vccd1 vccd1 _06141_ sky130_fd_sc_hd__a221o_1
XFILLER_0_31_363 vssd1 vssd1 vccd1 vccd1 sky130_fd_sc_hd__decap_4
XFILLER_0_102_741 vssd1 vssd1 vccd1 vccd1 sky130_ef_sc_hd__decap_12
X_11132_ _05228_ _05229_ vssd1 vssd1 vccd1 vccd1 _05230_ sky130_fd_sc_hd__or2_1
X_11063_ _05043_ _05045_ vssd1 vssd1 vccd1 vccd1 _05162_ sky130_fd_sc_hd__or2_2
X_10014_ net1053 net737 vssd1 vssd1 vccd1 vccd1 _04120_ sky130_fd_sc_hd__nand2_1
XFILLER_0_25_15 vssd1 vssd1 vccd1 vccd1 sky130_ef_sc_hd__decap_12
XFILLER_0_98_363 vssd1 vssd1 vccd1 vccd1 sky130_fd_sc_hd__fill_1
X_11965_ net1313 _05978_ net480 vssd1 vssd1 vccd1 vccd1 _00234_ sky130_fd_sc_hd__mux2_1
X_10916_ _04847_ _04850_ _05013_ _05015_ vssd1 vssd1 vccd1 vccd1 _05016_ sky130_fd_sc_hd__a211oi_4
XFILLER_0_129_638 vssd1 vssd1 vccd1 vccd1 sky130_fd_sc_hd__fill_1
X_11896_ temp1\[31\] net617 net610 net210 _05925_ vssd1 vssd1 vccd1 vccd1 _05926_
+ sky130_fd_sc_hd__a221o_1
X_10847_ _04944_ _04945_ _04766_ _04769_ vssd1 vssd1 vccd1 vccd1 _04948_ sky130_fd_sc_hd__a211oi_1
XFILLER_0_54_411 vssd1 vssd1 vccd1 vccd1 sky130_fd_sc_hd__decap_8
XFILLER_0_26_113 vssd1 vssd1 vccd1 vccd1 sky130_fd_sc_hd__fill_1
XFILLER_0_41_47 vssd1 vssd1 vccd1 vccd1 sky130_fd_sc_hd__fill_1
XFILLER_0_66_293 vssd1 vssd1 vccd1 vccd1 sky130_fd_sc_hd__decap_3
X_10778_ _04877_ _04878_ vssd1 vssd1 vccd1 vccd1 _04879_ sky130_fd_sc_hd__and2_1
XFILLER_0_54_455 vssd1 vssd1 vccd1 vccd1 sky130_fd_sc_hd__decap_8
XFILLER_0_54_433 vssd1 vssd1 vccd1 vccd1 sky130_fd_sc_hd__fill_2
XFILLER_0_15_809 vssd1 vssd1 vccd1 vccd1 sky130_ef_sc_hd__decap_12
XFILLER_0_27_669 vssd1 vssd1 vccd1 vccd1 sky130_fd_sc_hd__decap_3
X_12517_ net1242 net563 _06255_ vssd1 vssd1 vccd1 vccd1 _00509_ sky130_fd_sc_hd__a21o_1
XFILLER_0_124_365 vssd1 vssd1 vccd1 vccd1 sky130_ef_sc_hd__decap_12
XFILLER_0_81_296 vssd1 vssd1 vccd1 vccd1 sky130_fd_sc_hd__decap_3
X_12448_ temp1\[17\] _06217_ net571 vssd1 vssd1 vccd1 vccd1 _00478_ sky130_fd_sc_hd__mux2_1
XFILLER_0_1_202 vssd1 vssd1 vccd1 vccd1 sky130_fd_sc_hd__fill_2
X_12379_ net1463 _00818_ net684 vssd1 vssd1 vccd1 vccd1 _00431_ sky130_fd_sc_hd__mux2_1
XFILLER_0_1_279 vssd1 vssd1 vccd1 vccd1 sky130_fd_sc_hd__fill_1
XFILLER_0_5_69 vssd1 vssd1 vccd1 vccd1 sky130_fd_sc_hd__decap_6
X_06940_ _01029_ _01036_ _01052_ vssd1 vssd1 vccd1 vccd1 _01065_ sky130_fd_sc_hd__and3_1
X_06871_ _00608_ net636 net631 net605 vssd1 vssd1 vccd1 vccd1 _01000_ sky130_fd_sc_hd__or4_1
X_08610_ _02715_ _02722_ _02723_ vssd1 vssd1 vccd1 vccd1 _02725_ sky130_fd_sc_hd__nand3_1
X_09590_ net860 net962 _03696_ _03697_ vssd1 vssd1 vccd1 vccd1 _03699_ sky130_fd_sc_hd__a22o_1
X_08541_ _02594_ _02595_ _02654_ _02655_ vssd1 vssd1 vccd1 vccd1 _02657_ sky130_fd_sc_hd__o22a_1
X_08472_ _02584_ _02585_ _02586_ vssd1 vssd1 vccd1 vccd1 _02588_ sky130_fd_sc_hd__nand3_1
XFILLER_0_77_558 vssd1 vssd1 vccd1 vccd1 sky130_fd_sc_hd__fill_2
XFILLER_0_106_83 vssd1 vssd1 vccd1 vccd1 sky130_fd_sc_hd__fill_1
XFILLER_0_15_81 vssd1 vssd1 vccd1 vccd1 sky130_ef_sc_hd__decap_12
X_07423_ _01504_ _01512_ _01540_ _01546_ vssd1 vssd1 vccd1 vccd1 _01548_ sky130_fd_sc_hd__a211o_1
XFILLER_0_119_137 vssd1 vssd1 vccd1 vccd1 sky130_ef_sc_hd__decap_12
XFILLER_0_64_219 vssd1 vssd1 vccd1 vccd1 sky130_fd_sc_hd__fill_1
XFILLER_0_17_102 vssd1 vssd1 vccd1 vccd1 sky130_fd_sc_hd__decap_8
XFILLER_0_17_113 vssd1 vssd1 vccd1 vccd1 sky130_fd_sc_hd__decap_8
XFILLER_0_116_800 vssd1 vssd1 vccd1 vccd1 sky130_fd_sc_hd__decap_4
XFILLER_0_85_591 vssd1 vssd1 vccd1 vccd1 sky130_ef_sc_hd__decap_12
X_07354_ _01413_ _01467_ _01472_ vssd1 vssd1 vccd1 vccd1 _01479_ sky130_fd_sc_hd__a21o_1
XFILLER_0_93_3 vssd1 vssd1 vccd1 vccd1 sky130_ef_sc_hd__decap_12
X_07285_ net925 net910 net1082 net1090 vssd1 vssd1 vccd1 vccd1 _01410_ sky130_fd_sc_hd__nand4_2
X_06305_ _00614_ _00617_ vssd1 vssd1 vccd1 vccd1 net250 sky130_fd_sc_hd__nor2_2
XFILLER_0_33_617 vssd1 vssd1 vccd1 vccd1 sky130_fd_sc_hd__decap_6
X_09024_ _03005_ _03008_ _03135_ vssd1 vssd1 vccd1 vccd1 _03136_ sky130_fd_sc_hd__a21oi_2
XFILLER_0_103_505 vssd1 vssd1 vccd1 vccd1 sky130_fd_sc_hd__fill_1
XFILLER_0_5_552 vssd1 vssd1 vccd1 vccd1 sky130_fd_sc_hd__fill_1
Xhold220 x0mx2\[18\] vssd1 vssd1 vccd1 vccd1 net1435 sky130_fd_sc_hd__dlygate4sd3_1
XFILLER_0_41_661 vssd1 vssd1 vccd1 vccd1 sky130_fd_sc_hd__decap_8
Xhold253 l1\[17\] vssd1 vssd1 vccd1 vccd1 net1468 sky130_fd_sc_hd__dlygate4sd3_1
Xhold242 y2my0\[31\] vssd1 vssd1 vccd1 vccd1 net1457 sky130_fd_sc_hd__dlygate4sd3_1
XFILLER_0_41_694 vssd1 vssd1 vccd1 vccd1 sky130_fd_sc_hd__fill_1
Xhold231 net379 vssd1 vssd1 vccd1 vccd1 net1446 sky130_fd_sc_hd__dlygate4sd3_1
XFILLER_0_130_379 vssd1 vssd1 vccd1 vccd1 sky130_fd_sc_hd__fill_1
Xhold275 net343 vssd1 vssd1 vccd1 vccd1 net1490 sky130_fd_sc_hd__dlygate4sd3_1
Xfanout700 net701 vssd1 vssd1 vccd1 vccd1 net700 sky130_fd_sc_hd__buf_2
Xhold286 add1.a_i\[8\] vssd1 vssd1 vccd1 vccd1 net1501 sky130_fd_sc_hd__dlygate4sd3_1
XFILLER_0_1_9 vssd1 vssd1 vccd1 vccd1 sky130_ef_sc_hd__decap_12
Xhold264 x0mx2\[4\] vssd1 vssd1 vccd1 vccd1 net1479 sky130_fd_sc_hd__dlygate4sd3_1
XFILLER_0_40_182 vssd1 vssd1 vccd1 vccd1 sky130_fd_sc_hd__fill_1
Xfanout711 mul1.b\[28\] vssd1 vssd1 vccd1 vccd1 net711 sky130_fd_sc_hd__buf_2
X_09926_ _03867_ _03868_ _03870_ _03872_ _04023_ vssd1 vssd1 vccd1 vccd1 _04033_ sky130_fd_sc_hd__a41o_1
Xfanout722 net726 vssd1 vssd1 vccd1 vccd1 net722 sky130_fd_sc_hd__clkbuf_2
Xfanout733 mul1.b\[24\] vssd1 vssd1 vccd1 vccd1 net733 sky130_fd_sc_hd__buf_4
Xhold297 net378 vssd1 vssd1 vccd1 vccd1 net1512 sky130_fd_sc_hd__dlygate4sd3_1
Xfanout755 net756 vssd1 vssd1 vccd1 vccd1 net755 sky130_fd_sc_hd__clkbuf_4
Xfanout744 net746 vssd1 vssd1 vccd1 vccd1 net744 sky130_fd_sc_hd__clkbuf_4
Xfanout766 net771 vssd1 vssd1 vccd1 vccd1 net766 sky130_fd_sc_hd__buf_2
Xfanout777 net780 vssd1 vssd1 vccd1 vccd1 net777 sky130_fd_sc_hd__buf_2
XFILLER_0_99_105 vssd1 vssd1 vccd1 vccd1 sky130_fd_sc_hd__decap_6
X_09857_ net1038 net759 _03960_ _03962_ vssd1 vssd1 vccd1 vccd1 _03964_ sky130_fd_sc_hd__nand4_1
Xfanout788 net794 vssd1 vssd1 vccd1 vccd1 net788 sky130_fd_sc_hd__clkbuf_4
XTAP_580 vssd1 vccd1 sky130_fd_sc_hd__tapvpwrvgnd_1
XTAP_591 vssd1 vccd1 sky130_fd_sc_hd__tapvpwrvgnd_1
Xfanout799 net801 vssd1 vssd1 vccd1 vccd1 net799 sky130_fd_sc_hd__clkbuf_4
X_09788_ _03589_ _03738_ _03737_ vssd1 vssd1 vccd1 vccd1 _03896_ sky130_fd_sc_hd__a21boi_2
X_08808_ _02918_ _02921_ vssd1 vssd1 vccd1 vccd1 _02922_ sky130_fd_sc_hd__xor2_2
X_08739_ _02852_ vssd1 vssd1 vccd1 vccd1 _02853_ sky130_fd_sc_hd__inv_2
XTAP_1724 vssd1 vccd1 sky130_fd_sc_hd__tapvpwrvgnd_1
XTAP_1713 vssd1 vccd1 sky130_fd_sc_hd__tapvpwrvgnd_1
XTAP_1702 vssd1 vccd1 sky130_fd_sc_hd__tapvpwrvgnd_1
X_11750_ net248 net598 net578 net152 _05802_ vssd1 vssd1 vccd1 vccd1 _05803_ sky130_fd_sc_hd__a221o_1
XTAP_1757 vssd1 vccd1 sky130_fd_sc_hd__tapvpwrvgnd_1
XTAP_1746 vssd1 vccd1 sky130_fd_sc_hd__tapvpwrvgnd_1
XTAP_1735 vssd1 vccd1 sky130_fd_sc_hd__tapvpwrvgnd_1
X_10701_ _04529_ _04656_ _04655_ vssd1 vssd1 vccd1 vccd1 _04803_ sky130_fd_sc_hd__a21oi_1
XTAP_1768 vssd1 vccd1 sky130_fd_sc_hd__tapvpwrvgnd_1
XTAP_1779 vssd1 vccd1 sky130_fd_sc_hd__tapvpwrvgnd_1
XFILLER_0_83_517 vssd1 vssd1 vccd1 vccd1 sky130_fd_sc_hd__decap_8
X_11681_ net1314 _04065_ net538 vssd1 vssd1 vccd1 vccd1 _00173_ sky130_fd_sc_hd__mux2_1
XFILLER_0_119_671 vssd1 vssd1 vccd1 vccd1 sky130_fd_sc_hd__fill_1
X_10632_ _04727_ _04732_ vssd1 vssd1 vccd1 vccd1 _04734_ sky130_fd_sc_hd__xor2_1
XFILLER_0_91_561 vssd1 vssd1 vccd1 vccd1 sky130_fd_sc_hd__fill_2
X_10563_ _04664_ _04665_ vssd1 vssd1 vccd1 vccd1 _04666_ sky130_fd_sc_hd__xnor2_4
XFILLER_0_11_39 vssd1 vssd1 vccd1 vccd1 sky130_ef_sc_hd__decap_12
XFILLER_0_106_365 vssd1 vssd1 vccd1 vccd1 sky130_fd_sc_hd__fill_1
XFILLER_0_51_447 vssd1 vssd1 vccd1 vccd1 sky130_fd_sc_hd__fill_1
X_12302_ net1687 _00918_ net681 vssd1 vssd1 vccd1 vccd1 _00354_ sky130_fd_sc_hd__mux2_1
XFILLER_0_106_376 vssd1 vssd1 vccd1 vccd1 sky130_fd_sc_hd__fill_1
X_10494_ _04595_ _04596_ _04581_ vssd1 vssd1 vccd1 vccd1 _04597_ sky130_fd_sc_hd__a21o_1
XFILLER_0_121_335 vssd1 vssd1 vccd1 vccd1 sky130_fd_sc_hd__fill_1
X_12233_ net743 _06175_ net519 vssd1 vssd1 vccd1 vccd1 _00305_ sky130_fd_sc_hd__mux2_1
X_12164_ net605 net501 vssd1 vssd1 vccd1 vccd1 _06129_ sky130_fd_sc_hd__nor2_1
XFILLER_0_31_182 vssd1 vssd1 vccd1 vccd1 sky130_fd_sc_hd__decap_6
X_12095_ net1040 _06077_ net516 vssd1 vssd1 vccd1 vccd1 _00265_ sky130_fd_sc_hd__mux2_1
X_11115_ net807 net935 vssd1 vssd1 vccd1 vccd1 _05213_ sky130_fd_sc_hd__nand2_1
X_11046_ _05143_ _05144_ vssd1 vssd1 vccd1 vccd1 _05145_ sky130_fd_sc_hd__nand2b_1
XFILLER_0_127_27 vssd1 vssd1 vccd1 vccd1 sky130_ef_sc_hd__decap_12
X_12997_ clknet_leaf_48_clk_i _00383_ net1161 vssd1 vssd1 vccd1 vccd1 x2mx1\[18\]
+ sky130_fd_sc_hd__dfrtp_1
X_11948_ net124 net656 net503 net220 _05965_ vssd1 vssd1 vccd1 vccd1 _05966_ sky130_fd_sc_hd__a221o_1
XFILLER_0_74_528 vssd1 vssd1 vccd1 vccd1 sky130_fd_sc_hd__decap_4
XFILLER_0_52_79 vssd1 vssd1 vccd1 vccd1 sky130_fd_sc_hd__fill_1
X_11879_ net238 net600 net580 net142 _05911_ vssd1 vssd1 vccd1 vccd1 _05912_ sky130_fd_sc_hd__a221o_1
XFILLER_0_7_817 vssd1 vssd1 vccd1 vccd1 sky130_ef_sc_hd__decap_12
XFILLER_0_125_641 vssd1 vssd1 vccd1 vccd1 sky130_ef_sc_hd__decap_12
XFILLER_0_109_181 vssd1 vssd1 vccd1 vccd1 sky130_ef_sc_hd__decap_12
X_07070_ _01174_ _01175_ _01193_ _01194_ vssd1 vssd1 vccd1 vccd1 _01195_ sky130_fd_sc_hd__and4bb_2
XFILLER_0_42_447 vssd1 vssd1 vccd1 vccd1 sky130_ef_sc_hd__decap_12
XFILLER_0_125_685 vssd1 vssd1 vccd1 vccd1 sky130_ef_sc_hd__decap_12
Xoutput325 net325 vssd1 vssd1 vccd1 vccd1 div_mstream_o[90] sky130_fd_sc_hd__clkbuf_4
Xoutput314 net314 vssd1 vssd1 vccd1 vccd1 div_mstream_o[80] sky130_fd_sc_hd__clkbuf_4
Xoutput303 net303 vssd1 vssd1 vccd1 vccd1 div_mstream_o[70] sky130_fd_sc_hd__clkbuf_4
XFILLER_0_112_357 vssd1 vssd1 vccd1 vccd1 sky130_fd_sc_hd__decap_6
Xoutput347 net347 vssd1 vssd1 vccd1 vccd1 mstream_o[110] sky130_fd_sc_hd__clkbuf_4
Xoutput336 net336 vssd1 vssd1 vccd1 vccd1 mstream_o[100] sky130_fd_sc_hd__clkbuf_4
XFILLER_0_50_491 vssd1 vssd1 vccd1 vccd1 sky130_fd_sc_hd__decap_6
Xoutput369 net369 vssd1 vssd1 vccd1 vccd1 mstream_o[27] sky130_fd_sc_hd__clkbuf_4
Xoutput358 net358 vssd1 vssd1 vccd1 vccd1 mstream_o[17] sky130_fd_sc_hd__clkbuf_4
X_09711_ _03818_ _03817_ _03816_ vssd1 vssd1 vccd1 vccd1 _03819_ sky130_fd_sc_hd__nand3b_1
X_07972_ _02089_ _02090_ _02001_ _02004_ vssd1 vssd1 vccd1 vccd1 _02092_ sky130_fd_sc_hd__o211a_1
X_06923_ _01041_ _01046_ vssd1 vssd1 vccd1 vccd1 _01048_ sky130_fd_sc_hd__xor2_1
X_09642_ net1694 _03750_ net524 vssd1 vssd1 vccd1 vccd1 _00139_ sky130_fd_sc_hd__mux2_1
X_06854_ net1686 _00981_ _00984_ vssd1 vssd1 vccd1 vccd1 _00117_ sky130_fd_sc_hd__a21oi_1
X_09573_ _03679_ _03680_ _03681_ vssd1 vssd1 vccd1 vccd1 _03682_ sky130_fd_sc_hd__nand3_1
X_06785_ net401 net1249 net641 vssd1 vssd1 vccd1 vccd1 _00059_ sky130_fd_sc_hd__mux2_1
XFILLER_0_117_93 vssd1 vssd1 vccd1 vccd1 sky130_ef_sc_hd__decap_12
XFILLER_0_77_333 vssd1 vssd1 vccd1 vccd1 sky130_fd_sc_hd__decap_3
X_08524_ _02636_ _02637_ _02638_ vssd1 vssd1 vccd1 vccd1 _02640_ sky130_fd_sc_hd__a21o_1
XTAP_1009 vssd1 vccd1 sky130_fd_sc_hd__tapvpwrvgnd_1
X_08455_ _02568_ _02569_ _02570_ vssd1 vssd1 vccd1 vccd1 _02571_ sky130_fd_sc_hd__and3_1
XFILLER_0_37_219 vssd1 vssd1 vccd1 vccd1 sky130_fd_sc_hd__decap_4
X_08386_ net913 net967 net961 net921 vssd1 vssd1 vccd1 vccd1 _02503_ sky130_fd_sc_hd__a22o_1
XFILLER_0_9_165 vssd1 vssd1 vccd1 vccd1 sky130_fd_sc_hd__fill_1
X_07406_ net872 net863 net1136 net1144 vssd1 vssd1 vccd1 vccd1 _01531_ sky130_fd_sc_hd__and4_1
XFILLER_0_45_263 vssd1 vssd1 vccd1 vccd1 sky130_fd_sc_hd__fill_1
X_07337_ _01406_ _01407_ _01460_ vssd1 vssd1 vccd1 vccd1 _01462_ sky130_fd_sc_hd__a21oi_1
XFILLER_0_60_200 vssd1 vssd1 vccd1 vccd1 sky130_fd_sc_hd__decap_3
XFILLER_0_33_447 vssd1 vssd1 vccd1 vccd1 sky130_fd_sc_hd__fill_1
XFILLER_0_103_313 vssd1 vssd1 vccd1 vccd1 sky130_ef_sc_hd__decap_12
X_07268_ _01356_ _01357_ _01390_ _01391_ vssd1 vssd1 vccd1 vccd1 _01393_ sky130_fd_sc_hd__or4bb_4
X_09007_ net1148 net705 _03116_ _03118_ vssd1 vssd1 vccd1 vccd1 _03119_ sky130_fd_sc_hd__and4_1
XFILLER_0_14_694 vssd1 vssd1 vccd1 vccd1 sky130_fd_sc_hd__decap_6
X_07199_ _01321_ _01323_ _01201_ _01274_ vssd1 vssd1 vccd1 vccd1 _01324_ sky130_fd_sc_hd__o211a_1
Xfanout530 net331 vssd1 vssd1 vccd1 vccd1 net530 sky130_fd_sc_hd__buf_2
Xfanout541 net543 vssd1 vssd1 vccd1 vccd1 net541 sky130_fd_sc_hd__buf_4
Xfanout563 net564 vssd1 vssd1 vccd1 vccd1 net563 sky130_fd_sc_hd__buf_2
X_09909_ net860 net951 vssd1 vssd1 vccd1 vccd1 _04016_ sky130_fd_sc_hd__nand2_1
Xfanout552 net553 vssd1 vssd1 vccd1 vccd1 net552 sky130_fd_sc_hd__buf_2
Xfanout574 net575 vssd1 vssd1 vccd1 vccd1 net574 sky130_fd_sc_hd__clkbuf_4
Xfanout596 _05759_ vssd1 vssd1 vccd1 vccd1 net596 sky130_fd_sc_hd__clkbuf_4
Xfanout585 net586 vssd1 vssd1 vccd1 vccd1 net585 sky130_fd_sc_hd__clkbuf_4
X_12920_ clknet_leaf_32_clk_i _00306_ vssd1 vssd1 vccd1 vccd1 mul1.b\[23\] sky130_fd_sc_hd__dfxtp_1
XTAP_2200 vssd1 vccd1 sky130_fd_sc_hd__tapvpwrvgnd_1
X_12851_ clknet_leaf_36_clk_i _00237_ vssd1 vssd1 vccd1 vccd1 sub1.b_i\[18\] sky130_fd_sc_hd__dfxtp_1
Xclkbuf_leaf_24_clk_i clknet_3_5__leaf_clk_i vssd1 vssd1 vccd1 vccd1 clknet_leaf_24_clk_i
+ sky130_fd_sc_hd__clkbuf_16
XTAP_2244 vssd1 vccd1 sky130_fd_sc_hd__tapvpwrvgnd_1
XTAP_2233 vssd1 vccd1 sky130_fd_sc_hd__tapvpwrvgnd_1
XTAP_2222 vssd1 vccd1 sky130_fd_sc_hd__tapvpwrvgnd_1
XTAP_2211 vssd1 vccd1 sky130_fd_sc_hd__tapvpwrvgnd_1
X_11802_ net1624 _05846_ net480 vssd1 vssd1 vccd1 vccd1 _00203_ sky130_fd_sc_hd__mux2_1
XTAP_2255 vssd1 vccd1 sky130_fd_sc_hd__tapvpwrvgnd_1
XTAP_1532 vssd1 vccd1 sky130_fd_sc_hd__tapvpwrvgnd_1
XTAP_1521 vssd1 vccd1 sky130_fd_sc_hd__tapvpwrvgnd_1
XTAP_1510 vssd1 vccd1 sky130_fd_sc_hd__tapvpwrvgnd_1
X_12782_ clknet_leaf_1_clk_i _00168_ vssd1 vssd1 vccd1 vccd1 add1.b_i\[13\] sky130_fd_sc_hd__dfxtp_1
XTAP_1565 vssd1 vccd1 sky130_fd_sc_hd__tapvpwrvgnd_1
XTAP_1576 vssd1 vccd1 sky130_fd_sc_hd__tapvpwrvgnd_1
XTAP_1554 vssd1 vccd1 sky130_fd_sc_hd__tapvpwrvgnd_1
XTAP_1543 vssd1 vccd1 sky130_fd_sc_hd__tapvpwrvgnd_1
XFILLER_0_83_314 vssd1 vssd1 vccd1 vccd1 sky130_fd_sc_hd__decap_8
X_11733_ temp1\[5\] net611 net668 net117 _05788_ vssd1 vssd1 vccd1 vccd1 _05789_ sky130_fd_sc_hd__a221o_1
XPHY_50 vssd1 vssd1 vccd1 vccd1 sky130_fd_sc_hd__decap_3
Xclkbuf_leaf_39_clk_i clknet_3_4__leaf_clk_i vssd1 vssd1 vccd1 vccd1 clknet_leaf_39_clk_i
+ sky130_fd_sc_hd__clkbuf_16
XPHY_61 vssd1 vssd1 vccd1 vccd1 sky130_fd_sc_hd__decap_3
XPHY_72 vssd1 vssd1 vccd1 vccd1 sky130_fd_sc_hd__decap_3
XPHY_83 vssd1 vssd1 vccd1 vccd1 sky130_fd_sc_hd__decap_3
XTAP_1598 vssd1 vccd1 sky130_fd_sc_hd__tapvpwrvgnd_1
XTAP_1587 vssd1 vccd1 sky130_fd_sc_hd__tapvpwrvgnd_1
XPHY_94 vssd1 vssd1 vccd1 vccd1 sky130_fd_sc_hd__decap_3
XFILLER_0_22_27 vssd1 vssd1 vccd1 vccd1 sky130_fd_sc_hd__fill_1
X_11664_ net1602 _01760_ net536 vssd1 vssd1 vccd1 vccd1 _00156_ sky130_fd_sc_hd__mux2_1
X_10615_ _04715_ _04716_ vssd1 vssd1 vccd1 vccd1 _04717_ sky130_fd_sc_hd__nand2b_1
XFILLER_0_118_9 vssd1 vssd1 vccd1 vccd1 sky130_ef_sc_hd__decap_12
XFILLER_0_107_641 vssd1 vssd1 vccd1 vccd1 sky130_ef_sc_hd__decap_12
XFILLER_0_36_296 vssd1 vssd1 vccd1 vccd1 sky130_fd_sc_hd__fill_2
X_11595_ _05685_ _05688_ vssd1 vssd1 vccd1 vccd1 _05689_ sky130_fd_sc_hd__xnor2_1
X_10546_ _04646_ net486 _04502_ _04505_ vssd1 vssd1 vccd1 vccd1 _04649_ sky130_fd_sc_hd__o211a_1
XFILLER_0_12_609 vssd1 vssd1 vccd1 vccd1 sky130_fd_sc_hd__decap_4
X_10477_ _04571_ _04579_ vssd1 vssd1 vccd1 vccd1 _04580_ sky130_fd_sc_hd__or2_1
XFILLER_0_122_699 vssd1 vssd1 vccd1 vccd1 sky130_fd_sc_hd__fill_1
XFILLER_0_110_817 vssd1 vssd1 vccd1 vccd1 sky130_fd_sc_hd__fill_1
XFILLER_0_20_620 vssd1 vssd1 vccd1 vccd1 sky130_fd_sc_hd__fill_2
XFILLER_0_20_642 vssd1 vssd1 vccd1 vccd1 sky130_fd_sc_hd__fill_2
X_12216_ x2mx1\[17\] net604 net585 temp1\[17\] vssd1 vssd1 vccd1 vccd1 _06164_ sky130_fd_sc_hd__a22o_1
X_13196_ clknet_leaf_20_clk_i _00582_ net1179 vssd1 vssd1 vccd1 vccd1 l1\[25\] sky130_fd_sc_hd__dfrtp_1
X_12147_ net947 _06116_ net517 vssd1 vssd1 vccd1 vccd1 _00278_ sky130_fd_sc_hd__mux2_1
XFILLER_0_47_57 vssd1 vssd1 vccd1 vccd1 sky130_fd_sc_hd__decap_4
X_12078_ _00862_ _06064_ net499 vssd1 vssd1 vccd1 vccd1 _06065_ sky130_fd_sc_hd__mux2_1
X_11029_ _05118_ _05126_ vssd1 vssd1 vccd1 vccd1 _05128_ sky130_fd_sc_hd__xnor2_1
XFILLER_0_2_15 vssd1 vssd1 vccd1 vccd1 sky130_ef_sc_hd__decap_12
XFILLER_0_79_609 vssd1 vssd1 vccd1 vccd1 sky130_fd_sc_hd__decap_3
XFILLER_0_86_141 vssd1 vssd1 vccd1 vccd1 sky130_fd_sc_hd__fill_1
XFILLER_0_63_78 vssd1 vssd1 vccd1 vccd1 sky130_fd_sc_hd__decap_4
XFILLER_0_59_333 vssd1 vssd1 vccd1 vccd1 sky130_fd_sc_hd__decap_3
X_06570_ net1716 _00813_ net633 vssd1 vssd1 vccd1 vccd1 _00004_ sky130_fd_sc_hd__mux2_1
XFILLER_0_74_303 vssd1 vssd1 vccd1 vccd1 sky130_fd_sc_hd__decap_4
XFILLER_0_117_405 vssd1 vssd1 vccd1 vccd1 sky130_ef_sc_hd__decap_12
X_08240_ _02356_ _02357_ vssd1 vssd1 vccd1 vccd1 _02358_ sky130_fd_sc_hd__nand2b_1
XFILLER_0_7_614 vssd1 vssd1 vccd1 vccd1 sky130_fd_sc_hd__fill_2
XANTENNA_48 _00794_ vssd1 vssd1 vccd1 vccd1 sky130_fd_sc_hd__diode_2
XFILLER_0_117_449 vssd1 vssd1 vccd1 vccd1 sky130_ef_sc_hd__decap_12
XANTENNA_37 net51 vssd1 vssd1 vccd1 vccd1 sky130_fd_sc_hd__diode_2
XFILLER_0_103_51 vssd1 vssd1 vccd1 vccd1 sky130_fd_sc_hd__decap_4
X_08171_ _02205_ _02208_ _02288_ vssd1 vssd1 vccd1 vccd1 _02289_ sky130_fd_sc_hd__o21ai_1
XFILLER_0_62_509 vssd1 vssd1 vccd1 vccd1 sky130_fd_sc_hd__fill_1
XANTENNA_26 v2x[6] vssd1 vssd1 vccd1 vccd1 sky130_fd_sc_hd__diode_2
XANTENNA_15 v0y[24] vssd1 vssd1 vccd1 vccd1 sky130_fd_sc_hd__diode_2
XFILLER_0_70_531 vssd1 vssd1 vccd1 vccd1 sky130_fd_sc_hd__fill_1
XFILLER_0_70_520 vssd1 vssd1 vccd1 vccd1 sky130_fd_sc_hd__decap_4
X_07122_ _01245_ _01246_ vssd1 vssd1 vccd1 vccd1 _01247_ sky130_fd_sc_hd__nor2_1
XANTENNA_59 v1y[9] vssd1 vssd1 vccd1 vccd1 sky130_fd_sc_hd__diode_2
XFILLER_0_42_222 vssd1 vssd1 vccd1 vccd1 sky130_fd_sc_hd__fill_1
XFILLER_0_112_121 vssd1 vssd1 vccd1 vccd1 sky130_ef_sc_hd__decap_12
XFILLER_0_88_53 vssd1 vssd1 vccd1 vccd1 sky130_ef_sc_hd__decap_12
X_07053_ _01176_ _01177_ net829 net1120 vssd1 vssd1 vccd1 vccd1 _01178_ sky130_fd_sc_hd__and4bb_1
XFILLER_0_112_165 vssd1 vssd1 vccd1 vccd1 sky130_ef_sc_hd__decap_12
XFILLER_0_56_3 vssd1 vssd1 vccd1 vccd1 sky130_fd_sc_hd__decap_3
XFILLER_0_10_141 vssd1 vssd1 vccd1 vccd1 sky130_ef_sc_hd__decap_12
X_07955_ _02073_ _02074_ vssd1 vssd1 vccd1 vccd1 _02075_ sky130_fd_sc_hd__xnor2_1
X_06906_ net854 net1118 vssd1 vssd1 vccd1 vccd1 _01031_ sky130_fd_sc_hd__nand2_1
X_09625_ _03730_ _03731_ _03560_ _03562_ vssd1 vssd1 vccd1 vccd1 _03734_ sky130_fd_sc_hd__o211ai_2
X_07886_ _01909_ _01910_ _01911_ vssd1 vssd1 vccd1 vccd1 _02007_ sky130_fd_sc_hd__o21ba_1
X_06837_ net1489 net1474 net646 vssd1 vssd1 vccd1 vccd1 _00111_ sky130_fd_sc_hd__mux2_1
XFILLER_0_97_428 vssd1 vssd1 vccd1 vccd1 sky130_fd_sc_hd__decap_4
X_09556_ _03663_ _03664_ _03650_ vssd1 vssd1 vccd1 vccd1 _03665_ sky130_fd_sc_hd__a21oi_1
XFILLER_0_78_642 vssd1 vssd1 vccd1 vccd1 sky130_fd_sc_hd__fill_2
X_06768_ net1546 net1518 net637 vssd1 vssd1 vccd1 vccd1 _00042_ sky130_fd_sc_hd__mux2_1
X_09487_ net1108 net714 net707 net1116 vssd1 vssd1 vccd1 vccd1 _03596_ sky130_fd_sc_hd__a22o_1
XFILLER_0_93_623 vssd1 vssd1 vccd1 vccd1 sky130_fd_sc_hd__decap_4
X_08507_ _02621_ _02622_ vssd1 vssd1 vccd1 vccd1 _02623_ sky130_fd_sc_hd__nor2_1
X_06699_ _00914_ _00917_ _00915_ vssd1 vssd1 vccd1 vccd1 _00922_ sky130_fd_sc_hd__a21oi_4
X_08438_ _02439_ _02441_ _02552_ vssd1 vssd1 vccd1 vccd1 _02554_ sky130_fd_sc_hd__nand3_1
XFILLER_0_92_122 vssd1 vssd1 vccd1 vccd1 sky130_fd_sc_hd__fill_2
XFILLER_0_34_701 vssd1 vssd1 vccd1 vccd1 sky130_fd_sc_hd__fill_1
X_08369_ _02353_ _02355_ vssd1 vssd1 vccd1 vccd1 _02486_ sky130_fd_sc_hd__nand2_1
XFILLER_0_46_572 vssd1 vssd1 vccd1 vccd1 sky130_fd_sc_hd__fill_1
XFILLER_0_104_611 vssd1 vssd1 vccd1 vccd1 sky130_ef_sc_hd__decap_12
X_10400_ _04502_ _04503_ _04300_ _04303_ vssd1 vssd1 vccd1 vccd1 _04504_ sky130_fd_sc_hd__a211o_1
X_11380_ net757 net963 _05351_ _05350_ vssd1 vssd1 vccd1 vccd1 _05476_ sky130_fd_sc_hd__a31o_1
XFILLER_0_61_597 vssd1 vssd1 vccd1 vccd1 sky130_fd_sc_hd__fill_1
X_10331_ net859 net936 _04433_ _04434_ vssd1 vssd1 vccd1 vccd1 _04435_ sky130_fd_sc_hd__nand4_2
XFILLER_0_104_699 vssd1 vssd1 vccd1 vccd1 sky130_fd_sc_hd__fill_1
XFILLER_0_103_154 vssd1 vssd1 vccd1 vccd1 sky130_fd_sc_hd__fill_1
X_10262_ _04225_ _04366_ vssd1 vssd1 vccd1 vccd1 _04367_ sky130_fd_sc_hd__xnor2_4
X_13050_ clknet_leaf_53_clk_i _00436_ net1154 vssd1 vssd1 vccd1 vccd1 y2my0\[7\] sky130_fd_sc_hd__dfrtp_1
X_12001_ net1278 _06005_ net482 vssd1 vssd1 vccd1 vccd1 _00243_ sky130_fd_sc_hd__mux2_1
X_10193_ _04132_ _04140_ _04139_ vssd1 vssd1 vccd1 vccd1 _04298_ sky130_fd_sc_hd__a21bo_1
XFILLER_0_108_29 vssd1 vssd1 vccd1 vccd1 sky130_ef_sc_hd__decap_12
XFILLER_0_17_27 vssd1 vssd1 vccd1 vccd1 sky130_ef_sc_hd__decap_12
X_12903_ clknet_leaf_45_clk_i _00289_ vssd1 vssd1 vccd1 vccd1 mul1.b\[6\] sky130_fd_sc_hd__dfxtp_2
XTAP_2052 vssd1 vccd1 sky130_fd_sc_hd__tapvpwrvgnd_1
XTAP_2041 vssd1 vccd1 sky130_fd_sc_hd__tapvpwrvgnd_1
XTAP_2030 vssd1 vccd1 sky130_fd_sc_hd__tapvpwrvgnd_1
X_12834_ clknet_leaf_56_clk_i _00220_ vssd1 vssd1 vccd1 vccd1 sub1.b_i\[1\] sky130_fd_sc_hd__dfxtp_1
XTAP_2085 vssd1 vccd1 sky130_fd_sc_hd__tapvpwrvgnd_1
XTAP_2074 vssd1 vccd1 sky130_fd_sc_hd__tapvpwrvgnd_1
XTAP_2063 vssd1 vccd1 sky130_fd_sc_hd__tapvpwrvgnd_1
XTAP_1340 vssd1 vccd1 sky130_fd_sc_hd__tapvpwrvgnd_1
XFILLER_0_69_686 vssd1 vssd1 vccd1 vccd1 sky130_fd_sc_hd__fill_2
XFILLER_0_68_163 vssd1 vssd1 vccd1 vccd1 sky130_fd_sc_hd__decap_6
XFILLER_0_68_141 vssd1 vssd1 vccd1 vccd1 sky130_fd_sc_hd__decap_4
X_12765_ clknet_leaf_18_clk_i _00151_ vssd1 vssd1 vccd1 vccd1 add1.a_i\[28\] sky130_fd_sc_hd__dfxtp_1
XTAP_2096 vssd1 vccd1 sky130_fd_sc_hd__tapvpwrvgnd_1
XFILLER_0_84_645 vssd1 vssd1 vccd1 vccd1 sky130_fd_sc_hd__decap_8
XFILLER_0_83_111 vssd1 vssd1 vccd1 vccd1 sky130_fd_sc_hd__fill_1
XTAP_1384 vssd1 vccd1 sky130_fd_sc_hd__tapvpwrvgnd_1
XTAP_1362 vssd1 vccd1 sky130_fd_sc_hd__tapvpwrvgnd_1
XTAP_1373 vssd1 vccd1 sky130_fd_sc_hd__tapvpwrvgnd_1
XTAP_1351 vssd1 vccd1 sky130_fd_sc_hd__tapvpwrvgnd_1
XFILLER_0_68_185 vssd1 vssd1 vccd1 vccd1 sky130_fd_sc_hd__decap_3
X_11716_ net208 net607 net668 net112 vssd1 vssd1 vccd1 vccd1 _05775_ sky130_fd_sc_hd__a22o_1
X_12696_ clknet_leaf_13_clk_i net1459 net1186 vssd1 vssd1 vccd1 vccd1 net426 sky130_fd_sc_hd__dfrtp_1
XTAP_1395 vssd1 vccd1 sky130_fd_sc_hd__tapvpwrvgnd_1
XFILLER_0_37_550 vssd1 vssd1 vccd1 vccd1 sky130_fd_sc_hd__decap_3
XFILLER_0_37_561 vssd1 vssd1 vccd1 vccd1 sky130_fd_sc_hd__decap_6
Xinput13 div_sstream_i[1] vssd1 vssd1 vccd1 vccd1 net13 sky130_fd_sc_hd__clkbuf_8
X_11647_ _05737_ _05740_ vssd1 vssd1 vccd1 vccd1 _05741_ sky130_fd_sc_hd__xnor2_1
XFILLER_0_37_572 vssd1 vssd1 vccd1 vccd1 sky130_fd_sc_hd__decap_3
Xinput24 div_sstream_i[2] vssd1 vssd1 vccd1 vccd1 net24 sky130_fd_sc_hd__clkbuf_8
XFILLER_0_114_419 vssd1 vssd1 vccd1 vccd1 sky130_fd_sc_hd__fill_1
Xinput46 sstream_i[17] vssd1 vssd1 vccd1 vccd1 net46 sky130_fd_sc_hd__buf_4
Xinput35 mstream_i vssd1 vssd1 vccd1 vccd1 net35 sky130_fd_sc_hd__buf_1
X_11578_ net1343 _05672_ net525 vssd1 vssd1 vccd1 vccd1 _00153_ sky130_fd_sc_hd__mux2_1
X_10529_ net1037 net1047 net731 net725 vssd1 vssd1 vccd1 vccd1 _04632_ sky130_fd_sc_hd__nand4_2
Xinput57 sstream_i[9] vssd1 vssd1 vccd1 vccd1 net57 sky130_fd_sc_hd__buf_4
Xinput79 v0x[29] vssd1 vssd1 vccd1 vccd1 net79 sky130_fd_sc_hd__buf_1
Xinput68 v0x[19] vssd1 vssd1 vccd1 vccd1 net68 sky130_fd_sc_hd__buf_1
XFILLER_0_110_625 vssd1 vssd1 vccd1 vccd1 sky130_ef_sc_hd__decap_12
XFILLER_0_110_669 vssd1 vssd1 vccd1 vccd1 sky130_ef_sc_hd__decap_12
XFILLER_0_58_89 vssd1 vssd1 vccd1 vccd1 sky130_fd_sc_hd__decap_4
X_13179_ clknet_leaf_21_clk_i _00565_ net1176 vssd1 vssd1 vccd1 vccd1 l1\[8\] sky130_fd_sc_hd__dfrtp_1
X_07740_ net1115 net795 net786 net1123 vssd1 vssd1 vccd1 vccd1 _01862_ sky130_fd_sc_hd__a22o_1
X_07671_ net848 _01793_ _01792_ vssd1 vssd1 vccd1 vccd1 _01794_ sky130_fd_sc_hd__a21bo_1
XFILLER_0_94_409 vssd1 vssd1 vccd1 vccd1 sky130_fd_sc_hd__decap_4
X_09410_ _03510_ _03517_ _03518_ vssd1 vssd1 vccd1 vccd1 _03520_ sky130_fd_sc_hd__nand3_1
X_06622_ sub1.a_i\[10\] sub1.b_i\[10\] vssd1 vssd1 vccd1 vccd1 _00857_ sky130_fd_sc_hd__nand2b_1
X_09341_ _03447_ _03448_ _03449_ vssd1 vssd1 vccd1 vccd1 _03451_ sky130_fd_sc_hd__a21bo_1
XFILLER_0_59_163 vssd1 vssd1 vccd1 vccd1 sky130_fd_sc_hd__fill_2
X_06553_ _00597_ _00800_ vssd1 vssd1 vccd1 vccd1 _00801_ sky130_fd_sc_hd__nor2_1
XFILLER_0_90_65 vssd1 vssd1 vccd1 vccd1 sky130_ef_sc_hd__decap_12
XFILLER_0_118_725 vssd1 vssd1 vccd1 vccd1 sky130_ef_sc_hd__decap_12
XFILLER_0_114_83 vssd1 vssd1 vccd1 vccd1 sky130_fd_sc_hd__fill_1
X_09272_ _03224_ _03225_ _03226_ vssd1 vssd1 vccd1 vccd1 _03383_ sky130_fd_sc_hd__a21bo_1
X_06484_ _00777_ _00778_ vssd1 vssd1 vccd1 vccd1 _00779_ sky130_fd_sc_hd__xor2_4
XFILLER_0_35_509 vssd1 vssd1 vccd1 vccd1 sky130_fd_sc_hd__fill_1
X_08223_ net1059 net832 _02215_ _02216_ net849 vssd1 vssd1 vccd1 vccd1 _02341_ sky130_fd_sc_hd__a32o_1
XFILLER_0_117_279 vssd1 vssd1 vccd1 vccd1 sky130_fd_sc_hd__fill_1
X_08154_ _02270_ _02271_ _02174_ vssd1 vssd1 vccd1 vccd1 _02273_ sky130_fd_sc_hd__o21a_1
XFILLER_0_113_441 vssd1 vssd1 vccd1 vccd1 sky130_fd_sc_hd__decap_6
X_08085_ _02189_ _02202_ vssd1 vssd1 vccd1 vccd1 _02204_ sky130_fd_sc_hd__nor2_1
XFILLER_0_43_586 vssd1 vssd1 vccd1 vccd1 sky130_fd_sc_hd__fill_1
X_07105_ _01218_ _01219_ _01228_ vssd1 vssd1 vccd1 vccd1 _01230_ sky130_fd_sc_hd__nand3_1
X_07036_ _01113_ _01114_ _01115_ vssd1 vssd1 vccd1 vccd1 _01161_ sky130_fd_sc_hd__o21ba_1
XFILLER_0_113_485 vssd1 vssd1 vccd1 vccd1 sky130_ef_sc_hd__decap_12
X_08987_ _02964_ _03098_ _03099_ vssd1 vssd1 vccd1 vccd1 _03100_ sky130_fd_sc_hd__or3_1
X_07938_ _01955_ _01956_ _02057_ vssd1 vssd1 vccd1 vccd1 _02059_ sky130_fd_sc_hd__nand3_1
XFILLER_0_98_737 vssd1 vssd1 vccd1 vccd1 sky130_fd_sc_hd__decap_8
XFILLER_0_97_225 vssd1 vssd1 vccd1 vccd1 sky130_ef_sc_hd__decap_12
X_07869_ _01986_ _01989_ vssd1 vssd1 vccd1 vccd1 _01990_ sky130_fd_sc_hd__xor2_1
X_09608_ _03715_ _03716_ _03708_ vssd1 vssd1 vccd1 vccd1 _03717_ sky130_fd_sc_hd__a21o_1
X_10880_ _04958_ _04979_ vssd1 vssd1 vccd1 vccd1 _04980_ sky130_fd_sc_hd__xnor2_1
X_09539_ _03645_ _03646_ _03475_ _03477_ vssd1 vssd1 vccd1 vccd1 _03648_ sky130_fd_sc_hd__a211o_1
XFILLER_0_81_615 vssd1 vssd1 vccd1 vccd1 sky130_fd_sc_hd__fill_1
X_12550_ net1453 net13 net558 vssd1 vssd1 vccd1 vccd1 _00526_ sky130_fd_sc_hd__mux2_1
XFILLER_0_80_125 vssd1 vssd1 vccd1 vccd1 sky130_fd_sc_hd__fill_1
XFILLER_0_80_114 vssd1 vssd1 vccd1 vccd1 sky130_fd_sc_hd__decap_4
X_12481_ net1738 _06236_ net573 vssd1 vssd1 vccd1 vccd1 _00492_ sky130_fd_sc_hd__mux2_1
X_11501_ _05481_ _05489_ _05488_ vssd1 vssd1 vccd1 vccd1 _05596_ sky130_fd_sc_hd__a21oi_1
XFILLER_0_123_205 vssd1 vssd1 vccd1 vccd1 sky130_fd_sc_hd__decap_6
XFILLER_0_80_158 vssd1 vssd1 vccd1 vccd1 sky130_fd_sc_hd__fill_2
X_11432_ _05526_ _05527_ vssd1 vssd1 vccd1 vccd1 _05528_ sky130_fd_sc_hd__nor2_1
X_13102_ clknet_leaf_24_clk_i _00488_ vssd1 vssd1 vccd1 vccd1 temp1\[27\] sky130_fd_sc_hd__dfxtp_1
X_11363_ _05452_ _05457_ vssd1 vssd1 vccd1 vccd1 _05459_ sky130_fd_sc_hd__nand2_1
X_10314_ _04257_ _04260_ _04415_ _04417_ vssd1 vssd1 vccd1 vccd1 _04418_ sky130_fd_sc_hd__o211a_1
XFILLER_0_21_258 vssd1 vssd1 vccd1 vccd1 sky130_fd_sc_hd__fill_1
X_11294_ net1027 net702 vssd1 vssd1 vccd1 vccd1 _05391_ sky130_fd_sc_hd__nand2_1
X_10245_ _04348_ _04349_ _04165_ _04168_ vssd1 vssd1 vccd1 vccd1 _04350_ sky130_fd_sc_hd__o211a_1
XTAP_409 vssd1 vccd1 sky130_fd_sc_hd__tapvpwrvgnd_1
X_13033_ clknet_leaf_33_clk_i _00419_ net1167 vssd1 vssd1 vccd1 vccd1 x0mx2\[22\]
+ sky130_fd_sc_hd__dfrtp_1
XFILLER_0_119_39 vssd1 vssd1 vccd1 vccd1 sky130_ef_sc_hd__decap_12
Xfanout1100 net1102 vssd1 vssd1 vccd1 vccd1 net1100 sky130_fd_sc_hd__clkbuf_4
Xfanout1122 net1123 vssd1 vssd1 vccd1 vccd1 net1122 sky130_fd_sc_hd__buf_2
X_10176_ net1021 net760 _04277_ _04279_ vssd1 vssd1 vccd1 vccd1 _04281_ sky130_fd_sc_hd__nand4_1
Xfanout1111 net1112 vssd1 vssd1 vccd1 vccd1 net1111 sky130_fd_sc_hd__buf_2
XFILLER_0_28_15 vssd1 vssd1 vccd1 vccd1 sky130_ef_sc_hd__decap_12
Xfanout1133 net1134 vssd1 vssd1 vccd1 vccd1 net1133 sky130_fd_sc_hd__buf_2
Xfanout1144 net1146 vssd1 vssd1 vccd1 vccd1 net1144 sky130_fd_sc_hd__clkbuf_4
Xfanout1155 net1158 vssd1 vssd1 vccd1 vccd1 net1155 sky130_fd_sc_hd__clkbuf_4
Xfanout1188 net1189 vssd1 vssd1 vccd1 vccd1 net1188 sky130_fd_sc_hd__buf_2
XFILLER_0_89_715 vssd1 vssd1 vccd1 vccd1 sky130_ef_sc_hd__decap_12
Xfanout1177 net1180 vssd1 vssd1 vccd1 vccd1 net1177 sky130_fd_sc_hd__clkbuf_4
Xfanout1166 net1173 vssd1 vssd1 vccd1 vccd1 net1166 sky130_fd_sc_hd__buf_2
X_12817_ clknet_leaf_49_clk_i _00203_ vssd1 vssd1 vccd1 vccd1 sub1.a_i\[16\] sky130_fd_sc_hd__dfxtp_1
XFILLER_0_127_533 vssd1 vssd1 vccd1 vccd1 sky130_ef_sc_hd__decap_12
XTAP_1192 vssd1 vccd1 sky130_fd_sc_hd__tapvpwrvgnd_1
XTAP_1170 vssd1 vccd1 sky130_fd_sc_hd__tapvpwrvgnd_1
XTAP_1181 vssd1 vccd1 sky130_fd_sc_hd__tapvpwrvgnd_1
X_12748_ clknet_leaf_1_clk_i _00134_ vssd1 vssd1 vccd1 vccd1 add1.a_i\[11\] sky130_fd_sc_hd__dfxtp_1
XFILLER_0_84_475 vssd1 vssd1 vccd1 vccd1 sky130_fd_sc_hd__fill_1
X_12679_ clknet_leaf_15_clk_i _00065_ net1182 vssd1 vssd1 vccd1 vccd1 net408 sky130_fd_sc_hd__dfrtp_1
XFILLER_0_44_317 vssd1 vssd1 vccd1 vccd1 sky130_fd_sc_hd__fill_2
XFILLER_0_114_3 vssd1 vssd1 vccd1 vccd1 sky130_ef_sc_hd__decap_12
XFILLER_0_71_147 vssd1 vssd1 vccd1 vccd1 sky130_fd_sc_hd__decap_3
XFILLER_0_80_681 vssd1 vssd1 vccd1 vccd1 sky130_fd_sc_hd__fill_2
XFILLER_0_71_169 vssd1 vssd1 vccd1 vccd1 sky130_fd_sc_hd__decap_4
XFILLER_0_25_575 vssd1 vssd1 vccd1 vccd1 sky130_fd_sc_hd__fill_1
XFILLER_0_69_33 vssd1 vssd1 vccd1 vccd1 sky130_fd_sc_hd__decap_8
XFILLER_0_40_523 vssd1 vssd1 vccd1 vccd1 sky130_fd_sc_hd__fill_2
XFILLER_0_123_783 vssd1 vssd1 vccd1 vccd1 sky130_fd_sc_hd__fill_1
XFILLER_0_110_411 vssd1 vssd1 vccd1 vccd1 sky130_fd_sc_hd__decap_8
XFILLER_0_100_41 vssd1 vssd1 vccd1 vccd1 sky130_ef_sc_hd__decap_12
XFILLER_0_100_85 vssd1 vssd1 vccd1 vccd1 sky130_ef_sc_hd__decap_12
X_08910_ _03009_ _03022_ vssd1 vssd1 vccd1 vccd1 _03023_ sky130_fd_sc_hd__nor2_1
X_09890_ _03995_ _03996_ vssd1 vssd1 vccd1 vccd1 _03997_ sky130_fd_sc_hd__xor2_1
XTAP_910 vssd1 vccd1 sky130_fd_sc_hd__tapvpwrvgnd_1
XFILLER_0_110_477 vssd1 vssd1 vccd1 vccd1 sky130_ef_sc_hd__decap_12
X_08841_ _02953_ _02954_ vssd1 vssd1 vccd1 vccd1 _02955_ sky130_fd_sc_hd__nor2_2
XFILLER_0_85_21 vssd1 vssd1 vccd1 vccd1 sky130_ef_sc_hd__decap_12
XTAP_943 vssd1 vccd1 sky130_fd_sc_hd__tapvpwrvgnd_1
XTAP_932 vssd1 vccd1 sky130_fd_sc_hd__tapvpwrvgnd_1
XTAP_921 vssd1 vccd1 sky130_fd_sc_hd__tapvpwrvgnd_1
XTAP_976 vssd1 vccd1 sky130_fd_sc_hd__tapvpwrvgnd_1
XTAP_987 vssd1 vccd1 sky130_fd_sc_hd__tapvpwrvgnd_1
XTAP_965 vssd1 vccd1 sky130_fd_sc_hd__tapvpwrvgnd_1
XTAP_954 vssd1 vccd1 sky130_fd_sc_hd__tapvpwrvgnd_1
X_08772_ _02727_ _02730_ _02882_ _02883_ vssd1 vssd1 vccd1 vccd1 _02886_ sky130_fd_sc_hd__o211ai_2
XTAP_998 vssd1 vccd1 sky130_fd_sc_hd__tapvpwrvgnd_1
XFILLER_0_79_225 vssd1 vssd1 vccd1 vccd1 sky130_fd_sc_hd__fill_2
X_07723_ _01764_ _01844_ _01845_ vssd1 vssd1 vccd1 vccd1 _01846_ sky130_fd_sc_hd__or3_1
X_07654_ _01774_ _01775_ vssd1 vssd1 vccd1 vccd1 _01777_ sky130_fd_sc_hd__xnor2_1
XFILLER_0_19_3 vssd1 vssd1 vccd1 vccd1 sky130_ef_sc_hd__decap_12
XFILLER_0_95_729 vssd1 vssd1 vccd1 vccd1 sky130_ef_sc_hd__decap_12
X_06605_ sub1.b_i\[7\] sub1.a_i\[7\] vssd1 vssd1 vccd1 vccd1 _00843_ sky130_fd_sc_hd__and2b_1
XFILLER_0_125_93 vssd1 vssd1 vccd1 vccd1 sky130_ef_sc_hd__decap_12
XFILLER_0_75_420 vssd1 vssd1 vccd1 vccd1 sky130_fd_sc_hd__decap_4
X_07585_ _01705_ _01708_ vssd1 vssd1 vccd1 vccd1 _01709_ sky130_fd_sc_hd__xor2_1
XFILLER_0_47_111 vssd1 vssd1 vccd1 vccd1 sky130_fd_sc_hd__fill_1
XFILLER_0_118_533 vssd1 vssd1 vccd1 vccd1 sky130_ef_sc_hd__decap_12
X_09324_ net1133 net1141 net705 net700 vssd1 vssd1 vccd1 vccd1 _03434_ sky130_fd_sc_hd__and4_1
X_06536_ _00638_ _00658_ _00660_ vssd1 vssd1 vccd1 vccd1 _00791_ sky130_fd_sc_hd__and3_1
X_09255_ net861 net974 _03363_ _03364_ vssd1 vssd1 vccd1 vccd1 _03366_ sky130_fd_sc_hd__a22o_1
XFILLER_0_63_615 vssd1 vssd1 vccd1 vccd1 sky130_fd_sc_hd__fill_1
X_06467_ _00746_ _00760_ _00762_ _00763_ _00755_ vssd1 vssd1 vccd1 vccd1 _00764_ sky130_fd_sc_hd__a32o_1
XFILLER_0_35_317 vssd1 vssd1 vccd1 vccd1 sky130_fd_sc_hd__fill_1
XFILLER_0_106_717 vssd1 vssd1 vccd1 vccd1 sky130_fd_sc_hd__fill_2
XFILLER_0_105_205 vssd1 vssd1 vccd1 vccd1 sky130_ef_sc_hd__decap_12
X_08206_ _02309_ _02323_ vssd1 vssd1 vccd1 vccd1 _02324_ sky130_fd_sc_hd__nor2_1
XFILLER_0_47_199 vssd1 vssd1 vccd1 vccd1 sky130_fd_sc_hd__fill_1
XFILLER_0_121_709 vssd1 vssd1 vccd1 vccd1 sky130_ef_sc_hd__decap_12
X_09186_ _03137_ _03141_ _03295_ _03296_ vssd1 vssd1 vccd1 vccd1 _03297_ sky130_fd_sc_hd__a211oi_1
X_06398_ _00703_ _00704_ _00702_ vssd1 vssd1 vccd1 vccd1 _00705_ sky130_fd_sc_hd__o21ba_1
X_08137_ _02253_ _02254_ _02255_ vssd1 vssd1 vccd1 vccd1 _02256_ sky130_fd_sc_hd__nand3_4
XFILLER_0_43_372 vssd1 vssd1 vccd1 vccd1 sky130_fd_sc_hd__decap_4
XFILLER_0_31_523 vssd1 vssd1 vccd1 vccd1 sky130_ef_sc_hd__decap_12
XFILLER_0_101_422 vssd1 vssd1 vccd1 vccd1 sky130_fd_sc_hd__fill_1
X_08068_ _02185_ _02186_ vssd1 vssd1 vccd1 vccd1 _02187_ sky130_fd_sc_hd__and2b_1
XFILLER_0_31_567 vssd1 vssd1 vccd1 vccd1 sky130_fd_sc_hd__fill_2
XFILLER_0_113_293 vssd1 vssd1 vccd1 vccd1 sky130_ef_sc_hd__decap_12
XFILLER_0_101_433 vssd1 vssd1 vccd1 vccd1 sky130_fd_sc_hd__fill_1
X_07019_ net922 net1032 net1041 net914 vssd1 vssd1 vccd1 vccd1 _01144_ sky130_fd_sc_hd__a22o_1
X_10030_ net784 net1006 vssd1 vssd1 vccd1 vccd1 _04136_ sky130_fd_sc_hd__nand2_1
Xinput214 v2x[6] vssd1 vssd1 vccd1 vccd1 net214 sky130_fd_sc_hd__buf_1
Xinput203 v2x[25] vssd1 vssd1 vccd1 vccd1 net203 sky130_fd_sc_hd__buf_1
Xinput225 v2y[16] vssd1 vssd1 vccd1 vccd1 net225 sky130_fd_sc_hd__clkbuf_1
Xinput236 v2y[26] vssd1 vssd1 vccd1 vccd1 net236 sky130_fd_sc_hd__buf_1
Xinput247 v2y[7] vssd1 vssd1 vccd1 vccd1 net247 sky130_fd_sc_hd__buf_1
X_11981_ net1306 _05990_ net481 vssd1 vssd1 vccd1 vccd1 _00238_ sky130_fd_sc_hd__mux2_1
X_10932_ net1064 net698 net694 net1072 vssd1 vssd1 vccd1 vccd1 _05032_ sky130_fd_sc_hd__o2bb2a_1
XFILLER_0_98_589 vssd1 vssd1 vccd1 vccd1 sky130_fd_sc_hd__decap_4
X_10863_ net819 net940 net935 net828 vssd1 vssd1 vccd1 vccd1 _04963_ sky130_fd_sc_hd__a22o_1
XPHY_242 vssd1 vssd1 vccd1 vccd1 sky130_fd_sc_hd__decap_3
XPHY_231 vssd1 vssd1 vccd1 vccd1 sky130_fd_sc_hd__decap_3
XPHY_220 vssd1 vssd1 vccd1 vccd1 sky130_fd_sc_hd__decap_3
X_10794_ _04787_ _04790_ vssd1 vssd1 vccd1 vccd1 _04895_ sky130_fd_sc_hd__nand2b_1
X_12602_ net1440 net14 net556 vssd1 vssd1 vccd1 vccd1 _00577_ sky130_fd_sc_hd__mux2_1
X_12533_ net1228 net565 _06263_ vssd1 vssd1 vccd1 vccd1 _00517_ sky130_fd_sc_hd__a21o_1
XPHY_253 vssd1 vssd1 vccd1 vccd1 sky130_fd_sc_hd__decap_3
XFILLER_0_26_317 vssd1 vssd1 vccd1 vccd1 sky130_fd_sc_hd__decap_3
XFILLER_0_124_525 vssd1 vssd1 vccd1 vccd1 sky130_fd_sc_hd__decap_6
XFILLER_0_81_489 vssd1 vssd1 vccd1 vccd1 sky130_fd_sc_hd__fill_1
XFILLER_0_53_169 vssd1 vssd1 vccd1 vccd1 sky130_fd_sc_hd__decap_3
X_12464_ _00928_ net617 _04813_ net576 _06194_ vssd1 vssd1 vccd1 vccd1 _06228_ sky130_fd_sc_hd__a221o_1
XFILLER_0_124_569 vssd1 vssd1 vccd1 vccd1 sky130_ef_sc_hd__decap_12
XFILLER_0_105_761 vssd1 vssd1 vccd1 vccd1 sky130_fd_sc_hd__fill_1
XFILLER_0_62_692 vssd1 vssd1 vccd1 vccd1 sky130_fd_sc_hd__decap_8
X_12395_ net1373 _00903_ net684 vssd1 vssd1 vccd1 vccd1 _00447_ sky130_fd_sc_hd__mux2_1
XFILLER_0_22_545 vssd1 vssd1 vccd1 vccd1 sky130_fd_sc_hd__decap_6
X_11415_ _05509_ _05510_ vssd1 vssd1 vccd1 vccd1 _05511_ sky130_fd_sc_hd__or2_1
X_11346_ _05440_ _05441_ vssd1 vssd1 vccd1 vccd1 _05443_ sky130_fd_sc_hd__xnor2_1
XFILLER_0_22_589 vssd1 vssd1 vccd1 vccd1 sky130_fd_sc_hd__decap_3
XFILLER_0_39_36 vssd1 vssd1 vccd1 vccd1 sky130_ef_sc_hd__decap_12
X_13016_ clknet_leaf_52_clk_i _00402_ net1154 vssd1 vssd1 vccd1 vccd1 x0mx2\[5\] sky130_fd_sc_hd__dfrtp_1
X_11277_ _05373_ vssd1 vssd1 vccd1 vccd1 _05374_ sky130_fd_sc_hd__inv_2
X_10228_ _04184_ _04192_ _04191_ vssd1 vssd1 vccd1 vccd1 _04333_ sky130_fd_sc_hd__a21bo_1
Xhold2 _00112_ vssd1 vssd1 vccd1 vccd1 net1217 sky130_fd_sc_hd__dlygate4sd3_1
X_10159_ _04259_ _04261_ _04103_ _04106_ vssd1 vssd1 vccd1 vccd1 _04264_ sky130_fd_sc_hd__a211oi_1
XFILLER_0_77_729 vssd1 vssd1 vccd1 vccd1 sky130_ef_sc_hd__decap_12
XFILLER_0_71_23 vssd1 vssd1 vccd1 vccd1 sky130_fd_sc_hd__fill_2
X_07370_ _01482_ _01493_ _01494_ vssd1 vssd1 vccd1 vccd1 _01495_ sky130_fd_sc_hd__nor3_1
X_06321_ add1.a_i\[8\] add1.b_i\[8\] vssd1 vssd1 vccd1 vccd1 _00633_ sky130_fd_sc_hd__nand2_1
XFILLER_0_115_503 vssd1 vssd1 vccd1 vccd1 sky130_fd_sc_hd__fill_1
X_09040_ net1085 net749 net741 net1092 vssd1 vssd1 vccd1 vccd1 _03152_ sky130_fd_sc_hd__a22o_1
XFILLER_0_44_169 vssd1 vssd1 vccd1 vccd1 sky130_fd_sc_hd__decap_3
XFILLER_0_32_309 vssd1 vssd1 vccd1 vccd1 sky130_fd_sc_hd__decap_4
XFILLER_0_130_517 vssd1 vssd1 vccd1 vccd1 sky130_fd_sc_hd__decap_3
XFILLER_0_102_208 vssd1 vssd1 vccd1 vccd1 sky130_fd_sc_hd__decap_3
Xhold402 y1my2\[19\] vssd1 vssd1 vccd1 vccd1 net1617 sky130_fd_sc_hd__dlygate4sd3_1
XFILLER_0_25_372 vssd1 vssd1 vccd1 vccd1 sky130_fd_sc_hd__fill_1
Xhold435 y1my2\[0\] vssd1 vssd1 vccd1 vccd1 net1650 sky130_fd_sc_hd__dlygate4sd3_1
Xhold424 x2mx1\[18\] vssd1 vssd1 vccd1 vccd1 net1639 sky130_fd_sc_hd__dlygate4sd3_1
XFILLER_0_13_556 vssd1 vssd1 vccd1 vccd1 sky130_fd_sc_hd__decap_4
XFILLER_0_13_578 vssd1 vssd1 vccd1 vccd1 sky130_fd_sc_hd__fill_1
Xhold413 y1my2\[11\] vssd1 vssd1 vccd1 vccd1 net1628 sky130_fd_sc_hd__dlygate4sd3_1
XFILLER_0_111_753 vssd1 vssd1 vccd1 vccd1 sky130_fd_sc_hd__decap_6
XFILLER_0_96_53 vssd1 vssd1 vccd1 vccd1 sky130_ef_sc_hd__decap_12
X_09942_ _04047_ _04048_ vssd1 vssd1 vccd1 vccd1 _04049_ sky130_fd_sc_hd__nor2_1
Xhold468 sub1.b_i\[1\] vssd1 vssd1 vccd1 vccd1 net1683 sky130_fd_sc_hd__dlygate4sd3_1
Xhold446 x2mx1\[16\] vssd1 vssd1 vccd1 vccd1 net1661 sky130_fd_sc_hd__dlygate4sd3_1
Xhold457 x2mx1\[14\] vssd1 vssd1 vccd1 vccd1 net1672 sky130_fd_sc_hd__dlygate4sd3_1
Xfanout915 net916 vssd1 vssd1 vccd1 vccd1 net915 sky130_fd_sc_hd__clkbuf_4
Xfanout904 net905 vssd1 vssd1 vccd1 vccd1 net904 sky130_fd_sc_hd__buf_2
Xhold479 add1.a_i\[16\] vssd1 vssd1 vccd1 vccd1 net1694 sky130_fd_sc_hd__dlygate4sd3_1
XFILLER_0_96_97 vssd1 vssd1 vccd1 vccd1 sky130_fd_sc_hd__decap_8
X_09873_ _03970_ _03977_ _03978_ vssd1 vssd1 vccd1 vccd1 _03980_ sky130_fd_sc_hd__nand3_1
Xfanout926 net927 vssd1 vssd1 vccd1 vccd1 net926 sky130_fd_sc_hd__buf_4
Xfanout937 net938 vssd1 vssd1 vccd1 vccd1 net937 sky130_fd_sc_hd__buf_2
Xfanout948 mul1.a\[27\] vssd1 vssd1 vccd1 vccd1 net948 sky130_fd_sc_hd__buf_2
XTAP_740 vssd1 vccd1 sky130_fd_sc_hd__tapvpwrvgnd_1
XTAP_751 vssd1 vccd1 sky130_fd_sc_hd__tapvpwrvgnd_1
X_08824_ _02917_ _02934_ _02935_ vssd1 vssd1 vccd1 vccd1 _02938_ sky130_fd_sc_hd__nand3_2
Xfanout959 net960 vssd1 vssd1 vccd1 vccd1 net959 sky130_fd_sc_hd__buf_2
XTAP_762 vssd1 vccd1 sky130_fd_sc_hd__tapvpwrvgnd_1
XTAP_773 vssd1 vccd1 sky130_fd_sc_hd__tapvpwrvgnd_1
XTAP_795 vssd1 vccd1 sky130_fd_sc_hd__tapvpwrvgnd_1
XTAP_784 vssd1 vccd1 sky130_fd_sc_hd__tapvpwrvgnd_1
X_08755_ net1052 net797 net787 net1060 vssd1 vssd1 vccd1 vccd1 _02869_ sky130_fd_sc_hd__a22oi_1
X_07706_ _01819_ _01826_ _01827_ vssd1 vssd1 vccd1 vccd1 _01829_ sky130_fd_sc_hd__nand3_2
XTAP_1906 vssd1 vccd1 sky130_fd_sc_hd__tapvpwrvgnd_1
X_08686_ _02699_ _02799_ _02800_ vssd1 vssd1 vccd1 vccd1 _02801_ sky130_fd_sc_hd__nand3_2
XFILLER_0_68_718 vssd1 vssd1 vccd1 vccd1 sky130_fd_sc_hd__fill_1
XTAP_1939 vssd1 vccd1 sky130_fd_sc_hd__tapvpwrvgnd_1
XTAP_1928 vssd1 vccd1 sky130_fd_sc_hd__tapvpwrvgnd_1
XTAP_1917 vssd1 vccd1 sky130_fd_sc_hd__tapvpwrvgnd_1
X_07637_ temp1\[1\] _01760_ net540 vssd1 vssd1 vccd1 vccd1 _01761_ sky130_fd_sc_hd__mux2_1
XFILLER_0_82_209 vssd1 vssd1 vccd1 vccd1 sky130_fd_sc_hd__decap_8
X_07568_ _01689_ _01690_ net1096 net830 vssd1 vssd1 vccd1 vccd1 _01692_ sky130_fd_sc_hd__and4bb_1
X_06519_ det_t\[29\] net530 vssd1 vssd1 vccd1 vccd1 net273 sky130_fd_sc_hd__and2_1
X_09307_ _03103_ _03105_ _03261_ vssd1 vssd1 vccd1 vccd1 _03418_ sky130_fd_sc_hd__a21o_1
XFILLER_0_75_261 vssd1 vssd1 vccd1 vccd1 sky130_ef_sc_hd__decap_12
XFILLER_0_118_363 vssd1 vssd1 vccd1 vccd1 sky130_fd_sc_hd__fill_1
XFILLER_0_90_231 vssd1 vssd1 vccd1 vccd1 sky130_fd_sc_hd__fill_1
XFILLER_0_63_445 vssd1 vssd1 vccd1 vccd1 sky130_fd_sc_hd__decap_3
X_07499_ net904 net1138 _01622_ _01623_ vssd1 vssd1 vccd1 vccd1 _01624_ sky130_fd_sc_hd__and4_1
XFILLER_0_36_659 vssd1 vssd1 vccd1 vccd1 sky130_fd_sc_hd__fill_1
X_09238_ net852 net843 net988 net981 vssd1 vssd1 vccd1 vccd1 _03349_ sky130_fd_sc_hd__nand4_1
XFILLER_0_121_517 vssd1 vssd1 vccd1 vccd1 sky130_ef_sc_hd__decap_12
X_09169_ _03122_ _03278_ vssd1 vssd1 vccd1 vccd1 _03280_ sky130_fd_sc_hd__nor2_1
X_11200_ _05173_ _05175_ _05296_ _05297_ vssd1 vssd1 vccd1 vccd1 _05298_ sky130_fd_sc_hd__a211oi_1
X_12180_ x2mx1\[5\] net602 net582 temp1\[5\] vssd1 vssd1 vccd1 vccd1 _06140_ sky130_fd_sc_hd__a22o_1
XFILLER_0_102_753 vssd1 vssd1 vccd1 vccd1 sky130_fd_sc_hd__decap_3
X_11131_ net989 net735 _05226_ _05227_ vssd1 vssd1 vccd1 vccd1 _05229_ sky130_fd_sc_hd__a22oi_1
XFILLER_0_8_3 vssd1 vssd1 vccd1 vccd1 sky130_ef_sc_hd__decap_12
X_11062_ _05033_ _05159_ vssd1 vssd1 vccd1 vccd1 _05161_ sky130_fd_sc_hd__xor2_2
X_10013_ net752 _04118_ _04117_ vssd1 vssd1 vccd1 vccd1 _04119_ sky130_fd_sc_hd__a21bo_1
XFILLER_0_116_29 vssd1 vssd1 vccd1 vccd1 sky130_ef_sc_hd__decap_12
XFILLER_0_98_342 vssd1 vssd1 vccd1 vccd1 sky130_fd_sc_hd__fill_1
XFILLER_0_25_27 vssd1 vssd1 vccd1 vccd1 sky130_ef_sc_hd__decap_12
XFILLER_0_59_729 vssd1 vssd1 vccd1 vccd1 sky130_fd_sc_hd__fill_1
X_11964_ net128 net656 net503 net224 _05977_ vssd1 vssd1 vccd1 vccd1 _05978_ sky130_fd_sc_hd__a221o_1
XFILLER_0_129_617 vssd1 vssd1 vccd1 vccd1 sky130_fd_sc_hd__decap_6
X_10915_ _05011_ _05012_ _04999_ vssd1 vssd1 vccd1 vccd1 _05015_ sky130_fd_sc_hd__a21oi_2
X_11895_ net82 net680 net672 net114 vssd1 vssd1 vccd1 vccd1 _05925_ sky130_fd_sc_hd__a22o_1
X_10846_ _04766_ _04769_ _04944_ _04945_ vssd1 vssd1 vccd1 vccd1 _04947_ sky130_fd_sc_hd__o211ai_2
XFILLER_0_66_272 vssd1 vssd1 vccd1 vccd1 sky130_ef_sc_hd__decap_12
XFILLER_0_41_15 vssd1 vssd1 vccd1 vccd1 sky130_fd_sc_hd__fill_1
X_10777_ _04875_ _04876_ _04685_ _04687_ vssd1 vssd1 vccd1 vccd1 _04878_ sky130_fd_sc_hd__o211ai_1
X_12516_ _00693_ net563 vssd1 vssd1 vccd1 vccd1 _06255_ sky130_fd_sc_hd__nor2_1
XFILLER_0_109_385 vssd1 vssd1 vccd1 vccd1 sky130_fd_sc_hd__decap_6
X_12447_ _03905_ net575 _06216_ vssd1 vssd1 vccd1 vccd1 _06217_ sky130_fd_sc_hd__a21o_1
XFILLER_0_2_715 vssd1 vssd1 vccd1 vccd1 sky130_fd_sc_hd__fill_1
XFILLER_0_124_377 vssd1 vssd1 vccd1 vccd1 sky130_ef_sc_hd__decap_12
XFILLER_0_2_726 vssd1 vssd1 vccd1 vccd1 sky130_fd_sc_hd__fill_2
X_12378_ net1386 _00813_ net682 vssd1 vssd1 vccd1 vccd1 _00430_ sky130_fd_sc_hd__mux2_1
X_11329_ _05425_ vssd1 vssd1 vccd1 vccd1 _05426_ sky130_fd_sc_hd__inv_2
XFILLER_0_5_15 vssd1 vssd1 vccd1 vccd1 sky130_ef_sc_hd__decap_12
X_06870_ net1150 _00989_ net671 vssd1 vssd1 vccd1 vccd1 _00999_ sky130_fd_sc_hd__o21bai_1
XFILLER_0_89_375 vssd1 vssd1 vccd1 vccd1 sky130_fd_sc_hd__fill_1
X_08540_ _02594_ _02595_ _02654_ _02655_ vssd1 vssd1 vccd1 vccd1 _02656_ sky130_fd_sc_hd__nor4_2
X_08471_ _02584_ _02585_ _02586_ vssd1 vssd1 vccd1 vccd1 _02587_ sky130_fd_sc_hd__and3_1
XFILLER_0_119_105 vssd1 vssd1 vccd1 vccd1 sky130_fd_sc_hd__decap_6
XFILLER_0_15_93 vssd1 vssd1 vccd1 vccd1 sky130_ef_sc_hd__decap_12
X_07422_ _01540_ _01546_ _01504_ _01512_ vssd1 vssd1 vccd1 vccd1 _01547_ sky130_fd_sc_hd__o211ai_2
XFILLER_0_119_149 vssd1 vssd1 vccd1 vccd1 sky130_ef_sc_hd__decap_12
XFILLER_0_18_626 vssd1 vssd1 vccd1 vccd1 sky130_fd_sc_hd__fill_2
XFILLER_0_17_136 vssd1 vssd1 vccd1 vccd1 sky130_fd_sc_hd__decap_8
X_07353_ _01476_ _01477_ vssd1 vssd1 vccd1 vccd1 _01478_ sky130_fd_sc_hd__xnor2_1
XFILLER_0_122_83 vssd1 vssd1 vccd1 vccd1 sky130_fd_sc_hd__fill_1
XFILLER_0_72_253 vssd1 vssd1 vccd1 vccd1 sky130_ef_sc_hd__decap_12
XFILLER_0_17_169 vssd1 vssd1 vccd1 vccd1 sky130_fd_sc_hd__decap_4
X_06304_ _00589_ _00600_ _00616_ vssd1 vssd1 vccd1 vccd1 _00617_ sky130_fd_sc_hd__nor3_1
X_07284_ _01323_ _01408_ vssd1 vssd1 vccd1 vccd1 _01409_ sky130_fd_sc_hd__nor2_1
X_09023_ _03125_ _03133_ vssd1 vssd1 vccd1 vccd1 _03135_ sky130_fd_sc_hd__xnor2_1
XFILLER_0_86_3 vssd1 vssd1 vccd1 vccd1 sky130_ef_sc_hd__decap_12
XFILLER_0_31_92 vssd1 vssd1 vccd1 vccd1 sky130_fd_sc_hd__decap_3
Xhold210 _00053_ vssd1 vssd1 vccd1 vccd1 net1425 sky130_fd_sc_hd__dlygate4sd3_1
Xhold221 net441 vssd1 vssd1 vccd1 vccd1 net1436 sky130_fd_sc_hd__dlygate4sd3_1
Xhold243 net426 vssd1 vssd1 vccd1 vccd1 net1458 sky130_fd_sc_hd__dlygate4sd3_1
Xhold232 x0mx2\[23\] vssd1 vssd1 vccd1 vccd1 net1447 sky130_fd_sc_hd__dlygate4sd3_1
XFILLER_0_41_673 vssd1 vssd1 vccd1 vccd1 sky130_fd_sc_hd__fill_1
Xhold276 _00110_ vssd1 vssd1 vccd1 vccd1 net1491 sky130_fd_sc_hd__dlygate4sd3_1
Xhold265 net342 vssd1 vssd1 vccd1 vccd1 net1480 sky130_fd_sc_hd__dlygate4sd3_1
XFILLER_0_111_561 vssd1 vssd1 vccd1 vccd1 sky130_ef_sc_hd__decap_12
Xhold287 net415 vssd1 vssd1 vccd1 vccd1 net1502 sky130_fd_sc_hd__dlygate4sd3_1
Xhold254 net398 vssd1 vssd1 vccd1 vccd1 net1469 sky130_fd_sc_hd__dlygate4sd3_1
Xfanout723 net726 vssd1 vssd1 vccd1 vccd1 net723 sky130_fd_sc_hd__clkbuf_4
X_09925_ _04029_ _04030_ _04025_ vssd1 vssd1 vccd1 vccd1 _04032_ sky130_fd_sc_hd__a21o_1
Xhold298 net391 vssd1 vssd1 vccd1 vccd1 net1513 sky130_fd_sc_hd__dlygate4sd3_1
Xfanout712 mul1.b\[27\] vssd1 vssd1 vccd1 vccd1 net712 sky130_fd_sc_hd__clkbuf_4
Xfanout701 mul1.b\[30\] vssd1 vssd1 vccd1 vccd1 net701 sky130_fd_sc_hd__buf_2
Xfanout756 net762 vssd1 vssd1 vccd1 vccd1 net756 sky130_fd_sc_hd__clkbuf_4
Xfanout734 net739 vssd1 vssd1 vccd1 vccd1 net734 sky130_fd_sc_hd__clkbuf_4
Xfanout767 net770 vssd1 vssd1 vccd1 vccd1 net767 sky130_fd_sc_hd__buf_2
X_09856_ net1037 net759 _03960_ _03962_ vssd1 vssd1 vccd1 vccd1 _03963_ sky130_fd_sc_hd__and4_1
Xfanout745 net746 vssd1 vssd1 vccd1 vccd1 net745 sky130_fd_sc_hd__clkbuf_2
XTAP_570 vssd1 vccd1 sky130_fd_sc_hd__tapvpwrvgnd_1
XFILLER_0_99_117 vssd1 vssd1 vccd1 vccd1 sky130_fd_sc_hd__fill_1
Xfanout778 net779 vssd1 vssd1 vccd1 vccd1 net778 sky130_fd_sc_hd__dlymetal6s2s_1
X_08807_ net961 _02920_ _02919_ vssd1 vssd1 vccd1 vccd1 _02921_ sky130_fd_sc_hd__a21bo_1
XTAP_581 vssd1 vccd1 sky130_fd_sc_hd__tapvpwrvgnd_1
XTAP_592 vssd1 vccd1 sky130_fd_sc_hd__tapvpwrvgnd_1
Xfanout789 net791 vssd1 vssd1 vccd1 vccd1 net789 sky130_fd_sc_hd__clkbuf_4
XFILLER_0_99_139 vssd1 vssd1 vccd1 vccd1 sky130_fd_sc_hd__fill_1
X_09787_ _03752_ _03894_ vssd1 vssd1 vccd1 vccd1 _03895_ sky130_fd_sc_hd__xnor2_2
X_06999_ net872 net1088 net1095 net863 vssd1 vssd1 vccd1 vccd1 _01124_ sky130_fd_sc_hd__a22oi_1
X_08738_ net1099 net1107 net749 net741 vssd1 vssd1 vccd1 vccd1 _02852_ sky130_fd_sc_hd__and4_1
XFILLER_0_96_813 vssd1 vssd1 vccd1 vccd1 sky130_fd_sc_hd__fill_1
XTAP_1725 vssd1 vccd1 sky130_fd_sc_hd__tapvpwrvgnd_1
XTAP_1714 vssd1 vccd1 sky130_fd_sc_hd__tapvpwrvgnd_1
XTAP_1703 vssd1 vccd1 sky130_fd_sc_hd__tapvpwrvgnd_1
X_08669_ _02781_ _02782_ _02783_ vssd1 vssd1 vccd1 vccd1 _02784_ sky130_fd_sc_hd__nand3_4
XTAP_1758 vssd1 vccd1 sky130_fd_sc_hd__tapvpwrvgnd_1
XTAP_1747 vssd1 vccd1 sky130_fd_sc_hd__tapvpwrvgnd_1
XTAP_1736 vssd1 vccd1 sky130_fd_sc_hd__tapvpwrvgnd_1
X_10700_ _04798_ _04799_ _04800_ vssd1 vssd1 vccd1 vccd1 _04802_ sky130_fd_sc_hd__o21ba_1
XTAP_1769 vssd1 vccd1 sky130_fd_sc_hd__tapvpwrvgnd_1
XFILLER_0_76_581 vssd1 vssd1 vccd1 vccd1 sky130_fd_sc_hd__decap_6
X_11680_ net1535 _03905_ net538 vssd1 vssd1 vccd1 vccd1 _00172_ sky130_fd_sc_hd__mux2_1
X_10631_ _04727_ _04732_ vssd1 vssd1 vccd1 vccd1 _04733_ sky130_fd_sc_hd__or2_1
X_10562_ _04383_ _04519_ _04518_ vssd1 vssd1 vccd1 vccd1 _04665_ sky130_fd_sc_hd__a21oi_4
X_12301_ net1669 _00913_ net678 vssd1 vssd1 vccd1 vccd1 _00353_ sky130_fd_sc_hd__mux2_1
XFILLER_0_106_388 vssd1 vssd1 vccd1 vccd1 sky130_fd_sc_hd__fill_1
X_10493_ _04591_ _04592_ _04593_ vssd1 vssd1 vccd1 vccd1 _04596_ sky130_fd_sc_hd__a21o_1
X_12232_ _00923_ net511 net468 y1my2\[22\] _06174_ vssd1 vssd1 vccd1 vccd1 _06175_
+ sky130_fd_sc_hd__a221o_1
XFILLER_0_102_572 vssd1 vssd1 vccd1 vccd1 sky130_fd_sc_hd__decap_3
X_12163_ net929 _06128_ net519 vssd1 vssd1 vccd1 vccd1 _00282_ sky130_fd_sc_hd__mux2_1
X_12094_ _00882_ _06076_ net499 vssd1 vssd1 vccd1 vccd1 _06077_ sky130_fd_sc_hd__mux2_1
X_11114_ _05210_ _05211_ vssd1 vssd1 vccd1 vccd1 _05212_ sky130_fd_sc_hd__nand2b_1
X_11045_ net1030 net713 net709 net1036 vssd1 vssd1 vccd1 vccd1 _05144_ sky130_fd_sc_hd__a22o_1
XFILLER_0_127_39 vssd1 vssd1 vccd1 vccd1 sky130_ef_sc_hd__decap_12
XFILLER_0_36_15 vssd1 vssd1 vccd1 vccd1 sky130_ef_sc_hd__decap_12
XFILLER_0_99_640 vssd1 vssd1 vccd1 vccd1 sky130_fd_sc_hd__decap_8
XFILLER_0_99_673 vssd1 vssd1 vccd1 vccd1 sky130_ef_sc_hd__decap_12
X_12996_ clknet_leaf_47_clk_i _00382_ net1160 vssd1 vssd1 vccd1 vccd1 x2mx1\[17\]
+ sky130_fd_sc_hd__dfrtp_1
X_11947_ net4 net550 net625 net188 _05964_ vssd1 vssd1 vccd1 vccd1 _05965_ sky130_fd_sc_hd__a221o_1
X_11878_ temp1\[28\] net616 net672 net110 _05910_ vssd1 vssd1 vccd1 vccd1 _05911_
+ sky130_fd_sc_hd__a221o_1
XFILLER_0_117_609 vssd1 vssd1 vccd1 vccd1 sky130_fd_sc_hd__decap_6
X_10829_ _04782_ _04785_ _04928_ _04929_ vssd1 vssd1 vccd1 vccd1 _04930_ sky130_fd_sc_hd__o211a_1
XFILLER_0_67_592 vssd1 vssd1 vccd1 vccd1 sky130_ef_sc_hd__decap_12
XFILLER_0_7_829 vssd1 vssd1 vccd1 vccd1 sky130_fd_sc_hd__decap_8
XFILLER_0_82_540 vssd1 vssd1 vccd1 vccd1 sky130_fd_sc_hd__fill_1
XFILLER_0_54_253 vssd1 vssd1 vccd1 vccd1 sky130_fd_sc_hd__decap_4
XFILLER_0_125_653 vssd1 vssd1 vccd1 vccd1 sky130_ef_sc_hd__decap_12
XFILLER_0_124_141 vssd1 vssd1 vccd1 vccd1 sky130_ef_sc_hd__decap_12
XFILLER_0_109_193 vssd1 vssd1 vccd1 vccd1 sky130_ef_sc_hd__decap_12
XFILLER_0_125_697 vssd1 vssd1 vccd1 vccd1 sky130_ef_sc_hd__decap_12
XFILLER_0_124_174 vssd1 vssd1 vccd1 vccd1 sky130_fd_sc_hd__decap_8
XFILLER_0_113_837 vssd1 vssd1 vccd1 vccd1 sky130_fd_sc_hd__decap_3
XFILLER_0_70_757 vssd1 vssd1 vccd1 vccd1 sky130_fd_sc_hd__fill_1
XFILLER_0_14_139 vssd1 vssd1 vccd1 vccd1 sky130_fd_sc_hd__fill_1
XFILLER_0_42_459 vssd1 vssd1 vccd1 vccd1 sky130_fd_sc_hd__fill_1
Xoutput326 net326 vssd1 vssd1 vccd1 vccd1 div_mstream_o[91] sky130_fd_sc_hd__clkbuf_4
Xoutput315 net315 vssd1 vssd1 vccd1 vccd1 div_mstream_o[81] sky130_fd_sc_hd__clkbuf_4
Xoutput304 net304 vssd1 vssd1 vccd1 vccd1 div_mstream_o[71] sky130_fd_sc_hd__clkbuf_4
XFILLER_0_72_9 vssd1 vssd1 vccd1 vccd1 sky130_ef_sc_hd__decap_12
XFILLER_0_50_470 vssd1 vssd1 vccd1 vccd1 sky130_fd_sc_hd__fill_2
Xoutput348 net348 vssd1 vssd1 vccd1 vccd1 mstream_o[111] sky130_fd_sc_hd__clkbuf_4
Xoutput337 net337 vssd1 vssd1 vccd1 vccd1 mstream_o[101] sky130_fd_sc_hd__clkbuf_4
Xoutput359 net359 vssd1 vssd1 vccd1 vccd1 mstream_o[18] sky130_fd_sc_hd__clkbuf_4
X_07971_ _02001_ _02004_ _02089_ _02090_ vssd1 vssd1 vccd1 vccd1 _02091_ sky130_fd_sc_hd__a211oi_2
X_09710_ net1023 net784 vssd1 vssd1 vccd1 vccd1 _03818_ sky130_fd_sc_hd__nand2_1
X_06922_ _01041_ _01046_ vssd1 vssd1 vccd1 vccd1 _01047_ sky130_fd_sc_hd__and2_1
X_09641_ temp1\[16\] _03749_ net541 vssd1 vssd1 vccd1 vccd1 _03750_ sky130_fd_sc_hd__mux2_1
X_06853_ net1686 _00982_ vssd1 vssd1 vccd1 vccd1 _00984_ sky130_fd_sc_hd__nor2_1
X_09572_ net833 net985 vssd1 vssd1 vccd1 vccd1 _03681_ sky130_fd_sc_hd__and2_1
X_06784_ net1442 net1362 net639 vssd1 vssd1 vccd1 vccd1 _00058_ sky130_fd_sc_hd__mux2_1
X_08523_ _02636_ _02637_ _02638_ vssd1 vssd1 vccd1 vccd1 _02639_ sky130_fd_sc_hd__nand3_1
X_08454_ net1114 net756 _02434_ _02435_ net773 vssd1 vssd1 vccd1 vccd1 _02570_ sky130_fd_sc_hd__a32o_1
XFILLER_0_92_304 vssd1 vssd1 vccd1 vccd1 sky130_fd_sc_hd__decap_4
XFILLER_0_9_122 vssd1 vssd1 vccd1 vccd1 sky130_ef_sc_hd__decap_12
X_08385_ net908 net973 vssd1 vssd1 vccd1 vccd1 _02502_ sky130_fd_sc_hd__and2_1
XFILLER_0_58_581 vssd1 vssd1 vccd1 vccd1 sky130_fd_sc_hd__decap_6
X_07405_ _01480_ _01514_ _01529_ vssd1 vssd1 vccd1 vccd1 _01530_ sky130_fd_sc_hd__and3_1
XFILLER_0_9_199 vssd1 vssd1 vccd1 vccd1 sky130_fd_sc_hd__fill_1
X_07336_ _01406_ _01407_ _01460_ vssd1 vssd1 vccd1 vccd1 _01461_ sky130_fd_sc_hd__and3_1
XFILLER_0_45_286 vssd1 vssd1 vccd1 vccd1 sky130_fd_sc_hd__fill_1
X_09006_ _03117_ vssd1 vssd1 vccd1 vccd1 _03118_ sky130_fd_sc_hd__inv_2
X_07267_ _01356_ _01357_ _01390_ _01391_ vssd1 vssd1 vccd1 vccd1 _01392_ sky130_fd_sc_hd__a2bb2o_1
XFILLER_0_5_383 vssd1 vssd1 vccd1 vccd1 sky130_fd_sc_hd__fill_1
XFILLER_0_103_325 vssd1 vssd1 vccd1 vccd1 sky130_fd_sc_hd__decap_8
XFILLER_0_60_278 vssd1 vssd1 vccd1 vccd1 sky130_fd_sc_hd__fill_1
X_07198_ _01309_ _01315_ _01321_ _01322_ vssd1 vssd1 vccd1 vccd1 _01323_ sky130_fd_sc_hd__a211oi_2
XFILLER_0_111_391 vssd1 vssd1 vccd1 vccd1 sky130_fd_sc_hd__fill_1
Xfanout520 _06028_ vssd1 vssd1 vccd1 vccd1 net520 sky130_fd_sc_hd__clkbuf_4
Xfanout531 net533 vssd1 vssd1 vccd1 vccd1 net531 sky130_fd_sc_hd__buf_4
Xfanout542 net543 vssd1 vssd1 vccd1 vccd1 net542 sky130_fd_sc_hd__buf_4
Xfanout564 net567 vssd1 vssd1 vccd1 vccd1 net564 sky130_fd_sc_hd__buf_2
X_09908_ net879 net868 net945 net940 vssd1 vssd1 vccd1 vccd1 _04015_ sky130_fd_sc_hd__nand4_2
Xfanout553 net333 vssd1 vssd1 vccd1 vccd1 net553 sky130_fd_sc_hd__clkbuf_8
Xfanout575 net577 vssd1 vssd1 vccd1 vccd1 net575 sky130_fd_sc_hd__clkbuf_4
X_09839_ _03773_ _03788_ _03786_ vssd1 vssd1 vccd1 vccd1 _03946_ sky130_fd_sc_hd__a21oi_4
Xfanout597 _05759_ vssd1 vssd1 vccd1 vccd1 net597 sky130_fd_sc_hd__buf_2
Xfanout586 _05754_ vssd1 vssd1 vccd1 vccd1 net586 sky130_fd_sc_hd__buf_2
XTAP_2201 vssd1 vccd1 sky130_fd_sc_hd__tapvpwrvgnd_1
X_12850_ clknet_leaf_36_clk_i _00236_ vssd1 vssd1 vccd1 vccd1 sub1.b_i\[17\] sky130_fd_sc_hd__dfxtp_1
XTAP_2234 vssd1 vccd1 sky130_fd_sc_hd__tapvpwrvgnd_1
XTAP_2223 vssd1 vccd1 sky130_fd_sc_hd__tapvpwrvgnd_1
XTAP_2212 vssd1 vccd1 sky130_fd_sc_hd__tapvpwrvgnd_1
X_11801_ net161 net472 _05845_ vssd1 vssd1 vccd1 vccd1 _05846_ sky130_fd_sc_hd__o21a_1
XTAP_2256 vssd1 vccd1 sky130_fd_sc_hd__tapvpwrvgnd_1
XTAP_2245 vssd1 vccd1 sky130_fd_sc_hd__tapvpwrvgnd_1
XTAP_1533 vssd1 vccd1 sky130_fd_sc_hd__tapvpwrvgnd_1
XTAP_1522 vssd1 vccd1 sky130_fd_sc_hd__tapvpwrvgnd_1
XTAP_1511 vssd1 vccd1 sky130_fd_sc_hd__tapvpwrvgnd_1
XTAP_1500 vssd1 vccd1 sky130_fd_sc_hd__tapvpwrvgnd_1
X_12781_ clknet_leaf_1_clk_i _00167_ vssd1 vssd1 vccd1 vccd1 add1.b_i\[12\] sky130_fd_sc_hd__dfxtp_1
XPHY_40 vssd1 vssd1 vccd1 vccd1 sky130_fd_sc_hd__decap_3
XFILLER_0_96_698 vssd1 vssd1 vccd1 vccd1 sky130_fd_sc_hd__fill_2
XTAP_1566 vssd1 vccd1 sky130_fd_sc_hd__tapvpwrvgnd_1
XTAP_1555 vssd1 vccd1 sky130_fd_sc_hd__tapvpwrvgnd_1
XTAP_1544 vssd1 vccd1 sky130_fd_sc_hd__tapvpwrvgnd_1
X_11732_ net85 net677 net607 net213 vssd1 vssd1 vccd1 vccd1 _05788_ sky130_fd_sc_hd__a22o_1
XPHY_51 vssd1 vssd1 vccd1 vccd1 sky130_fd_sc_hd__decap_3
XPHY_62 vssd1 vssd1 vccd1 vccd1 sky130_fd_sc_hd__decap_3
XPHY_73 vssd1 vssd1 vccd1 vccd1 sky130_fd_sc_hd__decap_3
XTAP_1599 vssd1 vccd1 sky130_fd_sc_hd__tapvpwrvgnd_1
XTAP_1588 vssd1 vccd1 sky130_fd_sc_hd__tapvpwrvgnd_1
XTAP_1577 vssd1 vccd1 sky130_fd_sc_hd__tapvpwrvgnd_1
XFILLER_0_83_337 vssd1 vssd1 vccd1 vccd1 sky130_ef_sc_hd__decap_12
XPHY_95 vssd1 vssd1 vccd1 vccd1 sky130_fd_sc_hd__decap_3
X_11663_ net1691 _01667_ net536 vssd1 vssd1 vccd1 vccd1 _00155_ sky130_fd_sc_hd__mux2_1
XPHY_84 vssd1 vssd1 vccd1 vccd1 sky130_fd_sc_hd__decap_3
X_10614_ net769 net992 net985 net779 vssd1 vssd1 vccd1 vccd1 _04716_ sky130_fd_sc_hd__a22o_1
XFILLER_0_36_253 vssd1 vssd1 vccd1 vccd1 sky130_fd_sc_hd__decap_6
XFILLER_0_107_653 vssd1 vssd1 vccd1 vccd1 sky130_ef_sc_hd__decap_12
XFILLER_0_106_141 vssd1 vssd1 vccd1 vccd1 sky130_ef_sc_hd__decap_12
XFILLER_0_64_584 vssd1 vssd1 vccd1 vccd1 sky130_fd_sc_hd__decap_4
X_11594_ _05686_ _05687_ vssd1 vssd1 vccd1 vccd1 _05688_ sky130_fd_sc_hd__xnor2_1
XFILLER_0_122_601 vssd1 vssd1 vccd1 vccd1 sky130_ef_sc_hd__decap_12
X_10545_ _04502_ _04505_ _04646_ net486 vssd1 vssd1 vccd1 vccd1 _04648_ sky130_fd_sc_hd__a211oi_2
XFILLER_0_52_757 vssd1 vssd1 vccd1 vccd1 sky130_fd_sc_hd__fill_2
XFILLER_0_24_448 vssd1 vssd1 vccd1 vccd1 sky130_fd_sc_hd__fill_2
XFILLER_0_122_645 vssd1 vssd1 vccd1 vccd1 sky130_ef_sc_hd__decap_12
XFILLER_0_121_111 vssd1 vssd1 vccd1 vccd1 sky130_fd_sc_hd__fill_1
X_10476_ _04577_ _04578_ vssd1 vssd1 vccd1 vccd1 _04579_ sky130_fd_sc_hd__nand2_1
XFILLER_0_51_278 vssd1 vssd1 vccd1 vccd1 sky130_fd_sc_hd__fill_2
X_13195_ clknet_leaf_16_clk_i _00581_ net1178 vssd1 vssd1 vccd1 vccd1 l1\[24\] sky130_fd_sc_hd__dfrtp_1
X_12215_ net791 _06163_ net520 vssd1 vssd1 vccd1 vccd1 _00299_ sky130_fd_sc_hd__mux2_1
X_12146_ _00951_ _06115_ net500 vssd1 vssd1 vccd1 vccd1 _06116_ sky130_fd_sc_hd__mux2_1
XFILLER_0_20_698 vssd1 vssd1 vccd1 vccd1 sky130_fd_sc_hd__fill_2
X_12077_ y2my0\[10\] net583 net531 x2mx1\[10\] _06063_ vssd1 vssd1 vccd1 vccd1 _06064_
+ sky130_fd_sc_hd__a221o_1
X_11028_ _05118_ _05126_ vssd1 vssd1 vccd1 vccd1 _05127_ sky130_fd_sc_hd__nand2_1
XFILLER_0_63_24 vssd1 vssd1 vccd1 vccd1 sky130_ef_sc_hd__decap_12
XFILLER_0_2_27 vssd1 vssd1 vccd1 vccd1 sky130_fd_sc_hd__fill_1
XFILLER_0_63_57 vssd1 vssd1 vccd1 vccd1 sky130_fd_sc_hd__fill_1
XFILLER_0_63_68 vssd1 vssd1 vccd1 vccd1 sky130_fd_sc_hd__decap_6
X_12979_ clknet_leaf_54_clk_i _00365_ net1154 vssd1 vssd1 vccd1 vccd1 x2mx1\[0\] sky130_fd_sc_hd__dfrtp_1
XFILLER_0_129_233 vssd1 vssd1 vccd1 vccd1 sky130_fd_sc_hd__fill_2
XFILLER_0_117_417 vssd1 vssd1 vccd1 vccd1 sky130_ef_sc_hd__decap_12
XFILLER_0_74_326 vssd1 vssd1 vccd1 vccd1 sky130_fd_sc_hd__fill_1
XANTENNA_38 net51 vssd1 vssd1 vccd1 vccd1 sky130_fd_sc_hd__diode_2
X_08170_ _02177_ _02178_ _02188_ _02286_ _02287_ vssd1 vssd1 vccd1 vccd1 _02288_ sky130_fd_sc_hd__o32ai_2
XANTENNA_16 v0y[26] vssd1 vssd1 vccd1 vccd1 sky130_fd_sc_hd__diode_2
XANTENNA_27 v2y[11] vssd1 vssd1 vccd1 vccd1 sky130_fd_sc_hd__diode_2
XANTENNA_49 _00794_ vssd1 vssd1 vccd1 vccd1 sky130_fd_sc_hd__diode_2
XFILLER_0_82_370 vssd1 vssd1 vccd1 vccd1 sky130_fd_sc_hd__decap_6
X_07121_ net806 net1137 _01242_ _01244_ vssd1 vssd1 vccd1 vccd1 _01246_ sky130_fd_sc_hd__a22oi_1
XFILLER_0_125_461 vssd1 vssd1 vccd1 vccd1 sky130_ef_sc_hd__decap_12
XFILLER_0_12_83 vssd1 vssd1 vccd1 vccd1 sky130_fd_sc_hd__fill_1
XFILLER_0_112_133 vssd1 vssd1 vccd1 vccd1 sky130_fd_sc_hd__decap_6
XFILLER_0_2_331 vssd1 vssd1 vccd1 vccd1 sky130_fd_sc_hd__fill_1
X_07052_ net846 net837 net1103 net1113 vssd1 vssd1 vccd1 vccd1 _01177_ sky130_fd_sc_hd__and4_1
XFILLER_0_42_289 vssd1 vssd1 vccd1 vccd1 sky130_fd_sc_hd__fill_1
XFILLER_0_101_818 vssd1 vssd1 vccd1 vccd1 sky130_fd_sc_hd__fill_2
XFILLER_0_88_65 vssd1 vssd1 vccd1 vccd1 sky130_ef_sc_hd__decap_12
XFILLER_0_51_790 vssd1 vssd1 vccd1 vccd1 sky130_fd_sc_hd__fill_1
XFILLER_0_2_375 vssd1 vssd1 vccd1 vccd1 sky130_fd_sc_hd__fill_2
XFILLER_0_112_177 vssd1 vssd1 vccd1 vccd1 sky130_ef_sc_hd__decap_12
XFILLER_0_10_153 vssd1 vssd1 vccd1 vccd1 sky130_ef_sc_hd__decap_12
XFILLER_0_10_120 vssd1 vssd1 vccd1 vccd1 sky130_ef_sc_hd__decap_12
XFILLER_0_11_698 vssd1 vssd1 vccd1 vccd1 sky130_fd_sc_hd__decap_4
X_07954_ net1147 net748 vssd1 vssd1 vccd1 vccd1 _02074_ sky130_fd_sc_hd__nand2_1
XFILLER_0_49_3 vssd1 vssd1 vccd1 vccd1 sky130_fd_sc_hd__decap_8
XFILLER_0_10_197 vssd1 vssd1 vccd1 vccd1 sky130_fd_sc_hd__fill_2
X_07885_ _01901_ _01903_ vssd1 vssd1 vccd1 vccd1 _02006_ sky130_fd_sc_hd__or2_1
X_06905_ net871 net862 net1103 net1111 vssd1 vssd1 vccd1 vccd1 _01030_ sky130_fd_sc_hd__and4_1
X_06836_ net1490 posx\[2\] net646 vssd1 vssd1 vccd1 vccd1 _00110_ sky130_fd_sc_hd__mux2_1
X_09624_ _03560_ _03562_ _03730_ _03731_ vssd1 vssd1 vccd1 vccd1 _03733_ sky130_fd_sc_hd__a211o_1
XFILLER_0_37_80 vssd1 vssd1 vccd1 vccd1 sky130_ef_sc_hd__decap_12
X_09555_ _03660_ _03661_ _03662_ vssd1 vssd1 vccd1 vccd1 _03664_ sky130_fd_sc_hd__a21o_1
X_06767_ net1583 l1\[6\] net637 vssd1 vssd1 vccd1 vccd1 _00041_ sky130_fd_sc_hd__mux2_1
X_09486_ _03594_ vssd1 vssd1 vccd1 vccd1 _03595_ sky130_fd_sc_hd__inv_2
XFILLER_0_93_602 vssd1 vssd1 vccd1 vccd1 sky130_fd_sc_hd__fill_1
XFILLER_0_78_676 vssd1 vssd1 vccd1 vccd1 sky130_fd_sc_hd__fill_1
X_08506_ _02619_ _02620_ net858 net1008 vssd1 vssd1 vccd1 vccd1 _02622_ sky130_fd_sc_hd__and4bb_1
XFILLER_0_53_90 vssd1 vssd1 vccd1 vccd1 sky130_fd_sc_hd__fill_1
X_06698_ _00919_ _00920_ vssd1 vssd1 vccd1 vccd1 _00921_ sky130_fd_sc_hd__and2b_2
X_08437_ _02439_ _02441_ _02552_ vssd1 vssd1 vccd1 vccd1 _02553_ sky130_fd_sc_hd__a21oi_1
XFILLER_0_65_337 vssd1 vssd1 vccd1 vccd1 sky130_fd_sc_hd__fill_1
XFILLER_0_93_668 vssd1 vssd1 vccd1 vccd1 sky130_fd_sc_hd__fill_1
XFILLER_0_92_145 vssd1 vssd1 vccd1 vccd1 sky130_fd_sc_hd__decap_4
X_08368_ _02483_ _02484_ vssd1 vssd1 vccd1 vccd1 _02485_ sky130_fd_sc_hd__nand2_1
XFILLER_0_104_623 vssd1 vssd1 vccd1 vccd1 sky130_ef_sc_hd__decap_12
X_08299_ _02395_ _02397_ vssd1 vssd1 vccd1 vccd1 _02416_ sky130_fd_sc_hd__nand2_1
X_07319_ _01314_ _01443_ vssd1 vssd1 vccd1 vccd1 _01444_ sky130_fd_sc_hd__or2_1
XFILLER_0_104_645 vssd1 vssd1 vccd1 vccd1 sky130_ef_sc_hd__decap_12
XFILLER_0_103_111 vssd1 vssd1 vccd1 vccd1 sky130_fd_sc_hd__fill_1
X_10330_ net878 net867 net933 net927 vssd1 vssd1 vccd1 vccd1 _04434_ sky130_fd_sc_hd__nand4_2
X_10261_ _04363_ _04364_ vssd1 vssd1 vccd1 vccd1 _04366_ sky130_fd_sc_hd__xnor2_4
X_12000_ net138 net661 net504 net234 _06004_ vssd1 vssd1 vccd1 vccd1 _06005_ sky130_fd_sc_hd__a221o_1
XFILLER_0_100_840 vssd1 vssd1 vccd1 vccd1 sky130_fd_sc_hd__fill_2
X_10192_ _04287_ _04294_ _04295_ vssd1 vssd1 vccd1 vccd1 _04297_ sky130_fd_sc_hd__nand3_1
X_12902_ clknet_leaf_52_clk_i _00288_ vssd1 vssd1 vccd1 vccd1 mul1.b\[5\] sky130_fd_sc_hd__dfxtp_1
XFILLER_0_17_39 vssd1 vssd1 vccd1 vccd1 sky130_ef_sc_hd__decap_12
XFILLER_0_88_418 vssd1 vssd1 vccd1 vccd1 sky130_fd_sc_hd__fill_2
XFILLER_0_124_29 vssd1 vssd1 vccd1 vccd1 sky130_ef_sc_hd__decap_12
XTAP_2042 vssd1 vccd1 sky130_fd_sc_hd__tapvpwrvgnd_1
XTAP_2031 vssd1 vccd1 sky130_fd_sc_hd__tapvpwrvgnd_1
XTAP_2020 vssd1 vccd1 sky130_fd_sc_hd__tapvpwrvgnd_1
XFILLER_0_68_131 vssd1 vssd1 vccd1 vccd1 sky130_fd_sc_hd__decap_8
X_12833_ clknet_leaf_56_clk_i _00219_ vssd1 vssd1 vccd1 vccd1 sub1.b_i\[0\] sky130_fd_sc_hd__dfxtp_1
XTAP_2086 vssd1 vccd1 sky130_fd_sc_hd__tapvpwrvgnd_1
XTAP_2075 vssd1 vccd1 sky130_fd_sc_hd__tapvpwrvgnd_1
XTAP_2053 vssd1 vccd1 sky130_fd_sc_hd__tapvpwrvgnd_1
XTAP_2064 vssd1 vccd1 sky130_fd_sc_hd__tapvpwrvgnd_1
XFILLER_0_96_473 vssd1 vssd1 vccd1 vccd1 sky130_fd_sc_hd__decap_3
XTAP_1341 vssd1 vccd1 sky130_fd_sc_hd__tapvpwrvgnd_1
XTAP_1330 vssd1 vccd1 sky130_fd_sc_hd__tapvpwrvgnd_1
X_12764_ clknet_leaf_24_clk_i _00150_ vssd1 vssd1 vccd1 vccd1 add1.a_i\[27\] sky130_fd_sc_hd__dfxtp_1
XFILLER_0_130_9 vssd1 vssd1 vccd1 vccd1 sky130_ef_sc_hd__decap_12
XTAP_2097 vssd1 vccd1 sky130_fd_sc_hd__tapvpwrvgnd_1
XFILLER_0_84_635 vssd1 vssd1 vccd1 vccd1 sky130_fd_sc_hd__fill_2
XTAP_1363 vssd1 vccd1 sky130_fd_sc_hd__tapvpwrvgnd_1
XTAP_1374 vssd1 vccd1 sky130_fd_sc_hd__tapvpwrvgnd_1
XTAP_1352 vssd1 vccd1 sky130_fd_sc_hd__tapvpwrvgnd_1
XFILLER_0_56_337 vssd1 vssd1 vccd1 vccd1 sky130_ef_sc_hd__decap_12
X_11715_ net80 net677 net611 temp1\[2\] vssd1 vssd1 vccd1 vccd1 _05774_ sky130_fd_sc_hd__a22o_1
X_12695_ clknet_leaf_14_clk_i net1270 net1186 vssd1 vssd1 vccd1 vccd1 net425 sky130_fd_sc_hd__dfrtp_1
XTAP_1396 vssd1 vccd1 sky130_fd_sc_hd__tapvpwrvgnd_1
XTAP_1385 vssd1 vccd1 sky130_fd_sc_hd__tapvpwrvgnd_1
XFILLER_0_25_735 vssd1 vssd1 vccd1 vccd1 sky130_fd_sc_hd__fill_1
X_11646_ _05738_ _05739_ vssd1 vssd1 vccd1 vccd1 _05740_ sky130_fd_sc_hd__xnor2_1
Xinput25 div_sstream_i[30] vssd1 vssd1 vccd1 vccd1 net25 sky130_fd_sc_hd__buf_4
Xinput14 div_sstream_i[20] vssd1 vssd1 vccd1 vccd1 net14 sky130_fd_sc_hd__clkbuf_8
XFILLER_0_107_461 vssd1 vssd1 vccd1 vccd1 sky130_fd_sc_hd__decap_4
Xinput36 nrst_i vssd1 vssd1 vccd1 vccd1 net36 sky130_fd_sc_hd__clkbuf_4
X_11577_ temp1\[30\] _05671_ net543 vssd1 vssd1 vccd1 vccd1 _05672_ sky130_fd_sc_hd__mux2_1
Xinput47 sstream_i[18] vssd1 vssd1 vccd1 vccd1 net47 sky130_fd_sc_hd__buf_4
X_10528_ net1037 net731 net725 net1047 vssd1 vssd1 vccd1 vccd1 _04631_ sky130_fd_sc_hd__a22o_1
Xmax_cap506 net1757 vssd1 vssd1 vccd1 vccd1 net506 sky130_fd_sc_hd__buf_1
Xinput69 v0x[1] vssd1 vssd1 vccd1 vccd1 net69 sky130_fd_sc_hd__buf_1
Xinput58 v0x[0] vssd1 vssd1 vccd1 vccd1 net58 sky130_fd_sc_hd__buf_1
XFILLER_0_122_475 vssd1 vssd1 vccd1 vccd1 sky130_fd_sc_hd__fill_1
XFILLER_0_110_637 vssd1 vssd1 vccd1 vccd1 sky130_fd_sc_hd__decap_6
X_10459_ _04457_ _04460_ _04559_ _04560_ vssd1 vssd1 vccd1 vccd1 _04562_ sky130_fd_sc_hd__a211oi_2
XFILLER_0_58_68 vssd1 vssd1 vccd1 vccd1 sky130_fd_sc_hd__decap_4
X_13178_ clknet_leaf_21_clk_i _00564_ net1175 vssd1 vssd1 vccd1 vccd1 l1\[7\] sky130_fd_sc_hd__dfrtp_1
XFILLER_0_20_473 vssd1 vssd1 vccd1 vccd1 sky130_fd_sc_hd__decap_3
X_12129_ y2my0\[23\] net587 net534 x2mx1\[23\] _06102_ vssd1 vssd1 vccd1 vccd1 _06103_
+ sky130_fd_sc_hd__a221o_1
XFILLER_0_74_45 vssd1 vssd1 vccd1 vccd1 sky130_fd_sc_hd__fill_1
X_07670_ net1074 net1082 net839 vssd1 vssd1 vccd1 vccd1 _01793_ sky130_fd_sc_hd__and3_1
X_06621_ sub1.b_i\[10\] sub1.a_i\[10\] vssd1 vssd1 vccd1 vccd1 _00856_ sky130_fd_sc_hd__and2b_1
X_09340_ _03449_ _03448_ _03447_ vssd1 vssd1 vccd1 vccd1 _03450_ sky130_fd_sc_hd__nand3b_2
X_06552_ net1151 state\[1\] vssd1 vssd1 vccd1 vccd1 _00800_ sky130_fd_sc_hd__nand2_2
XFILLER_0_90_77 vssd1 vssd1 vccd1 vccd1 sky130_fd_sc_hd__decap_6
X_09271_ _03378_ _03379_ _03380_ vssd1 vssd1 vccd1 vccd1 _03382_ sky130_fd_sc_hd__nand3_1
XFILLER_0_118_737 vssd1 vssd1 vccd1 vccd1 sky130_ef_sc_hd__decap_12
XFILLER_0_117_225 vssd1 vssd1 vccd1 vccd1 sky130_ef_sc_hd__decap_12
X_08222_ _02336_ _02337_ _02338_ vssd1 vssd1 vccd1 vccd1 _02340_ sky130_fd_sc_hd__nand3_1
X_06483_ _00770_ _00771_ _00772_ vssd1 vssd1 vccd1 vccd1 _00778_ sky130_fd_sc_hd__o21ai_4
XFILLER_0_90_649 vssd1 vssd1 vccd1 vccd1 sky130_fd_sc_hd__decap_4
XFILLER_0_28_595 vssd1 vssd1 vccd1 vccd1 sky130_fd_sc_hd__fill_1
XFILLER_0_126_781 vssd1 vssd1 vccd1 vccd1 sky130_ef_sc_hd__decap_12
XFILLER_0_71_841 vssd1 vssd1 vccd1 vccd1 sky130_fd_sc_hd__fill_1
XFILLER_0_71_830 vssd1 vssd1 vccd1 vccd1 sky130_fd_sc_hd__fill_1
X_08153_ _02174_ _02270_ _02271_ vssd1 vssd1 vccd1 vccd1 _02272_ sky130_fd_sc_hd__nor3_2
XFILLER_0_43_543 vssd1 vssd1 vccd1 vccd1 sky130_fd_sc_hd__decap_8
XFILLER_0_15_223 vssd1 vssd1 vccd1 vccd1 sky130_fd_sc_hd__fill_1
XFILLER_0_130_61 vssd1 vssd1 vccd1 vccd1 sky130_fd_sc_hd__fill_1
X_08084_ _02189_ _02202_ vssd1 vssd1 vccd1 vccd1 _02203_ sky130_fd_sc_hd__and2_1
X_07104_ _01218_ _01219_ _01228_ vssd1 vssd1 vccd1 vccd1 _01229_ sky130_fd_sc_hd__and3_1
XFILLER_0_31_727 vssd1 vssd1 vccd1 vccd1 sky130_fd_sc_hd__fill_1
Xclkbuf_leaf_23_clk_i clknet_3_5__leaf_clk_i vssd1 vssd1 vccd1 vccd1 clknet_leaf_23_clk_i
+ sky130_fd_sc_hd__clkbuf_16
XFILLER_0_31_738 vssd1 vssd1 vccd1 vccd1 sky130_fd_sc_hd__fill_1
X_07035_ _01125_ _01126_ vssd1 vssd1 vccd1 vccd1 _01160_ sky130_fd_sc_hd__or2_1
XFILLER_0_113_497 vssd1 vssd1 vccd1 vccd1 sky130_fd_sc_hd__decap_6
XFILLER_0_100_147 vssd1 vssd1 vccd1 vccd1 sky130_fd_sc_hd__decap_4
XFILLER_0_2_194 vssd1 vssd1 vccd1 vccd1 sky130_fd_sc_hd__fill_2
X_08986_ _03096_ _03097_ _02949_ net1744 vssd1 vssd1 vccd1 vccd1 _03099_ sky130_fd_sc_hd__a211oi_1
Xclkbuf_leaf_38_clk_i clknet_3_1__leaf_clk_i vssd1 vssd1 vccd1 vccd1 clknet_leaf_38_clk_i
+ sky130_fd_sc_hd__clkbuf_16
X_07937_ _01955_ _01956_ _02057_ vssd1 vssd1 vccd1 vccd1 _02058_ sky130_fd_sc_hd__a21o_1
X_07868_ net822 _01988_ _01987_ vssd1 vssd1 vccd1 vccd1 _01989_ sky130_fd_sc_hd__a21bo_1
XFILLER_0_3_70 vssd1 vssd1 vccd1 vccd1 sky130_fd_sc_hd__fill_2
X_06819_ net439 net1224 net648 vssd1 vssd1 vccd1 vccd1 _00093_ sky130_fd_sc_hd__mux2_1
XFILLER_0_97_237 vssd1 vssd1 vccd1 vccd1 sky130_fd_sc_hd__decap_3
X_09607_ _03713_ _03714_ _03709_ vssd1 vssd1 vccd1 vccd1 _03716_ sky130_fd_sc_hd__a21o_1
X_07799_ _01917_ _01918_ _01919_ vssd1 vssd1 vccd1 vccd1 _01921_ sky130_fd_sc_hd__a21o_1
X_09538_ _03475_ _03477_ _03645_ _03646_ vssd1 vssd1 vccd1 vccd1 _03647_ sky130_fd_sc_hd__o211a_1
X_09469_ _03414_ _03575_ _03576_ vssd1 vssd1 vccd1 vccd1 _03579_ sky130_fd_sc_hd__nand3_1
XFILLER_0_19_551 vssd1 vssd1 vccd1 vccd1 sky130_fd_sc_hd__decap_3
X_11500_ _05585_ _05594_ vssd1 vssd1 vccd1 vccd1 _05595_ sky130_fd_sc_hd__xnor2_1
XFILLER_0_19_573 vssd1 vssd1 vccd1 vccd1 sky130_fd_sc_hd__fill_2
X_12480_ _00973_ net618 _05750_ net577 vssd1 vssd1 vccd1 vccd1 _06236_ sky130_fd_sc_hd__a22o_1
XFILLER_0_117_770 vssd1 vssd1 vccd1 vccd1 sky130_fd_sc_hd__decap_8
X_11431_ net989 net982 net729 net721 vssd1 vssd1 vccd1 vccd1 _05527_ sky130_fd_sc_hd__and4_1
XFILLER_0_123_239 vssd1 vssd1 vccd1 vccd1 sky130_fd_sc_hd__decap_4
XFILLER_0_34_587 vssd1 vssd1 vccd1 vccd1 sky130_fd_sc_hd__fill_1
X_11362_ _05452_ _05457_ vssd1 vssd1 vccd1 vccd1 _05458_ sky130_fd_sc_hd__or2_1
X_10313_ _04253_ _04256_ _04413_ _04414_ vssd1 vssd1 vccd1 vccd1 _04417_ sky130_fd_sc_hd__a211o_1
XFILLER_0_22_749 vssd1 vssd1 vccd1 vccd1 sky130_fd_sc_hd__fill_1
X_13101_ clknet_leaf_24_clk_i _00487_ vssd1 vssd1 vccd1 vccd1 temp1\[26\] sky130_fd_sc_hd__dfxtp_1
XFILLER_0_104_475 vssd1 vssd1 vccd1 vccd1 sky130_fd_sc_hd__fill_1
X_11293_ _05388_ _05389_ vssd1 vssd1 vccd1 vccd1 _05390_ sky130_fd_sc_hd__nand2b_1
X_10244_ _04346_ _04347_ _04333_ vssd1 vssd1 vccd1 vccd1 _04349_ sky130_fd_sc_hd__a21oi_2
X_13032_ clknet_leaf_35_clk_i _00418_ net1167 vssd1 vssd1 vccd1 vccd1 x0mx2\[21\]
+ sky130_fd_sc_hd__dfrtp_1
Xfanout1101 net1102 vssd1 vssd1 vccd1 vccd1 net1101 sky130_fd_sc_hd__dlymetal6s2s_1
X_10175_ net1021 net760 _04277_ _04279_ vssd1 vssd1 vccd1 vccd1 _04280_ sky130_fd_sc_hd__and4_1
Xfanout1112 net1113 vssd1 vssd1 vccd1 vccd1 net1112 sky130_fd_sc_hd__clkbuf_4
XFILLER_0_28_27 vssd1 vssd1 vccd1 vccd1 sky130_fd_sc_hd__fill_1
Xfanout1123 mul1.a\[3\] vssd1 vssd1 vccd1 vccd1 net1123 sky130_fd_sc_hd__clkbuf_4
Xfanout1145 net1146 vssd1 vssd1 vccd1 vccd1 net1145 sky130_fd_sc_hd__buf_2
Xfanout1134 mul1.a\[2\] vssd1 vssd1 vccd1 vccd1 net1134 sky130_fd_sc_hd__buf_4
Xfanout1156 net1158 vssd1 vssd1 vccd1 vccd1 net1156 sky130_fd_sc_hd__buf_4
Xfanout1189 net1197 vssd1 vssd1 vccd1 vccd1 net1189 sky130_fd_sc_hd__clkbuf_2
Xfanout1178 net1180 vssd1 vssd1 vccd1 vccd1 net1178 sky130_fd_sc_hd__clkbuf_4
Xfanout1167 net1173 vssd1 vssd1 vccd1 vccd1 net1167 sky130_fd_sc_hd__clkbuf_4
XFILLER_0_89_749 vssd1 vssd1 vccd1 vccd1 sky130_fd_sc_hd__fill_1
XFILLER_0_89_727 vssd1 vssd1 vccd1 vccd1 sky130_fd_sc_hd__fill_1
XFILLER_0_44_15 vssd1 vssd1 vccd1 vccd1 sky130_fd_sc_hd__decap_3
XFILLER_0_88_237 vssd1 vssd1 vccd1 vccd1 sky130_fd_sc_hd__decap_8
X_12816_ clknet_leaf_49_clk_i _00202_ vssd1 vssd1 vccd1 vccd1 sub1.a_i\[15\] sky130_fd_sc_hd__dfxtp_1
XFILLER_0_84_421 vssd1 vssd1 vccd1 vccd1 sky130_fd_sc_hd__fill_2
XTAP_1171 vssd1 vccd1 sky130_fd_sc_hd__tapvpwrvgnd_1
XTAP_1182 vssd1 vccd1 sky130_fd_sc_hd__tapvpwrvgnd_1
XTAP_1160 vssd1 vccd1 sky130_fd_sc_hd__tapvpwrvgnd_1
X_12747_ clknet_leaf_1_clk_i _00133_ vssd1 vssd1 vccd1 vccd1 add1.a_i\[10\] sky130_fd_sc_hd__dfxtp_1
XFILLER_0_127_545 vssd1 vssd1 vccd1 vccd1 sky130_ef_sc_hd__decap_12
X_12678_ clknet_leaf_15_clk_i _00064_ net1182 vssd1 vssd1 vccd1 vccd1 net407 sky130_fd_sc_hd__dfrtp_1
XTAP_1193 vssd1 vccd1 sky130_fd_sc_hd__tapvpwrvgnd_1
XFILLER_0_60_58 vssd1 vssd1 vccd1 vccd1 sky130_fd_sc_hd__fill_1
XFILLER_0_115_729 vssd1 vssd1 vccd1 vccd1 sky130_fd_sc_hd__decap_4
XFILLER_0_53_841 vssd1 vssd1 vccd1 vccd1 sky130_fd_sc_hd__fill_1
X_11629_ _05712_ _05722_ vssd1 vssd1 vccd1 vccd1 _05723_ sky130_fd_sc_hd__xnor2_1
XFILLER_0_107_3 vssd1 vssd1 vccd1 vccd1 sky130_ef_sc_hd__decap_12
XFILLER_0_8_15 vssd1 vssd1 vccd1 vccd1 sky130_ef_sc_hd__decap_12
XFILLER_0_107_291 vssd1 vssd1 vccd1 vccd1 sky130_fd_sc_hd__fill_1
XFILLER_0_12_204 vssd1 vssd1 vccd1 vccd1 sky130_fd_sc_hd__decap_6
XFILLER_0_100_53 vssd1 vssd1 vccd1 vccd1 sky130_ef_sc_hd__decap_12
XFILLER_0_100_97 vssd1 vssd1 vccd1 vccd1 sky130_ef_sc_hd__decap_12
XTAP_900 vssd1 vccd1 sky130_fd_sc_hd__tapvpwrvgnd_1
XFILLER_0_110_489 vssd1 vssd1 vccd1 vccd1 sky130_ef_sc_hd__decap_12
X_08840_ net455 _02952_ _02799_ _02801_ vssd1 vssd1 vccd1 vccd1 _02954_ sky130_fd_sc_hd__o211a_1
XFILLER_0_85_33 vssd1 vssd1 vccd1 vccd1 sky130_ef_sc_hd__decap_12
XTAP_944 vssd1 vccd1 sky130_fd_sc_hd__tapvpwrvgnd_1
XTAP_933 vssd1 vccd1 sky130_fd_sc_hd__tapvpwrvgnd_1
XTAP_922 vssd1 vccd1 sky130_fd_sc_hd__tapvpwrvgnd_1
XFILLER_0_0_676 vssd1 vssd1 vccd1 vccd1 sky130_fd_sc_hd__fill_1
XTAP_911 vssd1 vccd1 sky130_fd_sc_hd__tapvpwrvgnd_1
XTAP_977 vssd1 vccd1 sky130_fd_sc_hd__tapvpwrvgnd_1
XTAP_966 vssd1 vccd1 sky130_fd_sc_hd__tapvpwrvgnd_1
XTAP_955 vssd1 vccd1 sky130_fd_sc_hd__tapvpwrvgnd_1
XFILLER_0_109_51 vssd1 vssd1 vccd1 vccd1 sky130_fd_sc_hd__decap_4
X_08771_ _02727_ _02730_ _02882_ _02883_ vssd1 vssd1 vccd1 vccd1 _02885_ sky130_fd_sc_hd__o211a_1
XTAP_999 vssd1 vccd1 sky130_fd_sc_hd__tapvpwrvgnd_1
XTAP_988 vssd1 vccd1 sky130_fd_sc_hd__tapvpwrvgnd_1
X_07722_ _01842_ _01843_ _01743_ _01745_ vssd1 vssd1 vccd1 vccd1 _01845_ sky130_fd_sc_hd__a211oi_1
X_07653_ _01774_ _01775_ vssd1 vssd1 vccd1 vccd1 _01776_ sky130_fd_sc_hd__nand2_1
X_06604_ sub1.a_i\[7\] sub1.b_i\[7\] vssd1 vssd1 vccd1 vccd1 _00842_ sky130_fd_sc_hd__nand2b_1
X_09323_ net1133 net705 net700 net1141 vssd1 vssd1 vccd1 vccd1 _03433_ sky130_fd_sc_hd__a22oi_2
X_07584_ net873 _01707_ _01706_ vssd1 vssd1 vccd1 vccd1 _01708_ sky130_fd_sc_hd__a21bo_1
X_06535_ net544 _00790_ vssd1 vssd1 vccd1 vccd1 net301 sky130_fd_sc_hd__nor2_1
XFILLER_0_118_501 vssd1 vssd1 vccd1 vccd1 sky130_ef_sc_hd__decap_12
XFILLER_0_118_545 vssd1 vssd1 vccd1 vccd1 sky130_ef_sc_hd__decap_12
X_09254_ net861 net974 _03363_ _03364_ vssd1 vssd1 vccd1 vccd1 _03365_ sky130_fd_sc_hd__nand4_1
X_06466_ _00751_ _00756_ vssd1 vssd1 vccd1 vccd1 _00763_ sky130_fd_sc_hd__nand2_1
XFILLER_0_47_167 vssd1 vssd1 vccd1 vccd1 sky130_fd_sc_hd__fill_1
XFILLER_0_118_589 vssd1 vssd1 vccd1 vccd1 sky130_ef_sc_hd__decap_12
X_09185_ _03132_ _03134_ _03293_ _03294_ vssd1 vssd1 vccd1 vccd1 _03296_ sky130_fd_sc_hd__a211oi_2
XFILLER_0_105_217 vssd1 vssd1 vccd1 vccd1 sky130_fd_sc_hd__decap_6
X_08205_ _02320_ _02321_ vssd1 vssd1 vccd1 vccd1 _02323_ sky130_fd_sc_hd__xnor2_1
XFILLER_0_62_126 vssd1 vssd1 vccd1 vccd1 sky130_fd_sc_hd__decap_3
XFILLER_0_44_841 vssd1 vssd1 vccd1 vccd1 sky130_fd_sc_hd__fill_1
X_08136_ _02130_ _02138_ _02137_ vssd1 vssd1 vccd1 vccd1 _02255_ sky130_fd_sc_hd__a21bo_1
X_06397_ _00684_ _00687_ _00690_ _00697_ vssd1 vssd1 vccd1 vccd1 _00704_ sky130_fd_sc_hd__a211oi_1
XFILLER_0_120_209 vssd1 vssd1 vccd1 vccd1 sky130_ef_sc_hd__decap_12
XFILLER_0_16_598 vssd1 vssd1 vccd1 vccd1 sky130_fd_sc_hd__fill_2
XFILLER_0_31_535 vssd1 vssd1 vccd1 vccd1 sky130_fd_sc_hd__decap_6
XFILLER_0_113_261 vssd1 vssd1 vccd1 vccd1 sky130_ef_sc_hd__decap_12
XFILLER_0_101_401 vssd1 vssd1 vccd1 vccd1 sky130_fd_sc_hd__fill_2
X_08067_ _02066_ _02068_ vssd1 vssd1 vccd1 vccd1 _02186_ sky130_fd_sc_hd__or2_1
X_07018_ _01106_ _01108_ _01107_ vssd1 vssd1 vccd1 vccd1 _01143_ sky130_fd_sc_hd__a21bo_1
XFILLER_0_11_281 vssd1 vssd1 vccd1 vccd1 sky130_fd_sc_hd__fill_1
Xinput215 v2x[7] vssd1 vssd1 vccd1 vccd1 net215 sky130_fd_sc_hd__buf_1
Xinput204 v2x[26] vssd1 vssd1 vccd1 vccd1 net204 sky130_fd_sc_hd__buf_1
Xinput226 v2y[17] vssd1 vssd1 vccd1 vccd1 net226 sky130_fd_sc_hd__buf_1
X_08969_ _03061_ _03078_ _03079_ vssd1 vssd1 vccd1 vccd1 _03082_ sky130_fd_sc_hd__nand3_2
Xinput248 v2y[8] vssd1 vssd1 vccd1 vccd1 net248 sky130_fd_sc_hd__buf_1
Xinput237 v2y[27] vssd1 vssd1 vccd1 vccd1 net237 sky130_fd_sc_hd__buf_1
X_11980_ net132 net660 net504 net228 _05989_ vssd1 vssd1 vccd1 vccd1 _05990_ sky130_fd_sc_hd__a221o_1
X_10931_ _05028_ _05029_ vssd1 vssd1 vccd1 vccd1 _05031_ sky130_fd_sc_hd__xor2_1
XPHY_210 vssd1 vssd1 vccd1 vccd1 sky130_fd_sc_hd__decap_3
X_10862_ net828 net819 net941 net935 vssd1 vssd1 vccd1 vccd1 _04962_ sky130_fd_sc_hd__and4_1
XFILLER_0_14_29 vssd1 vssd1 vccd1 vccd1 sky130_ef_sc_hd__decap_12
XPHY_243 vssd1 vssd1 vccd1 vccd1 sky130_fd_sc_hd__decap_3
XPHY_232 vssd1 vssd1 vccd1 vccd1 sky130_fd_sc_hd__decap_3
XPHY_221 vssd1 vssd1 vccd1 vccd1 sky130_fd_sc_hd__decap_3
X_10793_ net458 _04892_ _04707_ _04746_ vssd1 vssd1 vccd1 vccd1 _04894_ sky130_fd_sc_hd__o211ai_4
X_12601_ net1360 net12 net556 vssd1 vssd1 vccd1 vccd1 _00576_ sky130_fd_sc_hd__mux2_1
X_12532_ _00744_ net565 vssd1 vssd1 vccd1 vccd1 _06263_ sky130_fd_sc_hd__nor2_1
XPHY_254 vssd1 vssd1 vccd1 vccd1 sky130_fd_sc_hd__decap_3
XFILLER_0_81_457 vssd1 vssd1 vccd1 vccd1 sky130_fd_sc_hd__decap_6
XFILLER_0_35_841 vssd1 vssd1 vccd1 vccd1 sky130_fd_sc_hd__fill_1
X_12463_ temp1\[22\] _06227_ net572 vssd1 vssd1 vccd1 vccd1 _00483_ sky130_fd_sc_hd__mux2_1
XFILLER_0_81_468 vssd1 vssd1 vccd1 vccd1 sky130_fd_sc_hd__fill_1
XFILLER_0_50_811 vssd1 vssd1 vccd1 vccd1 sky130_fd_sc_hd__fill_1
XFILLER_0_34_351 vssd1 vssd1 vccd1 vccd1 sky130_fd_sc_hd__decap_4
X_11414_ net1019 net702 _05506_ _05508_ vssd1 vssd1 vccd1 vccd1 _05510_ sky130_fd_sc_hd__a22oi_1
X_12394_ net1485 _00897_ net684 vssd1 vssd1 vccd1 vccd1 _00446_ sky130_fd_sc_hd__mux2_1
X_11345_ _05440_ _05441_ vssd1 vssd1 vccd1 vccd1 _05442_ sky130_fd_sc_hd__or2_1
XFILLER_0_22_557 vssd1 vssd1 vccd1 vccd1 sky130_fd_sc_hd__fill_2
XFILLER_0_39_15 vssd1 vssd1 vccd1 vccd1 sky130_fd_sc_hd__decap_4
XFILLER_0_39_26 vssd1 vssd1 vccd1 vccd1 sky130_fd_sc_hd__fill_1
XFILLER_0_39_48 vssd1 vssd1 vccd1 vccd1 sky130_fd_sc_hd__fill_1
X_11276_ _05360_ _05371_ _05372_ vssd1 vssd1 vccd1 vccd1 _05373_ sky130_fd_sc_hd__and3_2
X_10227_ _04328_ _04329_ _04330_ vssd1 vssd1 vccd1 vccd1 _04332_ sky130_fd_sc_hd__a21oi_2
X_13015_ clknet_leaf_52_clk_i _00401_ net1152 vssd1 vssd1 vccd1 vccd1 x0mx2\[4\] sky130_fd_sc_hd__dfrtp_1
X_10158_ _04262_ vssd1 vssd1 vccd1 vccd1 _04263_ sky130_fd_sc_hd__inv_2
Xhold3 l1\[14\] vssd1 vssd1 vccd1 vccd1 net1218 sky130_fd_sc_hd__dlygate4sd3_1
X_10089_ _04182_ _04183_ _04193_ _04194_ vssd1 vssd1 vccd1 vccd1 _04195_ sky130_fd_sc_hd__and4_1
XFILLER_0_55_36 vssd1 vssd1 vccd1 vccd1 sky130_fd_sc_hd__fill_2
XFILLER_0_76_229 vssd1 vssd1 vccd1 vccd1 sky130_fd_sc_hd__fill_2
XFILLER_0_85_741 vssd1 vssd1 vccd1 vccd1 sky130_fd_sc_hd__decap_8
XFILLER_0_71_57 vssd1 vssd1 vccd1 vccd1 sky130_fd_sc_hd__decap_8
XFILLER_0_57_487 vssd1 vssd1 vccd1 vccd1 sky130_ef_sc_hd__decap_12
X_06320_ _00630_ _00631_ vssd1 vssd1 vccd1 vccd1 _00632_ sky130_fd_sc_hd__nand2_2
XFILLER_0_29_167 vssd1 vssd1 vccd1 vccd1 sky130_fd_sc_hd__fill_1
XFILLER_0_29_178 vssd1 vssd1 vccd1 vccd1 sky130_fd_sc_hd__decap_8
XFILLER_0_72_457 vssd1 vssd1 vccd1 vccd1 sky130_fd_sc_hd__decap_3
XFILLER_0_115_559 vssd1 vssd1 vccd1 vccd1 sky130_fd_sc_hd__fill_1
XFILLER_0_53_682 vssd1 vssd1 vccd1 vccd1 sky130_fd_sc_hd__decap_6
XFILLER_0_52_170 vssd1 vssd1 vccd1 vccd1 sky130_fd_sc_hd__fill_1
XFILLER_0_4_245 vssd1 vssd1 vccd1 vccd1 sky130_fd_sc_hd__fill_1
XFILLER_0_111_721 vssd1 vssd1 vccd1 vccd1 sky130_fd_sc_hd__decap_6
Xhold425 y1my2\[25\] vssd1 vssd1 vccd1 vccd1 net1640 sky130_fd_sc_hd__dlygate4sd3_1
XFILLER_0_20_83 vssd1 vssd1 vccd1 vccd1 sky130_fd_sc_hd__fill_1
Xhold436 y1my2\[8\] vssd1 vssd1 vccd1 vccd1 net1651 sky130_fd_sc_hd__dlygate4sd3_1
Xhold414 y1my2\[10\] vssd1 vssd1 vccd1 vccd1 net1629 sky130_fd_sc_hd__dlygate4sd3_1
Xhold403 add1.b_i\[2\] vssd1 vssd1 vccd1 vccd1 net1618 sky130_fd_sc_hd__dlygate4sd3_1
X_09941_ _03834_ _03886_ _03885_ vssd1 vssd1 vccd1 vccd1 _04048_ sky130_fd_sc_hd__a21oi_2
Xhold447 y1my2\[22\] vssd1 vssd1 vccd1 vccd1 net1662 sky130_fd_sc_hd__dlygate4sd3_1
Xhold458 y1my2\[28\] vssd1 vssd1 vccd1 vccd1 net1673 sky130_fd_sc_hd__dlygate4sd3_1
Xhold469 add1.a_i\[4\] vssd1 vssd1 vccd1 vccd1 net1684 sky130_fd_sc_hd__dlygate4sd3_1
XFILLER_0_110_253 vssd1 vssd1 vccd1 vccd1 sky130_ef_sc_hd__decap_12
XFILLER_0_96_65 vssd1 vssd1 vccd1 vccd1 sky130_ef_sc_hd__decap_12
Xfanout916 mul1.b\[1\] vssd1 vssd1 vccd1 vccd1 net916 sky130_fd_sc_hd__buf_2
Xfanout905 mul1.b\[2\] vssd1 vssd1 vccd1 vccd1 net905 sky130_fd_sc_hd__buf_2
XFILLER_0_110_297 vssd1 vssd1 vccd1 vccd1 sky130_fd_sc_hd__decap_3
X_09872_ _03977_ _03978_ _03970_ vssd1 vssd1 vccd1 vccd1 _03979_ sky130_fd_sc_hd__a21o_1
Xfanout949 net950 vssd1 vssd1 vccd1 vccd1 net949 sky130_fd_sc_hd__buf_2
Xfanout927 net928 vssd1 vssd1 vccd1 vccd1 net927 sky130_fd_sc_hd__clkbuf_4
XFILLER_0_0_484 vssd1 vssd1 vccd1 vccd1 sky130_fd_sc_hd__fill_2
XTAP_730 vssd1 vccd1 sky130_fd_sc_hd__tapvpwrvgnd_1
XTAP_741 vssd1 vccd1 sky130_fd_sc_hd__tapvpwrvgnd_1
XTAP_752 vssd1 vccd1 sky130_fd_sc_hd__tapvpwrvgnd_1
Xfanout938 mul1.a\[29\] vssd1 vssd1 vccd1 vccd1 net938 sky130_fd_sc_hd__clkbuf_4
X_08823_ _02917_ _02934_ _02935_ vssd1 vssd1 vccd1 vccd1 _02937_ sky130_fd_sc_hd__and3_1
XFILLER_0_29_81 vssd1 vssd1 vccd1 vccd1 sky130_ef_sc_hd__decap_12
XTAP_763 vssd1 vccd1 sky130_fd_sc_hd__tapvpwrvgnd_1
XTAP_774 vssd1 vccd1 sky130_fd_sc_hd__tapvpwrvgnd_1
XTAP_785 vssd1 vccd1 sky130_fd_sc_hd__tapvpwrvgnd_1
X_08754_ net823 _02739_ _02740_ _02737_ vssd1 vssd1 vccd1 vccd1 _02868_ sky130_fd_sc_hd__o2bb2a_1
XFILLER_0_31_3 vssd1 vssd1 vccd1 vccd1 sky130_ef_sc_hd__decap_12
XTAP_796 vssd1 vccd1 sky130_fd_sc_hd__tapvpwrvgnd_1
X_07705_ _01826_ _01827_ _01819_ vssd1 vssd1 vccd1 vccd1 _01828_ sky130_fd_sc_hd__a21o_1
XTAP_1907 vssd1 vccd1 sky130_fd_sc_hd__tapvpwrvgnd_1
X_08685_ _02797_ _02798_ _02654_ net460 vssd1 vssd1 vccd1 vccd1 _02800_ sky130_fd_sc_hd__a211o_1
XTAP_1929 vssd1 vccd1 sky130_fd_sc_hd__tapvpwrvgnd_1
XTAP_1918 vssd1 vccd1 sky130_fd_sc_hd__tapvpwrvgnd_1
XFILLER_0_95_549 vssd1 vssd1 vccd1 vccd1 sky130_fd_sc_hd__fill_2
X_07636_ _01757_ _01758_ _01759_ vssd1 vssd1 vccd1 vccd1 _01760_ sky130_fd_sc_hd__and3_1
X_07567_ net1096 net830 _01689_ _01690_ vssd1 vssd1 vccd1 vccd1 _01691_ sky130_fd_sc_hd__o2bb2a_1
X_06518_ det_t\[28\] net530 vssd1 vssd1 vccd1 vccd1 net272 sky130_fd_sc_hd__and2_1
XFILLER_0_91_711 vssd1 vssd1 vccd1 vccd1 sky130_ef_sc_hd__decap_12
X_09306_ _03260_ _03415_ vssd1 vssd1 vccd1 vccd1 _03417_ sky130_fd_sc_hd__xor2_4
XFILLER_0_75_273 vssd1 vssd1 vccd1 vccd1 sky130_fd_sc_hd__decap_6
XFILLER_0_0_93 vssd1 vssd1 vccd1 vccd1 sky130_fd_sc_hd__fill_2
XFILLER_0_90_210 vssd1 vssd1 vccd1 vccd1 sky130_fd_sc_hd__decap_8
X_09237_ net843 net988 net981 net852 vssd1 vssd1 vccd1 vccd1 _03348_ sky130_fd_sc_hd__a22o_1
XFILLER_0_17_841 vssd1 vssd1 vccd1 vccd1 sky130_fd_sc_hd__fill_1
X_07498_ net918 net1121 net1130 net910 vssd1 vssd1 vccd1 vccd1 _01623_ sky130_fd_sc_hd__a22o_1
X_06449_ _00747_ _00748_ vssd1 vssd1 vccd1 vccd1 _00749_ sky130_fd_sc_hd__xnor2_4
X_09168_ _03122_ _03278_ vssd1 vssd1 vccd1 vccd1 _03279_ sky130_fd_sc_hd__and2_2
XFILLER_0_32_811 vssd1 vssd1 vccd1 vccd1 sky130_fd_sc_hd__fill_1
XFILLER_0_121_529 vssd1 vssd1 vccd1 vccd1 sky130_ef_sc_hd__decap_12
XFILLER_0_114_581 vssd1 vssd1 vccd1 vccd1 sky130_fd_sc_hd__decap_6
X_08119_ net882 net1007 vssd1 vssd1 vccd1 vccd1 _02238_ sky130_fd_sc_hd__and2_1
X_09099_ net869 net974 net968 net877 vssd1 vssd1 vccd1 vccd1 _03211_ sky130_fd_sc_hd__a22o_1
XFILLER_0_101_231 vssd1 vssd1 vccd1 vccd1 sky130_fd_sc_hd__fill_1
X_11130_ _05225_ _05227_ net989 net735 vssd1 vssd1 vccd1 vccd1 _05228_ sky130_fd_sc_hd__and4b_1
XFILLER_0_31_387 vssd1 vssd1 vccd1 vccd1 sky130_fd_sc_hd__decap_4
X_11061_ _05033_ _05157_ _05158_ vssd1 vssd1 vccd1 vccd1 _05160_ sky130_fd_sc_hd__nand3_1
X_10012_ net1038 net1046 net745 vssd1 vssd1 vccd1 vccd1 _04118_ sky130_fd_sc_hd__and3_1
XFILLER_0_99_833 vssd1 vssd1 vccd1 vccd1 sky130_fd_sc_hd__fill_1
XFILLER_0_98_332 vssd1 vssd1 vccd1 vccd1 sky130_fd_sc_hd__decap_3
XFILLER_0_98_365 vssd1 vssd1 vccd1 vccd1 sky130_fd_sc_hd__decap_6
XFILLER_0_59_719 vssd1 vssd1 vccd1 vccd1 sky130_fd_sc_hd__fill_1
X_11963_ net8 net551 net625 net192 _05976_ vssd1 vssd1 vccd1 vccd1 _05977_ sky130_fd_sc_hd__a221o_1
XFILLER_0_25_39 vssd1 vssd1 vccd1 vccd1 sky130_ef_sc_hd__decap_12
X_10914_ _05013_ vssd1 vssd1 vccd1 vccd1 _05014_ sky130_fd_sc_hd__inv_2
X_11894_ net1327 _05924_ net483 vssd1 vssd1 vccd1 vccd1 _00217_ sky130_fd_sc_hd__mux2_1
X_10845_ _04766_ _04769_ _04944_ _04945_ vssd1 vssd1 vccd1 vccd1 _04946_ sky130_fd_sc_hd__o211a_1
XFILLER_0_67_741 vssd1 vssd1 vccd1 vccd1 sky130_fd_sc_hd__decap_8
XFILLER_0_39_432 vssd1 vssd1 vccd1 vccd1 sky130_fd_sc_hd__decap_4
XFILLER_0_128_128 vssd1 vssd1 vccd1 vccd1 sky130_fd_sc_hd__fill_2
XFILLER_0_26_104 vssd1 vssd1 vccd1 vccd1 sky130_fd_sc_hd__decap_6
XFILLER_0_109_364 vssd1 vssd1 vccd1 vccd1 sky130_fd_sc_hd__fill_1
XFILLER_0_66_284 vssd1 vssd1 vccd1 vccd1 sky130_fd_sc_hd__fill_1
X_10776_ _04685_ _04687_ _04875_ _04876_ vssd1 vssd1 vccd1 vccd1 _04877_ sky130_fd_sc_hd__a211o_1
XFILLER_0_54_446 vssd1 vssd1 vccd1 vccd1 sky130_fd_sc_hd__fill_2
XFILLER_0_39_498 vssd1 vssd1 vccd1 vccd1 sky130_fd_sc_hd__decap_6
X_12515_ _00689_ net563 _06254_ vssd1 vssd1 vccd1 vccd1 _00508_ sky130_fd_sc_hd__o21ai_1
XFILLER_0_124_312 vssd1 vssd1 vccd1 vccd1 sky130_fd_sc_hd__fill_2
X_12446_ net49 net687 _00897_ net614 vssd1 vssd1 vccd1 vccd1 _06216_ sky130_fd_sc_hd__a22o_1
XFILLER_0_124_389 vssd1 vssd1 vccd1 vccd1 sky130_ef_sc_hd__decap_12
X_12377_ net1419 _00810_ net682 vssd1 vssd1 vccd1 vccd1 _00429_ sky130_fd_sc_hd__mux2_1
X_11328_ _05406_ _05423_ _05424_ vssd1 vssd1 vccd1 vccd1 _05425_ sky130_fd_sc_hd__nor3_2
XFILLER_0_5_27 vssd1 vssd1 vccd1 vccd1 sky130_ef_sc_hd__decap_12
XFILLER_0_66_24 vssd1 vssd1 vccd1 vccd1 sky130_fd_sc_hd__decap_4
X_11259_ _05354_ _05355_ vssd1 vssd1 vccd1 vccd1 _05356_ sky130_fd_sc_hd__nand2b_1
XFILLER_0_89_332 vssd1 vssd1 vccd1 vccd1 sky130_fd_sc_hd__decap_4
XFILLER_0_106_41 vssd1 vssd1 vccd1 vccd1 sky130_ef_sc_hd__decap_12
X_08470_ _02443_ _02451_ _02450_ vssd1 vssd1 vccd1 vccd1 _02586_ sky130_fd_sc_hd__a21bo_1
XFILLER_0_89_387 vssd1 vssd1 vccd1 vccd1 sky130_fd_sc_hd__fill_1
XFILLER_0_82_78 vssd1 vssd1 vccd1 vccd1 sky130_fd_sc_hd__decap_3
XFILLER_0_106_85 vssd1 vssd1 vccd1 vccd1 sky130_ef_sc_hd__decap_12
X_07421_ _01540_ _01544_ _01545_ vssd1 vssd1 vccd1 vccd1 _01546_ sky130_fd_sc_hd__nor3_1
XFILLER_0_57_240 vssd1 vssd1 vccd1 vccd1 sky130_fd_sc_hd__fill_2
XFILLER_0_9_337 vssd1 vssd1 vccd1 vccd1 sky130_fd_sc_hd__fill_2
X_07352_ net880 net1119 vssd1 vssd1 vccd1 vccd1 _01477_ sky130_fd_sc_hd__nand2_1
XFILLER_0_128_673 vssd1 vssd1 vccd1 vccd1 sky130_fd_sc_hd__decap_8
XFILLER_0_45_424 vssd1 vssd1 vccd1 vccd1 sky130_fd_sc_hd__fill_2
X_06303_ state\[3\] state\[2\] vssd1 vssd1 vccd1 vccd1 _00616_ sky130_fd_sc_hd__nand2b_4
XFILLER_0_128_684 vssd1 vssd1 vccd1 vccd1 sky130_fd_sc_hd__fill_1
XFILLER_0_72_265 vssd1 vssd1 vccd1 vccd1 sky130_ef_sc_hd__decap_12
X_07283_ _01321_ _01322_ _01309_ _01315_ vssd1 vssd1 vccd1 vccd1 _01408_ sky130_fd_sc_hd__o211a_1
X_09022_ _03125_ _03133_ vssd1 vssd1 vccd1 vccd1 _03134_ sky130_fd_sc_hd__nand2_1
XFILLER_0_60_416 vssd1 vssd1 vccd1 vccd1 sky130_fd_sc_hd__decap_4
XFILLER_0_32_129 vssd1 vssd1 vccd1 vccd1 sky130_fd_sc_hd__decap_8
Xhold211 l0\[22\] vssd1 vssd1 vccd1 vccd1 net1426 sky130_fd_sc_hd__dlygate4sd3_1
Xhold200 l1\[27\] vssd1 vssd1 vccd1 vccd1 net1415 sky130_fd_sc_hd__dlygate4sd3_1
Xhold233 l0\[28\] vssd1 vssd1 vccd1 vccd1 net1448 sky130_fd_sc_hd__dlygate4sd3_1
Xhold222 _00095_ vssd1 vssd1 vccd1 vccd1 net1437 sky130_fd_sc_hd__dlygate4sd3_1
Xhold244 _00082_ vssd1 vssd1 vccd1 vccd1 net1459 sky130_fd_sc_hd__dlygate4sd3_1
XFILLER_0_111_573 vssd1 vssd1 vccd1 vccd1 sky130_ef_sc_hd__decap_12
Xhold255 l0\[31\] vssd1 vssd1 vccd1 vccd1 net1470 sky130_fd_sc_hd__dlygate4sd3_1
Xhold266 l0\[0\] vssd1 vssd1 vccd1 vccd1 net1481 sky130_fd_sc_hd__dlygate4sd3_1
Xhold277 net397 vssd1 vssd1 vccd1 vccd1 net1492 sky130_fd_sc_hd__dlygate4sd3_1
Xhold288 net348 vssd1 vssd1 vccd1 vccd1 net1503 sky130_fd_sc_hd__dlygate4sd3_1
Xfanout724 net725 vssd1 vssd1 vccd1 vccd1 net724 sky130_fd_sc_hd__buf_4
X_09924_ _04025_ _04029_ _04030_ vssd1 vssd1 vccd1 vccd1 _04031_ sky130_fd_sc_hd__nand3_1
Xhold299 _00050_ vssd1 vssd1 vccd1 vccd1 net1514 sky130_fd_sc_hd__dlygate4sd3_1
Xfanout702 net706 vssd1 vssd1 vccd1 vccd1 net702 sky130_fd_sc_hd__clkbuf_4
Xfanout713 mul1.b\[27\] vssd1 vssd1 vccd1 vccd1 net713 sky130_fd_sc_hd__dlymetal6s2s_1
X_09855_ net1021 net1028 net778 net768 vssd1 vssd1 vccd1 vccd1 _03962_ sky130_fd_sc_hd__nand4_1
Xfanout746 net747 vssd1 vssd1 vccd1 vccd1 net746 sky130_fd_sc_hd__clkbuf_4
XTAP_560 vssd1 vccd1 sky130_fd_sc_hd__tapvpwrvgnd_1
Xfanout757 net758 vssd1 vssd1 vccd1 vccd1 net757 sky130_fd_sc_hd__clkbuf_4
Xfanout735 net736 vssd1 vssd1 vccd1 vccd1 net735 sky130_fd_sc_hd__clkbuf_4
Xfanout768 net769 vssd1 vssd1 vccd1 vccd1 net768 sky130_fd_sc_hd__dlymetal6s2s_1
Xfanout779 net780 vssd1 vssd1 vccd1 vccd1 net779 sky130_fd_sc_hd__buf_2
X_08806_ net903 net894 net968 vssd1 vssd1 vccd1 vccd1 _02920_ sky130_fd_sc_hd__and3_1
XTAP_582 vssd1 vccd1 sky130_fd_sc_hd__tapvpwrvgnd_1
XTAP_571 vssd1 vccd1 sky130_fd_sc_hd__tapvpwrvgnd_1
XTAP_593 vssd1 vccd1 sky130_fd_sc_hd__tapvpwrvgnd_1
X_09786_ _03891_ _03892_ vssd1 vssd1 vccd1 vccd1 _03894_ sky130_fd_sc_hd__xnor2_4
X_06998_ _01092_ _01093_ _01094_ vssd1 vssd1 vccd1 vccd1 _01123_ sky130_fd_sc_hd__o21ba_1
X_08737_ net1099 net749 net741 net1107 vssd1 vssd1 vccd1 vccd1 _02851_ sky130_fd_sc_hd__a22o_1
XTAP_1715 vssd1 vccd1 sky130_fd_sc_hd__tapvpwrvgnd_1
XTAP_1704 vssd1 vccd1 sky130_fd_sc_hd__tapvpwrvgnd_1
X_08668_ _02632_ _02640_ _02639_ vssd1 vssd1 vccd1 vccd1 _02783_ sky130_fd_sc_hd__a21bo_1
XTAP_1748 vssd1 vccd1 sky130_fd_sc_hd__tapvpwrvgnd_1
XTAP_1737 vssd1 vccd1 sky130_fd_sc_hd__tapvpwrvgnd_1
XTAP_1726 vssd1 vccd1 sky130_fd_sc_hd__tapvpwrvgnd_1
XFILLER_0_95_335 vssd1 vssd1 vccd1 vccd1 sky130_fd_sc_hd__fill_1
X_07619_ _01390_ _01393_ _01740_ net497 vssd1 vssd1 vccd1 vccd1 _01743_ sky130_fd_sc_hd__a211oi_2
X_08599_ _02704_ _02713_ vssd1 vssd1 vccd1 vccd1 _02714_ sky130_fd_sc_hd__xnor2_1
XTAP_1759 vssd1 vccd1 sky130_fd_sc_hd__tapvpwrvgnd_1
X_10630_ _04730_ _04731_ vssd1 vssd1 vccd1 vccd1 _04732_ sky130_fd_sc_hd__or2_1
XFILLER_0_48_251 vssd1 vssd1 vccd1 vccd1 sky130_fd_sc_hd__fill_1
XFILLER_0_119_673 vssd1 vssd1 vccd1 vccd1 sky130_ef_sc_hd__decap_12
XFILLER_0_64_744 vssd1 vssd1 vccd1 vccd1 sky130_fd_sc_hd__decap_4
XFILLER_0_63_221 vssd1 vssd1 vccd1 vccd1 sky130_fd_sc_hd__decap_3
X_10561_ _04662_ _04663_ vssd1 vssd1 vccd1 vccd1 _04664_ sky130_fd_sc_hd__or2_2
XFILLER_0_122_805 vssd1 vssd1 vccd1 vccd1 sky130_fd_sc_hd__decap_6
X_10492_ _04591_ _04592_ _04593_ vssd1 vssd1 vccd1 vccd1 _04595_ sky130_fd_sc_hd__nand3_1
X_12300_ net1617 _00908_ net678 vssd1 vssd1 vccd1 vccd1 _00352_ sky130_fd_sc_hd__mux2_1
XFILLER_0_51_449 vssd1 vssd1 vccd1 vccd1 sky130_fd_sc_hd__decap_8
X_12231_ x2mx1\[22\] net606 net589 temp1\[22\] vssd1 vssd1 vccd1 vccd1 _06174_ sky130_fd_sc_hd__a22o_1
XFILLER_0_121_337 vssd1 vssd1 vccd1 vccd1 sky130_ef_sc_hd__decap_12
XFILLER_0_32_685 vssd1 vssd1 vccd1 vccd1 sky130_fd_sc_hd__decap_4
XFILLER_0_102_551 vssd1 vssd1 vccd1 vccd1 sky130_fd_sc_hd__fill_1
X_12162_ _00973_ _06127_ net501 vssd1 vssd1 vccd1 vccd1 _06128_ sky130_fd_sc_hd__mux2_1
XFILLER_0_102_595 vssd1 vssd1 vccd1 vccd1 sky130_fd_sc_hd__fill_1
XFILLER_0_102_584 vssd1 vssd1 vccd1 vccd1 sky130_fd_sc_hd__decap_4
X_12093_ y2my0\[14\] net585 net532 x2mx1\[14\] _06075_ vssd1 vssd1 vccd1 vccd1 _06076_
+ sky130_fd_sc_hd__a221o_1
X_11113_ net816 net930 net928 net824 vssd1 vssd1 vccd1 vccd1 _05211_ sky130_fd_sc_hd__a22o_1
X_11044_ net1030 net1036 net713 net709 vssd1 vssd1 vccd1 vccd1 _05143_ sky130_fd_sc_hd__and4_1
XFILLER_0_36_27 vssd1 vssd1 vccd1 vccd1 sky130_fd_sc_hd__fill_1
XFILLER_0_99_630 vssd1 vssd1 vccd1 vccd1 sky130_fd_sc_hd__decap_6
X_12995_ clknet_leaf_46_clk_i _00381_ net1163 vssd1 vssd1 vccd1 vccd1 x2mx1\[16\]
+ sky130_fd_sc_hd__dfrtp_1
XFILLER_0_99_685 vssd1 vssd1 vccd1 vccd1 sky130_fd_sc_hd__fill_2
X_11946_ net92 net621 net595 net60 vssd1 vssd1 vccd1 vccd1 _05964_ sky130_fd_sc_hd__a22o_1
X_11877_ net78 net679 net609 net206 vssd1 vssd1 vccd1 vccd1 _05910_ sky130_fd_sc_hd__a22o_1
XFILLER_0_116_109 vssd1 vssd1 vccd1 vccd1 sky130_ef_sc_hd__decap_12
X_10828_ _04778_ _04780_ _04925_ _04927_ vssd1 vssd1 vccd1 vccd1 _04929_ sky130_fd_sc_hd__a211o_1
XFILLER_0_6_307 vssd1 vssd1 vccd1 vccd1 sky130_fd_sc_hd__fill_1
XFILLER_0_109_161 vssd1 vssd1 vccd1 vccd1 sky130_fd_sc_hd__decap_6
X_10759_ _04858_ _04859_ vssd1 vssd1 vccd1 vccd1 _04860_ sky130_fd_sc_hd__nand2_1
XFILLER_0_27_446 vssd1 vssd1 vccd1 vccd1 sky130_fd_sc_hd__fill_2
XFILLER_0_125_665 vssd1 vssd1 vccd1 vccd1 sky130_fd_sc_hd__decap_6
XFILLER_0_42_405 vssd1 vssd1 vccd1 vccd1 sky130_fd_sc_hd__decap_4
XFILLER_0_42_427 vssd1 vssd1 vccd1 vccd1 sky130_fd_sc_hd__decap_4
XFILLER_0_124_153 vssd1 vssd1 vccd1 vccd1 sky130_ef_sc_hd__decap_12
Xoutput305 net305 vssd1 vssd1 vccd1 vccd1 div_mstream_o[72] sky130_fd_sc_hd__clkbuf_4
Xoutput316 net316 vssd1 vssd1 vccd1 vccd1 div_mstream_o[82] sky130_fd_sc_hd__clkbuf_4
X_12429_ _00855_ net613 _02672_ net574 vssd1 vssd1 vccd1 vccd1 _06207_ sky130_fd_sc_hd__a22o_1
Xoutput327 net327 vssd1 vssd1 vccd1 vccd1 div_mstream_o[92] sky130_fd_sc_hd__clkbuf_4
Xoutput349 net349 vssd1 vssd1 vccd1 vccd1 mstream_o[112] sky130_fd_sc_hd__clkbuf_4
Xoutput338 net338 vssd1 vssd1 vccd1 vccd1 mstream_o[102] sky130_fd_sc_hd__clkbuf_4
XFILLER_0_22_195 vssd1 vssd1 vccd1 vccd1 sky130_fd_sc_hd__fill_1
X_07970_ _02075_ _02088_ vssd1 vssd1 vccd1 vccd1 _02090_ sky130_fd_sc_hd__and2_1
X_06921_ _01042_ _01045_ vssd1 vssd1 vccd1 vccd1 _01046_ sky130_fd_sc_hd__or2_1
XFILLER_0_93_55 vssd1 vssd1 vccd1 vccd1 sky130_fd_sc_hd__fill_1
X_09640_ _03588_ _03748_ vssd1 vssd1 vccd1 vccd1 _03749_ sky130_fd_sc_hd__xor2_2
X_06852_ _00982_ vssd1 vssd1 vccd1 vccd1 _00983_ sky130_fd_sc_hd__inv_2
XFILLER_0_117_51 vssd1 vssd1 vccd1 vccd1 sky130_fd_sc_hd__decap_4
XFILLER_0_93_77 vssd1 vssd1 vccd1 vccd1 sky130_fd_sc_hd__decap_3
X_09571_ net850 net841 net977 mul1.a\[23\] vssd1 vssd1 vccd1 vccd1 _03680_ sky130_fd_sc_hd__nand4_1
X_06783_ net399 net1220 net639 vssd1 vssd1 vccd1 vccd1 _00057_ sky130_fd_sc_hd__mux2_1
X_08522_ _02502_ _02503_ _02504_ vssd1 vssd1 vccd1 vccd1 _02638_ sky130_fd_sc_hd__a21bo_1
X_08453_ net1107 net755 _02566_ _02567_ vssd1 vssd1 vccd1 vccd1 _02569_ sky130_fd_sc_hd__nand4_1
XFILLER_0_89_195 vssd1 vssd1 vccd1 vccd1 sky130_fd_sc_hd__decap_8
XFILLER_0_89_184 vssd1 vssd1 vccd1 vccd1 sky130_fd_sc_hd__decap_6
XFILLER_0_77_346 vssd1 vssd1 vccd1 vccd1 sky130_fd_sc_hd__decap_8
XFILLER_0_77_379 vssd1 vssd1 vccd1 vccd1 sky130_fd_sc_hd__decap_6
XFILLER_0_9_134 vssd1 vssd1 vccd1 vccd1 sky130_fd_sc_hd__decap_8
X_07404_ _01526_ _01527_ _01521_ vssd1 vssd1 vccd1 vccd1 _01529_ sky130_fd_sc_hd__a21bo_1
X_08384_ _02497_ _02500_ vssd1 vssd1 vccd1 vccd1 _02501_ sky130_fd_sc_hd__xnor2_2
XFILLER_0_9_178 vssd1 vssd1 vccd1 vccd1 sky130_fd_sc_hd__fill_1
X_07335_ _01273_ _01457_ _01459_ vssd1 vssd1 vccd1 vccd1 _01460_ sky130_fd_sc_hd__nor3_1
XFILLER_0_116_643 vssd1 vssd1 vccd1 vccd1 sky130_fd_sc_hd__fill_1
XFILLER_0_73_585 vssd1 vssd1 vccd1 vccd1 sky130_fd_sc_hd__decap_3
X_07266_ _01387_ _01388_ _01219_ _01230_ vssd1 vssd1 vccd1 vccd1 _01391_ sky130_fd_sc_hd__o211ai_1
X_09005_ net1133 net1141 net716 net707 vssd1 vssd1 vccd1 vccd1 _03117_ sky130_fd_sc_hd__and4_1
XFILLER_0_5_373 vssd1 vssd1 vccd1 vccd1 sky130_fd_sc_hd__fill_2
XFILLER_0_5_351 vssd1 vssd1 vccd1 vccd1 sky130_fd_sc_hd__fill_1
XFILLER_0_103_337 vssd1 vssd1 vccd1 vccd1 sky130_ef_sc_hd__decap_12
X_07197_ _01140_ _01320_ _01319_ _01306_ vssd1 vssd1 vccd1 vccd1 _01322_ sky130_fd_sc_hd__o211a_1
XFILLER_0_130_145 vssd1 vssd1 vccd1 vccd1 sky130_fd_sc_hd__fill_1
X_09907_ net868 net945 net940 net879 vssd1 vssd1 vccd1 vccd1 _04014_ sky130_fd_sc_hd__a22o_1
Xfanout510 net512 vssd1 vssd1 vccd1 vccd1 net510 sky130_fd_sc_hd__clkbuf_4
Xfanout532 net533 vssd1 vssd1 vccd1 vccd1 net532 sky130_fd_sc_hd__clkbuf_2
Xfanout565 net567 vssd1 vssd1 vccd1 vccd1 net565 sky130_fd_sc_hd__buf_2
Xfanout554 net557 vssd1 vssd1 vccd1 vccd1 net554 sky130_fd_sc_hd__clkbuf_4
Xfanout543 _01015_ vssd1 vssd1 vccd1 vccd1 net543 sky130_fd_sc_hd__clkbuf_4
X_09838_ _03929_ _03944_ vssd1 vssd1 vccd1 vccd1 _03945_ sky130_fd_sc_hd__xnor2_4
XTAP_390 vssd1 vccd1 sky130_fd_sc_hd__tapvpwrvgnd_1
Xfanout598 _01003_ vssd1 vssd1 vccd1 vccd1 net598 sky130_fd_sc_hd__clkbuf_4
Xfanout587 net588 vssd1 vssd1 vccd1 vccd1 net587 sky130_fd_sc_hd__clkbuf_4
Xfanout576 net577 vssd1 vssd1 vccd1 vccd1 net576 sky130_fd_sc_hd__clkbuf_4
X_09769_ _03875_ _03876_ vssd1 vssd1 vccd1 vccd1 _03877_ sky130_fd_sc_hd__nand2b_1
XTAP_2235 vssd1 vccd1 sky130_fd_sc_hd__tapvpwrvgnd_1
XTAP_2224 vssd1 vccd1 sky130_fd_sc_hd__tapvpwrvgnd_1
XTAP_2213 vssd1 vccd1 sky130_fd_sc_hd__tapvpwrvgnd_1
XTAP_2202 vssd1 vccd1 sky130_fd_sc_hd__tapvpwrvgnd_1
XFILLER_0_96_611 vssd1 vssd1 vccd1 vccd1 sky130_fd_sc_hd__decap_8
XFILLER_0_69_836 vssd1 vssd1 vccd1 vccd1 sky130_fd_sc_hd__decap_4
X_11800_ net652 _00892_ net475 _05844_ vssd1 vssd1 vccd1 vccd1 _05845_ sky130_fd_sc_hd__a211o_1
XTAP_2246 vssd1 vccd1 sky130_fd_sc_hd__tapvpwrvgnd_1
XTAP_1523 vssd1 vccd1 sky130_fd_sc_hd__tapvpwrvgnd_1
XTAP_1512 vssd1 vccd1 sky130_fd_sc_hd__tapvpwrvgnd_1
XTAP_1501 vssd1 vccd1 sky130_fd_sc_hd__tapvpwrvgnd_1
X_12780_ clknet_leaf_1_clk_i _00166_ vssd1 vssd1 vccd1 vccd1 add1.b_i\[11\] sky130_fd_sc_hd__dfxtp_1
XPHY_30 vssd1 vssd1 vccd1 vccd1 sky130_fd_sc_hd__decap_3
XTAP_1556 vssd1 vccd1 sky130_fd_sc_hd__tapvpwrvgnd_1
XTAP_1567 vssd1 vccd1 sky130_fd_sc_hd__tapvpwrvgnd_1
XTAP_1545 vssd1 vccd1 sky130_fd_sc_hd__tapvpwrvgnd_1
XTAP_1534 vssd1 vccd1 sky130_fd_sc_hd__tapvpwrvgnd_1
X_11731_ net1564 _05787_ net477 vssd1 vssd1 vccd1 vccd1 _00191_ sky130_fd_sc_hd__mux2_1
XPHY_41 vssd1 vssd1 vccd1 vccd1 sky130_fd_sc_hd__decap_3
XPHY_52 vssd1 vssd1 vccd1 vccd1 sky130_fd_sc_hd__decap_3
XPHY_63 vssd1 vssd1 vccd1 vccd1 sky130_fd_sc_hd__decap_3
XPHY_74 vssd1 vssd1 vccd1 vccd1 sky130_fd_sc_hd__decap_3
XTAP_1589 vssd1 vccd1 sky130_fd_sc_hd__tapvpwrvgnd_1
XTAP_1578 vssd1 vccd1 sky130_fd_sc_hd__tapvpwrvgnd_1
XFILLER_0_83_349 vssd1 vssd1 vccd1 vccd1 sky130_fd_sc_hd__decap_4
XPHY_96 vssd1 vssd1 vccd1 vccd1 sky130_fd_sc_hd__decap_3
X_11662_ _00974_ _00991_ net605 net587 net1168 vssd1 vssd1 vccd1 vccd1 _05755_ sky130_fd_sc_hd__o41a_1
XFILLER_0_22_29 vssd1 vssd1 vccd1 vccd1 sky130_ef_sc_hd__decap_12
XPHY_85 vssd1 vssd1 vccd1 vccd1 sky130_fd_sc_hd__decap_3
XFILLER_0_107_610 vssd1 vssd1 vccd1 vccd1 sky130_fd_sc_hd__decap_6
X_10613_ net779 net769 net992 net985 vssd1 vssd1 vccd1 vccd1 _04715_ sky130_fd_sc_hd__and4_1
X_11593_ _05620_ _05621_ _05622_ _05618_ vssd1 vssd1 vccd1 vccd1 _05687_ sky130_fd_sc_hd__a31o_1
XFILLER_0_107_665 vssd1 vssd1 vccd1 vccd1 sky130_fd_sc_hd__decap_6
X_10544_ _04627_ _04644_ _04645_ vssd1 vssd1 vccd1 vccd1 _04647_ sky130_fd_sc_hd__nor3_1
XFILLER_0_24_427 vssd1 vssd1 vccd1 vccd1 sky130_fd_sc_hd__fill_2
XFILLER_0_122_613 vssd1 vssd1 vccd1 vccd1 sky130_ef_sc_hd__decap_12
XFILLER_0_106_153 vssd1 vssd1 vccd1 vccd1 sky130_ef_sc_hd__decap_12
XFILLER_0_122_657 vssd1 vssd1 vccd1 vccd1 sky130_ef_sc_hd__decap_12
X_10475_ _04574_ _04575_ _04576_ vssd1 vssd1 vccd1 vccd1 _04578_ sky130_fd_sc_hd__a21o_1
XFILLER_0_121_167 vssd1 vssd1 vccd1 vccd1 sky130_fd_sc_hd__fill_1
X_13194_ clknet_leaf_20_clk_i _00580_ net1179 vssd1 vssd1 vccd1 vccd1 l1\[23\] sky130_fd_sc_hd__dfrtp_1
X_12214_ _00892_ net510 net467 y1my2\[16\] _06162_ vssd1 vssd1 vccd1 vccd1 _06163_
+ sky130_fd_sc_hd__a221o_1
XFILLER_0_102_370 vssd1 vssd1 vccd1 vccd1 sky130_fd_sc_hd__decap_3
X_12145_ y2my0\[27\] net587 net534 x2mx1\[27\] _06114_ vssd1 vssd1 vccd1 vccd1 _06115_
+ sky130_fd_sc_hd__a221o_1
XFILLER_0_47_15 vssd1 vssd1 vccd1 vccd1 sky130_ef_sc_hd__decap_12
X_12076_ x0mx2\[10\] net629 net590 y1my2\[10\] vssd1 vssd1 vccd1 vccd1 _06063_ sky130_fd_sc_hd__a22o_1
X_11027_ _05119_ _05124_ vssd1 vssd1 vccd1 vccd1 _05126_ sky130_fd_sc_hd__xor2_1
XFILLER_0_99_471 vssd1 vssd1 vccd1 vccd1 sky130_fd_sc_hd__fill_1
X_12978_ clknet_leaf_30_clk_i _00364_ net1168 vssd1 vssd1 vccd1 vccd1 y1my2\[31\]
+ sky130_fd_sc_hd__dfrtp_1
X_11929_ net1332 _05951_ net478 vssd1 vssd1 vccd1 vccd1 _00225_ sky130_fd_sc_hd__mux2_1
XFILLER_0_117_429 vssd1 vssd1 vccd1 vccd1 sky130_ef_sc_hd__decap_12
XANTENNA_39 net53 vssd1 vssd1 vccd1 vccd1 sky130_fd_sc_hd__diode_2
XANTENNA_28 v2y[26] vssd1 vssd1 vccd1 vccd1 sky130_fd_sc_hd__diode_2
XANTENNA_17 v0y[8] vssd1 vssd1 vccd1 vccd1 sky130_fd_sc_hd__diode_2
X_07120_ net806 net1137 _01242_ _01244_ vssd1 vssd1 vccd1 vccd1 _01245_ sky130_fd_sc_hd__and4_1
XFILLER_0_125_473 vssd1 vssd1 vccd1 vccd1 sky130_ef_sc_hd__decap_12
XFILLER_0_70_555 vssd1 vssd1 vccd1 vccd1 sky130_fd_sc_hd__fill_1
XFILLER_0_70_533 vssd1 vssd1 vccd1 vccd1 sky130_fd_sc_hd__decap_4
XFILLER_0_3_833 vssd1 vssd1 vccd1 vccd1 sky130_fd_sc_hd__fill_1
XFILLER_0_30_419 vssd1 vssd1 vccd1 vccd1 sky130_fd_sc_hd__fill_1
X_07051_ net846 net1103 net1113 net837 vssd1 vssd1 vccd1 vccd1 _01176_ sky130_fd_sc_hd__a22oi_1
XFILLER_0_88_77 vssd1 vssd1 vccd1 vccd1 sky130_fd_sc_hd__decap_6
XFILLER_0_2_365 vssd1 vssd1 vccd1 vccd1 sky130_fd_sc_hd__fill_2
XFILLER_0_112_189 vssd1 vssd1 vccd1 vccd1 sky130_fd_sc_hd__decap_6
XFILLER_0_10_132 vssd1 vssd1 vccd1 vccd1 sky130_fd_sc_hd__decap_8
XFILLER_0_11_677 vssd1 vssd1 vccd1 vccd1 sky130_fd_sc_hd__fill_1
XFILLER_0_10_165 vssd1 vssd1 vccd1 vccd1 sky130_ef_sc_hd__decap_12
X_07953_ _02070_ _02071_ vssd1 vssd1 vccd1 vccd1 _02073_ sky130_fd_sc_hd__xnor2_1
X_07884_ _02001_ _02002_ _01985_ vssd1 vssd1 vccd1 vccd1 _02005_ sky130_fd_sc_hd__a21oi_1
X_06904_ _01023_ _01028_ vssd1 vssd1 vccd1 vccd1 _01029_ sky130_fd_sc_hd__nand2_1
XFILLER_0_128_83 vssd1 vssd1 vccd1 vccd1 sky130_fd_sc_hd__fill_1
X_06835_ net1480 net1462 net646 vssd1 vssd1 vccd1 vccd1 _00109_ sky130_fd_sc_hd__mux2_1
X_09623_ _03560_ _03562_ _03730_ _03731_ vssd1 vssd1 vccd1 vccd1 _03732_ sky130_fd_sc_hd__a211oi_1
XFILLER_0_37_92 vssd1 vssd1 vccd1 vccd1 sky130_fd_sc_hd__fill_2
X_09554_ _03660_ _03661_ _03662_ vssd1 vssd1 vccd1 vccd1 _03663_ sky130_fd_sc_hd__nand3_1
X_06766_ net1538 net1522 net637 vssd1 vssd1 vccd1 vccd1 _00040_ sky130_fd_sc_hd__mux2_1
X_09485_ _03592_ _03593_ vssd1 vssd1 vccd1 vccd1 _03594_ sky130_fd_sc_hd__nor2_1
XFILLER_0_77_154 vssd1 vssd1 vccd1 vccd1 sky130_fd_sc_hd__fill_1
XFILLER_0_77_143 vssd1 vssd1 vccd1 vccd1 sky130_fd_sc_hd__fill_1
X_08505_ net858 net1007 _02619_ _02620_ vssd1 vssd1 vccd1 vccd1 _02621_ sky130_fd_sc_hd__o2bb2a_1
X_06697_ sub1.b_i\[22\] sub1.a_i\[22\] vssd1 vssd1 vccd1 vccd1 _00920_ sky130_fd_sc_hd__nand2b_1
X_08436_ _02547_ _02550_ vssd1 vssd1 vccd1 vccd1 _02552_ sky130_fd_sc_hd__xnor2_1
XFILLER_0_92_102 vssd1 vssd1 vccd1 vccd1 sky130_ef_sc_hd__decap_12
XFILLER_0_77_187 vssd1 vssd1 vccd1 vccd1 sky130_ef_sc_hd__decap_12
X_08367_ _02464_ _02481_ _02482_ vssd1 vssd1 vccd1 vccd1 _02484_ sky130_fd_sc_hd__nand3_1
XFILLER_0_46_541 vssd1 vssd1 vccd1 vccd1 sky130_fd_sc_hd__fill_2
XFILLER_0_46_530 vssd1 vssd1 vccd1 vccd1 sky130_fd_sc_hd__fill_2
X_07318_ _01312_ _01313_ vssd1 vssd1 vccd1 vccd1 _01443_ sky130_fd_sc_hd__nor2_1
X_08298_ _02411_ _02414_ vssd1 vssd1 vccd1 vccd1 _02415_ sky130_fd_sc_hd__and2_2
XFILLER_0_61_522 vssd1 vssd1 vccd1 vccd1 sky130_fd_sc_hd__decap_8
XFILLER_0_104_635 vssd1 vssd1 vccd1 vccd1 sky130_fd_sc_hd__decap_8
X_07249_ net906 net1032 vssd1 vssd1 vccd1 vccd1 _01374_ sky130_fd_sc_hd__and2_1
XFILLER_0_33_279 vssd1 vssd1 vccd1 vccd1 sky130_fd_sc_hd__fill_1
XFILLER_0_104_657 vssd1 vssd1 vccd1 vccd1 sky130_ef_sc_hd__decap_12
X_10260_ _04364_ _04363_ vssd1 vssd1 vccd1 vccd1 _04365_ sky130_fd_sc_hd__nand2b_1
XFILLER_0_103_167 vssd1 vssd1 vccd1 vccd1 sky130_fd_sc_hd__fill_1
X_10191_ _04294_ _04295_ _04287_ vssd1 vssd1 vccd1 vccd1 _04296_ sky130_fd_sc_hd__a21o_1
X_12901_ clknet_leaf_52_clk_i _00287_ vssd1 vssd1 vccd1 vccd1 mul1.b\[4\] sky130_fd_sc_hd__dfxtp_1
XTAP_2010 vssd1 vccd1 sky130_fd_sc_hd__tapvpwrvgnd_1
XFILLER_0_124_19 vssd1 vssd1 vccd1 vccd1 sky130_fd_sc_hd__decap_8
XTAP_2043 vssd1 vccd1 sky130_fd_sc_hd__tapvpwrvgnd_1
XTAP_2032 vssd1 vccd1 sky130_fd_sc_hd__tapvpwrvgnd_1
XTAP_2021 vssd1 vccd1 sky130_fd_sc_hd__tapvpwrvgnd_1
XFILLER_0_69_633 vssd1 vssd1 vccd1 vccd1 sky130_fd_sc_hd__decap_3
X_12832_ clknet_leaf_28_clk_i _00218_ vssd1 vssd1 vccd1 vccd1 sub1.a_i\[31\] sky130_fd_sc_hd__dfxtp_1
XTAP_2076 vssd1 vccd1 sky130_fd_sc_hd__tapvpwrvgnd_1
XTAP_2054 vssd1 vccd1 sky130_fd_sc_hd__tapvpwrvgnd_1
XTAP_2065 vssd1 vccd1 sky130_fd_sc_hd__tapvpwrvgnd_1
XFILLER_0_84_614 vssd1 vssd1 vccd1 vccd1 sky130_fd_sc_hd__fill_2
XTAP_1331 vssd1 vccd1 sky130_fd_sc_hd__tapvpwrvgnd_1
XFILLER_0_69_677 vssd1 vssd1 vccd1 vccd1 sky130_fd_sc_hd__fill_1
XTAP_1320 vssd1 vccd1 sky130_fd_sc_hd__tapvpwrvgnd_1
X_12763_ clknet_leaf_24_clk_i _00149_ vssd1 vssd1 vccd1 vccd1 add1.a_i\[26\] sky130_fd_sc_hd__dfxtp_1
XTAP_2098 vssd1 vccd1 sky130_fd_sc_hd__tapvpwrvgnd_1
XTAP_2087 vssd1 vccd1 sky130_fd_sc_hd__tapvpwrvgnd_1
XTAP_1364 vssd1 vccd1 sky130_fd_sc_hd__tapvpwrvgnd_1
XTAP_1375 vssd1 vccd1 sky130_fd_sc_hd__tapvpwrvgnd_1
XTAP_1353 vssd1 vccd1 sky130_fd_sc_hd__tapvpwrvgnd_1
XTAP_1342 vssd1 vccd1 sky130_fd_sc_hd__tapvpwrvgnd_1
X_11714_ net1697 _05773_ net477 vssd1 vssd1 vccd1 vccd1 _00188_ sky130_fd_sc_hd__mux2_1
X_12694_ clknet_leaf_13_clk_i _00080_ net1186 vssd1 vssd1 vccd1 vccd1 net424 sky130_fd_sc_hd__dfrtp_1
XTAP_1397 vssd1 vccd1 sky130_fd_sc_hd__tapvpwrvgnd_1
XTAP_1386 vssd1 vccd1 sky130_fd_sc_hd__tapvpwrvgnd_1
XFILLER_0_56_349 vssd1 vssd1 vccd1 vccd1 sky130_fd_sc_hd__fill_1
XFILLER_0_25_725 vssd1 vssd1 vccd1 vccd1 sky130_fd_sc_hd__decap_3
X_11645_ net735 net963 vssd1 vssd1 vccd1 vccd1 _05739_ sky130_fd_sc_hd__nand2_1
XFILLER_0_37_585 vssd1 vssd1 vccd1 vccd1 sky130_fd_sc_hd__fill_1
Xinput37 run_i vssd1 vssd1 vccd1 vccd1 net37 sky130_fd_sc_hd__buf_2
Xinput26 div_sstream_i[31] vssd1 vssd1 vccd1 vccd1 net26 sky130_fd_sc_hd__buf_4
Xinput15 div_sstream_i[21] vssd1 vssd1 vccd1 vccd1 net15 sky130_fd_sc_hd__buf_4
X_11576_ _05669_ _05670_ vssd1 vssd1 vccd1 vccd1 _05671_ sky130_fd_sc_hd__xnor2_1
Xclkbuf_leaf_4_clk_i clknet_3_2__leaf_clk_i vssd1 vssd1 vccd1 vccd1 clknet_leaf_4_clk_i
+ sky130_fd_sc_hd__clkbuf_16
Xinput48 sstream_i[19] vssd1 vssd1 vccd1 vccd1 net48 sky130_fd_sc_hd__buf_2
XFILLER_0_122_421 vssd1 vssd1 vccd1 vccd1 sky130_ef_sc_hd__decap_12
X_10527_ net1037 net737 _04470_ _04471_ net753 vssd1 vssd1 vccd1 vccd1 _04630_ sky130_fd_sc_hd__a32o_1
Xinput59 v0x[10] vssd1 vssd1 vccd1 vccd1 net59 sky130_fd_sc_hd__buf_1
X_10458_ _04559_ _04560_ _04457_ _04460_ vssd1 vssd1 vccd1 vccd1 _04561_ sky130_fd_sc_hd__o211a_1
XFILLER_0_58_25 vssd1 vssd1 vccd1 vccd1 sky130_fd_sc_hd__decap_3
X_10389_ _04491_ _04492_ _04484_ vssd1 vssd1 vccd1 vccd1 _04493_ sky130_fd_sc_hd__a21o_1
X_13177_ clknet_leaf_21_clk_i _00563_ net1176 vssd1 vssd1 vccd1 vccd1 l1\[6\] sky130_fd_sc_hd__dfrtp_1
X_12128_ x0mx2\[23\] net632 net592 y1my2\[23\] vssd1 vssd1 vccd1 vccd1 _06102_ sky130_fd_sc_hd__a22o_1
X_12059_ net1110 _06050_ net513 vssd1 vssd1 vccd1 vccd1 _00256_ sky130_fd_sc_hd__mux2_1
X_06620_ net1714 _00855_ net634 vssd1 vssd1 vccd1 vccd1 _00012_ sky130_fd_sc_hd__mux2_1
X_06551_ net545 _00799_ vssd1 vssd1 vccd1 vccd1 net309 sky130_fd_sc_hd__nor2_1
XFILLER_0_114_41 vssd1 vssd1 vccd1 vccd1 sky130_ef_sc_hd__decap_12
X_09270_ _03379_ _03380_ _03378_ vssd1 vssd1 vccd1 vccd1 _03381_ sky130_fd_sc_hd__a21o_1
X_06482_ _00775_ _00776_ vssd1 vssd1 vccd1 vccd1 _00777_ sky130_fd_sc_hd__nand2_2
XFILLER_0_118_749 vssd1 vssd1 vccd1 vccd1 sky130_fd_sc_hd__decap_6
XFILLER_0_114_85 vssd1 vssd1 vccd1 vccd1 sky130_ef_sc_hd__decap_12
X_08221_ _02337_ _02338_ _02336_ vssd1 vssd1 vccd1 vccd1 _02339_ sky130_fd_sc_hd__a21o_1
XFILLER_0_117_237 vssd1 vssd1 vccd1 vccd1 sky130_ef_sc_hd__decap_12
XFILLER_0_90_628 vssd1 vssd1 vccd1 vccd1 sky130_fd_sc_hd__fill_1
XFILLER_0_62_319 vssd1 vssd1 vccd1 vccd1 sky130_fd_sc_hd__fill_1
X_08152_ _02268_ _02269_ _02152_ net1752 vssd1 vssd1 vccd1 vccd1 _02271_ sky130_fd_sc_hd__a211oi_2
XFILLER_0_126_793 vssd1 vssd1 vccd1 vccd1 sky130_ef_sc_hd__decap_12
X_08083_ _02199_ _02200_ vssd1 vssd1 vccd1 vccd1 _02202_ sky130_fd_sc_hd__xor2_1
X_07103_ _01220_ _01227_ vssd1 vssd1 vccd1 vccd1 _01228_ sky130_fd_sc_hd__xor2_2
XFILLER_0_70_396 vssd1 vssd1 vccd1 vccd1 sky130_fd_sc_hd__decap_3
X_07034_ _01142_ _01156_ _01157_ vssd1 vssd1 vccd1 vccd1 _01159_ sky130_fd_sc_hd__nand3_4
XFILLER_0_100_115 vssd1 vssd1 vccd1 vccd1 sky130_fd_sc_hd__fill_1
XFILLER_0_61_3 vssd1 vssd1 vccd1 vccd1 sky130_ef_sc_hd__decap_12
X_08985_ _02949_ net1744 _03096_ _03097_ vssd1 vssd1 vccd1 vccd1 _03098_ sky130_fd_sc_hd__o211a_1
X_07936_ _02055_ _02056_ vssd1 vssd1 vccd1 vccd1 _02057_ sky130_fd_sc_hd__xnor2_1
XFILLER_0_97_205 vssd1 vssd1 vccd1 vccd1 sky130_fd_sc_hd__decap_8
X_07867_ net1084 net1091 net814 vssd1 vssd1 vccd1 vccd1 _01988_ sky130_fd_sc_hd__and3_1
X_06818_ net437 net1253 net645 vssd1 vssd1 vccd1 vccd1 _00092_ sky130_fd_sc_hd__mux2_1
X_09606_ _03709_ _03713_ _03714_ vssd1 vssd1 vccd1 vccd1 _03715_ sky130_fd_sc_hd__nand3_1
X_07798_ _01917_ _01918_ _01919_ vssd1 vssd1 vccd1 vccd1 _01920_ sky130_fd_sc_hd__nand3_1
X_09537_ net1054 net759 _03641_ _03643_ vssd1 vssd1 vccd1 vccd1 _03646_ sky130_fd_sc_hd__a22o_1
XFILLER_0_78_463 vssd1 vssd1 vccd1 vccd1 sky130_fd_sc_hd__fill_2
X_06749_ _00961_ _00964_ vssd1 vssd1 vccd1 vccd1 _00965_ sky130_fd_sc_hd__xnor2_4
XFILLER_0_93_422 vssd1 vssd1 vccd1 vccd1 sky130_fd_sc_hd__fill_1
XFILLER_0_65_113 vssd1 vssd1 vccd1 vccd1 sky130_fd_sc_hd__decap_3
XFILLER_0_39_839 vssd1 vssd1 vccd1 vccd1 sky130_fd_sc_hd__fill_1
XFILLER_0_109_727 vssd1 vssd1 vccd1 vccd1 sky130_fd_sc_hd__fill_1
XFILLER_0_108_215 vssd1 vssd1 vccd1 vccd1 sky130_fd_sc_hd__fill_1
X_09468_ _03575_ _03576_ _03414_ vssd1 vssd1 vccd1 vccd1 _03578_ sky130_fd_sc_hd__a21o_1
XFILLER_0_65_146 vssd1 vssd1 vccd1 vccd1 sky130_fd_sc_hd__fill_1
XFILLER_0_65_124 vssd1 vssd1 vccd1 vccd1 sky130_fd_sc_hd__fill_2
XFILLER_0_81_617 vssd1 vssd1 vccd1 vccd1 sky130_fd_sc_hd__fill_2
X_09399_ net995 _03508_ _03507_ vssd1 vssd1 vccd1 vccd1 _03509_ sky130_fd_sc_hd__a21bo_1
XFILLER_0_80_105 vssd1 vssd1 vccd1 vccd1 sky130_fd_sc_hd__decap_6
X_08419_ _02534_ _02535_ vssd1 vssd1 vccd1 vccd1 _02536_ sky130_fd_sc_hd__or2_1
XFILLER_0_123_218 vssd1 vssd1 vccd1 vccd1 sky130_fd_sc_hd__fill_2
XFILLER_0_61_330 vssd1 vssd1 vccd1 vccd1 sky130_fd_sc_hd__decap_3
X_11430_ net982 net729 net721 net989 vssd1 vssd1 vccd1 vccd1 _05526_ sky130_fd_sc_hd__a22oi_1
XFILLER_0_34_533 vssd1 vssd1 vccd1 vccd1 sky130_ef_sc_hd__decap_12
X_11361_ _04960_ _05455_ vssd1 vssd1 vccd1 vccd1 _05457_ sky130_fd_sc_hd__xnor2_2
XFILLER_0_104_432 vssd1 vssd1 vccd1 vccd1 sky130_ef_sc_hd__decap_12
X_10312_ _04253_ _04256_ _04413_ _04414_ vssd1 vssd1 vccd1 vccd1 _04416_ sky130_fd_sc_hd__a211oi_1
X_13100_ clknet_leaf_24_clk_i _00486_ vssd1 vssd1 vccd1 vccd1 temp1\[25\] sky130_fd_sc_hd__dfxtp_1
X_11292_ net1011 net712 net708 net1019 vssd1 vssd1 vccd1 vccd1 _05389_ sky130_fd_sc_hd__a22o_1
X_10243_ _04333_ _04346_ _04347_ vssd1 vssd1 vccd1 vccd1 _04348_ sky130_fd_sc_hd__and3_2
X_13031_ clknet_leaf_35_clk_i _00417_ net1161 vssd1 vssd1 vccd1 vccd1 x0mx2\[20\]
+ sky130_fd_sc_hd__dfrtp_1
X_10174_ net1014 net1005 net779 net769 vssd1 vssd1 vccd1 vccd1 _04279_ sky130_fd_sc_hd__nand4_1
Xfanout1102 mul1.a\[6\] vssd1 vssd1 vccd1 vccd1 net1102 sky130_fd_sc_hd__buf_4
Xfanout1113 mul1.a\[4\] vssd1 vssd1 vccd1 vccd1 net1113 sky130_fd_sc_hd__clkbuf_4
Xfanout1124 net1125 vssd1 vssd1 vccd1 vccd1 net1124 sky130_fd_sc_hd__buf_2
Xfanout1146 net1149 vssd1 vssd1 vccd1 vccd1 net1146 sky130_fd_sc_hd__clkbuf_4
Xfanout1135 net1137 vssd1 vssd1 vccd1 vccd1 net1135 sky130_fd_sc_hd__buf_2
Xfanout1179 net1180 vssd1 vssd1 vccd1 vccd1 net1179 sky130_fd_sc_hd__clkbuf_2
Xfanout1168 net1169 vssd1 vssd1 vccd1 vccd1 net1168 sky130_fd_sc_hd__clkbuf_4
Xfanout1157 net1158 vssd1 vssd1 vccd1 vccd1 net1157 sky130_fd_sc_hd__buf_2
XFILLER_0_88_205 vssd1 vssd1 vccd1 vccd1 sky130_fd_sc_hd__fill_2
X_12815_ clknet_leaf_49_clk_i _00201_ vssd1 vssd1 vccd1 vccd1 sub1.a_i\[14\] sky130_fd_sc_hd__dfxtp_1
XTAP_1150 vssd1 vccd1 sky130_fd_sc_hd__tapvpwrvgnd_1
XFILLER_0_84_444 vssd1 vssd1 vccd1 vccd1 sky130_fd_sc_hd__decap_8
XTAP_1172 vssd1 vccd1 sky130_fd_sc_hd__tapvpwrvgnd_1
XTAP_1183 vssd1 vccd1 sky130_fd_sc_hd__tapvpwrvgnd_1
XFILLER_0_60_15 vssd1 vssd1 vccd1 vccd1 sky130_fd_sc_hd__decap_6
XTAP_1161 vssd1 vccd1 sky130_fd_sc_hd__tapvpwrvgnd_1
X_12746_ clknet_leaf_57_clk_i _00132_ vssd1 vssd1 vccd1 vccd1 add1.a_i\[9\] sky130_fd_sc_hd__dfxtp_1
XFILLER_0_127_557 vssd1 vssd1 vccd1 vccd1 sky130_fd_sc_hd__decap_3
X_12677_ clknet_leaf_16_clk_i net1355 net1182 vssd1 vssd1 vccd1 vccd1 net406 sky130_fd_sc_hd__dfrtp_1
XTAP_1194 vssd1 vccd1 sky130_fd_sc_hd__tapvpwrvgnd_1
XFILLER_0_25_500 vssd1 vssd1 vccd1 vccd1 sky130_fd_sc_hd__fill_1
XFILLER_0_65_680 vssd1 vssd1 vccd1 vccd1 sky130_fd_sc_hd__fill_1
XFILLER_0_25_533 vssd1 vssd1 vccd1 vccd1 sky130_fd_sc_hd__decap_3
X_11628_ _05719_ _05721_ vssd1 vssd1 vccd1 vccd1 _05722_ sky130_fd_sc_hd__xnor2_1
XFILLER_0_107_281 vssd1 vssd1 vccd1 vccd1 sky130_fd_sc_hd__fill_2
XFILLER_0_64_190 vssd1 vssd1 vccd1 vccd1 sky130_fd_sc_hd__decap_6
XFILLER_0_52_341 vssd1 vssd1 vccd1 vccd1 sky130_fd_sc_hd__decap_3
XFILLER_0_8_27 vssd1 vssd1 vccd1 vccd1 sky130_fd_sc_hd__fill_1
XFILLER_0_13_706 vssd1 vssd1 vccd1 vccd1 sky130_fd_sc_hd__fill_1
XFILLER_0_25_566 vssd1 vssd1 vccd1 vccd1 sky130_fd_sc_hd__fill_2
XFILLER_0_123_741 vssd1 vssd1 vccd1 vccd1 sky130_ef_sc_hd__decap_12
XFILLER_0_52_374 vssd1 vssd1 vccd1 vccd1 sky130_fd_sc_hd__fill_2
X_11559_ _05610_ _05653_ vssd1 vssd1 vccd1 vccd1 _05654_ sky130_fd_sc_hd__xor2_1
XFILLER_0_123_785 vssd1 vssd1 vccd1 vccd1 sky130_ef_sc_hd__decap_12
XFILLER_0_122_251 vssd1 vssd1 vccd1 vccd1 sky130_fd_sc_hd__fill_1
XFILLER_0_100_65 vssd1 vssd1 vccd1 vccd1 sky130_ef_sc_hd__decap_12
X_13229_ net507 vssd1 vssd1 vccd1 vccd1 net284 sky130_fd_sc_hd__clkbuf_1
XFILLER_0_110_446 vssd1 vssd1 vccd1 vccd1 sky130_ef_sc_hd__decap_12
XTAP_901 vssd1 vccd1 sky130_fd_sc_hd__tapvpwrvgnd_1
XTAP_934 vssd1 vccd1 sky130_fd_sc_hd__tapvpwrvgnd_1
XTAP_923 vssd1 vccd1 sky130_fd_sc_hd__tapvpwrvgnd_1
XTAP_912 vssd1 vccd1 sky130_fd_sc_hd__tapvpwrvgnd_1
XFILLER_0_85_45 vssd1 vssd1 vccd1 vccd1 sky130_fd_sc_hd__decap_8
XTAP_978 vssd1 vccd1 sky130_fd_sc_hd__tapvpwrvgnd_1
XTAP_967 vssd1 vccd1 sky130_fd_sc_hd__tapvpwrvgnd_1
XTAP_956 vssd1 vccd1 sky130_fd_sc_hd__tapvpwrvgnd_1
XTAP_945 vssd1 vccd1 sky130_fd_sc_hd__tapvpwrvgnd_1
X_08770_ _02882_ _02883_ _02727_ _02730_ vssd1 vssd1 vccd1 vccd1 _02884_ sky130_fd_sc_hd__a211oi_2
XFILLER_0_85_78 vssd1 vssd1 vccd1 vccd1 sky130_fd_sc_hd__decap_8
XTAP_989 vssd1 vccd1 sky130_fd_sc_hd__tapvpwrvgnd_1
XFILLER_0_79_216 vssd1 vssd1 vccd1 vccd1 sky130_fd_sc_hd__decap_8
X_07721_ _01743_ _01745_ _01842_ _01843_ vssd1 vssd1 vccd1 vccd1 _01844_ sky130_fd_sc_hd__o211a_1
XFILLER_0_18_83 vssd1 vssd1 vccd1 vccd1 sky130_fd_sc_hd__fill_1
X_07652_ _01327_ _01675_ _01676_ vssd1 vssd1 vccd1 vccd1 _01775_ sky130_fd_sc_hd__o21a_1
XFILLER_0_125_51 vssd1 vssd1 vccd1 vccd1 sky130_fd_sc_hd__decap_4
XFILLER_0_95_709 vssd1 vssd1 vccd1 vccd1 sky130_ef_sc_hd__decap_12
X_07583_ net1058 net1066 net864 vssd1 vssd1 vccd1 vccd1 _01707_ sky130_fd_sc_hd__and3_1
X_06603_ sub1.a_i\[7\] sub1.b_i\[7\] vssd1 vssd1 vccd1 vccd1 _00841_ sky130_fd_sc_hd__and2b_1
X_09322_ _03429_ _03430_ vssd1 vssd1 vccd1 vccd1 _03432_ sky130_fd_sc_hd__xnor2_1
XFILLER_0_94_219 vssd1 vssd1 vccd1 vccd1 sky130_fd_sc_hd__decap_4
X_06534_ _00656_ _00659_ vssd1 vssd1 vccd1 vccd1 _00790_ sky130_fd_sc_hd__xor2_4
XFILLER_0_47_113 vssd1 vssd1 vccd1 vccd1 sky130_fd_sc_hd__decap_8
XFILLER_0_118_513 vssd1 vssd1 vccd1 vccd1 sky130_ef_sc_hd__decap_12
XFILLER_0_118_557 vssd1 vssd1 vccd1 vccd1 sky130_ef_sc_hd__decap_12
XFILLER_0_90_403 vssd1 vssd1 vccd1 vccd1 sky130_fd_sc_hd__decap_4
X_09253_ net877 net869 net968 net962 vssd1 vssd1 vccd1 vccd1 _03364_ sky130_fd_sc_hd__nand4_2
XFILLER_0_63_617 vssd1 vssd1 vccd1 vccd1 sky130_ef_sc_hd__decap_12
X_06465_ add1.a_i\[25\] add1.b_i\[25\] add1.a_i\[24\] add1.b_i\[24\] vssd1 vssd1 vccd1
+ vccd1 _00762_ sky130_fd_sc_hd__a22o_1
XFILLER_0_8_755 vssd1 vssd1 vccd1 vccd1 sky130_fd_sc_hd__fill_1
XFILLER_0_16_500 vssd1 vssd1 vccd1 vccd1 sky130_fd_sc_hd__decap_3
X_09184_ _03293_ _03294_ _03132_ _03134_ vssd1 vssd1 vccd1 vccd1 _03295_ sky130_fd_sc_hd__o211a_1
X_08204_ _02320_ _02321_ vssd1 vssd1 vccd1 vccd1 _02322_ sky130_fd_sc_hd__and2b_1
X_06396_ add1.a_i\[16\] add1.b_i\[16\] _00694_ _00695_ vssd1 vssd1 vccd1 vccd1 _00703_
+ sky130_fd_sc_hd__a31o_1
XFILLER_0_114_730 vssd1 vssd1 vccd1 vccd1 sky130_fd_sc_hd__decap_6
X_08135_ _02244_ _02251_ _02252_ vssd1 vssd1 vccd1 vccd1 _02254_ sky130_fd_sc_hd__nand3_2
XFILLER_0_113_273 vssd1 vssd1 vccd1 vccd1 sky130_fd_sc_hd__decap_6
X_08066_ _02183_ _02184_ vssd1 vssd1 vccd1 vccd1 _02185_ sky130_fd_sc_hd__or2_2
XFILLER_0_3_460 vssd1 vssd1 vccd1 vccd1 sky130_fd_sc_hd__fill_2
X_07017_ _01111_ _01117_ _01112_ vssd1 vssd1 vccd1 vccd1 _01142_ sky130_fd_sc_hd__a21bo_1
Xinput216 v2x[8] vssd1 vssd1 vccd1 vccd1 net216 sky130_fd_sc_hd__buf_1
Xinput227 v2y[18] vssd1 vssd1 vccd1 vccd1 net227 sky130_fd_sc_hd__buf_1
Xinput205 v2x[27] vssd1 vssd1 vccd1 vccd1 net205 sky130_fd_sc_hd__buf_1
X_08968_ _03061_ _03078_ _03079_ vssd1 vssd1 vccd1 vccd1 _03081_ sky130_fd_sc_hd__and3_1
Xinput249 v2y[9] vssd1 vssd1 vccd1 vccd1 net249 sky130_fd_sc_hd__buf_1
Xinput238 v2y[28] vssd1 vssd1 vccd1 vccd1 net238 sky130_fd_sc_hd__clkbuf_1
X_08899_ net1044 net802 net793 net1052 vssd1 vssd1 vccd1 vccd1 _03012_ sky130_fd_sc_hd__a22oi_1
X_07919_ _02003_ _02005_ _02038_ _02039_ vssd1 vssd1 vccd1 vccd1 _02040_ sky130_fd_sc_hd__nor4_1
XFILLER_0_98_547 vssd1 vssd1 vccd1 vccd1 sky130_ef_sc_hd__decap_12
X_10930_ _05028_ _05029_ vssd1 vssd1 vccd1 vccd1 _05030_ sky130_fd_sc_hd__and2b_1
XFILLER_0_86_709 vssd1 vssd1 vccd1 vccd1 sky130_ef_sc_hd__decap_12
XPHY_200 vssd1 vssd1 vccd1 vccd1 sky130_fd_sc_hd__decap_3
XFILLER_0_85_219 vssd1 vssd1 vccd1 vccd1 sky130_fd_sc_hd__decap_4
XFILLER_0_79_783 vssd1 vssd1 vccd1 vccd1 sky130_fd_sc_hd__fill_1
X_12600_ net1528 net11 net556 vssd1 vssd1 vccd1 vccd1 _00575_ sky130_fd_sc_hd__mux2_1
X_10861_ _04676_ _04824_ vssd1 vssd1 vccd1 vccd1 _04961_ sky130_fd_sc_hd__nand2_2
XPHY_233 vssd1 vssd1 vccd1 vccd1 sky130_fd_sc_hd__decap_3
XPHY_222 vssd1 vssd1 vccd1 vccd1 sky130_fd_sc_hd__decap_3
XPHY_211 vssd1 vssd1 vccd1 vccd1 sky130_fd_sc_hd__decap_3
X_10792_ _04707_ _04746_ net458 _04892_ vssd1 vssd1 vccd1 vccd1 _04893_ sky130_fd_sc_hd__a211o_2
X_12531_ net1229 net565 _06262_ vssd1 vssd1 vccd1 vccd1 _00516_ sky130_fd_sc_hd__a21o_1
XPHY_255 vssd1 vssd1 vccd1 vccd1 sky130_fd_sc_hd__decap_3
XPHY_244 vssd1 vssd1 vccd1 vccd1 sky130_fd_sc_hd__decap_3
XFILLER_0_109_557 vssd1 vssd1 vccd1 vccd1 sky130_fd_sc_hd__decap_3
XFILLER_0_94_786 vssd1 vssd1 vccd1 vccd1 sky130_fd_sc_hd__fill_2
XFILLER_0_30_29 vssd1 vssd1 vccd1 vccd1 sky130_fd_sc_hd__fill_1
X_12462_ _04671_ net576 _06226_ vssd1 vssd1 vccd1 vccd1 _06227_ sky130_fd_sc_hd__a21o_1
X_11413_ net1019 net702 _05506_ _05508_ vssd1 vssd1 vccd1 vccd1 _05509_ sky130_fd_sc_hd__and4_1
XFILLER_0_61_160 vssd1 vssd1 vccd1 vccd1 sky130_fd_sc_hd__decap_8
X_12393_ net1486 _00892_ net684 vssd1 vssd1 vccd1 vccd1 _00445_ sky130_fd_sc_hd__mux2_1
XFILLER_0_34_363 vssd1 vssd1 vccd1 vccd1 sky130_fd_sc_hd__fill_1
XFILLER_0_34_374 vssd1 vssd1 vccd1 vccd1 sky130_fd_sc_hd__decap_4
X_11344_ _05153_ _05282_ _05281_ vssd1 vssd1 vccd1 vccd1 _05441_ sky130_fd_sc_hd__o21a_1
XFILLER_0_120_755 vssd1 vssd1 vccd1 vccd1 sky130_fd_sc_hd__fill_1
X_11275_ _05249_ _05251_ _05370_ vssd1 vssd1 vccd1 vccd1 _05372_ sky130_fd_sc_hd__nand3_1
X_10226_ _04328_ _04329_ _04330_ vssd1 vssd1 vccd1 vccd1 _04331_ sky130_fd_sc_hd__and3_2
X_13014_ clknet_leaf_50_clk_i _00400_ net1152 vssd1 vssd1 vccd1 vccd1 x0mx2\[3\] sky130_fd_sc_hd__dfrtp_1
X_10157_ _04103_ _04106_ _04259_ _04261_ vssd1 vssd1 vccd1 vccd1 _04262_ sky130_fd_sc_hd__o211a_1
XFILLER_0_55_15 vssd1 vssd1 vccd1 vccd1 sky130_fd_sc_hd__fill_1
Xhold4 _00049_ vssd1 vssd1 vccd1 vccd1 net1219 sky130_fd_sc_hd__dlygate4sd3_1
X_10088_ _04184_ _04191_ _04192_ vssd1 vssd1 vccd1 vccd1 _04194_ sky130_fd_sc_hd__nand3_2
Xclkbuf_leaf_22_clk_i clknet_3_5__leaf_clk_i vssd1 vssd1 vccd1 vccd1 clknet_leaf_22_clk_i
+ sky130_fd_sc_hd__clkbuf_16
XFILLER_0_97_591 vssd1 vssd1 vccd1 vccd1 sky130_fd_sc_hd__fill_2
XFILLER_0_29_113 vssd1 vssd1 vccd1 vccd1 sky130_fd_sc_hd__fill_1
X_12729_ clknet_leaf_8_clk_i net1223 net1194 vssd1 vssd1 vccd1 vccd1 net349 sky130_fd_sc_hd__dfrtp_1
Xclkbuf_leaf_37_clk_i clknet_3_1__leaf_clk_i vssd1 vssd1 vccd1 vccd1 clknet_leaf_37_clk_i
+ sky130_fd_sc_hd__clkbuf_16
XFILLER_0_115_505 vssd1 vssd1 vccd1 vccd1 sky130_ef_sc_hd__decap_12
XFILLER_0_57_499 vssd1 vssd1 vccd1 vccd1 sky130_fd_sc_hd__decap_4
XFILLER_0_44_127 vssd1 vssd1 vccd1 vccd1 sky130_ef_sc_hd__decap_12
XFILLER_0_5_736 vssd1 vssd1 vccd1 vccd1 sky130_fd_sc_hd__fill_1
XFILLER_0_41_801 vssd1 vssd1 vccd1 vccd1 sky130_fd_sc_hd__fill_1
XFILLER_0_111_53 vssd1 vssd1 vccd1 vccd1 sky130_fd_sc_hd__decap_3
XFILLER_0_13_503 vssd1 vssd1 vccd1 vccd1 sky130_fd_sc_hd__fill_1
Xhold415 sub1.b_i\[31\] vssd1 vssd1 vccd1 vccd1 net1630 sky130_fd_sc_hd__dlygate4sd3_1
XFILLER_0_13_547 vssd1 vssd1 vccd1 vccd1 sky130_fd_sc_hd__fill_1
Xhold426 x2mx1\[25\] vssd1 vssd1 vccd1 vccd1 net1641 sky130_fd_sc_hd__dlygate4sd3_1
Xhold404 y1my2\[30\] vssd1 vssd1 vccd1 vccd1 net1619 sky130_fd_sc_hd__dlygate4sd3_1
XFILLER_0_40_333 vssd1 vssd1 vccd1 vccd1 sky130_fd_sc_hd__decap_4
XFILLER_0_110_221 vssd1 vssd1 vccd1 vccd1 sky130_ef_sc_hd__decap_12
X_09940_ _03990_ _04046_ vssd1 vssd1 vccd1 vccd1 _04047_ sky130_fd_sc_hd__xnor2_4
Xhold459 y1my2\[2\] vssd1 vssd1 vccd1 vccd1 net1674 sky130_fd_sc_hd__dlygate4sd3_1
Xhold437 x2mx1\[24\] vssd1 vssd1 vccd1 vccd1 net1652 sky130_fd_sc_hd__dlygate4sd3_1
Xhold448 y1my2\[17\] vssd1 vssd1 vccd1 vccd1 net1663 sky130_fd_sc_hd__dlygate4sd3_1
XFILLER_0_110_265 vssd1 vssd1 vccd1 vccd1 sky130_ef_sc_hd__decap_12
XFILLER_0_96_77 vssd1 vssd1 vccd1 vccd1 sky130_fd_sc_hd__decap_6
XFILLER_0_21_591 vssd1 vssd1 vccd1 vccd1 sky130_fd_sc_hd__decap_4
XFILLER_0_40_399 vssd1 vssd1 vccd1 vccd1 sky130_fd_sc_hd__fill_2
Xfanout906 net908 vssd1 vssd1 vccd1 vccd1 net906 sky130_fd_sc_hd__clkbuf_2
X_09871_ _03975_ _03976_ _03971_ vssd1 vssd1 vccd1 vccd1 _03978_ sky130_fd_sc_hd__a21o_1
Xfanout939 net941 vssd1 vssd1 vccd1 vccd1 net939 sky130_fd_sc_hd__buf_2
Xfanout928 net929 vssd1 vssd1 vccd1 vccd1 net928 sky130_fd_sc_hd__buf_4
XFILLER_0_0_474 vssd1 vssd1 vccd1 vccd1 sky130_fd_sc_hd__fill_2
Xfanout917 net919 vssd1 vssd1 vccd1 vccd1 net917 sky130_fd_sc_hd__buf_2
XTAP_720 vssd1 vccd1 sky130_fd_sc_hd__tapvpwrvgnd_1
XTAP_731 vssd1 vccd1 sky130_fd_sc_hd__tapvpwrvgnd_1
XTAP_742 vssd1 vccd1 sky130_fd_sc_hd__tapvpwrvgnd_1
X_08822_ _02934_ _02935_ _02917_ vssd1 vssd1 vccd1 vccd1 _02936_ sky130_fd_sc_hd__a21oi_2
XFILLER_0_29_93 vssd1 vssd1 vccd1 vccd1 sky130_fd_sc_hd__fill_1
XTAP_753 vssd1 vccd1 sky130_fd_sc_hd__tapvpwrvgnd_1
XTAP_764 vssd1 vccd1 sky130_fd_sc_hd__tapvpwrvgnd_1
XTAP_775 vssd1 vccd1 sky130_fd_sc_hd__tapvpwrvgnd_1
XTAP_786 vssd1 vccd1 sky130_fd_sc_hd__tapvpwrvgnd_1
X_08753_ _02718_ _02720_ vssd1 vssd1 vccd1 vccd1 _02867_ sky130_fd_sc_hd__nand2_1
XTAP_797 vssd1 vccd1 sky130_fd_sc_hd__tapvpwrvgnd_1
X_07704_ _01823_ _01824_ _01825_ vssd1 vssd1 vccd1 vccd1 _01827_ sky130_fd_sc_hd__a21o_1
XFILLER_0_24_3 vssd1 vssd1 vccd1 vccd1 sky130_ef_sc_hd__decap_12
X_08684_ _02654_ net460 _02797_ _02798_ vssd1 vssd1 vccd1 vccd1 _02799_ sky130_fd_sc_hd__o211ai_4
XTAP_1919 vssd1 vccd1 sky130_fd_sc_hd__tapvpwrvgnd_1
XTAP_1908 vssd1 vccd1 sky130_fd_sc_hd__tapvpwrvgnd_1
X_07635_ _01461_ _01756_ vssd1 vssd1 vccd1 vccd1 _01759_ sky130_fd_sc_hd__nand2_1
X_07566_ net1082 net1089 net848 net838 vssd1 vssd1 vccd1 vccd1 _01690_ sky130_fd_sc_hd__and4_1
XFILLER_0_48_444 vssd1 vssd1 vccd1 vccd1 sky130_ef_sc_hd__decap_12
XFILLER_0_0_61 vssd1 vssd1 vccd1 vccd1 sky130_fd_sc_hd__fill_2
X_06517_ det_t\[27\] net530 vssd1 vssd1 vccd1 vccd1 net271 sky130_fd_sc_hd__and2_1
XFILLER_0_118_321 vssd1 vssd1 vccd1 vccd1 sky130_ef_sc_hd__decap_12
XFILLER_0_91_723 vssd1 vssd1 vccd1 vccd1 sky130_fd_sc_hd__decap_4
X_09305_ _03260_ _03415_ vssd1 vssd1 vccd1 vccd1 _03416_ sky130_fd_sc_hd__and2b_1
XFILLER_0_75_252 vssd1 vssd1 vccd1 vccd1 sky130_fd_sc_hd__decap_4
XFILLER_0_63_403 vssd1 vssd1 vccd1 vccd1 sky130_fd_sc_hd__fill_2
XFILLER_0_48_477 vssd1 vssd1 vccd1 vccd1 sky130_fd_sc_hd__decap_8
XFILLER_0_118_365 vssd1 vssd1 vccd1 vccd1 sky130_ef_sc_hd__decap_12
X_09236_ _03345_ _03346_ vssd1 vssd1 vccd1 vccd1 _03347_ sky130_fd_sc_hd__xor2_1
XFILLER_0_75_285 vssd1 vssd1 vccd1 vccd1 sky130_fd_sc_hd__fill_1
XFILLER_0_63_425 vssd1 vssd1 vccd1 vccd1 sky130_fd_sc_hd__fill_1
X_07497_ net918 net910 net1121 net1130 vssd1 vssd1 vccd1 vccd1 _01622_ sky130_fd_sc_hd__nand4_2
X_06448_ add1.a_i\[24\] add1.b_i\[24\] _00742_ vssd1 vssd1 vccd1 vccd1 _00748_ sky130_fd_sc_hd__a21oi_4
X_09167_ _03275_ _03276_ vssd1 vssd1 vccd1 vccd1 _03278_ sky130_fd_sc_hd__xnor2_1
X_06379_ _00687_ _00688_ vssd1 vssd1 vccd1 vccd1 _00689_ sky130_fd_sc_hd__nand2_4
XFILLER_0_43_160 vssd1 vssd1 vccd1 vccd1 sky130_fd_sc_hd__fill_1
X_08118_ _02229_ _02236_ vssd1 vssd1 vccd1 vccd1 _02237_ sky130_fd_sc_hd__xnor2_2
X_09098_ net885 net968 _03063_ _03064_ net955 vssd1 vssd1 vccd1 vccd1 _03210_ sky130_fd_sc_hd__a32o_1
XFILLER_0_9_81 vssd1 vssd1 vccd1 vccd1 sky130_fd_sc_hd__fill_1
XFILLER_0_3_290 vssd1 vssd1 vccd1 vccd1 sky130_fd_sc_hd__fill_2
X_08049_ temp1\[5\] _02168_ net540 vssd1 vssd1 vccd1 vccd1 _02169_ sky130_fd_sc_hd__mux2_1
X_11060_ _05157_ _05158_ vssd1 vssd1 vccd1 vccd1 _05159_ sky130_fd_sc_hd__nand2_1
X_10011_ net1038 net752 net745 net1046 vssd1 vssd1 vccd1 vccd1 _04117_ sky130_fd_sc_hd__a22o_1
X_11962_ net96 net621 net595 net64 vssd1 vssd1 vccd1 vccd1 _05976_ sky130_fd_sc_hd__a22o_1
X_10913_ _04999_ _05011_ _05012_ vssd1 vssd1 vccd1 vccd1 _05013_ sky130_fd_sc_hd__and3_2
X_11893_ net177 net472 _05923_ vssd1 vssd1 vccd1 vccd1 _05924_ sky130_fd_sc_hd__o21a_1
X_10844_ _04942_ _04943_ _04798_ net452 vssd1 vssd1 vccd1 vccd1 _04945_ sky130_fd_sc_hd__a211o_1
XFILLER_0_79_591 vssd1 vssd1 vccd1 vccd1 sky130_fd_sc_hd__fill_1
XFILLER_0_66_230 vssd1 vssd1 vccd1 vccd1 sky130_fd_sc_hd__decap_4
XFILLER_0_27_628 vssd1 vssd1 vccd1 vccd1 sky130_fd_sc_hd__fill_1
X_12514_ net1241 net563 vssd1 vssd1 vccd1 vccd1 _06254_ sky130_fd_sc_hd__nand2_1
XFILLER_0_109_354 vssd1 vssd1 vccd1 vccd1 sky130_fd_sc_hd__decap_6
XFILLER_0_54_425 vssd1 vssd1 vccd1 vccd1 sky130_fd_sc_hd__decap_8
X_10775_ net783 net970 _04873_ _04874_ vssd1 vssd1 vccd1 vccd1 _04876_ sky130_fd_sc_hd__o2bb2a_1
XFILLER_0_26_127 vssd1 vssd1 vccd1 vccd1 sky130_fd_sc_hd__decap_4
XFILLER_0_23_812 vssd1 vssd1 vccd1 vccd1 sky130_fd_sc_hd__fill_2
XFILLER_0_35_661 vssd1 vssd1 vccd1 vccd1 sky130_fd_sc_hd__decap_4
X_12445_ temp1\[16\] _06215_ net571 vssd1 vssd1 vccd1 vccd1 _00477_ sky130_fd_sc_hd__mux2_1
XFILLER_0_62_491 vssd1 vssd1 vccd1 vccd1 sky130_ef_sc_hd__decap_12
XFILLER_0_50_642 vssd1 vssd1 vccd1 vccd1 sky130_fd_sc_hd__fill_2
X_12376_ net1433 _00973_ net662 vssd1 vssd1 vccd1 vccd1 _00428_ sky130_fd_sc_hd__mux2_1
XFILLER_0_34_182 vssd1 vssd1 vccd1 vccd1 sky130_fd_sc_hd__decap_4
X_11327_ _05421_ _05422_ _05294_ _05296_ vssd1 vssd1 vccd1 vccd1 _05424_ sky130_fd_sc_hd__a211oi_2
XFILLER_0_5_39 vssd1 vssd1 vccd1 vccd1 sky130_ef_sc_hd__decap_12
X_11258_ net758 net972 _05232_ _05231_ vssd1 vssd1 vccd1 vccd1 _05355_ sky130_fd_sc_hd__a31o_1
X_10209_ _04024_ _04178_ _04312_ _04313_ vssd1 vssd1 vccd1 vccd1 _04314_ sky130_fd_sc_hd__nand4_2
X_11189_ _05285_ _05286_ net1011 net717 vssd1 vssd1 vccd1 vccd1 _05287_ sky130_fd_sc_hd__and4bb_1
XFILLER_0_106_53 vssd1 vssd1 vccd1 vccd1 sky130_ef_sc_hd__decap_12
XFILLER_0_106_97 vssd1 vssd1 vccd1 vccd1 sky130_ef_sc_hd__decap_12
XFILLER_0_15_51 vssd1 vssd1 vccd1 vccd1 sky130_fd_sc_hd__decap_4
X_07420_ _01496_ _01513_ _01530_ _01539_ vssd1 vssd1 vccd1 vccd1 _01545_ sky130_fd_sc_hd__a211oi_1
X_07351_ _01474_ _01475_ vssd1 vssd1 vccd1 vccd1 _01476_ sky130_fd_sc_hd__and2b_1
XFILLER_0_122_41 vssd1 vssd1 vccd1 vccd1 sky130_ef_sc_hd__decap_12
XFILLER_0_72_222 vssd1 vssd1 vccd1 vccd1 sky130_ef_sc_hd__decap_12
XFILLER_0_58_797 vssd1 vssd1 vccd1 vccd1 sky130_fd_sc_hd__fill_2
X_06302_ _00610_ _00613_ vssd1 vssd1 vccd1 vccd1 _00615_ sky130_fd_sc_hd__or2_1
XFILLER_0_116_825 vssd1 vssd1 vccd1 vccd1 sky130_fd_sc_hd__fill_1
XFILLER_0_5_500 vssd1 vssd1 vccd1 vccd1 sky130_fd_sc_hd__decap_4
X_07282_ _01404_ _01405_ _01325_ vssd1 vssd1 vccd1 vccd1 _01407_ sky130_fd_sc_hd__a21o_1
XFILLER_0_122_85 vssd1 vssd1 vccd1 vccd1 sky130_ef_sc_hd__decap_12
XFILLER_0_115_335 vssd1 vssd1 vccd1 vccd1 sky130_fd_sc_hd__fill_1
X_09021_ _03126_ _03131_ vssd1 vssd1 vccd1 vccd1 _03133_ sky130_fd_sc_hd__xor2_1
XFILLER_0_72_299 vssd1 vssd1 vccd1 vccd1 sky130_fd_sc_hd__decap_8
XFILLER_0_72_277 vssd1 vssd1 vccd1 vccd1 sky130_fd_sc_hd__decap_3
XFILLER_0_25_160 vssd1 vssd1 vccd1 vccd1 sky130_fd_sc_hd__decap_4
Xhold201 posx\[5\] vssd1 vssd1 vccd1 vccd1 net1416 sky130_fd_sc_hd__dlygate4sd3_1
XFILLER_0_25_193 vssd1 vssd1 vccd1 vccd1 sky130_fd_sc_hd__decap_4
Xhold234 l0\[12\] vssd1 vssd1 vccd1 vccd1 net1449 sky130_fd_sc_hd__dlygate4sd3_1
Xhold212 net422 vssd1 vssd1 vccd1 vccd1 net1427 sky130_fd_sc_hd__dlygate4sd3_1
Xclkbuf_3_1__f_clk_i clknet_0_clk_i vssd1 vssd1 vccd1 vccd1 clknet_3_1__leaf_clk_i
+ sky130_fd_sc_hd__clkbuf_16
Xhold223 y2my0\[26\] vssd1 vssd1 vccd1 vccd1 net1438 sky130_fd_sc_hd__dlygate4sd3_1
XFILLER_0_111_541 vssd1 vssd1 vccd1 vccd1 sky130_ef_sc_hd__decap_12
Xhold256 l0\[16\] vssd1 vssd1 vccd1 vccd1 net1471 sky130_fd_sc_hd__dlygate4sd3_1
Xhold245 sub1.a_i\[7\] vssd1 vssd1 vccd1 vccd1 net1460 sky130_fd_sc_hd__dlygate4sd3_1
Xhold267 y2my0\[4\] vssd1 vssd1 vccd1 vccd1 net1482 sky130_fd_sc_hd__dlygate4sd3_1
Xhold278 y2my0\[28\] vssd1 vssd1 vccd1 vccd1 net1493 sky130_fd_sc_hd__dlygate4sd3_1
Xhold289 _00114_ vssd1 vssd1 vccd1 vccd1 net1504 sky130_fd_sc_hd__dlygate4sd3_1
XFILLER_0_111_585 vssd1 vssd1 vccd1 vccd1 sky130_ef_sc_hd__decap_12
Xfanout714 net715 vssd1 vssd1 vccd1 vccd1 net714 sky130_fd_sc_hd__clkbuf_4
X_09923_ _04026_ _04027_ _04028_ vssd1 vssd1 vccd1 vccd1 _04030_ sky130_fd_sc_hd__a21o_1
Xfanout703 net706 vssd1 vssd1 vccd1 vccd1 net703 sky130_fd_sc_hd__clkbuf_2
X_09854_ net1021 net1028 net778 net768 vssd1 vssd1 vccd1 vccd1 _03961_ sky130_fd_sc_hd__and4_1
Xfanout725 net726 vssd1 vssd1 vccd1 vccd1 net725 sky130_fd_sc_hd__clkbuf_4
Xfanout758 net762 vssd1 vssd1 vccd1 vccd1 net758 sky130_fd_sc_hd__clkbuf_2
XTAP_550 vssd1 vccd1 sky130_fd_sc_hd__tapvpwrvgnd_1
XTAP_561 vssd1 vccd1 sky130_fd_sc_hd__tapvpwrvgnd_1
Xfanout747 mul1.b\[22\] vssd1 vssd1 vccd1 vccd1 net747 sky130_fd_sc_hd__buf_4
Xfanout736 net739 vssd1 vssd1 vccd1 vccd1 net736 sky130_fd_sc_hd__clkbuf_4
Xfanout769 net770 vssd1 vssd1 vccd1 vccd1 net769 sky130_fd_sc_hd__buf_2
X_08805_ net894 net967 net961 net903 vssd1 vssd1 vccd1 vccd1 _02919_ sky130_fd_sc_hd__a22o_1
XTAP_583 vssd1 vccd1 sky130_fd_sc_hd__tapvpwrvgnd_1
XTAP_572 vssd1 vccd1 sky130_fd_sc_hd__tapvpwrvgnd_1
XTAP_594 vssd1 vccd1 sky130_fd_sc_hd__tapvpwrvgnd_1
X_09785_ _03892_ _03891_ vssd1 vssd1 vccd1 vccd1 _03893_ sky130_fd_sc_hd__and2b_1
X_06997_ _01025_ _01026_ vssd1 vssd1 vccd1 vccd1 _01122_ sky130_fd_sc_hd__or2_1
X_08736_ _02693_ _02848_ vssd1 vssd1 vccd1 vccd1 _02850_ sky130_fd_sc_hd__nor2_1
XTAP_1705 vssd1 vccd1 sky130_fd_sc_hd__tapvpwrvgnd_1
XFILLER_0_68_528 vssd1 vssd1 vccd1 vccd1 sky130_fd_sc_hd__decap_4
X_08667_ _02772_ _02779_ _02780_ vssd1 vssd1 vccd1 vccd1 _02782_ sky130_fd_sc_hd__nand3_2
XTAP_1749 vssd1 vccd1 sky130_fd_sc_hd__tapvpwrvgnd_1
XTAP_1738 vssd1 vccd1 sky130_fd_sc_hd__tapvpwrvgnd_1
XTAP_1727 vssd1 vccd1 sky130_fd_sc_hd__tapvpwrvgnd_1
XTAP_1716 vssd1 vccd1 sky130_fd_sc_hd__tapvpwrvgnd_1
XFILLER_0_49_720 vssd1 vssd1 vccd1 vccd1 sky130_fd_sc_hd__fill_1
X_07618_ _01701_ _01702_ _01737_ _01739_ vssd1 vssd1 vccd1 vccd1 _01742_ sky130_fd_sc_hd__or4_1
X_08598_ _02709_ _02710_ vssd1 vssd1 vccd1 vccd1 _02713_ sky130_fd_sc_hd__xor2_1
XFILLER_0_76_561 vssd1 vssd1 vccd1 vccd1 sky130_ef_sc_hd__decap_12
XFILLER_0_64_701 vssd1 vssd1 vccd1 vccd1 sky130_fd_sc_hd__decap_6
XFILLER_0_49_775 vssd1 vssd1 vccd1 vccd1 sky130_fd_sc_hd__fill_1
XFILLER_0_119_641 vssd1 vssd1 vccd1 vccd1 sky130_ef_sc_hd__decap_12
X_07549_ net1146 net781 vssd1 vssd1 vccd1 vccd1 _01673_ sky130_fd_sc_hd__nand2_1
XFILLER_0_119_685 vssd1 vssd1 vccd1 vccd1 sky130_ef_sc_hd__decap_12
X_10560_ _04528_ _04661_ vssd1 vssd1 vccd1 vccd1 _04663_ sky130_fd_sc_hd__nor2_1
XFILLER_0_118_195 vssd1 vssd1 vccd1 vccd1 sky130_fd_sc_hd__fill_1
X_09219_ _03320_ _03329_ vssd1 vssd1 vccd1 vccd1 _03330_ sky130_fd_sc_hd__xnor2_1
X_10491_ _04591_ _04592_ _04593_ vssd1 vssd1 vccd1 vccd1 _04594_ sky130_fd_sc_hd__and3_1
XFILLER_0_63_277 vssd1 vssd1 vccd1 vccd1 sky130_fd_sc_hd__decap_3
XFILLER_0_51_428 vssd1 vssd1 vccd1 vccd1 sky130_fd_sc_hd__decap_4
XFILLER_0_121_305 vssd1 vssd1 vccd1 vccd1 sky130_ef_sc_hd__decap_12
X_12230_ net750 _06173_ net519 vssd1 vssd1 vccd1 vccd1 _00304_ sky130_fd_sc_hd__mux2_1
XFILLER_0_32_642 vssd1 vssd1 vccd1 vccd1 sky130_fd_sc_hd__fill_2
XFILLER_0_121_349 vssd1 vssd1 vccd1 vccd1 sky130_ef_sc_hd__decap_12
X_12161_ y2my0\[31\] net587 net534 x2mx1\[31\] _06126_ vssd1 vssd1 vccd1 vccd1 _06127_
+ sky130_fd_sc_hd__a221o_1
X_12092_ x0mx2\[14\] net629 net591 y1my2\[14\] vssd1 vssd1 vccd1 vccd1 _06075_ sky130_fd_sc_hd__a22o_1
X_11112_ net824 net816 net930 net928 vssd1 vssd1 vccd1 vccd1 _05210_ sky130_fd_sc_hd__and4_1
X_11043_ _05056_ _05059_ vssd1 vssd1 vccd1 vccd1 _05142_ sky130_fd_sc_hd__nand2b_1
X_12994_ clknet_leaf_45_clk_i _00380_ net1156 vssd1 vssd1 vccd1 vccd1 x2mx1\[15\]
+ sky130_fd_sc_hd__dfrtp_1
XFILLER_0_87_815 vssd1 vssd1 vccd1 vccd1 sky130_fd_sc_hd__decap_4
X_11945_ net1315 _05963_ net479 vssd1 vssd1 vccd1 vccd1 _00229_ sky130_fd_sc_hd__mux2_1
XFILLER_0_52_27 vssd1 vssd1 vccd1 vccd1 sky130_fd_sc_hd__fill_1
XFILLER_0_86_369 vssd1 vssd1 vccd1 vccd1 sky130_fd_sc_hd__fill_1
X_11876_ net1302 _05909_ net482 vssd1 vssd1 vccd1 vccd1 _00214_ sky130_fd_sc_hd__mux2_1
XFILLER_0_39_252 vssd1 vssd1 vccd1 vccd1 sky130_fd_sc_hd__fill_2
X_10827_ _04925_ _04927_ _04778_ _04780_ vssd1 vssd1 vccd1 vccd1 _04928_ sky130_fd_sc_hd__o211ai_2
X_10758_ net1013 net736 _04856_ _04857_ vssd1 vssd1 vccd1 vccd1 _04859_ sky130_fd_sc_hd__a22o_1
XFILLER_0_27_458 vssd1 vssd1 vccd1 vccd1 sky130_fd_sc_hd__decap_4
XFILLER_0_124_121 vssd1 vssd1 vccd1 vccd1 sky130_ef_sc_hd__decap_12
XFILLER_0_42_417 vssd1 vssd1 vccd1 vccd1 sky130_fd_sc_hd__decap_3
XFILLER_0_124_165 vssd1 vssd1 vccd1 vccd1 sky130_fd_sc_hd__decap_4
X_10689_ _04752_ _04789_ _04790_ vssd1 vssd1 vccd1 vccd1 _04791_ sky130_fd_sc_hd__and3_2
X_12428_ net1701 _06206_ net570 vssd1 vssd1 vccd1 vccd1 _00469_ sky130_fd_sc_hd__mux2_1
Xoutput306 net306 vssd1 vssd1 vccd1 vccd1 div_mstream_o[73] sky130_fd_sc_hd__clkbuf_4
Xoutput317 net317 vssd1 vssd1 vccd1 vccd1 div_mstream_o[83] sky130_fd_sc_hd__clkbuf_4
Xoutput328 net328 vssd1 vssd1 vccd1 vccd1 div_mstream_o[93] sky130_fd_sc_hd__clkbuf_4
Xoutput339 net339 vssd1 vssd1 vccd1 vccd1 mstream_o[103] sky130_fd_sc_hd__clkbuf_4
XFILLER_0_77_35 vssd1 vssd1 vccd1 vccd1 sky130_fd_sc_hd__decap_3
X_12359_ net1554 _00882_ net658 vssd1 vssd1 vccd1 vccd1 _00411_ sky130_fd_sc_hd__mux2_1
XFILLER_0_58_9 vssd1 vssd1 vccd1 vccd1 sky130_fd_sc_hd__fill_2
X_06920_ _01042_ _01044_ net829 net1135 vssd1 vssd1 vccd1 vccd1 _01045_ sky130_fd_sc_hd__and4b_1
X_06851_ net37 _00615_ _00981_ vssd1 vssd1 vccd1 vccd1 _00982_ sky130_fd_sc_hd__o21a_2
X_09570_ net841 net977 net968 net850 vssd1 vssd1 vccd1 vccd1 _03679_ sky130_fd_sc_hd__a22o_1
X_06782_ net1469 net1358 net639 vssd1 vssd1 vccd1 vccd1 _00056_ sky130_fd_sc_hd__mux2_1
X_08521_ _02633_ _02634_ _02635_ vssd1 vssd1 vccd1 vccd1 _02637_ sky130_fd_sc_hd__nand3_1
X_08452_ net1107 net755 _02566_ _02567_ vssd1 vssd1 vccd1 vccd1 _02568_ sky130_fd_sc_hd__a22o_1
X_07403_ _01521_ _01526_ _01527_ vssd1 vssd1 vccd1 vccd1 _01528_ sky130_fd_sc_hd__nand3_1
XFILLER_0_85_380 vssd1 vssd1 vccd1 vccd1 sky130_fd_sc_hd__fill_2
X_08383_ _02498_ _02499_ vssd1 vssd1 vccd1 vccd1 _02500_ sky130_fd_sc_hd__nor2_1
XFILLER_0_45_233 vssd1 vssd1 vccd1 vccd1 sky130_fd_sc_hd__fill_1
X_07334_ _01324_ _01458_ vssd1 vssd1 vccd1 vccd1 _01459_ sky130_fd_sc_hd__or2_1
XFILLER_0_42_82 vssd1 vssd1 vccd1 vccd1 sky130_fd_sc_hd__fill_2
XFILLER_0_91_3 vssd1 vssd1 vccd1 vccd1 sky130_ef_sc_hd__decap_12
XFILLER_0_60_214 vssd1 vssd1 vccd1 vccd1 sky130_fd_sc_hd__decap_4
X_07265_ _01219_ _01230_ _01387_ _01388_ vssd1 vssd1 vccd1 vccd1 _01390_ sky130_fd_sc_hd__a211o_1
XFILLER_0_116_699 vssd1 vssd1 vccd1 vccd1 sky130_fd_sc_hd__fill_1
XFILLER_0_104_839 vssd1 vssd1 vccd1 vccd1 sky130_fd_sc_hd__decap_3
X_09004_ net1133 net716 net707 net1141 vssd1 vssd1 vccd1 vccd1 _03116_ sky130_fd_sc_hd__a22o_1
XFILLER_0_60_225 vssd1 vssd1 vccd1 vccd1 sky130_fd_sc_hd__decap_4
XFILLER_0_130_113 vssd1 vssd1 vccd1 vccd1 sky130_fd_sc_hd__fill_2
XFILLER_0_103_349 vssd1 vssd1 vccd1 vccd1 sky130_ef_sc_hd__decap_12
X_07196_ _01306_ _01319_ _01320_ net498 vssd1 vssd1 vccd1 vccd1 _01321_ sky130_fd_sc_hd__a211oi_2
XFILLER_0_13_174 vssd1 vssd1 vccd1 vccd1 sky130_fd_sc_hd__decap_4
XFILLER_0_41_494 vssd1 vssd1 vccd1 vccd1 sky130_fd_sc_hd__decap_3
XFILLER_0_111_393 vssd1 vssd1 vccd1 vccd1 sky130_ef_sc_hd__decap_12
X_09906_ net883 net940 _03865_ _03705_ net931 vssd1 vssd1 vccd1 vccd1 _04013_ sky130_fd_sc_hd__a32o_1
Xfanout522 net523 vssd1 vssd1 vccd1 vccd1 net522 sky130_fd_sc_hd__clkbuf_4
Xfanout533 _06027_ vssd1 vssd1 vccd1 vccd1 net533 sky130_fd_sc_hd__clkbuf_4
Xfanout500 net501 vssd1 vssd1 vccd1 vccd1 net500 sky130_fd_sc_hd__buf_4
Xfanout511 net512 vssd1 vssd1 vccd1 vccd1 net511 sky130_fd_sc_hd__clkbuf_4
Xfanout544 net548 vssd1 vssd1 vccd1 vccd1 net544 sky130_fd_sc_hd__buf_2
Xfanout566 net567 vssd1 vssd1 vccd1 vccd1 net566 sky130_fd_sc_hd__buf_2
Xfanout555 net556 vssd1 vssd1 vccd1 vccd1 net555 sky130_fd_sc_hd__clkbuf_4
X_09837_ _03942_ _03943_ vssd1 vssd1 vccd1 vccd1 _03944_ sky130_fd_sc_hd__nor2_2
XTAP_380 vssd1 vccd1 sky130_fd_sc_hd__tapvpwrvgnd_1
XTAP_391 vssd1 vccd1 sky130_fd_sc_hd__tapvpwrvgnd_1
Xfanout599 _01003_ vssd1 vssd1 vccd1 vccd1 net599 sky130_fd_sc_hd__clkbuf_2
Xfanout588 net589 vssd1 vssd1 vccd1 vccd1 net588 sky130_fd_sc_hd__clkbuf_4
Xfanout577 _06196_ vssd1 vssd1 vccd1 vccd1 net577 sky130_fd_sc_hd__clkbuf_4
X_09768_ _03708_ _03716_ _03715_ vssd1 vssd1 vccd1 vccd1 _03876_ sky130_fd_sc_hd__a21bo_2
XTAP_2225 vssd1 vccd1 sky130_fd_sc_hd__tapvpwrvgnd_1
XTAP_2214 vssd1 vccd1 sky130_fd_sc_hd__tapvpwrvgnd_1
XTAP_2203 vssd1 vccd1 sky130_fd_sc_hd__tapvpwrvgnd_1
X_08719_ _02827_ _02832_ vssd1 vssd1 vccd1 vccd1 _02833_ sky130_fd_sc_hd__nand2_1
XFILLER_0_69_815 vssd1 vssd1 vccd1 vccd1 sky130_fd_sc_hd__fill_1
XTAP_2247 vssd1 vccd1 sky130_fd_sc_hd__tapvpwrvgnd_1
XTAP_2236 vssd1 vccd1 sky130_fd_sc_hd__tapvpwrvgnd_1
X_09699_ net1046 net759 _03804_ _03806_ vssd1 vssd1 vccd1 vccd1 _03807_ sky130_fd_sc_hd__and4_1
XFILLER_0_96_645 vssd1 vssd1 vccd1 vccd1 sky130_ef_sc_hd__decap_12
XTAP_1524 vssd1 vccd1 sky130_fd_sc_hd__tapvpwrvgnd_1
XTAP_1513 vssd1 vccd1 sky130_fd_sc_hd__tapvpwrvgnd_1
XTAP_1502 vssd1 vccd1 sky130_fd_sc_hd__tapvpwrvgnd_1
XPHY_20 vssd1 vssd1 vccd1 vccd1 sky130_fd_sc_hd__decap_3
X_11730_ net651 _00828_ net473 net180 _05786_ vssd1 vssd1 vccd1 vccd1 _05787_ sky130_fd_sc_hd__a221o_1
XPHY_31 vssd1 vssd1 vccd1 vccd1 sky130_fd_sc_hd__decap_3
XFILLER_0_96_678 vssd1 vssd1 vccd1 vccd1 sky130_ef_sc_hd__decap_12
XFILLER_0_95_155 vssd1 vssd1 vccd1 vccd1 sky130_fd_sc_hd__fill_1
XTAP_1557 vssd1 vccd1 sky130_fd_sc_hd__tapvpwrvgnd_1
XTAP_1546 vssd1 vccd1 sky130_fd_sc_hd__tapvpwrvgnd_1
XTAP_1535 vssd1 vccd1 sky130_fd_sc_hd__tapvpwrvgnd_1
XPHY_42 vssd1 vssd1 vccd1 vccd1 sky130_fd_sc_hd__decap_3
XPHY_53 vssd1 vssd1 vccd1 vccd1 sky130_fd_sc_hd__decap_3
XPHY_64 vssd1 vssd1 vccd1 vccd1 sky130_fd_sc_hd__decap_3
XTAP_1579 vssd1 vccd1 sky130_fd_sc_hd__tapvpwrvgnd_1
XTAP_1568 vssd1 vccd1 sky130_fd_sc_hd__tapvpwrvgnd_1
XPHY_97 vssd1 vssd1 vccd1 vccd1 sky130_fd_sc_hd__decap_3
X_11661_ net1150 _05752_ vssd1 vssd1 vccd1 vccd1 _05754_ sky130_fd_sc_hd__nor2_1
XPHY_75 vssd1 vssd1 vccd1 vccd1 sky130_fd_sc_hd__decap_3
XPHY_86 vssd1 vssd1 vccd1 vccd1 sky130_fd_sc_hd__decap_3
XFILLER_0_126_419 vssd1 vssd1 vccd1 vccd1 sky130_fd_sc_hd__fill_1
X_10612_ _04712_ _04713_ vssd1 vssd1 vccd1 vccd1 _04714_ sky130_fd_sc_hd__nand2_1
XFILLER_0_64_542 vssd1 vssd1 vccd1 vccd1 sky130_fd_sc_hd__decap_3
X_11592_ _05661_ _05662_ _05660_ vssd1 vssd1 vccd1 vccd1 _05686_ sky130_fd_sc_hd__o21ba_1
XFILLER_0_106_121 vssd1 vssd1 vccd1 vccd1 sky130_ef_sc_hd__decap_12
X_10543_ _04644_ _04645_ _04627_ vssd1 vssd1 vccd1 vccd1 _04646_ sky130_fd_sc_hd__o21a_1
XFILLER_0_52_704 vssd1 vssd1 vccd1 vccd1 sky130_fd_sc_hd__fill_2
XFILLER_0_106_165 vssd1 vssd1 vccd1 vccd1 sky130_ef_sc_hd__decap_12
XFILLER_0_51_225 vssd1 vssd1 vccd1 vccd1 sky130_fd_sc_hd__decap_3
XFILLER_0_122_625 vssd1 vssd1 vccd1 vccd1 sky130_ef_sc_hd__decap_12
XFILLER_0_121_113 vssd1 vssd1 vccd1 vccd1 sky130_ef_sc_hd__decap_12
X_10474_ _04574_ _04575_ _04576_ vssd1 vssd1 vccd1 vccd1 _04577_ sky130_fd_sc_hd__nand3_2
XFILLER_0_122_669 vssd1 vssd1 vccd1 vccd1 sky130_ef_sc_hd__decap_12
X_13193_ clknet_leaf_19_clk_i _00579_ net1178 vssd1 vssd1 vccd1 vccd1 l1\[22\] sky130_fd_sc_hd__dfrtp_1
X_12213_ x2mx1\[16\] net604 net586 temp1\[16\] vssd1 vssd1 vccd1 vccd1 _06162_ sky130_fd_sc_hd__a22o_1
X_12144_ x0mx2\[27\] net631 net592 y1my2\[27\] vssd1 vssd1 vccd1 vccd1 _06114_ sky130_fd_sc_hd__a22o_1
XFILLER_0_47_27 vssd1 vssd1 vccd1 vccd1 sky130_fd_sc_hd__fill_1
X_12075_ net1077 _06062_ net514 vssd1 vssd1 vccd1 vccd1 _00260_ sky130_fd_sc_hd__mux2_1
X_11026_ _05119_ _05124_ vssd1 vssd1 vccd1 vccd1 _05125_ sky130_fd_sc_hd__or2_1
XFILLER_0_2_29 vssd1 vssd1 vccd1 vccd1 sky130_ef_sc_hd__decap_12
XFILLER_0_63_48 vssd1 vssd1 vccd1 vccd1 sky130_fd_sc_hd__decap_8
X_12977_ clknet_leaf_32_clk_i _00363_ net1166 vssd1 vssd1 vccd1 vccd1 y1my2\[30\]
+ sky130_fd_sc_hd__dfrtp_1
X_11928_ net150 net659 net502 net246 _05950_ vssd1 vssd1 vccd1 vccd1 _05951_ sky130_fd_sc_hd__a221o_1
X_11859_ net75 net679 net609 net203 vssd1 vssd1 vccd1 vccd1 _05895_ sky130_fd_sc_hd__a22o_1
XFILLER_0_67_391 vssd1 vssd1 vccd1 vccd1 sky130_fd_sc_hd__fill_1
XANTENNA_29 net6 vssd1 vssd1 vccd1 vccd1 sky130_fd_sc_hd__diode_2
XFILLER_0_6_116 vssd1 vssd1 vccd1 vccd1 sky130_fd_sc_hd__fill_1
XANTENNA_18 v1x[27] vssd1 vssd1 vccd1 vccd1 sky130_fd_sc_hd__diode_2
XFILLER_0_12_41 vssd1 vssd1 vccd1 vccd1 sky130_ef_sc_hd__decap_12
XFILLER_0_15_406 vssd1 vssd1 vccd1 vccd1 sky130_fd_sc_hd__fill_1
XFILLER_0_27_277 vssd1 vssd1 vccd1 vccd1 sky130_fd_sc_hd__decap_3
XFILLER_0_125_441 vssd1 vssd1 vccd1 vccd1 sky130_fd_sc_hd__decap_6
XFILLER_0_12_85 vssd1 vssd1 vccd1 vccd1 sky130_ef_sc_hd__decap_12
X_07050_ _01121_ _01134_ _01171_ _01173_ vssd1 vssd1 vccd1 vccd1 _01175_ sky130_fd_sc_hd__a211oi_4
XFILLER_0_125_485 vssd1 vssd1 vccd1 vccd1 sky130_ef_sc_hd__decap_12
XFILLER_0_70_589 vssd1 vssd1 vccd1 vccd1 sky130_fd_sc_hd__decap_6
XFILLER_0_88_89 vssd1 vssd1 vccd1 vccd1 sky130_fd_sc_hd__fill_1
XFILLER_0_2_344 vssd1 vssd1 vccd1 vccd1 sky130_fd_sc_hd__decap_4
XFILLER_0_10_177 vssd1 vssd1 vccd1 vccd1 sky130_ef_sc_hd__decap_12
X_07952_ _02070_ _02071_ vssd1 vssd1 vccd1 vccd1 _02072_ sky130_fd_sc_hd__and2b_1
X_07883_ _01985_ _02001_ _02002_ vssd1 vssd1 vccd1 vccd1 _02004_ sky130_fd_sc_hd__nand3_1
X_06903_ _01026_ _01027_ vssd1 vssd1 vccd1 vccd1 _01028_ sky130_fd_sc_hd__nor2_1
X_06834_ net1531 posx\[0\] net646 vssd1 vssd1 vccd1 vccd1 _00108_ sky130_fd_sc_hd__mux2_1
X_09622_ _03728_ _03729_ _03671_ vssd1 vssd1 vccd1 vccd1 _03731_ sky130_fd_sc_hd__a21oi_2
X_09553_ _03484_ _03492_ _03491_ vssd1 vssd1 vccd1 vccd1 _03662_ sky130_fd_sc_hd__a21bo_1
XFILLER_0_78_645 vssd1 vssd1 vccd1 vccd1 sky130_fd_sc_hd__fill_2
X_08504_ net875 net866 net1000 net993 vssd1 vssd1 vccd1 vccd1 _02620_ sky130_fd_sc_hd__and4_1
X_06765_ net1446 net1398 net637 vssd1 vssd1 vccd1 vccd1 _00039_ sky130_fd_sc_hd__mux2_1
X_09484_ net1142 net700 net695 net1133 vssd1 vssd1 vccd1 vccd1 _03593_ sky130_fd_sc_hd__and4b_2
XFILLER_0_78_689 vssd1 vssd1 vccd1 vccd1 sky130_fd_sc_hd__decap_3
X_06696_ sub1.a_i\[22\] sub1.b_i\[22\] vssd1 vssd1 vccd1 vccd1 _00919_ sky130_fd_sc_hd__and2b_1
X_08435_ _02547_ _02550_ vssd1 vssd1 vccd1 vccd1 _02551_ sky130_fd_sc_hd__nand2_1
XFILLER_0_92_114 vssd1 vssd1 vccd1 vccd1 sky130_fd_sc_hd__decap_8
XFILLER_0_77_199 vssd1 vssd1 vccd1 vccd1 sky130_fd_sc_hd__decap_6
XFILLER_0_19_701 vssd1 vssd1 vccd1 vccd1 sky130_fd_sc_hd__fill_2
X_08366_ _02481_ _02482_ _02464_ vssd1 vssd1 vccd1 vccd1 _02483_ sky130_fd_sc_hd__a21o_1
XFILLER_0_46_520 vssd1 vssd1 vccd1 vccd1 sky130_fd_sc_hd__decap_3
XFILLER_0_19_767 vssd1 vssd1 vccd1 vccd1 sky130_fd_sc_hd__fill_1
XFILLER_0_73_350 vssd1 vssd1 vccd1 vccd1 sky130_fd_sc_hd__fill_1
XFILLER_0_46_564 vssd1 vssd1 vccd1 vccd1 sky130_fd_sc_hd__decap_8
X_07317_ _01440_ _01441_ vssd1 vssd1 vccd1 vccd1 _01442_ sky130_fd_sc_hd__nand2_1
X_08297_ _02409_ _02412_ _02413_ _02404_ vssd1 vssd1 vccd1 vccd1 _02414_ sky130_fd_sc_hd__o211a_1
XFILLER_0_46_597 vssd1 vssd1 vccd1 vccd1 sky130_fd_sc_hd__decap_6
XFILLER_0_33_225 vssd1 vssd1 vccd1 vccd1 sky130_fd_sc_hd__fill_2
XFILLER_0_103_113 vssd1 vssd1 vccd1 vccd1 sky130_ef_sc_hd__decap_12
X_07248_ _01369_ _01372_ vssd1 vssd1 vccd1 vccd1 _01373_ sky130_fd_sc_hd__xnor2_1
XFILLER_0_6_694 vssd1 vssd1 vccd1 vccd1 sky130_fd_sc_hd__fill_1
XFILLER_0_104_669 vssd1 vssd1 vccd1 vccd1 sky130_ef_sc_hd__decap_12
X_07179_ _01290_ _01301_ _01302_ vssd1 vssd1 vccd1 vccd1 _01304_ sky130_fd_sc_hd__nand3_1
XFILLER_0_103_179 vssd1 vssd1 vccd1 vccd1 sky130_fd_sc_hd__decap_6
X_10190_ _04292_ _04293_ _04288_ vssd1 vssd1 vccd1 vccd1 _04295_ sky130_fd_sc_hd__a21o_1
X_12900_ clknet_leaf_50_clk_i _00286_ vssd1 vssd1 vccd1 vccd1 mul1.b\[3\] sky130_fd_sc_hd__dfxtp_1
XTAP_2000 vssd1 vccd1 sky130_fd_sc_hd__tapvpwrvgnd_1
X_12831_ clknet_leaf_28_clk_i _00217_ vssd1 vssd1 vccd1 vccd1 sub1.a_i\[30\] sky130_fd_sc_hd__dfxtp_1
XTAP_2033 vssd1 vccd1 sky130_fd_sc_hd__tapvpwrvgnd_1
XTAP_2022 vssd1 vccd1 sky130_fd_sc_hd__tapvpwrvgnd_1
XTAP_2011 vssd1 vccd1 sky130_fd_sc_hd__tapvpwrvgnd_1
XFILLER_0_68_111 vssd1 vssd1 vccd1 vccd1 sky130_fd_sc_hd__fill_1
XTAP_2077 vssd1 vccd1 sky130_fd_sc_hd__tapvpwrvgnd_1
XTAP_2055 vssd1 vccd1 sky130_fd_sc_hd__tapvpwrvgnd_1
XTAP_2066 vssd1 vccd1 sky130_fd_sc_hd__tapvpwrvgnd_1
XTAP_2044 vssd1 vccd1 sky130_fd_sc_hd__tapvpwrvgnd_1
XTAP_1332 vssd1 vccd1 sky130_fd_sc_hd__tapvpwrvgnd_1
XTAP_1321 vssd1 vccd1 sky130_fd_sc_hd__tapvpwrvgnd_1
XTAP_1310 vssd1 vccd1 sky130_fd_sc_hd__tapvpwrvgnd_1
X_12762_ clknet_leaf_24_clk_i _00148_ vssd1 vssd1 vccd1 vccd1 add1.a_i\[25\] sky130_fd_sc_hd__dfxtp_1
XTAP_2099 vssd1 vccd1 sky130_fd_sc_hd__tapvpwrvgnd_1
XTAP_2088 vssd1 vccd1 sky130_fd_sc_hd__tapvpwrvgnd_1
X_12693_ clknet_leaf_14_clk_i net1405 net1186 vssd1 vssd1 vccd1 vccd1 net423 sky130_fd_sc_hd__dfrtp_1
XFILLER_0_83_103 vssd1 vssd1 vccd1 vccd1 sky130_fd_sc_hd__decap_8
XTAP_1365 vssd1 vccd1 sky130_fd_sc_hd__tapvpwrvgnd_1
XTAP_1354 vssd1 vccd1 sky130_fd_sc_hd__tapvpwrvgnd_1
XTAP_1343 vssd1 vccd1 sky130_fd_sc_hd__tapvpwrvgnd_1
X_11713_ net165 net473 _05770_ _05772_ vssd1 vssd1 vccd1 vccd1 _05773_ sky130_fd_sc_hd__a211o_1
XTAP_1398 vssd1 vccd1 sky130_fd_sc_hd__tapvpwrvgnd_1
XTAP_1387 vssd1 vccd1 sky130_fd_sc_hd__tapvpwrvgnd_1
XTAP_1376 vssd1 vccd1 sky130_fd_sc_hd__tapvpwrvgnd_1
X_11644_ net789 net929 vssd1 vssd1 vccd1 vccd1 _05738_ sky130_fd_sc_hd__nand2_1
XFILLER_0_83_169 vssd1 vssd1 vccd1 vccd1 sky130_fd_sc_hd__decap_4
XFILLER_0_24_203 vssd1 vssd1 vccd1 vccd1 sky130_fd_sc_hd__fill_1
Xinput16 div_sstream_i[22] vssd1 vssd1 vccd1 vccd1 net16 sky130_fd_sc_hd__clkbuf_8
Xinput27 div_sstream_i[3] vssd1 vssd1 vccd1 vccd1 net27 sky130_fd_sc_hd__clkbuf_8
X_11575_ _05445_ _05448_ _05559_ _05560_ vssd1 vssd1 vccd1 vccd1 _05670_ sky130_fd_sc_hd__a31o_1
X_10526_ _04405_ _04407_ vssd1 vssd1 vccd1 vccd1 _04629_ sky130_fd_sc_hd__nand2_1
Xinput49 sstream_i[1] vssd1 vssd1 vccd1 vccd1 net49 sky130_fd_sc_hd__buf_4
Xinput38 sstream_i[0] vssd1 vssd1 vccd1 vccd1 net38 sky130_fd_sc_hd__buf_4
XFILLER_0_122_433 vssd1 vssd1 vccd1 vccd1 sky130_ef_sc_hd__decap_12
X_10457_ _04557_ _04558_ _04545_ vssd1 vssd1 vccd1 vccd1 _04560_ sky130_fd_sc_hd__a21oi_1
XFILLER_0_52_589 vssd1 vssd1 vccd1 vccd1 sky130_fd_sc_hd__decap_4
XFILLER_0_122_477 vssd1 vssd1 vccd1 vccd1 sky130_ef_sc_hd__decap_12
X_10388_ _04489_ _04490_ _04485_ vssd1 vssd1 vccd1 vccd1 _04492_ sky130_fd_sc_hd__a21o_1
X_13176_ clknet_leaf_21_clk_i _00562_ net1174 vssd1 vssd1 vccd1 vccd1 l1\[5\] sky130_fd_sc_hd__dfrtp_1
X_12127_ net978 _06101_ net517 vssd1 vssd1 vccd1 vccd1 _00273_ sky130_fd_sc_hd__mux2_1
X_12058_ net526 _05752_ _06032_ _06049_ vssd1 vssd1 vccd1 vccd1 _06050_ sky130_fd_sc_hd__a31o_1
X_11009_ net765 net969 net963 net775 vssd1 vssd1 vccd1 vccd1 _05108_ sky130_fd_sc_hd__a22o_1
XFILLER_0_59_111 vssd1 vssd1 vccd1 vccd1 sky130_fd_sc_hd__fill_1
X_06550_ _00623_ _00673_ vssd1 vssd1 vccd1 vccd1 _00799_ sky130_fd_sc_hd__xor2_4
XFILLER_0_75_637 vssd1 vssd1 vccd1 vccd1 sky130_fd_sc_hd__fill_1
XFILLER_0_75_615 vssd1 vssd1 vccd1 vccd1 sky130_fd_sc_hd__fill_1
X_06481_ add1.a_i\[30\] add1.b_i\[30\] vssd1 vssd1 vccd1 vccd1 _00776_ sky130_fd_sc_hd__or2_1
XFILLER_0_117_205 vssd1 vssd1 vccd1 vccd1 sky130_ef_sc_hd__decap_12
XFILLER_0_114_53 vssd1 vssd1 vccd1 vccd1 sky130_ef_sc_hd__decap_12
X_08220_ net1033 net1043 net849 net840 vssd1 vssd1 vccd1 vccd1 _02338_ sky130_fd_sc_hd__nand4_1
XFILLER_0_59_199 vssd1 vssd1 vccd1 vccd1 sky130_ef_sc_hd__decap_12
XFILLER_0_23_51 vssd1 vssd1 vccd1 vccd1 sky130_fd_sc_hd__decap_4
XFILLER_0_117_249 vssd1 vssd1 vccd1 vccd1 sky130_ef_sc_hd__decap_12
XFILLER_0_114_97 vssd1 vssd1 vccd1 vccd1 sky130_ef_sc_hd__decap_12
XFILLER_0_62_309 vssd1 vssd1 vccd1 vccd1 sky130_fd_sc_hd__decap_4
XFILLER_0_28_553 vssd1 vssd1 vccd1 vccd1 sky130_ef_sc_hd__decap_12
XFILLER_0_99_55 vssd1 vssd1 vccd1 vccd1 sky130_fd_sc_hd__fill_1
X_08151_ _02152_ net1753 _02268_ _02269_ vssd1 vssd1 vccd1 vccd1 _02270_ sky130_fd_sc_hd__o211a_2
XFILLER_0_55_383 vssd1 vssd1 vccd1 vccd1 sky130_fd_sc_hd__decap_3
XFILLER_0_82_191 vssd1 vssd1 vccd1 vccd1 sky130_fd_sc_hd__decap_4
X_08082_ _02199_ _02200_ vssd1 vssd1 vccd1 vccd1 _02201_ sky130_fd_sc_hd__and2b_1
X_07102_ _01225_ _01226_ vssd1 vssd1 vccd1 vccd1 _01227_ sky130_fd_sc_hd__and2b_1
XFILLER_0_130_85 vssd1 vssd1 vccd1 vccd1 sky130_fd_sc_hd__decap_4
X_07033_ _01156_ _01157_ _01142_ vssd1 vssd1 vccd1 vccd1 _01158_ sky130_fd_sc_hd__a21o_1
X_08984_ _02991_ _02992_ _03093_ _03094_ vssd1 vssd1 vccd1 vccd1 _03097_ sky130_fd_sc_hd__o22ai_1
XFILLER_0_54_3 vssd1 vssd1 vccd1 vccd1 sky130_ef_sc_hd__decap_12
X_07935_ _01848_ _01946_ _01945_ vssd1 vssd1 vccd1 vccd1 _02056_ sky130_fd_sc_hd__o21ai_1
X_07866_ net1084 net822 net814 net1091 vssd1 vssd1 vccd1 vccd1 _01987_ sky130_fd_sc_hd__a22o_1
X_09605_ _03710_ _03711_ _03712_ vssd1 vssd1 vccd1 vccd1 _03714_ sky130_fd_sc_hd__or3_1
XFILLER_0_3_61 vssd1 vssd1 vccd1 vccd1 sky130_fd_sc_hd__fill_1
X_06817_ net1408 net1380 net645 vssd1 vssd1 vccd1 vccd1 _00091_ sky130_fd_sc_hd__mux2_1
X_07797_ _01820_ _01821_ _01822_ vssd1 vssd1 vccd1 vccd1 _01919_ sky130_fd_sc_hd__a21bo_1
X_09536_ net1054 net759 _03641_ _03643_ vssd1 vssd1 vccd1 vccd1 _03645_ sky130_fd_sc_hd__nand4_1
X_06748_ _00962_ _00963_ vssd1 vssd1 vccd1 vccd1 _00964_ sky130_fd_sc_hd__nand2_2
X_09467_ _03575_ _03576_ vssd1 vssd1 vccd1 vccd1 _03577_ sky130_fd_sc_hd__nand2_1
X_08418_ _02532_ _02533_ _02289_ vssd1 vssd1 vccd1 vccd1 _02535_ sky130_fd_sc_hd__o21a_1
X_06679_ sub1.b_i\[19\] sub1.a_i\[19\] vssd1 vssd1 vccd1 vccd1 _00905_ sky130_fd_sc_hd__and2b_1
XFILLER_0_19_520 vssd1 vssd1 vccd1 vccd1 sky130_fd_sc_hd__fill_2
XFILLER_0_38_339 vssd1 vssd1 vccd1 vccd1 sky130_fd_sc_hd__decap_4
X_09398_ net833 net827 net988 vssd1 vssd1 vccd1 vccd1 _03508_ sky130_fd_sc_hd__and3_1
XFILLER_0_65_169 vssd1 vssd1 vccd1 vccd1 sky130_fd_sc_hd__decap_4
X_08349_ net1067 net805 vssd1 vssd1 vccd1 vccd1 _02466_ sky130_fd_sc_hd__nand2_1
XFILLER_0_80_139 vssd1 vssd1 vccd1 vccd1 sky130_fd_sc_hd__fill_1
XFILLER_0_73_191 vssd1 vssd1 vccd1 vccd1 sky130_fd_sc_hd__decap_3
XFILLER_0_34_545 vssd1 vssd1 vccd1 vccd1 sky130_fd_sc_hd__decap_4
X_11360_ _04961_ _05455_ vssd1 vssd1 vccd1 vccd1 _05456_ sky130_fd_sc_hd__nand2_1
XFILLER_0_104_444 vssd1 vssd1 vccd1 vccd1 sky130_fd_sc_hd__decap_4
X_10311_ _04413_ _04414_ _04253_ _04256_ vssd1 vssd1 vccd1 vccd1 _04415_ sky130_fd_sc_hd__o211ai_2
XFILLER_0_6_491 vssd1 vssd1 vccd1 vccd1 sky130_fd_sc_hd__fill_1
XFILLER_0_15_781 vssd1 vssd1 vccd1 vccd1 sky130_fd_sc_hd__decap_3
XFILLER_0_34_589 vssd1 vssd1 vccd1 vccd1 sky130_ef_sc_hd__decap_12
X_13030_ clknet_leaf_35_clk_i _00416_ net1161 vssd1 vssd1 vccd1 vccd1 x0mx2\[19\]
+ sky130_fd_sc_hd__dfrtp_1
X_11291_ net1019 net1011 net712 net708 vssd1 vssd1 vccd1 vccd1 _05388_ sky130_fd_sc_hd__and4_1
XFILLER_0_104_499 vssd1 vssd1 vccd1 vccd1 sky130_fd_sc_hd__decap_8
X_10242_ _04338_ _04344_ _04345_ vssd1 vssd1 vccd1 vccd1 _04347_ sky130_fd_sc_hd__nand3_2
X_10173_ net1013 net1005 net779 net769 vssd1 vssd1 vccd1 vccd1 _04278_ sky130_fd_sc_hd__and4_1
Xfanout1103 net1104 vssd1 vssd1 vccd1 vccd1 net1103 sky130_fd_sc_hd__buf_2
XFILLER_0_28_29 vssd1 vssd1 vccd1 vccd1 sky130_fd_sc_hd__decap_8
Xfanout1114 net1115 vssd1 vssd1 vccd1 vccd1 net1114 sky130_fd_sc_hd__buf_2
Xfanout1125 mul1.a\[3\] vssd1 vssd1 vccd1 vccd1 net1125 sky130_fd_sc_hd__dlymetal6s2s_1
Xfanout1147 net1148 vssd1 vssd1 vccd1 vccd1 net1147 sky130_fd_sc_hd__clkbuf_4
Xfanout1136 net1137 vssd1 vssd1 vccd1 vccd1 net1136 sky130_fd_sc_hd__clkbuf_2
Xfanout1158 net1164 vssd1 vssd1 vccd1 vccd1 net1158 sky130_fd_sc_hd__clkbuf_2
Xfanout1169 net1173 vssd1 vssd1 vccd1 vccd1 net1169 sky130_fd_sc_hd__clkbuf_2
XFILLER_0_89_729 vssd1 vssd1 vccd1 vccd1 sky130_ef_sc_hd__decap_12
X_12814_ clknet_leaf_50_clk_i _00200_ vssd1 vssd1 vccd1 vccd1 sub1.a_i\[13\] sky130_fd_sc_hd__dfxtp_1
XTAP_1140 vssd1 vccd1 sky130_fd_sc_hd__tapvpwrvgnd_1
XFILLER_0_56_114 vssd1 vssd1 vccd1 vccd1 sky130_ef_sc_hd__decap_12
X_12745_ clknet_leaf_58_clk_i _00131_ vssd1 vssd1 vccd1 vccd1 add1.a_i\[8\] sky130_fd_sc_hd__dfxtp_1
XFILLER_0_127_503 vssd1 vssd1 vccd1 vccd1 sky130_fd_sc_hd__fill_1
XTAP_1173 vssd1 vccd1 sky130_fd_sc_hd__tapvpwrvgnd_1
XTAP_1162 vssd1 vccd1 sky130_fd_sc_hd__tapvpwrvgnd_1
XTAP_1151 vssd1 vccd1 sky130_fd_sc_hd__tapvpwrvgnd_1
XFILLER_0_84_467 vssd1 vssd1 vccd1 vccd1 sky130_fd_sc_hd__decap_8
X_12676_ clknet_leaf_15_clk_i net1345 net1182 vssd1 vssd1 vccd1 vccd1 net404 sky130_fd_sc_hd__dfrtp_1
XTAP_1195 vssd1 vccd1 sky130_fd_sc_hd__tapvpwrvgnd_1
XTAP_1184 vssd1 vccd1 sky130_fd_sc_hd__tapvpwrvgnd_1
X_11627_ _05622_ _05720_ vssd1 vssd1 vccd1 vccd1 _05721_ sky130_fd_sc_hd__xnor2_1
X_11558_ _05611_ _05652_ vssd1 vssd1 vccd1 vccd1 _05653_ sky130_fd_sc_hd__xor2_1
XFILLER_0_123_753 vssd1 vssd1 vccd1 vccd1 sky130_ef_sc_hd__decap_12
XFILLER_0_80_673 vssd1 vssd1 vccd1 vccd1 sky130_fd_sc_hd__decap_8
X_10509_ net1078 net704 _04609_ _04610_ vssd1 vssd1 vccd1 vccd1 _04612_ sky130_fd_sc_hd__o2bb2a_1
XFILLER_0_123_797 vssd1 vssd1 vccd1 vccd1 sky130_ef_sc_hd__decap_12
XFILLER_0_52_397 vssd1 vssd1 vccd1 vccd1 sky130_fd_sc_hd__fill_1
X_11489_ _05575_ _05583_ vssd1 vssd1 vccd1 vccd1 _05584_ sky130_fd_sc_hd__xor2_1
X_13228_ net507 vssd1 vssd1 vccd1 vccd1 net283 sky130_fd_sc_hd__clkbuf_1
XFILLER_0_100_77 vssd1 vssd1 vccd1 vccd1 sky130_fd_sc_hd__decap_6
XFILLER_0_110_458 vssd1 vssd1 vccd1 vccd1 sky130_fd_sc_hd__fill_2
X_13159_ clknet_leaf_12_clk_i _00545_ net1187 vssd1 vssd1 vccd1 vccd1 l0\[20\] sky130_fd_sc_hd__dfrtp_1
XTAP_935 vssd1 vccd1 sky130_fd_sc_hd__tapvpwrvgnd_1
XTAP_924 vssd1 vccd1 sky130_fd_sc_hd__tapvpwrvgnd_1
XTAP_902 vssd1 vccd1 sky130_fd_sc_hd__tapvpwrvgnd_1
XTAP_913 vssd1 vccd1 sky130_fd_sc_hd__tapvpwrvgnd_1
XFILLER_0_85_57 vssd1 vssd1 vccd1 vccd1 sky130_fd_sc_hd__decap_3
XTAP_968 vssd1 vccd1 sky130_fd_sc_hd__tapvpwrvgnd_1
XTAP_957 vssd1 vccd1 sky130_fd_sc_hd__tapvpwrvgnd_1
XTAP_946 vssd1 vccd1 sky130_fd_sc_hd__tapvpwrvgnd_1
XFILLER_0_40_9 vssd1 vssd1 vccd1 vccd1 sky130_fd_sc_hd__decap_8
X_07720_ _01783_ _01784_ _01840_ _01841_ vssd1 vssd1 vccd1 vccd1 _01843_ sky130_fd_sc_hd__a22o_1
XTAP_979 vssd1 vccd1 sky130_fd_sc_hd__tapvpwrvgnd_1
X_07651_ _01765_ _01773_ vssd1 vssd1 vccd1 vccd1 _01774_ sky130_fd_sc_hd__xor2_1
X_07582_ net1058 net873 net864 net1066 vssd1 vssd1 vccd1 vccd1 _01706_ sky130_fd_sc_hd__a22o_1
X_06602_ net1720 _00840_ net650 vssd1 vssd1 vccd1 vccd1 _00009_ sky130_fd_sc_hd__mux2_1
X_06533_ net544 _00789_ vssd1 vssd1 vccd1 vccd1 net300 sky130_fd_sc_hd__nor2_1
X_09321_ _03427_ _03428_ _03430_ vssd1 vssd1 vccd1 vccd1 _03431_ sky130_fd_sc_hd__or3_1
XFILLER_0_88_773 vssd1 vssd1 vccd1 vccd1 sky130_fd_sc_hd__fill_2
XFILLER_0_75_401 vssd1 vssd1 vccd1 vccd1 sky130_fd_sc_hd__fill_1
XFILLER_0_34_61 vssd1 vssd1 vccd1 vccd1 sky130_fd_sc_hd__decap_8
XFILLER_0_75_445 vssd1 vssd1 vccd1 vccd1 sky130_fd_sc_hd__decap_3
XFILLER_0_47_136 vssd1 vssd1 vccd1 vccd1 sky130_fd_sc_hd__decap_3
XFILLER_0_34_83 vssd1 vssd1 vccd1 vccd1 sky130_fd_sc_hd__fill_1
XFILLER_0_118_525 vssd1 vssd1 vccd1 vccd1 sky130_fd_sc_hd__decap_6
X_09252_ net869 net968 net962 net877 vssd1 vssd1 vccd1 vccd1 _03363_ sky130_fd_sc_hd__a22o_1
X_06464_ _00745_ _00746_ _00760_ vssd1 vssd1 vccd1 vccd1 _00761_ sky130_fd_sc_hd__and3_1
XFILLER_0_47_169 vssd1 vssd1 vccd1 vccd1 sky130_fd_sc_hd__fill_2
XFILLER_0_118_569 vssd1 vssd1 vccd1 vccd1 sky130_ef_sc_hd__decap_12
X_09183_ _03164_ _03167_ _03292_ vssd1 vssd1 vccd1 vccd1 _03294_ sky130_fd_sc_hd__and3_1
XFILLER_0_106_709 vssd1 vssd1 vccd1 vccd1 sky130_fd_sc_hd__decap_8
X_08203_ _02190_ _02198_ _02197_ vssd1 vssd1 vccd1 vccd1 _02321_ sky130_fd_sc_hd__a21o_1
XFILLER_0_56_692 vssd1 vssd1 vccd1 vccd1 sky130_fd_sc_hd__decap_3
X_06395_ _00700_ _00701_ vssd1 vssd1 vccd1 vccd1 _00702_ sky130_fd_sc_hd__or2_1
XFILLER_0_71_662 vssd1 vssd1 vccd1 vccd1 sky130_fd_sc_hd__decap_3
X_08134_ _02251_ _02252_ _02244_ vssd1 vssd1 vccd1 vccd1 _02253_ sky130_fd_sc_hd__a21o_1
XFILLER_0_55_191 vssd1 vssd1 vccd1 vccd1 sky130_fd_sc_hd__fill_2
XFILLER_0_50_93 vssd1 vssd1 vccd1 vccd1 sky130_fd_sc_hd__fill_2
XFILLER_0_71_673 vssd1 vssd1 vccd1 vccd1 sky130_fd_sc_hd__fill_1
XFILLER_0_70_172 vssd1 vssd1 vccd1 vccd1 sky130_fd_sc_hd__decap_3
XFILLER_0_16_578 vssd1 vssd1 vccd1 vccd1 sky130_fd_sc_hd__fill_2
X_08065_ net1131 net755 _02180_ _02182_ vssd1 vssd1 vccd1 vccd1 _02184_ sky130_fd_sc_hd__a22oi_1
XFILLER_0_101_447 vssd1 vssd1 vccd1 vccd1 sky130_fd_sc_hd__fill_1
X_07016_ _01066_ _01136_ _01138_ _01139_ vssd1 vssd1 vccd1 vccd1 _01141_ sky130_fd_sc_hd__or4_4
XFILLER_0_59_91 vssd1 vssd1 vccd1 vccd1 sky130_fd_sc_hd__fill_1
XFILLER_0_12_784 vssd1 vssd1 vccd1 vccd1 sky130_ef_sc_hd__decap_12
Xinput217 v2x[9] vssd1 vssd1 vccd1 vccd1 net217 sky130_fd_sc_hd__buf_1
Xinput206 v2x[28] vssd1 vssd1 vccd1 vccd1 net206 sky130_fd_sc_hd__buf_1
X_08967_ _03078_ _03079_ _03061_ vssd1 vssd1 vccd1 vccd1 _03080_ sky130_fd_sc_hd__a21oi_2
Xinput228 v2y[19] vssd1 vssd1 vccd1 vccd1 net228 sky130_fd_sc_hd__buf_1
Xinput239 v2y[29] vssd1 vssd1 vccd1 vccd1 net239 sky130_fd_sc_hd__buf_1
X_08898_ net825 _02889_ _02890_ _02887_ vssd1 vssd1 vccd1 vccd1 _03011_ sky130_fd_sc_hd__o2bb2a_1
X_07918_ _02035_ _02037_ _01925_ _01929_ vssd1 vssd1 vccd1 vccd1 _02039_ sky130_fd_sc_hd__o211a_1
X_07849_ net1106 net1115 net786 vssd1 vssd1 vccd1 vccd1 _01970_ sky130_fd_sc_hd__and3_1
Xclkbuf_leaf_3_clk_i clknet_3_2__leaf_clk_i vssd1 vssd1 vccd1 vccd1 clknet_leaf_3_clk_i
+ sky130_fd_sc_hd__clkbuf_16
XFILLER_0_98_559 vssd1 vssd1 vccd1 vccd1 sky130_fd_sc_hd__fill_1
X_10860_ _04677_ _04822_ _04675_ vssd1 vssd1 vccd1 vccd1 _04960_ sky130_fd_sc_hd__a21oi_4
X_09519_ _03625_ _03626_ _03456_ _03459_ vssd1 vssd1 vccd1 vccd1 _03628_ sky130_fd_sc_hd__a211oi_2
XPHY_201 vssd1 vssd1 vccd1 vccd1 sky130_fd_sc_hd__decap_3
XPHY_234 vssd1 vssd1 vccd1 vccd1 sky130_fd_sc_hd__decap_3
XPHY_223 vssd1 vssd1 vccd1 vccd1 sky130_fd_sc_hd__decap_3
XPHY_212 vssd1 vssd1 vccd1 vccd1 sky130_fd_sc_hd__decap_3
XFILLER_0_93_220 vssd1 vssd1 vccd1 vccd1 sky130_fd_sc_hd__decap_4
X_10791_ _04854_ _04855_ _04889_ _04890_ vssd1 vssd1 vccd1 vccd1 _04892_ sky130_fd_sc_hd__o22a_1
XFILLER_0_38_136 vssd1 vssd1 vccd1 vccd1 sky130_fd_sc_hd__decap_4
XFILLER_0_39_648 vssd1 vssd1 vccd1 vccd1 sky130_fd_sc_hd__fill_1
X_12530_ _00738_ net565 vssd1 vssd1 vccd1 vccd1 _06262_ sky130_fd_sc_hd__nor2_1
XPHY_256 vssd1 vssd1 vccd1 vccd1 sky130_fd_sc_hd__decap_3
XPHY_245 vssd1 vssd1 vccd1 vccd1 sky130_fd_sc_hd__decap_3
XFILLER_0_109_525 vssd1 vssd1 vccd1 vccd1 sky130_fd_sc_hd__decap_8
X_12461_ net54 net688 _00923_ net617 vssd1 vssd1 vccd1 vccd1 _06226_ sky130_fd_sc_hd__a22o_1
X_11412_ _05507_ vssd1 vssd1 vccd1 vccd1 _05508_ sky130_fd_sc_hd__inv_2
XFILLER_0_62_673 vssd1 vssd1 vccd1 vccd1 sky130_fd_sc_hd__fill_2
X_12392_ net1549 _00887_ net683 vssd1 vssd1 vccd1 vccd1 _00444_ sky130_fd_sc_hd__mux2_1
XFILLER_0_120_701 vssd1 vssd1 vccd1 vccd1 sky130_ef_sc_hd__decap_12
X_11343_ _05438_ _05439_ vssd1 vssd1 vccd1 vccd1 _05440_ sky130_fd_sc_hd__nand2_1
X_11274_ _05249_ _05251_ _05370_ vssd1 vssd1 vccd1 vccd1 _05371_ sky130_fd_sc_hd__a21o_1
X_10225_ _04183_ _04193_ _04194_ _04181_ vssd1 vssd1 vccd1 vccd1 _04330_ sky130_fd_sc_hd__a31o_1
X_13013_ clknet_leaf_50_clk_i _00399_ net1159 vssd1 vssd1 vccd1 vccd1 x0mx2\[2\] sky130_fd_sc_hd__dfrtp_1
X_10156_ _04099_ _04102_ _04257_ _04258_ vssd1 vssd1 vccd1 vccd1 _04261_ sky130_fd_sc_hd__a211o_1
X_10087_ _04191_ _04192_ _04184_ vssd1 vssd1 vccd1 vccd1 _04193_ sky130_fd_sc_hd__a21o_1
Xhold5 l1\[22\] vssd1 vssd1 vccd1 vccd1 net1220 sky130_fd_sc_hd__dlygate4sd3_1
XFILLER_0_71_15 vssd1 vssd1 vccd1 vccd1 sky130_fd_sc_hd__decap_8
XFILLER_0_57_412 vssd1 vssd1 vccd1 vccd1 sky130_ef_sc_hd__decap_12
X_10989_ _04968_ _04969_ _04836_ vssd1 vssd1 vccd1 vccd1 _05088_ sky130_fd_sc_hd__a21o_1
XFILLER_0_29_125 vssd1 vssd1 vccd1 vccd1 sky130_fd_sc_hd__decap_3
X_12728_ clknet_leaf_8_clk_i net1504 net1194 vssd1 vssd1 vccd1 vccd1 net348 sky130_fd_sc_hd__dfrtp_1
XFILLER_0_84_253 vssd1 vssd1 vccd1 vccd1 sky130_fd_sc_hd__decap_8
X_12659_ clknet_leaf_21_clk_i _00045_ net1175 vssd1 vssd1 vccd1 vccd1 net386 sky130_fd_sc_hd__dfrtp_1
XFILLER_0_44_139 vssd1 vssd1 vccd1 vccd1 sky130_fd_sc_hd__fill_1
XFILLER_0_26_821 vssd1 vssd1 vccd1 vccd1 sky130_fd_sc_hd__fill_1
XFILLER_0_127_377 vssd1 vssd1 vccd1 vccd1 sky130_fd_sc_hd__fill_1
XFILLER_0_115_517 vssd1 vssd1 vccd1 vccd1 sky130_ef_sc_hd__decap_12
XFILLER_0_112_3 vssd1 vssd1 vccd1 vccd1 sky130_ef_sc_hd__decap_12
XFILLER_0_111_21 vssd1 vssd1 vccd1 vccd1 sky130_ef_sc_hd__decap_12
XFILLER_0_5_726 vssd1 vssd1 vccd1 vccd1 sky130_fd_sc_hd__fill_2
XFILLER_0_37_191 vssd1 vssd1 vccd1 vccd1 sky130_fd_sc_hd__fill_1
XFILLER_0_20_41 vssd1 vssd1 vccd1 vccd1 sky130_ef_sc_hd__decap_12
XFILLER_0_123_561 vssd1 vssd1 vccd1 vccd1 sky130_ef_sc_hd__decap_12
Xhold405 y1my2\[26\] vssd1 vssd1 vccd1 vccd1 net1620 sky130_fd_sc_hd__dlygate4sd3_1
XFILLER_0_20_85 vssd1 vssd1 vccd1 vccd1 sky130_ef_sc_hd__decap_12
Xhold427 x2mx1\[27\] vssd1 vssd1 vccd1 vccd1 net1642 sky130_fd_sc_hd__dlygate4sd3_1
Xhold416 y1my2\[9\] vssd1 vssd1 vccd1 vccd1 net1631 sky130_fd_sc_hd__dlygate4sd3_1
XFILLER_0_0_431 vssd1 vssd1 vccd1 vccd1 sky130_fd_sc_hd__fill_2
Xhold438 x2mx1\[20\] vssd1 vssd1 vccd1 vccd1 net1653 sky130_fd_sc_hd__dlygate4sd3_1
Xhold449 x2mx1\[21\] vssd1 vssd1 vccd1 vccd1 net1664 sky130_fd_sc_hd__dlygate4sd3_1
XFILLER_0_110_233 vssd1 vssd1 vccd1 vccd1 sky130_ef_sc_hd__decap_12
X_09870_ _03971_ _03975_ _03976_ vssd1 vssd1 vccd1 vccd1 _03977_ sky130_fd_sc_hd__nand3_1
Xfanout907 net908 vssd1 vssd1 vccd1 vccd1 net907 sky130_fd_sc_hd__clkbuf_4
XTAP_710 vssd1 vccd1 sky130_fd_sc_hd__tapvpwrvgnd_1
XFILLER_0_110_277 vssd1 vssd1 vccd1 vccd1 sky130_ef_sc_hd__decap_12
X_08821_ _02931_ _02932_ _02933_ vssd1 vssd1 vccd1 vccd1 _02935_ sky130_fd_sc_hd__a21o_1
Xfanout918 net919 vssd1 vssd1 vccd1 vccd1 net918 sky130_fd_sc_hd__clkbuf_2
Xfanout929 mul1.a\[31\] vssd1 vssd1 vccd1 vccd1 net929 sky130_fd_sc_hd__clkbuf_4
XTAP_721 vssd1 vccd1 sky130_fd_sc_hd__tapvpwrvgnd_1
XTAP_732 vssd1 vccd1 sky130_fd_sc_hd__tapvpwrvgnd_1
XTAP_743 vssd1 vccd1 sky130_fd_sc_hd__tapvpwrvgnd_1
XTAP_754 vssd1 vccd1 sky130_fd_sc_hd__tapvpwrvgnd_1
XTAP_765 vssd1 vccd1 sky130_fd_sc_hd__tapvpwrvgnd_1
XTAP_776 vssd1 vccd1 sky130_fd_sc_hd__tapvpwrvgnd_1
X_08752_ _02856_ _02864_ vssd1 vssd1 vccd1 vccd1 _02866_ sky130_fd_sc_hd__xnor2_1
XTAP_787 vssd1 vccd1 sky130_fd_sc_hd__tapvpwrvgnd_1
XTAP_798 vssd1 vccd1 sky130_fd_sc_hd__tapvpwrvgnd_1
X_08683_ _02794_ _02795_ _02735_ vssd1 vssd1 vccd1 vccd1 _02798_ sky130_fd_sc_hd__o21ai_2
X_07703_ _01823_ _01824_ _01825_ vssd1 vssd1 vccd1 vccd1 _01826_ sky130_fd_sc_hd__nand3_1
XFILLER_0_17_3 vssd1 vssd1 vccd1 vccd1 sky130_ef_sc_hd__decap_12
X_07634_ _01461_ _01462_ _01664_ _01756_ vssd1 vssd1 vccd1 vccd1 _01758_ sky130_fd_sc_hd__or4b_4
XTAP_1909 vssd1 vccd1 sky130_fd_sc_hd__tapvpwrvgnd_1
XFILLER_0_119_812 vssd1 vssd1 vccd1 vccd1 sky130_fd_sc_hd__fill_1
XFILLER_0_76_743 vssd1 vssd1 vccd1 vccd1 sky130_fd_sc_hd__fill_1
X_07565_ net1082 net848 net838 net1089 vssd1 vssd1 vccd1 vccd1 _01689_ sky130_fd_sc_hd__a22oi_1
X_06516_ det_t\[26\] net529 vssd1 vssd1 vccd1 vccd1 net270 sky130_fd_sc_hd__and2_1
X_09304_ _03265_ _03412_ vssd1 vssd1 vccd1 vccd1 _03415_ sky130_fd_sc_hd__xnor2_4
XFILLER_0_48_456 vssd1 vssd1 vccd1 vccd1 sky130_fd_sc_hd__fill_1
XFILLER_0_8_531 vssd1 vssd1 vccd1 vccd1 sky130_fd_sc_hd__fill_1
XFILLER_0_0_73 vssd1 vssd1 vccd1 vccd1 sky130_fd_sc_hd__fill_2
X_07496_ net917 net909 net1120 net1130 vssd1 vssd1 vccd1 vccd1 _01621_ sky130_fd_sc_hd__and4_1
XFILLER_0_118_333 vssd1 vssd1 vccd1 vccd1 sky130_ef_sc_hd__decap_12
X_09235_ net1017 net810 vssd1 vssd1 vccd1 vccd1 _03346_ sky130_fd_sc_hd__nand2_1
X_06447_ _00745_ _00746_ vssd1 vssd1 vccd1 vccd1 _00747_ sky130_fd_sc_hd__nand2_2
XFILLER_0_17_821 vssd1 vssd1 vccd1 vccd1 sky130_fd_sc_hd__fill_1
XFILLER_0_118_377 vssd1 vssd1 vccd1 vccd1 sky130_ef_sc_hd__decap_12
X_09166_ net1149 net700 _03275_ vssd1 vssd1 vccd1 vccd1 _03277_ sky130_fd_sc_hd__nand3_1
X_06378_ _00678_ _00681_ _00686_ vssd1 vssd1 vccd1 vccd1 _00688_ sky130_fd_sc_hd__nand3_1
X_08117_ _02234_ _02235_ vssd1 vssd1 vccd1 vccd1 _02236_ sky130_fd_sc_hd__nand2b_1
X_09097_ _03054_ _03055_ vssd1 vssd1 vccd1 vccd1 _03209_ sky130_fd_sc_hd__or2_1
X_08048_ _02166_ _02167_ vssd1 vssd1 vccd1 vccd1 _02168_ sky130_fd_sc_hd__nor2_1
XFILLER_0_101_266 vssd1 vssd1 vccd1 vccd1 sky130_ef_sc_hd__decap_12
X_10010_ _03979_ _03980_ _03981_ _03985_ vssd1 vssd1 vccd1 vccd1 _04116_ sky130_fd_sc_hd__a31o_1
X_09999_ _04103_ _04104_ vssd1 vssd1 vccd1 vccd1 _04105_ sky130_fd_sc_hd__or2_2
XFILLER_0_99_813 vssd1 vssd1 vccd1 vccd1 sky130_fd_sc_hd__fill_2
X_11961_ net1317 _05975_ net480 vssd1 vssd1 vccd1 vccd1 _00233_ sky130_fd_sc_hd__mux2_1
X_10912_ _04877_ _04880_ _05010_ vssd1 vssd1 vccd1 vccd1 _05012_ sky130_fd_sc_hd__nand3_1
X_11892_ net653 _00970_ net476 _05922_ vssd1 vssd1 vccd1 vccd1 _05923_ sky130_fd_sc_hd__a211o_1
XFILLER_0_129_609 vssd1 vssd1 vccd1 vccd1 sky130_fd_sc_hd__decap_6
XFILLER_0_128_108 vssd1 vssd1 vccd1 vccd1 sky130_ef_sc_hd__decap_12
X_10843_ _04798_ net452 _04942_ _04943_ vssd1 vssd1 vccd1 vccd1 _04944_ sky130_fd_sc_hd__o211ai_4
XFILLER_0_94_573 vssd1 vssd1 vccd1 vccd1 sky130_fd_sc_hd__fill_1
X_10774_ _04873_ _04874_ net782 net970 vssd1 vssd1 vccd1 vccd1 _04875_ sky130_fd_sc_hd__and4bb_1
XFILLER_0_41_29 vssd1 vssd1 vccd1 vccd1 sky130_fd_sc_hd__decap_6
X_12513_ _00683_ net563 _06253_ vssd1 vssd1 vccd1 vccd1 _00507_ sky130_fd_sc_hd__o21ai_1
XFILLER_0_82_757 vssd1 vssd1 vccd1 vccd1 sky130_fd_sc_hd__fill_2
X_12444_ _03749_ net575 _06214_ vssd1 vssd1 vccd1 vccd1 _06215_ sky130_fd_sc_hd__a21o_1
XFILLER_0_1_206 vssd1 vssd1 vccd1 vccd1 sky130_fd_sc_hd__fill_2
X_12375_ net1420 _00970_ net663 vssd1 vssd1 vccd1 vccd1 _00427_ sky130_fd_sc_hd__mux2_1
XFILLER_0_23_835 vssd1 vssd1 vccd1 vccd1 sky130_fd_sc_hd__decap_4
XFILLER_0_34_172 vssd1 vssd1 vccd1 vccd1 sky130_fd_sc_hd__decap_6
XFILLER_0_120_531 vssd1 vssd1 vccd1 vccd1 sky130_fd_sc_hd__fill_1
XFILLER_0_105_594 vssd1 vssd1 vccd1 vccd1 sky130_fd_sc_hd__fill_1
X_11326_ _05294_ _05296_ _05421_ _05422_ vssd1 vssd1 vccd1 vccd1 _05423_ sky130_fd_sc_hd__o211a_1
X_11257_ _05352_ _05353_ vssd1 vssd1 vccd1 vccd1 _05354_ sky130_fd_sc_hd__xnor2_1
X_10208_ _04025_ _04309_ _04310_ vssd1 vssd1 vccd1 vccd1 _04313_ sky130_fd_sc_hd__nand3b_2
X_11188_ net996 net729 net721 net1003 vssd1 vssd1 vccd1 vccd1 _05286_ sky130_fd_sc_hd__a22oi_1
X_10139_ _04081_ _04242_ vssd1 vssd1 vccd1 vccd1 _04244_ sky130_fd_sc_hd__xor2_2
XFILLER_0_89_356 vssd1 vssd1 vccd1 vccd1 sky130_fd_sc_hd__fill_2
XFILLER_0_49_209 vssd1 vssd1 vccd1 vccd1 sky130_fd_sc_hd__decap_6
XFILLER_0_106_65 vssd1 vssd1 vccd1 vccd1 sky130_ef_sc_hd__decap_12
XFILLER_0_58_732 vssd1 vssd1 vccd1 vccd1 sky130_fd_sc_hd__fill_2
XFILLER_0_57_253 vssd1 vssd1 vccd1 vccd1 sky130_ef_sc_hd__decap_12
X_07350_ net895 net1104 net1111 net887 vssd1 vssd1 vccd1 vccd1 _01475_ sky130_fd_sc_hd__a22o_1
X_06301_ _00610_ _00613_ vssd1 vssd1 vccd1 vccd1 _00614_ sky130_fd_sc_hd__nor2_2
XFILLER_0_122_53 vssd1 vssd1 vccd1 vccd1 sky130_ef_sc_hd__decap_12
X_09020_ _03126_ _03131_ vssd1 vssd1 vccd1 vccd1 _03132_ sky130_fd_sc_hd__nand2_1
XFILLER_0_72_234 vssd1 vssd1 vccd1 vccd1 sky130_ef_sc_hd__decap_12
X_07281_ _01325_ _01404_ _01405_ vssd1 vssd1 vccd1 vccd1 _01406_ sky130_fd_sc_hd__nand3_1
XFILLER_0_122_97 vssd1 vssd1 vccd1 vccd1 sky130_ef_sc_hd__decap_12
XFILLER_0_14_813 vssd1 vssd1 vccd1 vccd1 sky130_ef_sc_hd__decap_12
Xhold202 x0mx2\[24\] vssd1 vssd1 vccd1 vccd1 net1417 sky130_fd_sc_hd__dlygate4sd3_1
Xhold213 _00078_ vssd1 vssd1 vccd1 vccd1 net1428 sky130_fd_sc_hd__dlygate4sd3_1
Xhold235 net411 vssd1 vssd1 vccd1 vccd1 net1450 sky130_fd_sc_hd__dlygate4sd3_1
XFILLER_0_13_345 vssd1 vssd1 vccd1 vccd1 sky130_fd_sc_hd__decap_4
Xhold224 l1\[3\] vssd1 vssd1 vccd1 vccd1 net1439 sky130_fd_sc_hd__dlygate4sd3_1
XFILLER_0_123_391 vssd1 vssd1 vccd1 vccd1 sky130_fd_sc_hd__fill_1
XFILLER_0_111_553 vssd1 vssd1 vccd1 vccd1 sky130_fd_sc_hd__decap_6
Xhold246 x0mx2\[2\] vssd1 vssd1 vccd1 vccd1 net1461 sky130_fd_sc_hd__dlygate4sd3_1
Xhold268 sub1.b_i\[20\] vssd1 vssd1 vccd1 vccd1 net1483 sky130_fd_sc_hd__dlygate4sd3_1
Xhold257 y2my0\[7\] vssd1 vssd1 vccd1 vccd1 net1472 sky130_fd_sc_hd__dlygate4sd3_1
XFILLER_0_111_597 vssd1 vssd1 vccd1 vccd1 sky130_ef_sc_hd__decap_12
Xfanout704 net705 vssd1 vssd1 vccd1 vccd1 net704 sky130_fd_sc_hd__clkbuf_4
Xfanout715 net716 vssd1 vssd1 vccd1 vccd1 net715 sky130_fd_sc_hd__clkbuf_4
X_09922_ _04026_ _04027_ _04028_ vssd1 vssd1 vccd1 vccd1 _04029_ sky130_fd_sc_hd__nand3_1
XFILLER_0_0_250 vssd1 vssd1 vccd1 vccd1 sky130_fd_sc_hd__fill_2
Xhold279 y2my0\[21\] vssd1 vssd1 vccd1 vccd1 net1494 sky130_fd_sc_hd__dlygate4sd3_1
X_09853_ net1021 net777 net767 net1028 vssd1 vssd1 vccd1 vccd1 _03960_ sky130_fd_sc_hd__a22o_1
Xfanout748 net749 vssd1 vssd1 vccd1 vccd1 net748 sky130_fd_sc_hd__clkbuf_4
Xfanout737 net738 vssd1 vssd1 vccd1 vccd1 net737 sky130_fd_sc_hd__buf_4
XTAP_540 vssd1 vccd1 sky130_fd_sc_hd__tapvpwrvgnd_1
Xfanout726 mul1.b\[25\] vssd1 vssd1 vccd1 vccd1 net726 sky130_fd_sc_hd__clkbuf_4
XTAP_551 vssd1 vccd1 sky130_fd_sc_hd__tapvpwrvgnd_1
Xfanout759 net760 vssd1 vssd1 vccd1 vccd1 net759 sky130_fd_sc_hd__buf_2
X_09784_ _03634_ _03734_ _03732_ vssd1 vssd1 vccd1 vccd1 _03892_ sky130_fd_sc_hd__a21oi_2
X_08804_ net885 net973 vssd1 vssd1 vccd1 vccd1 _02918_ sky130_fd_sc_hd__nand2_1
XTAP_562 vssd1 vccd1 sky130_fd_sc_hd__tapvpwrvgnd_1
XTAP_584 vssd1 vccd1 sky130_fd_sc_hd__tapvpwrvgnd_1
XTAP_573 vssd1 vccd1 sky130_fd_sc_hd__tapvpwrvgnd_1
X_08735_ _02693_ _02848_ vssd1 vssd1 vccd1 vccd1 _02849_ sky130_fd_sc_hd__and2_1
XTAP_595 vssd1 vccd1 sky130_fd_sc_hd__tapvpwrvgnd_1
X_06996_ _01104_ _01118_ _01119_ vssd1 vssd1 vccd1 vccd1 _01121_ sky130_fd_sc_hd__nand3_4
XTAP_1706 vssd1 vccd1 sky130_fd_sc_hd__tapvpwrvgnd_1
X_08666_ _02779_ _02780_ _02772_ vssd1 vssd1 vccd1 vccd1 _02781_ sky130_fd_sc_hd__a21o_1
XFILLER_0_49_710 vssd1 vssd1 vccd1 vccd1 sky130_fd_sc_hd__fill_2
X_08597_ _02709_ _02710_ vssd1 vssd1 vccd1 vccd1 _02712_ sky130_fd_sc_hd__nor2_1
XTAP_1739 vssd1 vccd1 sky130_fd_sc_hd__tapvpwrvgnd_1
XTAP_1728 vssd1 vccd1 sky130_fd_sc_hd__tapvpwrvgnd_1
XTAP_1717 vssd1 vccd1 sky130_fd_sc_hd__tapvpwrvgnd_1
XFILLER_0_95_337 vssd1 vssd1 vccd1 vccd1 sky130_fd_sc_hd__decap_6
X_07617_ _01701_ _01702_ _01737_ _01739_ vssd1 vssd1 vccd1 vccd1 _01741_ sky130_fd_sc_hd__nor4_1
XFILLER_0_72_91 vssd1 vssd1 vccd1 vccd1 sky130_fd_sc_hd__fill_1
X_07548_ _01670_ _01671_ vssd1 vssd1 vccd1 vccd1 _01672_ sky130_fd_sc_hd__nor2_1
XFILLER_0_48_253 vssd1 vssd1 vccd1 vccd1 sky130_fd_sc_hd__fill_1
XFILLER_0_119_653 vssd1 vssd1 vccd1 vccd1 sky130_ef_sc_hd__decap_12
XFILLER_0_118_141 vssd1 vssd1 vccd1 vccd1 sky130_ef_sc_hd__decap_12
XFILLER_0_119_697 vssd1 vssd1 vccd1 vccd1 sky130_ef_sc_hd__decap_12
XFILLER_0_106_314 vssd1 vssd1 vccd1 vccd1 sky130_fd_sc_hd__fill_1
XFILLER_0_64_757 vssd1 vssd1 vccd1 vccd1 sky130_fd_sc_hd__fill_2
XFILLER_0_8_372 vssd1 vssd1 vccd1 vccd1 sky130_fd_sc_hd__fill_1
X_07479_ _01603_ _01588_ vssd1 vssd1 vccd1 vccd1 _01604_ sky130_fd_sc_hd__and2b_1
X_09218_ _03327_ _03328_ vssd1 vssd1 vccd1 vccd1 _03329_ sky130_fd_sc_hd__and2b_1
X_10490_ _04484_ _04492_ _04491_ vssd1 vssd1 vccd1 vccd1 _04593_ sky130_fd_sc_hd__a21bo_1
X_09149_ _03258_ _03259_ vssd1 vssd1 vccd1 vccd1 _03261_ sky130_fd_sc_hd__xnor2_4
XFILLER_0_16_172 vssd1 vssd1 vccd1 vccd1 sky130_fd_sc_hd__decap_4
XFILLER_0_32_610 vssd1 vssd1 vccd1 vccd1 sky130_ef_sc_hd__decap_12
XFILLER_0_121_317 vssd1 vssd1 vccd1 vccd1 sky130_ef_sc_hd__decap_12
Xclkbuf_leaf_21_clk_i clknet_3_5__leaf_clk_i vssd1 vssd1 vccd1 vccd1 clknet_leaf_21_clk_i
+ sky130_fd_sc_hd__clkbuf_16
X_12160_ x0mx2\[31\] net631 net593 y1my2\[31\] vssd1 vssd1 vccd1 vccd1 _06126_ sky130_fd_sc_hd__a22o_1
X_11111_ _05089_ _05207_ vssd1 vssd1 vccd1 vccd1 _05209_ sky130_fd_sc_hd__nand2b_4
XFILLER_0_31_175 vssd1 vssd1 vccd1 vccd1 sky130_fd_sc_hd__fill_1
XFILLER_0_6_3 vssd1 vssd1 vccd1 vccd1 sky130_ef_sc_hd__decap_12
X_12091_ net1048 _06074_ net514 vssd1 vssd1 vccd1 vccd1 _00264_ sky130_fd_sc_hd__mux2_1
X_11042_ net1750 _05138_ _04982_ _05020_ vssd1 vssd1 vccd1 vccd1 _05141_ sky130_fd_sc_hd__o211ai_4
Xclkbuf_leaf_36_clk_i clknet_3_1__leaf_clk_i vssd1 vssd1 vccd1 vccd1 clknet_leaf_36_clk_i
+ sky130_fd_sc_hd__clkbuf_16
XFILLER_0_36_29 vssd1 vssd1 vccd1 vccd1 sky130_fd_sc_hd__decap_4
X_12993_ clknet_leaf_42_clk_i _00379_ net1163 vssd1 vssd1 vccd1 vccd1 x2mx1\[14\]
+ sky130_fd_sc_hd__dfrtp_1
XFILLER_0_98_175 vssd1 vssd1 vccd1 vccd1 sky130_fd_sc_hd__fill_2
X_11944_ net123 net656 net503 net219 _05962_ vssd1 vssd1 vccd1 vccd1 _05963_ sky130_fd_sc_hd__a221o_1
X_11875_ net173 net471 _05908_ vssd1 vssd1 vccd1 vccd1 _05909_ sky130_fd_sc_hd__o21a_1
XFILLER_0_129_439 vssd1 vssd1 vccd1 vccd1 sky130_fd_sc_hd__fill_1
XFILLER_0_86_359 vssd1 vssd1 vccd1 vccd1 sky130_fd_sc_hd__decap_4
X_10826_ _04721_ _04724_ _04924_ vssd1 vssd1 vccd1 vccd1 _04927_ sky130_fd_sc_hd__and3_1
XFILLER_0_54_201 vssd1 vssd1 vccd1 vccd1 sky130_fd_sc_hd__fill_1
X_10757_ net1012 net736 _04856_ _04857_ vssd1 vssd1 vccd1 vccd1 _04858_ sky130_fd_sc_hd__nand4_2
XFILLER_0_124_133 vssd1 vssd1 vccd1 vccd1 sky130_fd_sc_hd__decap_6
XFILLER_0_82_587 vssd1 vssd1 vccd1 vccd1 sky130_fd_sc_hd__fill_1
X_10688_ _04770_ _04787_ _04788_ vssd1 vssd1 vccd1 vccd1 _04790_ sky130_fd_sc_hd__or3_1
XFILLER_0_14_109 vssd1 vssd1 vccd1 vccd1 sky130_ef_sc_hd__decap_12
XFILLER_0_23_643 vssd1 vssd1 vccd1 vccd1 sky130_fd_sc_hd__fill_1
X_12427_ _00852_ net612 _02542_ net574 vssd1 vssd1 vccd1 vccd1 _06206_ sky130_fd_sc_hd__a22o_1
Xoutput307 net307 vssd1 vssd1 vccd1 vccd1 div_mstream_o[74] sky130_fd_sc_hd__clkbuf_4
Xoutput329 net329 vssd1 vssd1 vccd1 vccd1 div_mstream_o[94] sky130_fd_sc_hd__clkbuf_4
Xoutput318 net318 vssd1 vssd1 vccd1 vccd1 div_mstream_o[84] sky130_fd_sc_hd__clkbuf_4
X_12358_ net1553 _00877_ net657 vssd1 vssd1 vccd1 vccd1 _00410_ sky130_fd_sc_hd__mux2_1
X_11309_ _05277_ _05403_ vssd1 vssd1 vccd1 vccd1 _05406_ sky130_fd_sc_hd__xor2_2
XFILLER_0_22_197 vssd1 vssd1 vccd1 vccd1 sky130_fd_sc_hd__decap_8
X_12289_ net1651 _00852_ net675 vssd1 vssd1 vccd1 vccd1 _00341_ sky130_fd_sc_hd__mux2_1
X_06850_ net1 net548 _00978_ _00589_ _00980_ vssd1 vssd1 vccd1 vccd1 _00981_ sky130_fd_sc_hd__o221a_1
XFILLER_0_93_57 vssd1 vssd1 vccd1 vccd1 sky130_ef_sc_hd__decap_12
X_06781_ net1492 net1440 net638 vssd1 vssd1 vccd1 vccd1 _00055_ sky130_fd_sc_hd__mux2_1
X_08520_ _02634_ _02635_ _02633_ vssd1 vssd1 vccd1 vccd1 _02636_ sky130_fd_sc_hd__a21o_1
X_08451_ net1092 net1099 net773 net764 vssd1 vssd1 vccd1 vccd1 _02567_ sky130_fd_sc_hd__nand4_1
XFILLER_0_77_337 vssd1 vssd1 vccd1 vccd1 sky130_fd_sc_hd__fill_1
X_07402_ _01471_ _01515_ _01520_ vssd1 vssd1 vccd1 vccd1 _01527_ sky130_fd_sc_hd__a21o_1
X_08382_ net900 net891 net986 net979 vssd1 vssd1 vccd1 vccd1 _02499_ sky130_fd_sc_hd__and4_1
XFILLER_0_116_601 vssd1 vssd1 vccd1 vccd1 sky130_ef_sc_hd__decap_12
XFILLER_0_73_554 vssd1 vssd1 vccd1 vccd1 sky130_fd_sc_hd__decap_6
XFILLER_0_9_169 vssd1 vssd1 vccd1 vccd1 sky130_fd_sc_hd__decap_3
X_07333_ _01201_ _01274_ _01321_ _01323_ vssd1 vssd1 vccd1 vccd1 _01458_ sky130_fd_sc_hd__a211oi_1
XFILLER_0_116_645 vssd1 vssd1 vccd1 vccd1 sky130_ef_sc_hd__decap_12
XFILLER_0_115_111 vssd1 vssd1 vccd1 vccd1 sky130_fd_sc_hd__fill_1
XFILLER_0_61_727 vssd1 vssd1 vccd1 vccd1 sky130_fd_sc_hd__fill_1
X_07264_ _01368_ _01385_ _01386_ vssd1 vssd1 vccd1 vccd1 _01389_ sky130_fd_sc_hd__nand3_1
X_09003_ _02985_ _02988_ vssd1 vssd1 vccd1 vccd1 _03115_ sky130_fd_sc_hd__nor2_1
XFILLER_0_84_3 vssd1 vssd1 vccd1 vccd1 sky130_ef_sc_hd__decap_12
XFILLER_0_60_259 vssd1 vssd1 vccd1 vccd1 sky130_fd_sc_hd__fill_1
XFILLER_0_14_643 vssd1 vssd1 vccd1 vccd1 sky130_fd_sc_hd__fill_1
X_07195_ _01136_ _01138_ _01139_ _01066_ vssd1 vssd1 vccd1 vccd1 _01320_ sky130_fd_sc_hd__o22a_1
XFILLER_0_111_361 vssd1 vssd1 vccd1 vccd1 sky130_ef_sc_hd__decap_12
X_09905_ _03858_ _03859_ vssd1 vssd1 vccd1 vccd1 _04012_ sky130_fd_sc_hd__nand2_1
Xfanout523 net524 vssd1 vssd1 vccd1 vccd1 net523 sky130_fd_sc_hd__buf_2
Xfanout501 _06034_ vssd1 vssd1 vccd1 vccd1 net501 sky130_fd_sc_hd__clkbuf_4
Xfanout512 _06033_ vssd1 vssd1 vccd1 vccd1 net512 sky130_fd_sc_hd__buf_2
Xfanout545 net548 vssd1 vssd1 vccd1 vccd1 net545 sky130_fd_sc_hd__clkbuf_2
Xfanout556 net557 vssd1 vssd1 vccd1 vccd1 net556 sky130_fd_sc_hd__clkbuf_4
Xfanout534 net535 vssd1 vssd1 vccd1 vccd1 net534 sky130_fd_sc_hd__clkbuf_4
Xfanout567 _06238_ vssd1 vssd1 vccd1 vccd1 net567 sky130_fd_sc_hd__clkbuf_2
X_09836_ _03940_ _03941_ _03930_ vssd1 vssd1 vccd1 vccd1 _03943_ sky130_fd_sc_hd__a21boi_1
XTAP_381 vssd1 vccd1 sky130_fd_sc_hd__tapvpwrvgnd_1
XTAP_392 vssd1 vccd1 sky130_fd_sc_hd__tapvpwrvgnd_1
XTAP_370 vssd1 vccd1 sky130_fd_sc_hd__tapvpwrvgnd_1
Xfanout578 _05760_ vssd1 vssd1 vccd1 vccd1 net578 sky130_fd_sc_hd__clkbuf_4
Xfanout589 _05754_ vssd1 vssd1 vccd1 vccd1 net589 sky130_fd_sc_hd__clkbuf_4
X_09767_ _03873_ _03874_ vssd1 vssd1 vccd1 vccd1 _03875_ sky130_fd_sc_hd__or2_2
X_06979_ _01090_ _01096_ _01091_ vssd1 vssd1 vccd1 vccd1 _01104_ sky130_fd_sc_hd__a21bo_1
XTAP_2226 vssd1 vccd1 sky130_fd_sc_hd__tapvpwrvgnd_1
XTAP_2215 vssd1 vccd1 sky130_fd_sc_hd__tapvpwrvgnd_1
XTAP_2204 vssd1 vccd1 sky130_fd_sc_hd__tapvpwrvgnd_1
X_08718_ _02830_ _02831_ vssd1 vssd1 vccd1 vccd1 _02832_ sky130_fd_sc_hd__xnor2_1
X_09698_ net1028 net1037 net777 net767 vssd1 vssd1 vccd1 vccd1 _03806_ sky130_fd_sc_hd__nand4_1
XTAP_2248 vssd1 vccd1 sky130_fd_sc_hd__tapvpwrvgnd_1
XTAP_2237 vssd1 vccd1 sky130_fd_sc_hd__tapvpwrvgnd_1
XFILLER_0_96_657 vssd1 vssd1 vccd1 vccd1 sky130_fd_sc_hd__fill_2
XTAP_1514 vssd1 vccd1 sky130_fd_sc_hd__tapvpwrvgnd_1
XTAP_1503 vssd1 vccd1 sky130_fd_sc_hd__tapvpwrvgnd_1
X_08649_ _02758_ _02761_ _02762_ vssd1 vssd1 vccd1 vccd1 _02764_ sky130_fd_sc_hd__or3_1
XPHY_10 vssd1 vssd1 vccd1 vccd1 sky130_fd_sc_hd__decap_3
XPHY_21 vssd1 vssd1 vccd1 vccd1 sky130_fd_sc_hd__decap_3
XFILLER_0_95_167 vssd1 vssd1 vccd1 vccd1 sky130_fd_sc_hd__fill_1
XTAP_1547 vssd1 vccd1 sky130_fd_sc_hd__tapvpwrvgnd_1
XTAP_1536 vssd1 vccd1 sky130_fd_sc_hd__tapvpwrvgnd_1
XTAP_1525 vssd1 vccd1 sky130_fd_sc_hd__tapvpwrvgnd_1
XFILLER_0_49_551 vssd1 vssd1 vccd1 vccd1 sky130_fd_sc_hd__decap_3
XPHY_32 vssd1 vssd1 vccd1 vccd1 sky130_fd_sc_hd__decap_3
XPHY_43 vssd1 vssd1 vccd1 vccd1 sky130_fd_sc_hd__decap_3
XPHY_54 vssd1 vssd1 vccd1 vccd1 sky130_fd_sc_hd__decap_3
XPHY_65 vssd1 vssd1 vccd1 vccd1 sky130_fd_sc_hd__decap_3
XTAP_1558 vssd1 vccd1 sky130_fd_sc_hd__tapvpwrvgnd_1
XTAP_1569 vssd1 vccd1 sky130_fd_sc_hd__tapvpwrvgnd_1
XPHY_98 vssd1 vssd1 vccd1 vccd1 sky130_fd_sc_hd__decap_3
XPHY_87 vssd1 vssd1 vccd1 vccd1 sky130_fd_sc_hd__decap_3
X_11660_ _05752_ vssd1 vssd1 vccd1 vccd1 _05753_ sky130_fd_sc_hd__inv_2
XFILLER_0_36_201 vssd1 vssd1 vccd1 vccd1 sky130_fd_sc_hd__fill_1
XFILLER_0_37_724 vssd1 vssd1 vccd1 vccd1 sky130_fd_sc_hd__decap_4
XPHY_76 vssd1 vssd1 vccd1 vccd1 sky130_fd_sc_hd__decap_3
XFILLER_0_119_461 vssd1 vssd1 vccd1 vccd1 sky130_ef_sc_hd__decap_12
X_10611_ net1022 net737 _04710_ _04711_ vssd1 vssd1 vccd1 vccd1 _04713_ sky130_fd_sc_hd__a22o_1
X_11591_ _05610_ _05653_ _05608_ vssd1 vssd1 vccd1 vccd1 _05685_ sky130_fd_sc_hd__a21o_1
X_10542_ _04642_ _04643_ _04413_ _04416_ vssd1 vssd1 vccd1 vccd1 _04645_ sky130_fd_sc_hd__a211oi_1
XFILLER_0_106_133 vssd1 vssd1 vccd1 vccd1 sky130_fd_sc_hd__decap_6
XFILLER_0_122_637 vssd1 vssd1 vccd1 vccd1 sky130_fd_sc_hd__decap_6
XFILLER_0_121_125 vssd1 vssd1 vccd1 vccd1 sky130_ef_sc_hd__decap_12
XFILLER_0_106_177 vssd1 vssd1 vccd1 vccd1 sky130_ef_sc_hd__decap_12
X_10473_ _04475_ _04477_ _04476_ vssd1 vssd1 vccd1 vccd1 _04576_ sky130_fd_sc_hd__a21bo_1
X_12212_ net801 _06161_ net515 vssd1 vssd1 vccd1 vccd1 _00298_ sky130_fd_sc_hd__mux2_1
X_13192_ clknet_leaf_19_clk_i _00578_ net1178 vssd1 vssd1 vccd1 vccd1 l1\[21\] sky130_fd_sc_hd__dfrtp_1
XFILLER_0_32_484 vssd1 vssd1 vccd1 vccd1 sky130_ef_sc_hd__decap_12
XFILLER_0_121_169 vssd1 vssd1 vccd1 vccd1 sky130_ef_sc_hd__decap_12
X_12143_ net954 _06113_ net517 vssd1 vssd1 vccd1 vccd1 _00277_ sky130_fd_sc_hd__mux2_1
X_12074_ _00855_ _06061_ net499 vssd1 vssd1 vccd1 vccd1 _06062_ sky130_fd_sc_hd__mux2_1
X_11025_ _05122_ _05123_ vssd1 vssd1 vccd1 vccd1 _05124_ sky130_fd_sc_hd__or2_1
XFILLER_0_87_635 vssd1 vssd1 vccd1 vccd1 sky130_fd_sc_hd__decap_3
XFILLER_0_86_101 vssd1 vssd1 vccd1 vccd1 sky130_ef_sc_hd__decap_12
XFILLER_0_59_337 vssd1 vssd1 vccd1 vccd1 sky130_fd_sc_hd__decap_6
X_12976_ clknet_leaf_25_clk_i _00362_ net1172 vssd1 vssd1 vccd1 vccd1 y1my2\[29\]
+ sky130_fd_sc_hd__dfrtp_1
X_11927_ net31 net549 net624 net214 _05949_ vssd1 vssd1 vccd1 vccd1 _05950_ sky130_fd_sc_hd__a221o_1
XFILLER_0_74_307 vssd1 vssd1 vccd1 vccd1 sky130_fd_sc_hd__fill_1
X_11858_ net1273 _05894_ net482 vssd1 vssd1 vccd1 vccd1 _00211_ sky130_fd_sc_hd__mux2_1
XFILLER_0_83_841 vssd1 vssd1 vccd1 vccd1 sky130_fd_sc_hd__fill_1
X_10809_ _04759_ _04764_ _04909_ vssd1 vssd1 vccd1 vccd1 _04910_ sky130_fd_sc_hd__o21ai_2
XFILLER_0_55_543 vssd1 vssd1 vccd1 vccd1 sky130_ef_sc_hd__decap_12
XANTENNA_19 v1x[6] vssd1 vssd1 vccd1 vccd1 sky130_fd_sc_hd__diode_2
X_11789_ net1287 _05835_ net479 vssd1 vssd1 vccd1 vccd1 _00201_ sky130_fd_sc_hd__mux2_1
XFILLER_0_103_55 vssd1 vssd1 vccd1 vccd1 sky130_fd_sc_hd__fill_1
XFILLER_0_82_362 vssd1 vssd1 vccd1 vccd1 sky130_fd_sc_hd__fill_2
XFILLER_0_12_53 vssd1 vssd1 vccd1 vccd1 sky130_ef_sc_hd__decap_12
XFILLER_0_27_256 vssd1 vssd1 vccd1 vccd1 sky130_fd_sc_hd__fill_1
XFILLER_0_42_204 vssd1 vssd1 vccd1 vccd1 sky130_fd_sc_hd__decap_4
XFILLER_0_12_97 vssd1 vssd1 vccd1 vccd1 sky130_ef_sc_hd__decap_12
XFILLER_0_42_237 vssd1 vssd1 vccd1 vccd1 sky130_fd_sc_hd__fill_1
XFILLER_0_125_497 vssd1 vssd1 vccd1 vccd1 sky130_fd_sc_hd__decap_6
XFILLER_0_113_615 vssd1 vssd1 vccd1 vccd1 sky130_fd_sc_hd__fill_1
X_07951_ _01960_ _01961_ _01959_ vssd1 vssd1 vccd1 vccd1 _02071_ sky130_fd_sc_hd__o21ai_1
XFILLER_0_10_189 vssd1 vssd1 vccd1 vccd1 sky130_fd_sc_hd__decap_6
X_06902_ net854 net1112 _01024_ _01025_ vssd1 vssd1 vccd1 vccd1 _01027_ sky130_fd_sc_hd__o2bb2a_1
XFILLER_0_128_41 vssd1 vssd1 vccd1 vccd1 sky130_ef_sc_hd__decap_12
X_07882_ _01985_ _02001_ _02002_ vssd1 vssd1 vccd1 vccd1 _02003_ sky130_fd_sc_hd__and3_1
XFILLER_0_128_96 vssd1 vssd1 vccd1 vccd1 sky130_ef_sc_hd__decap_12
XFILLER_0_128_85 vssd1 vssd1 vccd1 vccd1 sky130_fd_sc_hd__decap_4
X_06833_ net1524 posy\[8\] net646 vssd1 vssd1 vccd1 vccd1 _00107_ sky130_fd_sc_hd__mux2_1
X_09621_ _03671_ _03728_ _03729_ vssd1 vssd1 vccd1 vccd1 _03730_ sky130_fd_sc_hd__and3_1
X_09552_ _03651_ _03658_ _03659_ vssd1 vssd1 vccd1 vccd1 _03661_ sky130_fd_sc_hd__nand3_1
X_06764_ net1512 net1439 net637 vssd1 vssd1 vccd1 vccd1 _00038_ sky130_fd_sc_hd__mux2_1
XFILLER_0_77_101 vssd1 vssd1 vccd1 vccd1 sky130_fd_sc_hd__fill_1
X_08503_ net866 net1000 net993 net875 vssd1 vssd1 vccd1 vccd1 _02619_ sky130_fd_sc_hd__a22oi_1
X_09483_ net1133 net700 net693 net1141 vssd1 vssd1 vccd1 vccd1 _03592_ sky130_fd_sc_hd__o2bb2a_1
X_06695_ net1308 _00918_ net635 vssd1 vssd1 vccd1 vccd1 _00024_ sky130_fd_sc_hd__mux2_1
X_08434_ _02548_ _02549_ vssd1 vssd1 vccd1 vccd1 _02550_ sky130_fd_sc_hd__nor2_1
XFILLER_0_93_627 vssd1 vssd1 vccd1 vccd1 sky130_fd_sc_hd__fill_1
XFILLER_0_129_781 vssd1 vssd1 vccd1 vccd1 sky130_fd_sc_hd__decap_3
XFILLER_0_92_137 vssd1 vssd1 vccd1 vccd1 sky130_fd_sc_hd__decap_3
X_08365_ _02479_ _02480_ _02465_ vssd1 vssd1 vccd1 vccd1 _02482_ sky130_fd_sc_hd__a21o_1
XFILLER_0_74_841 vssd1 vssd1 vccd1 vccd1 sky130_fd_sc_hd__fill_1
XFILLER_0_18_212 vssd1 vssd1 vccd1 vccd1 sky130_ef_sc_hd__decap_12
X_07316_ _01301_ _01303_ vssd1 vssd1 vccd1 vccd1 _01441_ sky130_fd_sc_hd__xnor2_1
X_08296_ _02161_ _02402_ _02279_ _02278_ vssd1 vssd1 vccd1 vccd1 _02413_ sky130_fd_sc_hd__a211o_1
XFILLER_0_33_204 vssd1 vssd1 vccd1 vccd1 sky130_fd_sc_hd__fill_1
XFILLER_0_116_475 vssd1 vssd1 vccd1 vccd1 sky130_fd_sc_hd__fill_1
X_07247_ _01370_ _01371_ vssd1 vssd1 vccd1 vccd1 _01372_ sky130_fd_sc_hd__nor2_1
XFILLER_0_33_259 vssd1 vssd1 vccd1 vccd1 sky130_fd_sc_hd__fill_2
XFILLER_0_103_125 vssd1 vssd1 vccd1 vccd1 sky130_ef_sc_hd__decap_12
XFILLER_0_5_183 vssd1 vssd1 vccd1 vccd1 sky130_fd_sc_hd__fill_1
X_07178_ _01288_ _01289_ vssd1 vssd1 vccd1 vccd1 _01303_ sky130_fd_sc_hd__xnor2_1
XFILLER_0_100_810 vssd1 vssd1 vccd1 vccd1 sky130_fd_sc_hd__fill_2
XFILLER_0_112_681 vssd1 vssd1 vccd1 vccd1 sky130_ef_sc_hd__decap_12
X_09819_ _03924_ _03925_ vssd1 vssd1 vccd1 vccd1 _03926_ sky130_fd_sc_hd__or2_2
XTAP_2001 vssd1 vccd1 sky130_fd_sc_hd__tapvpwrvgnd_1
X_12830_ clknet_leaf_29_clk_i _00216_ vssd1 vssd1 vccd1 vccd1 sub1.a_i\[29\] sky130_fd_sc_hd__dfxtp_1
XTAP_2034 vssd1 vccd1 sky130_fd_sc_hd__tapvpwrvgnd_1
XTAP_2023 vssd1 vccd1 sky130_fd_sc_hd__tapvpwrvgnd_1
XTAP_2012 vssd1 vccd1 sky130_fd_sc_hd__tapvpwrvgnd_1
XFILLER_0_96_421 vssd1 vssd1 vccd1 vccd1 sky130_fd_sc_hd__decap_8
XTAP_2056 vssd1 vccd1 sky130_fd_sc_hd__tapvpwrvgnd_1
XTAP_2067 vssd1 vccd1 sky130_fd_sc_hd__tapvpwrvgnd_1
XTAP_2045 vssd1 vccd1 sky130_fd_sc_hd__tapvpwrvgnd_1
XTAP_1322 vssd1 vccd1 sky130_fd_sc_hd__tapvpwrvgnd_1
XTAP_1311 vssd1 vccd1 sky130_fd_sc_hd__tapvpwrvgnd_1
XTAP_1300 vssd1 vccd1 sky130_fd_sc_hd__tapvpwrvgnd_1
XFILLER_0_68_123 vssd1 vssd1 vccd1 vccd1 sky130_fd_sc_hd__fill_2
X_12761_ clknet_leaf_18_clk_i _00147_ vssd1 vssd1 vccd1 vccd1 add1.a_i\[24\] sky130_fd_sc_hd__dfxtp_2
XTAP_2089 vssd1 vccd1 sky130_fd_sc_hd__tapvpwrvgnd_1
XTAP_2078 vssd1 vccd1 sky130_fd_sc_hd__tapvpwrvgnd_1
X_12692_ clknet_leaf_13_clk_i net1428 net1186 vssd1 vssd1 vccd1 vccd1 net422 sky130_fd_sc_hd__dfrtp_1
XTAP_1366 vssd1 vccd1 sky130_fd_sc_hd__tapvpwrvgnd_1
XTAP_1355 vssd1 vccd1 sky130_fd_sc_hd__tapvpwrvgnd_1
XTAP_1344 vssd1 vccd1 sky130_fd_sc_hd__tapvpwrvgnd_1
XTAP_1333 vssd1 vccd1 sky130_fd_sc_hd__tapvpwrvgnd_1
XFILLER_0_56_307 vssd1 vssd1 vccd1 vccd1 sky130_fd_sc_hd__fill_1
X_11712_ net229 net598 net578 net133 _05771_ vssd1 vssd1 vccd1 vccd1 _05772_ sky130_fd_sc_hd__a221o_1
XFILLER_0_127_729 vssd1 vssd1 vccd1 vccd1 sky130_ef_sc_hd__decap_12
XTAP_1399 vssd1 vccd1 sky130_fd_sc_hd__tapvpwrvgnd_1
XTAP_1388 vssd1 vccd1 sky130_fd_sc_hd__tapvpwrvgnd_1
XTAP_1377 vssd1 vccd1 sky130_fd_sc_hd__tapvpwrvgnd_1
XFILLER_0_65_841 vssd1 vssd1 vccd1 vccd1 sky130_fd_sc_hd__fill_1
X_11643_ _05735_ _05736_ vssd1 vssd1 vccd1 vccd1 _05737_ sky130_fd_sc_hd__xor2_1
XFILLER_0_80_811 vssd1 vssd1 vccd1 vccd1 sky130_fd_sc_hd__fill_1
Xinput28 div_sstream_i[48] vssd1 vssd1 vccd1 vccd1 net28 sky130_fd_sc_hd__clkbuf_4
Xinput17 div_sstream_i[23] vssd1 vssd1 vccd1 vccd1 net17 sky130_fd_sc_hd__clkbuf_8
X_11574_ _05665_ _05666_ vssd1 vssd1 vccd1 vccd1 _05669_ sky130_fd_sc_hd__xnor2_1
XFILLER_0_122_401 vssd1 vssd1 vccd1 vccd1 sky130_ef_sc_hd__decap_12
XFILLER_0_91_192 vssd1 vssd1 vccd1 vccd1 sky130_fd_sc_hd__fill_1
X_10525_ _04474_ _04481_ _04480_ vssd1 vssd1 vccd1 vccd1 _04628_ sky130_fd_sc_hd__a21o_1
Xinput39 sstream_i[10] vssd1 vssd1 vccd1 vccd1 net39 sky130_fd_sc_hd__buf_4
XFILLER_0_122_445 vssd1 vssd1 vccd1 vccd1 sky130_ef_sc_hd__decap_12
X_10456_ _04545_ _04557_ _04558_ vssd1 vssd1 vccd1 vccd1 _04559_ sky130_fd_sc_hd__and3_1
XFILLER_0_122_489 vssd1 vssd1 vccd1 vccd1 sky130_ef_sc_hd__decap_12
X_13175_ clknet_leaf_22_clk_i _00561_ net1176 vssd1 vssd1 vccd1 vccd1 l1\[4\] sky130_fd_sc_hd__dfrtp_1
XFILLER_0_0_816 vssd1 vssd1 vccd1 vccd1 sky130_fd_sc_hd__fill_2
X_10387_ _04485_ _04489_ _04490_ vssd1 vssd1 vccd1 vccd1 _04491_ sky130_fd_sc_hd__nand3_1
XFILLER_0_58_49 vssd1 vssd1 vccd1 vccd1 sky130_ef_sc_hd__decap_12
X_12126_ _00923_ _06100_ net500 vssd1 vssd1 vccd1 vccd1 _06101_ sky130_fd_sc_hd__mux2_1
XFILLER_0_102_191 vssd1 vssd1 vccd1 vccd1 sky130_fd_sc_hd__fill_1
XFILLER_0_74_15 vssd1 vssd1 vccd1 vccd1 sky130_ef_sc_hd__decap_12
X_12057_ y2my0\[5\] net582 net531 x2mx1\[5\] _06048_ vssd1 vssd1 vccd1 vccd1 _06049_
+ sky130_fd_sc_hd__a221o_1
X_11008_ net775 net765 net969 net963 vssd1 vssd1 vccd1 vccd1 _05107_ sky130_fd_sc_hd__and4_1
X_12959_ clknet_leaf_44_clk_i _00345_ net1157 vssd1 vssd1 vccd1 vccd1 y1my2\[12\]
+ sky130_fd_sc_hd__dfrtp_1
X_06480_ add1.a_i\[30\] add1.b_i\[30\] vssd1 vssd1 vccd1 vccd1 _00775_ sky130_fd_sc_hd__nand2_1
XFILLER_0_114_65 vssd1 vssd1 vccd1 vccd1 sky130_ef_sc_hd__decap_12
XFILLER_0_117_217 vssd1 vssd1 vccd1 vccd1 sky130_fd_sc_hd__decap_6
X_08150_ _02207_ _02208_ _02266_ _02267_ vssd1 vssd1 vccd1 vccd1 _02269_ sky130_fd_sc_hd__a2bb2o_1
XFILLER_0_28_565 vssd1 vssd1 vccd1 vccd1 sky130_fd_sc_hd__decap_3
X_07101_ _01223_ _01224_ _01152_ _01153_ vssd1 vssd1 vccd1 vccd1 _01226_ sky130_fd_sc_hd__a211o_1
XFILLER_0_43_535 vssd1 vssd1 vccd1 vccd1 sky130_fd_sc_hd__decap_3
XFILLER_0_15_215 vssd1 vssd1 vccd1 vccd1 sky130_fd_sc_hd__decap_8
XFILLER_0_130_42 vssd1 vssd1 vccd1 vccd1 sky130_fd_sc_hd__fill_2
X_08081_ _02076_ _02084_ _02083_ vssd1 vssd1 vccd1 vccd1 _02200_ sky130_fd_sc_hd__a21o_1
X_07032_ _01149_ _01150_ _01155_ vssd1 vssd1 vccd1 vccd1 _01157_ sky130_fd_sc_hd__a21o_1
XFILLER_0_100_139 vssd1 vssd1 vccd1 vccd1 sky130_fd_sc_hd__fill_1
X_08983_ _02991_ _02992_ _03093_ _03094_ vssd1 vssd1 vccd1 vccd1 _03096_ sky130_fd_sc_hd__or4_1
X_07934_ _02052_ _02054_ vssd1 vssd1 vccd1 vccd1 _02055_ sky130_fd_sc_hd__nor2_1
XFILLER_0_48_82 vssd1 vssd1 vccd1 vccd1 sky130_fd_sc_hd__fill_2
XFILLER_0_47_3 vssd1 vssd1 vccd1 vccd1 sky130_ef_sc_hd__decap_12
X_07865_ net1098 net805 vssd1 vssd1 vccd1 vccd1 _01986_ sky130_fd_sc_hd__nand2_1
X_09604_ _03710_ _03711_ _03712_ vssd1 vssd1 vccd1 vccd1 _03713_ sky130_fd_sc_hd__o21ai_1
XFILLER_0_3_51 vssd1 vssd1 vccd1 vccd1 sky130_fd_sc_hd__decap_4
X_06816_ net435 net1421 net645 vssd1 vssd1 vccd1 vccd1 _00090_ sky130_fd_sc_hd__mux2_1
XFILLER_0_78_421 vssd1 vssd1 vccd1 vccd1 sky130_fd_sc_hd__decap_4
X_07796_ _01914_ _01915_ _01916_ vssd1 vssd1 vccd1 vccd1 _01918_ sky130_fd_sc_hd__nand3_1
X_09535_ net1054 net759 _03641_ _03643_ vssd1 vssd1 vccd1 vccd1 _03644_ sky130_fd_sc_hd__and4_1
X_06747_ sub1.b_i\[29\] sub1.a_i\[29\] vssd1 vssd1 vccd1 vccd1 _00963_ sky130_fd_sc_hd__nand2b_1
X_09466_ _03573_ _03574_ _03279_ vssd1 vssd1 vccd1 vccd1 _03576_ sky130_fd_sc_hd__a21o_1
X_06678_ _00899_ _00902_ _00898_ vssd1 vssd1 vccd1 vccd1 _00904_ sky130_fd_sc_hd__a21o_2
XFILLER_0_38_318 vssd1 vssd1 vccd1 vccd1 sky130_fd_sc_hd__fill_1
XFILLER_0_109_729 vssd1 vssd1 vccd1 vccd1 sky130_ef_sc_hd__decap_12
X_08417_ _02289_ _02532_ _02533_ vssd1 vssd1 vccd1 vccd1 _02534_ sky130_fd_sc_hd__nor3_1
XFILLER_0_59_690 vssd1 vssd1 vccd1 vccd1 sky130_fd_sc_hd__decap_3
XFILLER_0_47_841 vssd1 vssd1 vccd1 vccd1 sky130_fd_sc_hd__fill_1
X_09397_ net825 net995 net988 net833 vssd1 vssd1 vccd1 vccd1 _03507_ sky130_fd_sc_hd__a22o_1
X_08348_ _02351_ _02357_ _02356_ vssd1 vssd1 vccd1 vccd1 _02465_ sky130_fd_sc_hd__a21o_1
XFILLER_0_61_321 vssd1 vssd1 vccd1 vccd1 sky130_fd_sc_hd__fill_1
X_08279_ _02173_ _02395_ _02396_ vssd1 vssd1 vccd1 vccd1 _02397_ sky130_fd_sc_hd__nand3_2
X_10310_ _04411_ _04412_ _04401_ vssd1 vssd1 vccd1 vccd1 _04414_ sky130_fd_sc_hd__a21oi_2
XFILLER_0_61_376 vssd1 vssd1 vccd1 vccd1 sky130_fd_sc_hd__decap_3
X_11290_ _05258_ _05261_ vssd1 vssd1 vccd1 vccd1 _05387_ sky130_fd_sc_hd__nor2_1
X_10241_ _04344_ _04345_ _04338_ vssd1 vssd1 vccd1 vccd1 _04346_ sky130_fd_sc_hd__a21o_1
X_10172_ net1005 net779 net769 net1013 vssd1 vssd1 vccd1 vccd1 _04277_ sky130_fd_sc_hd__a22o_1
Xfanout1104 net1105 vssd1 vssd1 vccd1 vccd1 net1104 sky130_fd_sc_hd__clkbuf_4
Xfanout1115 net1117 vssd1 vssd1 vccd1 vccd1 net1115 sky130_fd_sc_hd__clkbuf_4
Xfanout1137 net1142 vssd1 vssd1 vccd1 vccd1 net1137 sky130_fd_sc_hd__clkbuf_4
Xfanout1126 net1128 vssd1 vssd1 vccd1 vccd1 net1126 sky130_fd_sc_hd__clkbuf_4
Xfanout1148 net1149 vssd1 vssd1 vccd1 vccd1 net1148 sky130_fd_sc_hd__clkbuf_4
Xfanout1159 net1163 vssd1 vssd1 vccd1 vccd1 net1159 sky130_fd_sc_hd__clkbuf_4
XFILLER_0_44_29 vssd1 vssd1 vccd1 vccd1 sky130_ef_sc_hd__decap_12
XFILLER_0_97_741 vssd1 vssd1 vccd1 vccd1 sky130_fd_sc_hd__decap_8
X_12813_ clknet_leaf_50_clk_i _00199_ vssd1 vssd1 vccd1 vccd1 sub1.a_i\[12\] sky130_fd_sc_hd__dfxtp_1
XFILLER_0_96_251 vssd1 vssd1 vccd1 vccd1 sky130_fd_sc_hd__fill_1
XFILLER_0_57_627 vssd1 vssd1 vccd1 vccd1 sky130_fd_sc_hd__fill_1
XTAP_1141 vssd1 vccd1 sky130_fd_sc_hd__tapvpwrvgnd_1
XTAP_1130 vssd1 vccd1 sky130_fd_sc_hd__tapvpwrvgnd_1
X_12744_ clknet_leaf_58_clk_i _00130_ vssd1 vssd1 vccd1 vccd1 add1.a_i\[7\] sky130_fd_sc_hd__dfxtp_1
XFILLER_0_29_307 vssd1 vssd1 vccd1 vccd1 sky130_fd_sc_hd__fill_2
XFILLER_0_84_435 vssd1 vssd1 vccd1 vccd1 sky130_fd_sc_hd__fill_2
XTAP_1174 vssd1 vccd1 sky130_fd_sc_hd__tapvpwrvgnd_1
XTAP_1163 vssd1 vccd1 sky130_fd_sc_hd__tapvpwrvgnd_1
XTAP_1152 vssd1 vccd1 sky130_fd_sc_hd__tapvpwrvgnd_1
XFILLER_0_56_126 vssd1 vssd1 vccd1 vccd1 sky130_fd_sc_hd__fill_1
X_12675_ clknet_leaf_19_clk_i net1261 net1178 vssd1 vssd1 vccd1 vccd1 net403 sky130_fd_sc_hd__dfrtp_1
XTAP_1196 vssd1 vccd1 sky130_fd_sc_hd__tapvpwrvgnd_1
XTAP_1185 vssd1 vccd1 sky130_fd_sc_hd__tapvpwrvgnd_1
XFILLER_0_65_671 vssd1 vssd1 vccd1 vccd1 sky130_fd_sc_hd__fill_1
X_11626_ _05516_ _05628_ _05626_ vssd1 vssd1 vccd1 vccd1 _05720_ sky130_fd_sc_hd__a21o_1
XFILLER_0_37_362 vssd1 vssd1 vccd1 vccd1 sky130_fd_sc_hd__fill_1
XFILLER_0_123_721 vssd1 vssd1 vccd1 vccd1 sky130_fd_sc_hd__decap_6
XFILLER_0_114_209 vssd1 vssd1 vccd1 vccd1 sky130_ef_sc_hd__decap_12
XFILLER_0_107_272 vssd1 vssd1 vccd1 vccd1 sky130_fd_sc_hd__fill_1
XFILLER_0_8_29 vssd1 vssd1 vccd1 vccd1 sky130_ef_sc_hd__decap_12
X_11557_ _05650_ _05651_ vssd1 vssd1 vccd1 vccd1 _05652_ sky130_fd_sc_hd__nor2_1
X_10508_ _04609_ _04610_ net1078 net704 vssd1 vssd1 vccd1 vccd1 _04611_ sky130_fd_sc_hd__and4bb_1
XFILLER_0_69_15 vssd1 vssd1 vccd1 vccd1 sky130_fd_sc_hd__decap_6
XFILLER_0_123_765 vssd1 vssd1 vccd1 vccd1 sky130_ef_sc_hd__decap_12
XFILLER_0_122_253 vssd1 vssd1 vccd1 vccd1 sky130_ef_sc_hd__decap_12
X_11488_ _05581_ _05582_ vssd1 vssd1 vccd1 vccd1 _05583_ sky130_fd_sc_hd__nand2_1
XFILLER_0_40_549 vssd1 vssd1 vccd1 vccd1 sky130_fd_sc_hd__fill_1
X_13227_ net507 vssd1 vssd1 vccd1 vccd1 net282 sky130_fd_sc_hd__clkbuf_1
X_10439_ _04429_ _04439_ _04440_ _04428_ vssd1 vssd1 vccd1 vccd1 _04542_ sky130_fd_sc_hd__a31o_1
X_13158_ clknet_leaf_13_clk_i _00544_ net1188 vssd1 vssd1 vccd1 vccd1 l0\[19\] sky130_fd_sc_hd__dfrtp_1
XTAP_925 vssd1 vccd1 sky130_fd_sc_hd__tapvpwrvgnd_1
XFILLER_0_21_785 vssd1 vssd1 vccd1 vccd1 sky130_fd_sc_hd__fill_1
XTAP_903 vssd1 vccd1 sky130_fd_sc_hd__tapvpwrvgnd_1
XTAP_914 vssd1 vccd1 sky130_fd_sc_hd__tapvpwrvgnd_1
XTAP_958 vssd1 vccd1 sky130_fd_sc_hd__tapvpwrvgnd_1
XTAP_947 vssd1 vccd1 sky130_fd_sc_hd__tapvpwrvgnd_1
XTAP_936 vssd1 vccd1 sky130_fd_sc_hd__tapvpwrvgnd_1
X_13089_ clknet_leaf_42_clk_i _00475_ vssd1 vssd1 vccd1 vccd1 temp1\[14\] sky130_fd_sc_hd__dfxtp_1
X_12109_ y2my0\[18\] net585 net533 x2mx1\[18\] _06087_ vssd1 vssd1 vccd1 vccd1 _06088_
+ sky130_fd_sc_hd__a221o_1
XTAP_969 vssd1 vccd1 sky130_fd_sc_hd__tapvpwrvgnd_1
XFILLER_0_18_41 vssd1 vssd1 vccd1 vccd1 sky130_ef_sc_hd__decap_12
XFILLER_0_33_9 vssd1 vssd1 vccd1 vccd1 sky130_fd_sc_hd__decap_4
XFILLER_0_18_85 vssd1 vssd1 vccd1 vccd1 sky130_fd_sc_hd__fill_2
X_07650_ _01766_ _01771_ vssd1 vssd1 vccd1 vccd1 _01773_ sky130_fd_sc_hd__xor2_1
X_07581_ net1074 net856 vssd1 vssd1 vccd1 vccd1 _01705_ sky130_fd_sc_hd__nand2_1
X_06601_ _00836_ _00839_ vssd1 vssd1 vccd1 vccd1 _00840_ sky130_fd_sc_hd__xor2_4
X_09320_ _03269_ _03270_ vssd1 vssd1 vccd1 vccd1 _03430_ sky130_fd_sc_hd__nor2_1
X_06532_ _00641_ _00655_ vssd1 vssd1 vccd1 vccd1 _00789_ sky130_fd_sc_hd__xnor2_4
XFILLER_0_75_424 vssd1 vssd1 vccd1 vccd1 sky130_fd_sc_hd__fill_1
X_09251_ net885 net962 _03220_ _03221_ net949 vssd1 vssd1 vccd1 vccd1 _03362_ sky130_fd_sc_hd__a32o_1
XFILLER_0_29_841 vssd1 vssd1 vccd1 vccd1 sky130_fd_sc_hd__fill_1
X_08202_ _02310_ _02319_ vssd1 vssd1 vccd1 vccd1 _02320_ sky130_fd_sc_hd__xnor2_1
X_06463_ _00752_ _00757_ vssd1 vssd1 vccd1 vccd1 _00760_ sky130_fd_sc_hd__nor2_1
X_09182_ _03164_ _03167_ _03292_ vssd1 vssd1 vccd1 vccd1 _03293_ sky130_fd_sc_hd__a21oi_2
XFILLER_0_62_118 vssd1 vssd1 vccd1 vccd1 sky130_fd_sc_hd__decap_8
X_06394_ add1.a_i\[18\] add1.b_i\[18\] vssd1 vssd1 vccd1 vccd1 _00701_ sky130_fd_sc_hd__nor2_1
XFILLER_0_28_362 vssd1 vssd1 vccd1 vccd1 sky130_fd_sc_hd__fill_2
XFILLER_0_126_581 vssd1 vssd1 vccd1 vccd1 sky130_fd_sc_hd__decap_6
X_08133_ _02248_ _02249_ _02250_ vssd1 vssd1 vccd1 vccd1 _02252_ sky130_fd_sc_hd__a21o_1
XFILLER_0_50_83 vssd1 vssd1 vccd1 vccd1 sky130_fd_sc_hd__fill_1
XFILLER_0_7_278 vssd1 vssd1 vccd1 vccd1 sky130_fd_sc_hd__fill_2
X_08064_ net1131 net755 _02180_ _02182_ vssd1 vssd1 vccd1 vccd1 _02183_ sky130_fd_sc_hd__and4_1
XFILLER_0_43_354 vssd1 vssd1 vccd1 vccd1 sky130_fd_sc_hd__fill_2
XFILLER_0_31_505 vssd1 vssd1 vccd1 vccd1 sky130_fd_sc_hd__fill_1
XFILLER_0_114_776 vssd1 vssd1 vccd1 vccd1 sky130_fd_sc_hd__decap_3
X_07015_ _01066_ _01136_ _01138_ _01139_ vssd1 vssd1 vccd1 vccd1 _01140_ sky130_fd_sc_hd__nor4_1
XFILLER_0_12_796 vssd1 vssd1 vccd1 vccd1 sky130_ef_sc_hd__decap_12
Xinput207 v2x[29] vssd1 vssd1 vccd1 vccd1 net207 sky130_fd_sc_hd__buf_1
Xinput218 v2y[0] vssd1 vssd1 vccd1 vccd1 net218 sky130_fd_sc_hd__buf_1
X_08966_ _03075_ _03076_ _03077_ vssd1 vssd1 vccd1 vccd1 _03079_ sky130_fd_sc_hd__a21o_1
Xinput229 v2y[1] vssd1 vssd1 vccd1 vccd1 net229 sky130_fd_sc_hd__buf_1
X_08897_ net797 _02870_ _02871_ _02872_ vssd1 vssd1 vccd1 vccd1 _03010_ sky130_fd_sc_hd__a22o_1
X_07917_ _01925_ _01929_ _02035_ _02037_ vssd1 vssd1 vccd1 vccd1 _02038_ sky130_fd_sc_hd__a211oi_4
X_07848_ net1106 net795 net786 net1115 vssd1 vssd1 vccd1 vccd1 _01969_ sky130_fd_sc_hd__a22o_1
X_09518_ _03456_ _03459_ _03625_ _03626_ vssd1 vssd1 vccd1 vccd1 _03627_ sky130_fd_sc_hd__o211a_1
XFILLER_0_79_785 vssd1 vssd1 vccd1 vccd1 sky130_fd_sc_hd__decap_3
X_07779_ net1042 net1050 net874 net864 vssd1 vssd1 vccd1 vccd1 _01901_ sky130_fd_sc_hd__and4_1
XPHY_224 vssd1 vssd1 vccd1 vccd1 sky130_fd_sc_hd__decap_3
XPHY_213 vssd1 vssd1 vccd1 vccd1 sky130_fd_sc_hd__decap_3
XPHY_202 vssd1 vssd1 vccd1 vccd1 sky130_fd_sc_hd__decap_3
XFILLER_0_94_755 vssd1 vssd1 vccd1 vccd1 sky130_fd_sc_hd__fill_1
X_10790_ _04854_ _04855_ _04889_ _04890_ vssd1 vssd1 vccd1 vccd1 _04891_ sky130_fd_sc_hd__nor4_1
XPHY_257 vssd1 vssd1 vccd1 vccd1 sky130_fd_sc_hd__decap_3
XPHY_246 vssd1 vssd1 vccd1 vccd1 sky130_fd_sc_hd__decap_3
XPHY_235 vssd1 vssd1 vccd1 vccd1 sky130_fd_sc_hd__decap_3
XFILLER_0_81_405 vssd1 vssd1 vccd1 vccd1 sky130_fd_sc_hd__decap_6
X_09449_ _03525_ _03556_ _03557_ vssd1 vssd1 vccd1 vccd1 _03559_ sky130_fd_sc_hd__nor3_2
XFILLER_0_54_608 vssd1 vssd1 vccd1 vccd1 sky130_fd_sc_hd__fill_1
XFILLER_0_93_298 vssd1 vssd1 vccd1 vccd1 sky130_fd_sc_hd__decap_4
XFILLER_0_81_427 vssd1 vssd1 vccd1 vccd1 sky130_fd_sc_hd__fill_1
XFILLER_0_19_362 vssd1 vssd1 vccd1 vccd1 sky130_fd_sc_hd__decap_4
X_12460_ net1723 _06225_ net572 vssd1 vssd1 vccd1 vccd1 _00482_ sky130_fd_sc_hd__mux2_1
XFILLER_0_62_641 vssd1 vssd1 vccd1 vccd1 sky130_fd_sc_hd__decap_3
X_11411_ net1011 net1003 net712 net708 vssd1 vssd1 vccd1 vccd1 _05507_ sky130_fd_sc_hd__and4_1
X_12391_ net1454 _00882_ net683 vssd1 vssd1 vccd1 vccd1 _00443_ sky130_fd_sc_hd__mux2_1
XFILLER_0_62_663 vssd1 vssd1 vccd1 vccd1 sky130_fd_sc_hd__decap_4
X_11342_ _05436_ _05437_ _05309_ _05311_ vssd1 vssd1 vccd1 vccd1 _05439_ sky130_fd_sc_hd__a211o_1
XFILLER_0_120_713 vssd1 vssd1 vccd1 vccd1 sky130_ef_sc_hd__decap_12
XFILLER_0_104_253 vssd1 vssd1 vccd1 vccd1 sky130_fd_sc_hd__fill_2
X_11273_ _05361_ _05369_ vssd1 vssd1 vccd1 vccd1 _05370_ sky130_fd_sc_hd__xnor2_1
XFILLER_0_120_757 vssd1 vssd1 vccd1 vccd1 sky130_ef_sc_hd__decap_12
X_10224_ _04314_ _04316_ _04326_ _04327_ vssd1 vssd1 vccd1 vccd1 _04329_ sky130_fd_sc_hd__a22o_1
X_13012_ clknet_leaf_45_clk_i _00398_ net1153 vssd1 vssd1 vccd1 vccd1 x0mx2\[1\] sky130_fd_sc_hd__dfrtp_1
X_10155_ _04099_ _04102_ _04257_ _04258_ vssd1 vssd1 vccd1 vccd1 _04260_ sky130_fd_sc_hd__a211oi_1
XFILLER_0_89_505 vssd1 vssd1 vccd1 vccd1 sky130_fd_sc_hd__fill_1
X_10086_ _04189_ _04190_ _04185_ vssd1 vssd1 vccd1 vccd1 _04192_ sky130_fd_sc_hd__a21o_1
Xhold6 _00057_ vssd1 vssd1 vccd1 vccd1 net1221 sky130_fd_sc_hd__dlygate4sd3_1
XFILLER_0_128_813 vssd1 vssd1 vccd1 vccd1 sky130_ef_sc_hd__decap_12
XFILLER_0_69_284 vssd1 vssd1 vccd1 vccd1 sky130_fd_sc_hd__fill_2
XFILLER_0_57_424 vssd1 vssd1 vccd1 vccd1 sky130_ef_sc_hd__decap_12
X_10988_ _05085_ _05086_ vssd1 vssd1 vccd1 vccd1 _05087_ sky130_fd_sc_hd__xnor2_1
X_12727_ clknet_leaf_7_clk_i _00113_ net1194 vssd1 vssd1 vccd1 vccd1 net347 sky130_fd_sc_hd__dfrtp_1
XFILLER_0_45_608 vssd1 vssd1 vccd1 vccd1 sky130_fd_sc_hd__decap_8
X_12658_ clknet_leaf_21_clk_i net1580 net1175 vssd1 vssd1 vccd1 vccd1 net385 sky130_fd_sc_hd__dfrtp_1
XFILLER_0_115_529 vssd1 vssd1 vccd1 vccd1 sky130_ef_sc_hd__decap_12
X_11609_ _05701_ _05702_ vssd1 vssd1 vccd1 vccd1 _05703_ sky130_fd_sc_hd__xnor2_1
XFILLER_0_111_33 vssd1 vssd1 vccd1 vccd1 sky130_ef_sc_hd__decap_12
X_12589_ net1518 net32 net554 vssd1 vssd1 vccd1 vccd1 _00564_ sky130_fd_sc_hd__mux2_1
XFILLER_0_123_573 vssd1 vssd1 vccd1 vccd1 sky130_ef_sc_hd__decap_12
XFILLER_0_20_53 vssd1 vssd1 vccd1 vccd1 sky130_ef_sc_hd__decap_12
Xhold417 x2mx1\[17\] vssd1 vssd1 vccd1 vccd1 net1632 sky130_fd_sc_hd__dlygate4sd3_1
Xhold406 x2mx1\[28\] vssd1 vssd1 vccd1 vccd1 net1621 sky130_fd_sc_hd__dlygate4sd3_1
Xhold439 x2mx1\[19\] vssd1 vssd1 vccd1 vccd1 net1654 sky130_fd_sc_hd__dlygate4sd3_1
XFILLER_0_20_97 vssd1 vssd1 vccd1 vccd1 sky130_fd_sc_hd__fill_2
Xhold428 x2mx1\[30\] vssd1 vssd1 vccd1 vccd1 net1643 sky130_fd_sc_hd__dlygate4sd3_1
XFILLER_0_110_245 vssd1 vssd1 vccd1 vccd1 sky130_fd_sc_hd__decap_6
XFILLER_0_21_571 vssd1 vssd1 vccd1 vccd1 sky130_fd_sc_hd__decap_3
XTAP_700 vssd1 vccd1 sky130_fd_sc_hd__tapvpwrvgnd_1
XFILLER_0_110_289 vssd1 vssd1 vccd1 vccd1 sky130_fd_sc_hd__decap_8
X_08820_ _02931_ _02932_ _02933_ vssd1 vssd1 vccd1 vccd1 _02934_ sky130_fd_sc_hd__nand3_4
Xfanout908 mul1.b\[2\] vssd1 vssd1 vccd1 vccd1 net908 sky130_fd_sc_hd__buf_2
Xfanout919 net925 vssd1 vssd1 vccd1 vccd1 net919 sky130_fd_sc_hd__clkbuf_4
XTAP_711 vssd1 vccd1 sky130_fd_sc_hd__tapvpwrvgnd_1
XTAP_722 vssd1 vccd1 sky130_fd_sc_hd__tapvpwrvgnd_1
XTAP_733 vssd1 vccd1 sky130_fd_sc_hd__tapvpwrvgnd_1
XTAP_744 vssd1 vccd1 sky130_fd_sc_hd__tapvpwrvgnd_1
XTAP_755 vssd1 vccd1 sky130_fd_sc_hd__tapvpwrvgnd_1
XTAP_766 vssd1 vccd1 sky130_fd_sc_hd__tapvpwrvgnd_1
XTAP_777 vssd1 vccd1 sky130_fd_sc_hd__tapvpwrvgnd_1
X_08751_ _02856_ _02864_ vssd1 vssd1 vccd1 vccd1 _02865_ sky130_fd_sc_hd__nand2b_1
XTAP_788 vssd1 vccd1 sky130_fd_sc_hd__tapvpwrvgnd_1
XTAP_799 vssd1 vccd1 sky130_fd_sc_hd__tapvpwrvgnd_1
X_08682_ _02735_ _02794_ _02795_ vssd1 vssd1 vccd1 vccd1 _02797_ sky130_fd_sc_hd__or3_2
X_07702_ _01721_ _01722_ _01723_ vssd1 vssd1 vccd1 vccd1 _01825_ sky130_fd_sc_hd__a21bo_1
X_07633_ _01461_ _01756_ _01665_ vssd1 vssd1 vccd1 vccd1 _01757_ sky130_fd_sc_hd__or3b_1
XFILLER_0_45_94 vssd1 vssd1 vccd1 vccd1 sky130_fd_sc_hd__fill_2
X_07564_ _01683_ _01687_ vssd1 vssd1 vccd1 vccd1 _01688_ sky130_fd_sc_hd__xor2_2
X_06515_ det_t\[25\] net529 vssd1 vssd1 vccd1 vccd1 net269 sky130_fd_sc_hd__and2_1
XFILLER_0_118_301 vssd1 vssd1 vccd1 vccd1 sky130_fd_sc_hd__decap_6
X_09303_ _03265_ _03410_ _03411_ vssd1 vssd1 vccd1 vccd1 _03414_ sky130_fd_sc_hd__or3_1
XFILLER_0_75_232 vssd1 vssd1 vccd1 vccd1 sky130_fd_sc_hd__fill_1
X_07495_ _01590_ _01592_ _01591_ vssd1 vssd1 vccd1 vccd1 _01620_ sky130_fd_sc_hd__o21ai_1
XFILLER_0_118_345 vssd1 vssd1 vccd1 vccd1 sky130_ef_sc_hd__decap_12
X_09234_ net1002 _03344_ _03343_ vssd1 vssd1 vccd1 vccd1 _03345_ sky130_fd_sc_hd__a21bo_1
XFILLER_0_61_82 vssd1 vssd1 vccd1 vccd1 sky130_ef_sc_hd__decap_12
X_06446_ add1.a_i\[25\] add1.b_i\[25\] vssd1 vssd1 vccd1 vccd1 _00746_ sky130_fd_sc_hd__or2_1
XFILLER_0_29_660 vssd1 vssd1 vccd1 vccd1 sky130_fd_sc_hd__fill_2
XFILLER_0_118_389 vssd1 vssd1 vccd1 vccd1 sky130_ef_sc_hd__decap_12
X_09165_ net1149 net700 vssd1 vssd1 vccd1 vccd1 _03276_ sky130_fd_sc_hd__nand2_1
XFILLER_0_63_449 vssd1 vssd1 vccd1 vccd1 sky130_fd_sc_hd__decap_8
X_08116_ _02232_ _02233_ _02126_ _02128_ vssd1 vssd1 vccd1 vccd1 _02235_ sky130_fd_sc_hd__a211o_1
X_06377_ _00678_ _00681_ _00686_ vssd1 vssd1 vccd1 vccd1 _00687_ sky130_fd_sc_hd__a21o_1
XFILLER_0_16_365 vssd1 vssd1 vccd1 vccd1 sky130_fd_sc_hd__decap_3
X_09096_ _03042_ _03044_ _03205_ net521 vssd1 vssd1 vccd1 vccd1 _03208_ sky130_fd_sc_hd__a211oi_4
X_08047_ _02058_ _02164_ _02165_ vssd1 vssd1 vccd1 vccd1 _02167_ sky130_fd_sc_hd__and3_1
XFILLER_0_102_757 vssd1 vssd1 vccd1 vccd1 sky130_fd_sc_hd__decap_8
XFILLER_0_101_223 vssd1 vssd1 vccd1 vccd1 sky130_fd_sc_hd__fill_1
XFILLER_0_101_278 vssd1 vssd1 vccd1 vccd1 sky130_fd_sc_hd__fill_2
Xmax_cap692 _03869_ vssd1 vssd1 vccd1 vccd1 net692 sky130_fd_sc_hd__clkbuf_2
X_09998_ _04101_ _04102_ _04091_ vssd1 vssd1 vccd1 vccd1 _04104_ sky130_fd_sc_hd__a21boi_1
X_08949_ net885 net967 vssd1 vssd1 vccd1 vccd1 _03062_ sky130_fd_sc_hd__nand2_1
X_11960_ net127 net656 net503 net223 _05974_ vssd1 vssd1 vccd1 vccd1 _05975_ sky130_fd_sc_hd__a221o_1
XFILLER_0_98_357 vssd1 vssd1 vccd1 vccd1 sky130_fd_sc_hd__decap_6
X_10911_ _04877_ _04880_ _05010_ vssd1 vssd1 vccd1 vccd1 _05011_ sky130_fd_sc_hd__a21o_1
X_11891_ net241 net601 net580 net145 _05921_ vssd1 vssd1 vccd1 vccd1 _05922_ sky130_fd_sc_hd__a221o_1
X_10842_ _04940_ _04941_ _04791_ _04793_ vssd1 vssd1 vccd1 vccd1 _04943_ sky130_fd_sc_hd__a211o_1
X_10773_ net790 net965 net960 net800 vssd1 vssd1 vccd1 vccd1 _04874_ sky130_fd_sc_hd__a22oi_1
XFILLER_0_39_468 vssd1 vssd1 vccd1 vccd1 sky130_ef_sc_hd__decap_12
X_12512_ net1265 net563 vssd1 vssd1 vccd1 vccd1 _06253_ sky130_fd_sc_hd__nand2_1
XFILLER_0_125_827 vssd1 vssd1 vccd1 vccd1 sky130_fd_sc_hd__fill_1
XFILLER_0_109_378 vssd1 vssd1 vccd1 vccd1 sky130_fd_sc_hd__decap_4
XFILLER_0_19_192 vssd1 vssd1 vccd1 vccd1 sky130_fd_sc_hd__decap_8
XFILLER_0_50_600 vssd1 vssd1 vccd1 vccd1 sky130_ef_sc_hd__decap_12
XFILLER_0_23_825 vssd1 vssd1 vccd1 vccd1 sky130_fd_sc_hd__fill_1
X_12443_ net38 net688 _00892_ net614 vssd1 vssd1 vccd1 vccd1 _06214_ sky130_fd_sc_hd__a22o_1
X_12374_ net1509 _00965_ net663 vssd1 vssd1 vccd1 vccd1 _00426_ sky130_fd_sc_hd__mux2_1
XFILLER_0_34_195 vssd1 vssd1 vccd1 vccd1 sky130_fd_sc_hd__fill_1
X_11325_ _05419_ _05420_ _05289_ _05292_ vssd1 vssd1 vccd1 vccd1 _05422_ sky130_fd_sc_hd__o211ai_2
XFILLER_0_50_699 vssd1 vssd1 vccd1 vccd1 sky130_fd_sc_hd__fill_1
X_11256_ net757 net963 vssd1 vssd1 vccd1 vccd1 _05353_ sky130_fd_sc_hd__nand2_1
XFILLER_0_120_587 vssd1 vssd1 vccd1 vccd1 sky130_fd_sc_hd__fill_1
X_10207_ _04309_ _04310_ _04025_ vssd1 vssd1 vccd1 vccd1 _04312_ sky130_fd_sc_hd__a21bo_1
X_11187_ net1003 net996 net729 net721 vssd1 vssd1 vccd1 vccd1 _05285_ sky130_fd_sc_hd__and4_1
X_10138_ _04242_ vssd1 vssd1 vccd1 vccd1 _04243_ sky130_fd_sc_hd__inv_2
X_10069_ net902 net893 net926 vssd1 vssd1 vccd1 vccd1 _04175_ sky130_fd_sc_hd__o21a_2
XFILLER_0_89_324 vssd1 vssd1 vccd1 vccd1 sky130_fd_sc_hd__fill_1
XFILLER_0_82_15 vssd1 vssd1 vccd1 vccd1 sky130_ef_sc_hd__decap_12
XFILLER_0_106_77 vssd1 vssd1 vccd1 vccd1 sky130_fd_sc_hd__decap_6
XFILLER_0_57_232 vssd1 vssd1 vccd1 vccd1 sky130_fd_sc_hd__decap_8
XFILLER_0_128_665 vssd1 vssd1 vccd1 vccd1 sky130_fd_sc_hd__fill_1
XFILLER_0_128_643 vssd1 vssd1 vccd1 vccd1 sky130_fd_sc_hd__fill_1
XFILLER_0_57_265 vssd1 vssd1 vccd1 vccd1 sky130_ef_sc_hd__decap_12
X_06300_ state\[2\] state\[3\] state\[4\] vssd1 vssd1 vccd1 vccd1 _00613_ sky130_fd_sc_hd__or3_4
X_07280_ _01401_ _01402_ _01269_ _01271_ vssd1 vssd1 vccd1 vccd1 _01405_ sky130_fd_sc_hd__o211ai_2
XFILLER_0_122_65 vssd1 vssd1 vccd1 vccd1 sky130_ef_sc_hd__decap_12
XFILLER_0_73_747 vssd1 vssd1 vccd1 vccd1 sky130_fd_sc_hd__fill_1
XFILLER_0_72_246 vssd1 vssd1 vccd1 vccd1 sky130_fd_sc_hd__decap_6
XFILLER_0_26_641 vssd1 vssd1 vccd1 vccd1 sky130_fd_sc_hd__decap_3
XFILLER_0_31_41 vssd1 vssd1 vccd1 vccd1 sky130_fd_sc_hd__decap_8
XFILLER_0_115_337 vssd1 vssd1 vccd1 vccd1 sky130_ef_sc_hd__decap_12
XFILLER_0_14_825 vssd1 vssd1 vccd1 vccd1 sky130_fd_sc_hd__decap_4
XFILLER_0_31_63 vssd1 vssd1 vccd1 vccd1 sky130_fd_sc_hd__fill_1
Xclkbuf_leaf_2_clk_i clknet_3_2__leaf_clk_i vssd1 vssd1 vccd1 vccd1 clknet_leaf_2_clk_i
+ sky130_fd_sc_hd__clkbuf_16
Xhold214 l0\[19\] vssd1 vssd1 vccd1 vccd1 net1429 sky130_fd_sc_hd__dlygate4sd3_1
Xhold225 l1\[20\] vssd1 vssd1 vccd1 vccd1 net1440 sky130_fd_sc_hd__dlygate4sd3_1
Xhold203 x0mx2\[7\] vssd1 vssd1 vccd1 vccd1 net1418 sky130_fd_sc_hd__dlygate4sd3_1
XFILLER_0_41_677 vssd1 vssd1 vccd1 vccd1 sky130_fd_sc_hd__decap_6
Xhold247 posx\[1\] vssd1 vssd1 vccd1 vccd1 net1462 sky130_fd_sc_hd__dlygate4sd3_1
Xhold236 _00068_ vssd1 vssd1 vccd1 vccd1 net1451 sky130_fd_sc_hd__dlygate4sd3_1
X_09921_ net883 net936 vssd1 vssd1 vccd1 vccd1 _04028_ sky130_fd_sc_hd__and2_1
Xhold258 x0mx2\[8\] vssd1 vssd1 vccd1 vccd1 net1473 sky130_fd_sc_hd__dlygate4sd3_1
Xhold269 net365 vssd1 vssd1 vccd1 vccd1 net1484 sky130_fd_sc_hd__dlygate4sd3_1
Xfanout705 net706 vssd1 vssd1 vccd1 vccd1 net705 sky130_fd_sc_hd__buf_4
Xfanout749 mul1.b\[21\] vssd1 vssd1 vccd1 vccd1 net749 sky130_fd_sc_hd__clkbuf_4
X_09852_ _03957_ _03958_ vssd1 vssd1 vccd1 vccd1 _03959_ sky130_fd_sc_hd__xnor2_2
Xfanout727 net733 vssd1 vssd1 vccd1 vccd1 net727 sky130_fd_sc_hd__clkbuf_4
Xfanout716 mul1.b\[27\] vssd1 vssd1 vccd1 vccd1 net716 sky130_fd_sc_hd__buf_4
Xfanout738 net739 vssd1 vssd1 vccd1 vccd1 net738 sky130_fd_sc_hd__clkbuf_4
XTAP_530 vssd1 vccd1 sky130_fd_sc_hd__tapvpwrvgnd_1
XTAP_541 vssd1 vccd1 sky130_fd_sc_hd__tapvpwrvgnd_1
XTAP_552 vssd1 vccd1 sky130_fd_sc_hd__tapvpwrvgnd_1
X_09783_ _03797_ _03890_ vssd1 vssd1 vccd1 vccd1 _03891_ sky130_fd_sc_hd__xor2_4
X_08803_ _02907_ _02915_ vssd1 vssd1 vccd1 vccd1 _02917_ sky130_fd_sc_hd__xor2_2
XTAP_563 vssd1 vccd1 sky130_fd_sc_hd__tapvpwrvgnd_1
XTAP_585 vssd1 vccd1 sky130_fd_sc_hd__tapvpwrvgnd_1
XTAP_574 vssd1 vccd1 sky130_fd_sc_hd__tapvpwrvgnd_1
X_08734_ _02823_ _02846_ vssd1 vssd1 vccd1 vccd1 _02848_ sky130_fd_sc_hd__xnor2_1
XTAP_596 vssd1 vccd1 sky130_fd_sc_hd__tapvpwrvgnd_1
X_06995_ _01118_ _01119_ _01104_ vssd1 vssd1 vccd1 vccd1 _01120_ sky130_fd_sc_hd__a21o_1
X_08665_ _02776_ _02777_ _02778_ vssd1 vssd1 vccd1 vccd1 _02780_ sky130_fd_sc_hd__a21o_1
X_08596_ _02709_ _02710_ vssd1 vssd1 vccd1 vccd1 _02711_ sky130_fd_sc_hd__nand2_1
XTAP_1729 vssd1 vccd1 sky130_fd_sc_hd__tapvpwrvgnd_1
XTAP_1718 vssd1 vccd1 sky130_fd_sc_hd__tapvpwrvgnd_1
XTAP_1707 vssd1 vccd1 sky130_fd_sc_hd__tapvpwrvgnd_1
X_07616_ _01701_ _01702_ _01737_ _01739_ vssd1 vssd1 vccd1 vccd1 _01740_ sky130_fd_sc_hd__o22a_1
X_07547_ net1129 net1137 net798 net788 vssd1 vssd1 vccd1 vccd1 _01671_ sky130_fd_sc_hd__and4_1
XFILLER_0_48_243 vssd1 vssd1 vccd1 vccd1 sky130_fd_sc_hd__decap_8
XFILLER_0_63_213 vssd1 vssd1 vccd1 vccd1 sky130_fd_sc_hd__decap_8
XFILLER_0_9_841 vssd1 vssd1 vccd1 vccd1 sky130_fd_sc_hd__fill_1
XFILLER_0_119_665 vssd1 vssd1 vccd1 vccd1 sky130_fd_sc_hd__decap_6
XFILLER_0_118_153 vssd1 vssd1 vccd1 vccd1 sky130_ef_sc_hd__decap_12
X_07478_ _01600_ _01601_ _01595_ vssd1 vssd1 vccd1 vccd1 _01603_ sky130_fd_sc_hd__a21oi_1
XFILLER_0_118_197 vssd1 vssd1 vccd1 vccd1 sky130_ef_sc_hd__decap_12
X_09217_ _03325_ _03326_ _03321_ vssd1 vssd1 vccd1 vccd1 _03328_ sky130_fd_sc_hd__a21o_1
X_06429_ _00724_ _00725_ _00730_ _00721_ vssd1 vssd1 vccd1 vccd1 _00732_ sky130_fd_sc_hd__o211a_1
X_09148_ _03258_ _03259_ vssd1 vssd1 vccd1 vccd1 _03260_ sky130_fd_sc_hd__or2_4
XFILLER_0_16_162 vssd1 vssd1 vccd1 vccd1 sky130_fd_sc_hd__fill_1
XFILLER_0_121_329 vssd1 vssd1 vccd1 vccd1 sky130_fd_sc_hd__decap_6
X_09079_ net1017 net825 net818 vssd1 vssd1 vccd1 vccd1 _03191_ sky130_fd_sc_hd__and3_1
XFILLER_0_31_132 vssd1 vssd1 vccd1 vccd1 sky130_fd_sc_hd__decap_4
XFILLER_0_130_841 vssd1 vssd1 vccd1 vccd1 sky130_fd_sc_hd__fill_1
X_11110_ _05091_ _05207_ vssd1 vssd1 vccd1 vccd1 _05208_ sky130_fd_sc_hd__nand2_1
XFILLER_0_32_699 vssd1 vssd1 vccd1 vccd1 sky130_fd_sc_hd__fill_1
X_12090_ _00877_ _06073_ net499 vssd1 vssd1 vccd1 vccd1 _06074_ sky130_fd_sc_hd__mux2_1
X_11041_ _04982_ _05020_ net1750 _05138_ vssd1 vssd1 vccd1 vccd1 _05140_ sky130_fd_sc_hd__a211o_1
XFILLER_0_98_132 vssd1 vssd1 vccd1 vccd1 sky130_fd_sc_hd__decap_8
X_12992_ clknet_leaf_42_clk_i _00378_ net1157 vssd1 vssd1 vccd1 vccd1 x2mx1\[13\]
+ sky130_fd_sc_hd__dfrtp_1
X_11943_ net3 net550 net625 net187 _05961_ vssd1 vssd1 vccd1 vccd1 _05962_ sky130_fd_sc_hd__a221o_1
XFILLER_0_52_29 vssd1 vssd1 vccd1 vccd1 sky130_fd_sc_hd__decap_4
X_11874_ net653 _00951_ net476 _05907_ vssd1 vssd1 vccd1 vccd1 _05908_ sky130_fd_sc_hd__a211o_1
X_10825_ _04721_ _04724_ _04924_ vssd1 vssd1 vccd1 vccd1 _04926_ sky130_fd_sc_hd__a21o_1
XFILLER_0_67_541 vssd1 vssd1 vccd1 vccd1 sky130_fd_sc_hd__decap_8
XFILLER_0_94_360 vssd1 vssd1 vccd1 vccd1 sky130_fd_sc_hd__decap_4
XFILLER_0_67_574 vssd1 vssd1 vccd1 vccd1 sky130_fd_sc_hd__decap_3
X_10756_ net999 net751 net743 net1005 vssd1 vssd1 vccd1 vccd1 _04857_ sky130_fd_sc_hd__a22o_1
X_10687_ _04787_ _04788_ _04770_ vssd1 vssd1 vccd1 vccd1 _04789_ sky130_fd_sc_hd__o21ai_1
XFILLER_0_54_257 vssd1 vssd1 vccd1 vccd1 sky130_fd_sc_hd__fill_1
XFILLER_0_112_307 vssd1 vssd1 vccd1 vccd1 sky130_fd_sc_hd__fill_1
XFILLER_0_23_611 vssd1 vssd1 vccd1 vccd1 sky130_fd_sc_hd__decap_4
X_12426_ net1740 _06205_ net570 vssd1 vssd1 vccd1 vccd1 _00468_ sky130_fd_sc_hd__mux2_1
XFILLER_0_35_471 vssd1 vssd1 vccd1 vccd1 sky130_fd_sc_hd__fill_1
Xoutput308 net308 vssd1 vssd1 vccd1 vccd1 div_mstream_o[75] sky130_fd_sc_hd__clkbuf_4
XFILLER_0_22_132 vssd1 vssd1 vccd1 vccd1 sky130_fd_sc_hd__fill_1
Xoutput319 net319 vssd1 vssd1 vccd1 vccd1 div_mstream_o[85] sky130_fd_sc_hd__clkbuf_4
XFILLER_0_121_841 vssd1 vssd1 vccd1 vccd1 sky130_fd_sc_hd__fill_1
XFILLER_0_77_15 vssd1 vssd1 vccd1 vccd1 sky130_ef_sc_hd__decap_12
X_12357_ net1530 _00872_ net657 vssd1 vssd1 vccd1 vccd1 _00409_ sky130_fd_sc_hd__mux2_1
X_11308_ _05277_ _05404_ vssd1 vssd1 vccd1 vccd1 _05405_ sky130_fd_sc_hd__nand2_1
X_12288_ net1681 _00846_ net675 vssd1 vssd1 vccd1 vccd1 _00340_ sky130_fd_sc_hd__mux2_1
X_11239_ _04960_ _05334_ vssd1 vssd1 vccd1 vccd1 _05336_ sky130_fd_sc_hd__xnor2_1
XFILLER_0_93_69 vssd1 vssd1 vccd1 vccd1 sky130_fd_sc_hd__decap_8
X_06780_ net1476 net1360 net638 vssd1 vssd1 vccd1 vccd1 _00054_ sky130_fd_sc_hd__mux2_1
XFILLER_0_26_41 vssd1 vssd1 vccd1 vccd1 sky130_ef_sc_hd__decap_12
X_08450_ net1092 net773 net764 net1099 vssd1 vssd1 vccd1 vccd1 _02566_ sky130_fd_sc_hd__a22o_1
XFILLER_0_26_85 vssd1 vssd1 vccd1 vccd1 sky130_fd_sc_hd__decap_3
X_08381_ net891 net986 net979 net900 vssd1 vssd1 vccd1 vccd1 _02498_ sky130_fd_sc_hd__a22oi_1
X_07401_ _01524_ _01525_ vssd1 vssd1 vccd1 vccd1 _01526_ sky130_fd_sc_hd__xnor2_1
X_07332_ _01453_ _01455_ _01409_ vssd1 vssd1 vccd1 vccd1 _01457_ sky130_fd_sc_hd__a21bo_1
XFILLER_0_42_51 vssd1 vssd1 vccd1 vccd1 sky130_fd_sc_hd__decap_6
XFILLER_0_42_62 vssd1 vssd1 vccd1 vccd1 sky130_fd_sc_hd__fill_2
XFILLER_0_116_613 vssd1 vssd1 vccd1 vccd1 sky130_ef_sc_hd__decap_12
XFILLER_0_85_393 vssd1 vssd1 vccd1 vccd1 sky130_fd_sc_hd__fill_2
XFILLER_0_73_522 vssd1 vssd1 vccd1 vccd1 sky130_fd_sc_hd__fill_2
XFILLER_0_58_596 vssd1 vssd1 vccd1 vccd1 sky130_fd_sc_hd__decap_8
X_07263_ _01368_ _01385_ _01386_ vssd1 vssd1 vccd1 vccd1 _01388_ sky130_fd_sc_hd__and3_1
XFILLER_0_33_419 vssd1 vssd1 vccd1 vccd1 sky130_fd_sc_hd__fill_2
XFILLER_0_116_657 vssd1 vssd1 vccd1 vccd1 sky130_ef_sc_hd__decap_12
X_09002_ _02989_ _02992_ vssd1 vssd1 vccd1 vccd1 _03114_ sky130_fd_sc_hd__or2_2
XFILLER_0_54_791 vssd1 vssd1 vccd1 vccd1 sky130_fd_sc_hd__fill_2
X_07194_ _01306_ _01316_ _01317_ vssd1 vssd1 vccd1 vccd1 _01319_ sky130_fd_sc_hd__nand3_1
XFILLER_0_115_167 vssd1 vssd1 vccd1 vccd1 sky130_fd_sc_hd__fill_1
XFILLER_0_130_126 vssd1 vssd1 vccd1 vccd1 sky130_fd_sc_hd__decap_3
XFILLER_0_77_3 vssd1 vssd1 vccd1 vccd1 sky130_ef_sc_hd__decap_12
XFILLER_0_41_474 vssd1 vssd1 vccd1 vccd1 sky130_ef_sc_hd__decap_12
XFILLER_0_111_373 vssd1 vssd1 vccd1 vccd1 sky130_ef_sc_hd__decap_12
X_09904_ _03991_ _04009_ vssd1 vssd1 vccd1 vccd1 _04011_ sky130_fd_sc_hd__xnor2_4
Xfanout502 _05930_ vssd1 vssd1 vccd1 vccd1 net502 sky130_fd_sc_hd__clkbuf_4
XFILLER_0_6_73 vssd1 vssd1 vccd1 vccd1 sky130_fd_sc_hd__fill_2
Xfanout513 net515 vssd1 vssd1 vccd1 vccd1 net513 sky130_fd_sc_hd__buf_4
Xfanout524 net525 vssd1 vssd1 vccd1 vccd1 net524 sky130_fd_sc_hd__clkbuf_4
Xfanout546 net548 vssd1 vssd1 vccd1 vccd1 net546 sky130_fd_sc_hd__buf_2
X_09835_ _03930_ _03940_ _03941_ vssd1 vssd1 vccd1 vccd1 _03942_ sky130_fd_sc_hd__and3b_1
XTAP_360 vssd1 vccd1 sky130_fd_sc_hd__tapvpwrvgnd_1
Xfanout535 _06027_ vssd1 vssd1 vccd1 vccd1 net535 sky130_fd_sc_hd__buf_2
Xfanout557 _06272_ vssd1 vssd1 vccd1 vccd1 net557 sky130_fd_sc_hd__buf_2
Xfanout568 net569 vssd1 vssd1 vccd1 vccd1 net568 sky130_fd_sc_hd__buf_2
XTAP_393 vssd1 vccd1 sky130_fd_sc_hd__tapvpwrvgnd_1
XTAP_371 vssd1 vccd1 sky130_fd_sc_hd__tapvpwrvgnd_1
XTAP_382 vssd1 vccd1 sky130_fd_sc_hd__tapvpwrvgnd_1
Xfanout579 _05760_ vssd1 vssd1 vccd1 vccd1 net579 sky130_fd_sc_hd__clkbuf_2
X_09766_ _03867_ _03868_ _03870_ _03872_ vssd1 vssd1 vccd1 vccd1 _03874_ sky130_fd_sc_hd__and4_1
X_06978_ _01102_ vssd1 vssd1 vccd1 vccd1 _01103_ sky130_fd_sc_hd__inv_2
XTAP_2216 vssd1 vccd1 sky130_fd_sc_hd__tapvpwrvgnd_1
XTAP_2205 vssd1 vccd1 sky130_fd_sc_hd__tapvpwrvgnd_1
X_08717_ net1140 net720 vssd1 vssd1 vccd1 vccd1 _02831_ sky130_fd_sc_hd__nand2_1
X_09697_ net1028 net1037 net777 net767 vssd1 vssd1 vccd1 vccd1 _03805_ sky130_fd_sc_hd__and4_1
XTAP_2249 vssd1 vccd1 sky130_fd_sc_hd__tapvpwrvgnd_1
XTAP_2238 vssd1 vccd1 sky130_fd_sc_hd__tapvpwrvgnd_1
XTAP_2227 vssd1 vccd1 sky130_fd_sc_hd__tapvpwrvgnd_1
XTAP_1515 vssd1 vccd1 sky130_fd_sc_hd__tapvpwrvgnd_1
XTAP_1504 vssd1 vccd1 sky130_fd_sc_hd__tapvpwrvgnd_1
X_08648_ _02761_ _02762_ vssd1 vssd1 vccd1 vccd1 _02763_ sky130_fd_sc_hd__nor2_1
XFILLER_0_68_316 vssd1 vssd1 vccd1 vccd1 sky130_fd_sc_hd__fill_2
XPHY_11 vssd1 vssd1 vccd1 vccd1 sky130_fd_sc_hd__decap_3
XPHY_22 vssd1 vssd1 vccd1 vccd1 sky130_fd_sc_hd__decap_3
XTAP_1548 vssd1 vccd1 sky130_fd_sc_hd__tapvpwrvgnd_1
XTAP_1537 vssd1 vccd1 sky130_fd_sc_hd__tapvpwrvgnd_1
XTAP_1526 vssd1 vccd1 sky130_fd_sc_hd__tapvpwrvgnd_1
XPHY_33 vssd1 vssd1 vccd1 vccd1 sky130_fd_sc_hd__decap_3
XPHY_44 vssd1 vssd1 vccd1 vccd1 sky130_fd_sc_hd__decap_3
XPHY_55 vssd1 vssd1 vccd1 vccd1 sky130_fd_sc_hd__decap_3
X_08579_ _02554_ _02691_ _02690_ vssd1 vssd1 vccd1 vccd1 _02694_ sky130_fd_sc_hd__a21o_1
XTAP_1559 vssd1 vccd1 sky130_fd_sc_hd__tapvpwrvgnd_1
XPHY_88 vssd1 vssd1 vccd1 vccd1 sky130_fd_sc_hd__decap_3
XPHY_66 vssd1 vssd1 vccd1 vccd1 sky130_fd_sc_hd__decap_3
XPHY_77 vssd1 vssd1 vccd1 vccd1 sky130_fd_sc_hd__decap_3
XFILLER_0_119_473 vssd1 vssd1 vccd1 vccd1 sky130_ef_sc_hd__decap_12
XFILLER_0_64_533 vssd1 vssd1 vccd1 vccd1 sky130_fd_sc_hd__fill_1
X_10610_ net1022 net737 _04710_ _04711_ vssd1 vssd1 vccd1 vccd1 _04712_ sky130_fd_sc_hd__nand4_2
XPHY_99 vssd1 vssd1 vccd1 vccd1 sky130_fd_sc_hd__decap_3
X_11590_ _05682_ _05683_ vssd1 vssd1 vccd1 vccd1 _05684_ sky130_fd_sc_hd__and2b_1
XFILLER_0_36_235 vssd1 vssd1 vccd1 vccd1 sky130_fd_sc_hd__fill_1
X_10541_ _04413_ _04416_ _04642_ _04643_ vssd1 vssd1 vccd1 vccd1 _04644_ sky130_fd_sc_hd__o211a_1
XFILLER_0_24_419 vssd1 vssd1 vccd1 vccd1 sky130_fd_sc_hd__fill_1
XFILLER_0_51_216 vssd1 vssd1 vccd1 vccd1 sky130_fd_sc_hd__fill_2
XFILLER_0_106_189 vssd1 vssd1 vccd1 vccd1 sky130_fd_sc_hd__fill_1
X_10472_ net1006 net760 _04572_ _04573_ vssd1 vssd1 vccd1 vccd1 _04575_ sky130_fd_sc_hd__a22o_1
X_12211_ _00887_ net510 net467 y1my2\[15\] _06160_ vssd1 vssd1 vccd1 vccd1 _06161_
+ sky130_fd_sc_hd__a221o_1
XFILLER_0_121_137 vssd1 vssd1 vccd1 vccd1 sky130_ef_sc_hd__decap_12
XFILLER_0_103_841 vssd1 vssd1 vccd1 vccd1 sky130_fd_sc_hd__fill_1
X_13191_ clknet_leaf_19_clk_i _00577_ net1178 vssd1 vssd1 vccd1 vccd1 l1\[20\] sky130_fd_sc_hd__dfrtp_1
XFILLER_0_32_474 vssd1 vssd1 vccd1 vccd1 sky130_fd_sc_hd__fill_2
X_12142_ _00946_ _06112_ net500 vssd1 vssd1 vccd1 vccd1 _06113_ sky130_fd_sc_hd__mux2_1
XFILLER_0_32_496 vssd1 vssd1 vccd1 vccd1 sky130_ef_sc_hd__decap_12
X_12073_ y2my0\[9\] net583 net531 x2mx1\[9\] _06060_ vssd1 vssd1 vccd1 vccd1 _06061_
+ sky130_fd_sc_hd__a221o_1
X_11024_ net783 mul1.a\[25\] _05120_ _05121_ vssd1 vssd1 vccd1 vccd1 _05123_ sky130_fd_sc_hd__o2bb2a_1
X_12975_ clknet_leaf_25_clk_i _00361_ net1172 vssd1 vssd1 vccd1 vccd1 y1my2\[28\]
+ sky130_fd_sc_hd__dfrtp_1
XFILLER_0_87_614 vssd1 vssd1 vccd1 vccd1 sky130_fd_sc_hd__fill_2
XFILLER_0_86_113 vssd1 vssd1 vccd1 vccd1 sky130_fd_sc_hd__decap_4
X_11926_ net118 net620 net594 net86 vssd1 vssd1 vccd1 vccd1 _05949_ sky130_fd_sc_hd__a22o_1
XFILLER_0_86_124 vssd1 vssd1 vccd1 vccd1 sky130_fd_sc_hd__decap_4
X_11857_ net170 net471 _05893_ vssd1 vssd1 vccd1 vccd1 _05894_ sky130_fd_sc_hd__o21a_1
X_10808_ _04903_ _04907_ vssd1 vssd1 vccd1 vccd1 _04909_ sky130_fd_sc_hd__xnor2_1
XFILLER_0_67_393 vssd1 vssd1 vccd1 vccd1 sky130_fd_sc_hd__fill_2
X_11788_ net159 net470 _05834_ vssd1 vssd1 vccd1 vccd1 _05835_ sky130_fd_sc_hd__o21a_1
XFILLER_0_55_555 vssd1 vssd1 vccd1 vccd1 sky130_fd_sc_hd__decap_4
X_10739_ _04839_ _04838_ _04837_ vssd1 vssd1 vccd1 vccd1 _04840_ sky130_fd_sc_hd__nand3b_2
XFILLER_0_12_65 vssd1 vssd1 vccd1 vccd1 sky130_ef_sc_hd__decap_12
XFILLER_0_70_569 vssd1 vssd1 vccd1 vccd1 sky130_fd_sc_hd__decap_6
X_12409_ net691 net613 vssd1 vssd1 vccd1 vccd1 _06196_ sky130_fd_sc_hd__nor2_1
XFILLER_0_121_671 vssd1 vssd1 vccd1 vccd1 sky130_fd_sc_hd__fill_1
XFILLER_0_11_647 vssd1 vssd1 vccd1 vccd1 sky130_fd_sc_hd__decap_4
X_07950_ _02068_ _02069_ vssd1 vssd1 vccd1 vccd1 _02070_ sky130_fd_sc_hd__or2_1
XFILLER_0_11_669 vssd1 vssd1 vccd1 vccd1 sky130_fd_sc_hd__decap_3
X_06901_ _01024_ _01025_ net854 net1111 vssd1 vssd1 vccd1 vccd1 _01026_ sky130_fd_sc_hd__and4bb_1
XFILLER_0_128_53 vssd1 vssd1 vccd1 vccd1 sky130_ef_sc_hd__decap_12
X_07881_ _01905_ _01907_ _02000_ vssd1 vssd1 vccd1 vccd1 _02002_ sky130_fd_sc_hd__nand3_1
X_06832_ net1571 posy\[7\] net646 vssd1 vssd1 vccd1 vccd1 _00106_ sky130_fd_sc_hd__mux2_1
X_09620_ _03726_ _03727_ _03556_ _03559_ vssd1 vssd1 vccd1 vccd1 _03729_ sky130_fd_sc_hd__a211o_1
X_09551_ _03658_ _03659_ _03651_ vssd1 vssd1 vccd1 vccd1 _03660_ sky130_fd_sc_hd__a21o_1
X_06763_ net377 net1262 net637 vssd1 vssd1 vccd1 vccd1 _00037_ sky130_fd_sc_hd__mux2_1
X_08502_ _02497_ _02498_ _02499_ vssd1 vssd1 vccd1 vccd1 _02618_ sky130_fd_sc_hd__o21ba_1
X_09482_ _03500_ _03503_ vssd1 vssd1 vccd1 vccd1 _03591_ sky130_fd_sc_hd__nor2_2
Xclkbuf_leaf_20_clk_i clknet_3_5__leaf_clk_i vssd1 vssd1 vccd1 vccd1 clknet_leaf_20_clk_i
+ sky130_fd_sc_hd__clkbuf_16
X_06694_ _00914_ _00917_ vssd1 vssd1 vccd1 vccd1 _00918_ sky130_fd_sc_hd__xor2_4
X_08433_ net1140 net1148 net727 net723 vssd1 vssd1 vccd1 vccd1 _02549_ sky130_fd_sc_hd__and4_1
XFILLER_0_65_319 vssd1 vssd1 vccd1 vccd1 sky130_fd_sc_hd__decap_3
X_08364_ _02465_ _02479_ _02480_ vssd1 vssd1 vccd1 vccd1 _02481_ sky130_fd_sc_hd__nand3_2
XFILLER_0_18_224 vssd1 vssd1 vccd1 vccd1 sky130_fd_sc_hd__decap_4
XFILLER_0_116_421 vssd1 vssd1 vccd1 vccd1 sky130_ef_sc_hd__decap_12
XFILLER_0_61_503 vssd1 vssd1 vccd1 vccd1 sky130_fd_sc_hd__fill_1
Xclkbuf_leaf_35_clk_i clknet_3_4__leaf_clk_i vssd1 vssd1 vccd1 vccd1 clknet_leaf_35_clk_i
+ sky130_fd_sc_hd__clkbuf_16
X_07315_ _01426_ _01439_ vssd1 vssd1 vccd1 vccd1 _01440_ sky130_fd_sc_hd__nand2_1
X_08295_ _02164_ _02165_ _02282_ vssd1 vssd1 vccd1 vccd1 _02412_ sky130_fd_sc_hd__o21ba_1
XFILLER_0_61_569 vssd1 vssd1 vccd1 vccd1 sky130_fd_sc_hd__fill_1
X_07246_ net1041 net899 net890 net1049 vssd1 vssd1 vccd1 vccd1 _01371_ sky130_fd_sc_hd__and4_1
XFILLER_0_14_430 vssd1 vssd1 vccd1 vccd1 sky130_fd_sc_hd__decap_4
XFILLER_0_26_290 vssd1 vssd1 vccd1 vccd1 sky130_fd_sc_hd__fill_2
XFILLER_0_103_148 vssd1 vssd1 vccd1 vccd1 sky130_fd_sc_hd__decap_6
XFILLER_0_103_137 vssd1 vssd1 vccd1 vccd1 sky130_fd_sc_hd__decap_4
X_07177_ _01288_ _01289_ vssd1 vssd1 vccd1 vccd1 _01302_ sky130_fd_sc_hd__or2_1
XFILLER_0_41_260 vssd1 vssd1 vccd1 vccd1 sky130_fd_sc_hd__decap_4
XFILLER_0_112_693 vssd1 vssd1 vccd1 vccd1 sky130_fd_sc_hd__decap_6
XFILLER_0_111_181 vssd1 vssd1 vccd1 vccd1 sky130_ef_sc_hd__decap_12
X_09818_ _03761_ _03766_ _03923_ vssd1 vssd1 vccd1 vccd1 _03925_ sky130_fd_sc_hd__nor3_1
X_09749_ net868 net951 net945 net878 vssd1 vssd1 vccd1 vccd1 _03857_ sky130_fd_sc_hd__a22o_1
XTAP_2024 vssd1 vccd1 sky130_fd_sc_hd__tapvpwrvgnd_1
XTAP_2013 vssd1 vccd1 sky130_fd_sc_hd__tapvpwrvgnd_1
XTAP_2002 vssd1 vccd1 sky130_fd_sc_hd__tapvpwrvgnd_1
XTAP_2057 vssd1 vccd1 sky130_fd_sc_hd__tapvpwrvgnd_1
XTAP_2068 vssd1 vccd1 sky130_fd_sc_hd__tapvpwrvgnd_1
XTAP_2046 vssd1 vccd1 sky130_fd_sc_hd__tapvpwrvgnd_1
XTAP_2035 vssd1 vccd1 sky130_fd_sc_hd__tapvpwrvgnd_1
XTAP_1323 vssd1 vccd1 sky130_fd_sc_hd__tapvpwrvgnd_1
XTAP_1312 vssd1 vccd1 sky130_fd_sc_hd__tapvpwrvgnd_1
XTAP_1301 vssd1 vccd1 sky130_fd_sc_hd__tapvpwrvgnd_1
X_12760_ clknet_leaf_18_clk_i _00146_ vssd1 vssd1 vccd1 vccd1 add1.a_i\[23\] sky130_fd_sc_hd__dfxtp_1
XTAP_2079 vssd1 vccd1 sky130_fd_sc_hd__tapvpwrvgnd_1
XFILLER_0_96_477 vssd1 vssd1 vccd1 vccd1 sky130_fd_sc_hd__fill_2
X_12691_ clknet_leaf_14_clk_i _00077_ net1186 vssd1 vssd1 vccd1 vccd1 net421 sky130_fd_sc_hd__dfrtp_1
XTAP_1356 vssd1 vccd1 sky130_fd_sc_hd__tapvpwrvgnd_1
XTAP_1345 vssd1 vccd1 sky130_fd_sc_hd__tapvpwrvgnd_1
XTAP_1334 vssd1 vccd1 sky130_fd_sc_hd__tapvpwrvgnd_1
X_11711_ net651 _00813_ vssd1 vssd1 vccd1 vccd1 _05771_ sky130_fd_sc_hd__and2_1
XFILLER_0_83_138 vssd1 vssd1 vccd1 vccd1 sky130_fd_sc_hd__fill_2
XTAP_1389 vssd1 vccd1 sky130_fd_sc_hd__tapvpwrvgnd_1
XTAP_1367 vssd1 vccd1 sky130_fd_sc_hd__tapvpwrvgnd_1
XTAP_1378 vssd1 vccd1 sky130_fd_sc_hd__tapvpwrvgnd_1
XFILLER_0_49_393 vssd1 vssd1 vccd1 vccd1 sky130_fd_sc_hd__fill_2
X_11642_ net742 net957 vssd1 vssd1 vccd1 vccd1 _05736_ sky130_fd_sc_hd__nand2_1
XFILLER_0_119_281 vssd1 vssd1 vccd1 vccd1 sky130_ef_sc_hd__decap_12
Xinput18 div_sstream_i[24] vssd1 vssd1 vccd1 vccd1 net18 sky130_fd_sc_hd__buf_4
XFILLER_0_64_363 vssd1 vssd1 vccd1 vccd1 sky130_fd_sc_hd__fill_1
X_11573_ _05666_ _05665_ vssd1 vssd1 vccd1 vccd1 _05668_ sky130_fd_sc_hd__and2b_1
Xinput29 div_sstream_i[4] vssd1 vssd1 vccd1 vccd1 net29 sky130_fd_sc_hd__clkbuf_8
XFILLER_0_122_413 vssd1 vssd1 vccd1 vccd1 sky130_fd_sc_hd__decap_6
XFILLER_0_107_465 vssd1 vssd1 vccd1 vccd1 sky130_fd_sc_hd__fill_1
X_10524_ _04394_ _04625_ vssd1 vssd1 vccd1 vccd1 _04627_ sky130_fd_sc_hd__xnor2_1
XFILLER_0_122_457 vssd1 vssd1 vccd1 vccd1 sky130_ef_sc_hd__decap_12
X_10455_ _04550_ _04555_ _04556_ vssd1 vssd1 vccd1 vccd1 _04558_ sky130_fd_sc_hd__nand3_2
XFILLER_0_33_772 vssd1 vssd1 vccd1 vccd1 sky130_fd_sc_hd__decap_4
XFILLER_0_0_806 vssd1 vssd1 vccd1 vccd1 sky130_fd_sc_hd__fill_2
X_13174_ clknet_leaf_23_clk_i _00560_ net1174 vssd1 vssd1 vccd1 vccd1 l1\[3\] sky130_fd_sc_hd__dfrtp_1
X_10386_ _04486_ _04487_ _04488_ vssd1 vssd1 vccd1 vccd1 _04490_ sky130_fd_sc_hd__a21bo_1
X_12125_ y2my0\[22\] net589 net535 x2mx1\[22\] _06099_ vssd1 vssd1 vccd1 vccd1 _06100_
+ sky130_fd_sc_hd__a221o_1
X_12056_ x0mx2\[5\] net628 net590 y1my2\[5\] vssd1 vssd1 vccd1 vccd1 _06048_ sky130_fd_sc_hd__a22o_1
XFILLER_0_74_27 vssd1 vssd1 vccd1 vccd1 sky130_fd_sc_hd__fill_1
X_11007_ _05104_ _05105_ vssd1 vssd1 vccd1 vccd1 _05106_ sky130_fd_sc_hd__nand2_1
XFILLER_0_87_422 vssd1 vssd1 vccd1 vccd1 sky130_fd_sc_hd__decap_6
XFILLER_0_90_15 vssd1 vssd1 vccd1 vccd1 sky130_ef_sc_hd__decap_12
X_12958_ clknet_leaf_44_clk_i _00344_ net1156 vssd1 vssd1 vccd1 vccd1 y1my2\[11\]
+ sky130_fd_sc_hd__dfrtp_1
XFILLER_0_75_617 vssd1 vssd1 vccd1 vccd1 sky130_ef_sc_hd__decap_12
X_11909_ net1683 _05936_ net477 vssd1 vssd1 vccd1 vccd1 _00220_ sky130_fd_sc_hd__mux2_1
X_12889_ clknet_leaf_32_clk_i _00275_ vssd1 vssd1 vccd1 vccd1 mul1.a\[24\] sky130_fd_sc_hd__dfxtp_2
XFILLER_0_114_77 vssd1 vssd1 vccd1 vccd1 sky130_fd_sc_hd__decap_6
XFILLER_0_28_522 vssd1 vssd1 vccd1 vccd1 sky130_fd_sc_hd__fill_1
XTAP_1890 vssd1 vccd1 sky130_fd_sc_hd__tapvpwrvgnd_1
XFILLER_0_23_86 vssd1 vssd1 vccd1 vccd1 sky130_fd_sc_hd__decap_6
XFILLER_0_130_21 vssd1 vssd1 vccd1 vccd1 sky130_fd_sc_hd__decap_6
X_07100_ _01152_ _01153_ _01223_ _01224_ vssd1 vssd1 vccd1 vccd1 _01225_ sky130_fd_sc_hd__o211a_1
XFILLER_0_99_57 vssd1 vssd1 vccd1 vccd1 sky130_ef_sc_hd__decap_12
X_08080_ _02190_ _02198_ vssd1 vssd1 vccd1 vccd1 _02199_ sky130_fd_sc_hd__xnor2_1
XFILLER_0_70_344 vssd1 vssd1 vccd1 vccd1 sky130_fd_sc_hd__fill_1
XFILLER_0_30_219 vssd1 vssd1 vccd1 vccd1 sky130_fd_sc_hd__decap_3
X_07031_ _01149_ _01150_ _01155_ vssd1 vssd1 vccd1 vccd1 _01156_ sky130_fd_sc_hd__nand3_2
X_08982_ _02991_ _02992_ _03093_ _03094_ vssd1 vssd1 vccd1 vccd1 _03095_ sky130_fd_sc_hd__nor4_1
X_07933_ _02049_ _02050_ _02051_ vssd1 vssd1 vccd1 vccd1 _02054_ sky130_fd_sc_hd__a21oi_2
X_07864_ _01890_ _01893_ vssd1 vssd1 vccd1 vccd1 _01985_ sky130_fd_sc_hd__nand2_1
X_06815_ net1475 net1426 net645 vssd1 vssd1 vccd1 vccd1 _00089_ sky130_fd_sc_hd__mux2_1
X_09603_ net907 net931 vssd1 vssd1 vccd1 vccd1 _03712_ sky130_fd_sc_hd__nand2_1
XFILLER_0_97_219 vssd1 vssd1 vccd1 vccd1 sky130_fd_sc_hd__decap_4
X_07795_ _01915_ _01916_ _01914_ vssd1 vssd1 vccd1 vccd1 _01917_ sky130_fd_sc_hd__a21o_1
X_09534_ net1039 net1047 net777 net767 vssd1 vssd1 vccd1 vccd1 _03643_ sky130_fd_sc_hd__nand4_2
X_06746_ sub1.a_i\[29\] sub1.b_i\[29\] vssd1 vssd1 vccd1 vccd1 _00962_ sky130_fd_sc_hd__nand2b_2
X_09465_ _03279_ _03573_ _03574_ vssd1 vssd1 vccd1 vccd1 _03575_ sky130_fd_sc_hd__nand3_1
X_06677_ net1342 _00903_ net635 vssd1 vssd1 vccd1 vccd1 _00021_ sky130_fd_sc_hd__mux2_1
X_08416_ _02530_ _02531_ _02391_ _02393_ vssd1 vssd1 vccd1 vccd1 _02533_ sky130_fd_sc_hd__o211a_1
X_09396_ net818 net1002 vssd1 vssd1 vccd1 vccd1 _03506_ sky130_fd_sc_hd__nand2_1
XFILLER_0_80_81 vssd1 vssd1 vccd1 vccd1 sky130_fd_sc_hd__decap_3
X_08347_ _02342_ _02345_ vssd1 vssd1 vccd1 vccd1 _02464_ sky130_fd_sc_hd__nand2_1
XFILLER_0_61_300 vssd1 vssd1 vccd1 vccd1 sky130_fd_sc_hd__decap_3
XFILLER_0_117_785 vssd1 vssd1 vccd1 vccd1 sky130_fd_sc_hd__fill_2
XFILLER_0_116_251 vssd1 vssd1 vccd1 vccd1 sky130_fd_sc_hd__fill_1
XFILLER_0_104_402 vssd1 vssd1 vccd1 vccd1 sky130_fd_sc_hd__fill_1
X_08278_ _02393_ _02394_ _02270_ _02272_ vssd1 vssd1 vccd1 vccd1 _02396_ sky130_fd_sc_hd__a211o_1
X_07229_ _01339_ _01352_ _01353_ vssd1 vssd1 vccd1 vccd1 _01354_ sky130_fd_sc_hd__and3_1
X_10240_ _04341_ _04343_ _04162_ _04163_ vssd1 vssd1 vccd1 vccd1 _04345_ sky130_fd_sc_hd__o211ai_2
X_10171_ _04274_ _04275_ vssd1 vssd1 vccd1 vccd1 _04276_ sky130_fd_sc_hd__xor2_2
Xfanout1116 net1117 vssd1 vssd1 vccd1 vccd1 net1116 sky130_fd_sc_hd__buf_2
Xfanout1138 net1142 vssd1 vssd1 vccd1 vccd1 net1138 sky130_fd_sc_hd__buf_2
Xfanout1105 net1110 vssd1 vssd1 vccd1 vccd1 net1105 sky130_fd_sc_hd__clkbuf_4
Xfanout1127 net1128 vssd1 vssd1 vccd1 vccd1 net1127 sky130_fd_sc_hd__dlymetal6s2s_1
Xfanout1149 mul1.a\[0\] vssd1 vssd1 vccd1 vccd1 net1149 sky130_fd_sc_hd__clkbuf_4
X_12812_ clknet_leaf_51_clk_i _00198_ vssd1 vssd1 vccd1 vccd1 sub1.a_i\[11\] sky130_fd_sc_hd__dfxtp_1
XTAP_1131 vssd1 vccd1 sky130_fd_sc_hd__tapvpwrvgnd_1
XTAP_1120 vssd1 vccd1 sky130_fd_sc_hd__tapvpwrvgnd_1
X_12743_ clknet_leaf_0_clk_i _00129_ vssd1 vssd1 vccd1 vccd1 add1.a_i\[6\] sky130_fd_sc_hd__dfxtp_1
XTAP_1164 vssd1 vccd1 sky130_fd_sc_hd__tapvpwrvgnd_1
XTAP_1153 vssd1 vccd1 sky130_fd_sc_hd__tapvpwrvgnd_1
XTAP_1142 vssd1 vccd1 sky130_fd_sc_hd__tapvpwrvgnd_1
XFILLER_0_56_138 vssd1 vssd1 vccd1 vccd1 sky130_fd_sc_hd__fill_2
X_12674_ clknet_leaf_15_clk_i _00060_ net1179 vssd1 vssd1 vccd1 vccd1 net402 sky130_fd_sc_hd__dfrtp_1
XTAP_1197 vssd1 vccd1 sky130_fd_sc_hd__tapvpwrvgnd_1
XTAP_1175 vssd1 vccd1 sky130_fd_sc_hd__tapvpwrvgnd_1
XTAP_1186 vssd1 vccd1 sky130_fd_sc_hd__tapvpwrvgnd_1
XFILLER_0_60_29 vssd1 vssd1 vccd1 vccd1 sky130_fd_sc_hd__fill_1
XFILLER_0_49_190 vssd1 vssd1 vccd1 vccd1 sky130_fd_sc_hd__decap_6
XFILLER_0_108_730 vssd1 vssd1 vccd1 vccd1 sky130_ef_sc_hd__decap_12
X_11625_ _05715_ _05718_ vssd1 vssd1 vccd1 vccd1 _05719_ sky130_fd_sc_hd__xnor2_1
XFILLER_0_4_419 vssd1 vssd1 vccd1 vccd1 sky130_fd_sc_hd__fill_1
X_11556_ _05648_ _05649_ _05497_ _05501_ vssd1 vssd1 vccd1 vccd1 _05651_ sky130_fd_sc_hd__o211a_1
XFILLER_0_122_221 vssd1 vssd1 vccd1 vccd1 sky130_ef_sc_hd__decap_12
X_10507_ net1062 net1070 net715 net710 vssd1 vssd1 vccd1 vccd1 _04610_ sky130_fd_sc_hd__and4_1
XFILLER_0_52_355 vssd1 vssd1 vccd1 vccd1 sky130_fd_sc_hd__fill_1
X_13226_ net507 vssd1 vssd1 vccd1 vccd1 net281 sky130_fd_sc_hd__clkbuf_1
XFILLER_0_123_777 vssd1 vssd1 vccd1 vccd1 sky130_fd_sc_hd__decap_6
XFILLER_0_122_265 vssd1 vssd1 vccd1 vccd1 sky130_ef_sc_hd__decap_12
X_11487_ _05471_ _05473_ _05580_ vssd1 vssd1 vccd1 vccd1 _05582_ sky130_fd_sc_hd__or3b_1
X_10438_ _04538_ _04539_ _04430_ vssd1 vssd1 vccd1 vccd1 _04541_ sky130_fd_sc_hd__o21ai_1
X_13157_ clknet_leaf_12_clk_i _00543_ net1187 vssd1 vssd1 vccd1 vccd1 l0\[18\] sky130_fd_sc_hd__dfrtp_1
X_10369_ net1037 net737 vssd1 vssd1 vccd1 vccd1 _04473_ sky130_fd_sc_hd__nand2_1
XTAP_926 vssd1 vccd1 sky130_fd_sc_hd__tapvpwrvgnd_1
XFILLER_0_21_797 vssd1 vssd1 vccd1 vccd1 sky130_fd_sc_hd__fill_2
XTAP_904 vssd1 vccd1 sky130_fd_sc_hd__tapvpwrvgnd_1
XTAP_915 vssd1 vccd1 sky130_fd_sc_hd__tapvpwrvgnd_1
XTAP_959 vssd1 vccd1 sky130_fd_sc_hd__tapvpwrvgnd_1
XTAP_948 vssd1 vccd1 sky130_fd_sc_hd__tapvpwrvgnd_1
XTAP_937 vssd1 vccd1 sky130_fd_sc_hd__tapvpwrvgnd_1
X_13088_ clknet_leaf_42_clk_i _00474_ vssd1 vssd1 vccd1 vccd1 temp1\[13\] sky130_fd_sc_hd__dfxtp_1
X_12108_ x0mx2\[18\] net630 net593 y1my2\[18\] vssd1 vssd1 vccd1 vccd1 _06087_ sky130_fd_sc_hd__a22o_1
XFILLER_0_109_55 vssd1 vssd1 vccd1 vccd1 sky130_fd_sc_hd__fill_1
X_12039_ net1146 _06035_ net513 vssd1 vssd1 vccd1 vccd1 _00251_ sky130_fd_sc_hd__mux2_1
XFILLER_0_18_53 vssd1 vssd1 vccd1 vccd1 sky130_ef_sc_hd__decap_12
X_07580_ _01369_ _01370_ _01371_ vssd1 vssd1 vccd1 vccd1 _01704_ sky130_fd_sc_hd__o21ba_1
X_06600_ _00824_ _00827_ _00831_ _00838_ vssd1 vssd1 vccd1 vccd1 _00839_ sky130_fd_sc_hd__a31o_2
X_06531_ net544 _00788_ vssd1 vssd1 vccd1 vccd1 net299 sky130_fd_sc_hd__nor2_1
XFILLER_0_48_628 vssd1 vssd1 vccd1 vccd1 sky130_fd_sc_hd__fill_1
X_09250_ _03212_ _03213_ vssd1 vssd1 vccd1 vccd1 _03361_ sky130_fd_sc_hd__nand2_1
X_06462_ net547 _00759_ vssd1 vssd1 vccd1 vccd1 net326 sky130_fd_sc_hd__nor2_1
X_08201_ _02317_ _02318_ vssd1 vssd1 vccd1 vccd1 _02319_ sky130_fd_sc_hd__and2b_1
XFILLER_0_63_609 vssd1 vssd1 vccd1 vccd1 sky130_fd_sc_hd__decap_6
X_09181_ _03282_ _03290_ vssd1 vssd1 vccd1 vccd1 _03292_ sky130_fd_sc_hd__xnor2_1
XFILLER_0_50_51 vssd1 vssd1 vccd1 vccd1 sky130_fd_sc_hd__decap_8
X_06393_ add1.a_i\[18\] add1.b_i\[18\] vssd1 vssd1 vccd1 vccd1 _00700_ sky130_fd_sc_hd__and2_1
XFILLER_0_43_311 vssd1 vssd1 vccd1 vccd1 sky130_fd_sc_hd__fill_1
X_08132_ _02248_ _02249_ _02250_ vssd1 vssd1 vccd1 vccd1 _02251_ sky130_fd_sc_hd__nand3_2
XFILLER_0_114_755 vssd1 vssd1 vccd1 vccd1 sky130_fd_sc_hd__fill_1
X_08063_ _02181_ vssd1 vssd1 vccd1 vccd1 _02182_ sky130_fd_sc_hd__inv_2
XFILLER_0_70_141 vssd1 vssd1 vccd1 vccd1 sky130_fd_sc_hd__fill_2
X_07014_ _01053_ _01065_ _01064_ _01061_ vssd1 vssd1 vccd1 vccd1 _01139_ sky130_fd_sc_hd__o211a_1
X_08965_ _03075_ _03076_ _03077_ vssd1 vssd1 vccd1 vccd1 _03078_ sky130_fd_sc_hd__nand3_4
Xinput208 v2x[2] vssd1 vssd1 vccd1 vccd1 net208 sky130_fd_sc_hd__buf_1
X_07916_ _02033_ _02034_ _02016_ vssd1 vssd1 vccd1 vccd1 _02037_ sky130_fd_sc_hd__a21oi_2
Xinput219 v2y[10] vssd1 vssd1 vccd1 vccd1 net219 sky130_fd_sc_hd__buf_1
X_08896_ _03007_ _03008_ vssd1 vssd1 vccd1 vccd1 _03009_ sky130_fd_sc_hd__and2_1
X_07847_ net1123 net781 vssd1 vssd1 vccd1 vccd1 _01968_ sky130_fd_sc_hd__nand2_1
X_07778_ net1042 net873 net864 net1050 vssd1 vssd1 vccd1 vccd1 _01900_ sky130_fd_sc_hd__a22oi_1
X_09517_ _03452_ _03455_ _03623_ _03624_ vssd1 vssd1 vccd1 vccd1 _03626_ sky130_fd_sc_hd__a211o_1
XFILLER_0_94_701 vssd1 vssd1 vccd1 vccd1 sky130_ef_sc_hd__decap_12
X_06729_ sub1.a_i\[27\] sub1.b_i\[27\] vssd1 vssd1 vccd1 vccd1 _00947_ sky130_fd_sc_hd__and2b_1
XPHY_225 vssd1 vssd1 vccd1 vccd1 sky130_fd_sc_hd__decap_3
XPHY_214 vssd1 vssd1 vccd1 vccd1 sky130_fd_sc_hd__decap_3
XPHY_203 vssd1 vssd1 vccd1 vccd1 sky130_fd_sc_hd__decap_3
XPHY_258 vssd1 vssd1 vccd1 vccd1 sky130_fd_sc_hd__decap_3
XPHY_247 vssd1 vssd1 vccd1 vccd1 sky130_fd_sc_hd__decap_3
XPHY_236 vssd1 vssd1 vccd1 vccd1 sky130_fd_sc_hd__decap_3
X_09448_ _03556_ _03557_ _03525_ vssd1 vssd1 vccd1 vccd1 _03558_ sky130_fd_sc_hd__o21a_1
XFILLER_0_38_149 vssd1 vssd1 vccd1 vccd1 sky130_fd_sc_hd__fill_2
XFILLER_0_109_549 vssd1 vssd1 vccd1 vccd1 sky130_fd_sc_hd__decap_8
XFILLER_0_93_277 vssd1 vssd1 vccd1 vccd1 sky130_fd_sc_hd__decap_3
XFILLER_0_93_266 vssd1 vssd1 vccd1 vccd1 sky130_fd_sc_hd__fill_1
X_09379_ _03488_ _03487_ _03486_ vssd1 vssd1 vccd1 vccd1 _03489_ sky130_fd_sc_hd__nand3b_1
X_11410_ net1003 net712 net708 net1011 vssd1 vssd1 vccd1 vccd1 _05506_ sky130_fd_sc_hd__a22o_1
X_12390_ net1555 _00877_ net683 vssd1 vssd1 vccd1 vccd1 _00442_ sky130_fd_sc_hd__mux2_1
X_11341_ _05309_ _05311_ _05436_ _05437_ vssd1 vssd1 vccd1 vccd1 _05438_ sky130_fd_sc_hd__o211ai_2
XFILLER_0_7_780 vssd1 vssd1 vccd1 vccd1 sky130_fd_sc_hd__fill_1
XFILLER_0_120_725 vssd1 vssd1 vccd1 vccd1 sky130_ef_sc_hd__decap_12
XFILLER_0_39_19 vssd1 vssd1 vccd1 vccd1 sky130_fd_sc_hd__fill_1
X_11272_ _05362_ _05367_ vssd1 vssd1 vccd1 vccd1 _05369_ sky130_fd_sc_hd__xor2_1
XFILLER_0_120_769 vssd1 vssd1 vccd1 vccd1 sky130_ef_sc_hd__decap_12
X_10223_ _04314_ _04316_ _04326_ _04327_ vssd1 vssd1 vccd1 vccd1 _04328_ sky130_fd_sc_hd__nand4_2
X_13011_ clknet_leaf_51_clk_i _00397_ net1154 vssd1 vssd1 vccd1 vccd1 x0mx2\[0\] sky130_fd_sc_hd__dfrtp_1
X_10154_ _04257_ _04258_ _04099_ _04102_ vssd1 vssd1 vccd1 vccd1 _04259_ sky130_fd_sc_hd__o211ai_2
Xhold7 posx\[7\] vssd1 vssd1 vccd1 vccd1 net1222 sky130_fd_sc_hd__dlygate4sd3_1
X_10085_ _04185_ _04189_ _04190_ vssd1 vssd1 vccd1 vccd1 _04191_ sky130_fd_sc_hd__nand3_1
XFILLER_0_69_263 vssd1 vssd1 vccd1 vccd1 sky130_fd_sc_hd__fill_1
XFILLER_0_69_296 vssd1 vssd1 vccd1 vccd1 sky130_fd_sc_hd__fill_1
X_10987_ net807 net941 vssd1 vssd1 vccd1 vccd1 _05086_ sky130_fd_sc_hd__nand2_1
XFILLER_0_128_825 vssd1 vssd1 vccd1 vccd1 sky130_ef_sc_hd__decap_12
X_12726_ clknet_leaf_8_clk_i net1217 net1194 vssd1 vssd1 vccd1 vccd1 net345 sky130_fd_sc_hd__dfrtp_1
XFILLER_0_84_233 vssd1 vssd1 vccd1 vccd1 sky130_fd_sc_hd__decap_6
XFILLER_0_29_138 vssd1 vssd1 vccd1 vccd1 sky130_fd_sc_hd__decap_6
X_12657_ clknet_leaf_21_clk_i net1592 net1175 vssd1 vssd1 vccd1 vccd1 net384 sky130_fd_sc_hd__dfrtp_1
XFILLER_0_108_560 vssd1 vssd1 vccd1 vccd1 sky130_ef_sc_hd__decap_12
X_11608_ _05589_ _05590_ vssd1 vssd1 vccd1 vccd1 _05702_ sky130_fd_sc_hd__nand2_1
XFILLER_0_111_45 vssd1 vssd1 vccd1 vccd1 sky130_fd_sc_hd__decap_8
X_12588_ net1606 net31 net554 vssd1 vssd1 vccd1 vccd1 _00563_ sky130_fd_sc_hd__mux2_1
XFILLER_0_20_21 vssd1 vssd1 vccd1 vccd1 sky130_fd_sc_hd__decap_6
XFILLER_0_123_541 vssd1 vssd1 vccd1 vccd1 sky130_ef_sc_hd__decap_12
XFILLER_0_52_185 vssd1 vssd1 vccd1 vccd1 sky130_fd_sc_hd__fill_1
Xhold418 x2mx1\[23\] vssd1 vssd1 vccd1 vccd1 net1633 sky130_fd_sc_hd__dlygate4sd3_1
Xhold407 x2mx1\[26\] vssd1 vssd1 vccd1 vccd1 net1622 sky130_fd_sc_hd__dlygate4sd3_1
XFILLER_0_20_65 vssd1 vssd1 vccd1 vccd1 sky130_ef_sc_hd__decap_12
X_11539_ net983 net975 net729 net721 vssd1 vssd1 vccd1 vccd1 _05634_ sky130_fd_sc_hd__and4_1
XFILLER_0_41_837 vssd1 vssd1 vccd1 vccd1 sky130_fd_sc_hd__decap_3
XFILLER_0_123_585 vssd1 vssd1 vccd1 vccd1 sky130_ef_sc_hd__decap_12
Xhold429 y1my2\[13\] vssd1 vssd1 vccd1 vccd1 net1644 sky130_fd_sc_hd__dlygate4sd3_1
XFILLER_0_111_769 vssd1 vssd1 vccd1 vccd1 sky130_fd_sc_hd__fill_2
XTAP_701 vssd1 vccd1 sky130_fd_sc_hd__tapvpwrvgnd_1
Xfanout909 net910 vssd1 vssd1 vccd1 vccd1 net909 sky130_fd_sc_hd__buf_2
XTAP_712 vssd1 vccd1 sky130_fd_sc_hd__tapvpwrvgnd_1
XTAP_723 vssd1 vccd1 sky130_fd_sc_hd__tapvpwrvgnd_1
XTAP_734 vssd1 vccd1 sky130_fd_sc_hd__tapvpwrvgnd_1
XFILLER_0_29_63 vssd1 vssd1 vccd1 vccd1 sky130_fd_sc_hd__fill_1
XTAP_745 vssd1 vccd1 sky130_fd_sc_hd__tapvpwrvgnd_1
XTAP_756 vssd1 vccd1 sky130_fd_sc_hd__tapvpwrvgnd_1
XTAP_767 vssd1 vccd1 sky130_fd_sc_hd__tapvpwrvgnd_1
X_08750_ _02861_ _02862_ vssd1 vssd1 vccd1 vccd1 _02864_ sky130_fd_sc_hd__xor2_1
XTAP_789 vssd1 vccd1 sky130_fd_sc_hd__tapvpwrvgnd_1
XTAP_778 vssd1 vccd1 sky130_fd_sc_hd__tapvpwrvgnd_1
X_08681_ _02735_ _02794_ _02795_ vssd1 vssd1 vccd1 vccd1 _02796_ sky130_fd_sc_hd__nor3_1
X_07701_ _01820_ _01821_ _01822_ vssd1 vssd1 vccd1 vccd1 _01824_ sky130_fd_sc_hd__nand3_1
X_07632_ _01754_ _01755_ vssd1 vssd1 vccd1 vccd1 _01756_ sky130_fd_sc_hd__xnor2_1
X_09302_ _03265_ _03412_ vssd1 vssd1 vccd1 vccd1 _03413_ sky130_fd_sc_hd__and2b_1
XFILLER_0_88_583 vssd1 vssd1 vccd1 vccd1 sky130_fd_sc_hd__fill_1
XFILLER_0_75_222 vssd1 vssd1 vccd1 vccd1 sky130_fd_sc_hd__fill_2
X_07563_ _01684_ _01686_ vssd1 vssd1 vccd1 vccd1 _01687_ sky130_fd_sc_hd__nand2_1
X_06514_ det_t\[24\] net529 vssd1 vssd1 vccd1 vccd1 net268 sky130_fd_sc_hd__and2_1
XFILLER_0_76_778 vssd1 vssd1 vccd1 vccd1 sky130_fd_sc_hd__fill_2
XFILLER_0_75_244 vssd1 vssd1 vccd1 vccd1 sky130_fd_sc_hd__decap_4
X_07494_ _01600_ _01602_ vssd1 vssd1 vccd1 vccd1 _01619_ sky130_fd_sc_hd__xnor2_1
XFILLER_0_118_357 vssd1 vssd1 vccd1 vccd1 sky130_fd_sc_hd__decap_6
X_09233_ net825 net818 net1009 vssd1 vssd1 vccd1 vccd1 _03344_ sky130_fd_sc_hd__and3_1
XFILLER_0_61_94 vssd1 vssd1 vccd1 vccd1 sky130_fd_sc_hd__decap_3
X_06445_ add1.a_i\[25\] add1.b_i\[25\] vssd1 vssd1 vccd1 vccd1 _00745_ sky130_fd_sc_hd__nand2_1
X_09164_ _03272_ _03273_ vssd1 vssd1 vccd1 vccd1 _03275_ sky130_fd_sc_hd__xnor2_1
XFILLER_0_44_642 vssd1 vssd1 vccd1 vccd1 sky130_fd_sc_hd__fill_2
X_08115_ _02126_ _02128_ _02232_ _02233_ vssd1 vssd1 vccd1 vccd1 _02234_ sky130_fd_sc_hd__o211a_1
X_06376_ _00684_ _00685_ vssd1 vssd1 vccd1 vccd1 _00686_ sky130_fd_sc_hd__nand2_1
XFILLER_0_43_152 vssd1 vssd1 vccd1 vccd1 sky130_fd_sc_hd__decap_3
XFILLER_0_43_141 vssd1 vssd1 vccd1 vccd1 sky130_fd_sc_hd__decap_6
XFILLER_0_9_51 vssd1 vssd1 vccd1 vccd1 sky130_fd_sc_hd__decap_4
XFILLER_0_8_599 vssd1 vssd1 vccd1 vccd1 sky130_fd_sc_hd__fill_1
X_09095_ _03205_ _03206_ _03042_ _03044_ vssd1 vssd1 vccd1 vccd1 _03207_ sky130_fd_sc_hd__o211a_1
XFILLER_0_43_185 vssd1 vssd1 vccd1 vccd1 sky130_fd_sc_hd__decap_3
XFILLER_0_31_314 vssd1 vssd1 vccd1 vccd1 sky130_fd_sc_hd__fill_2
X_08046_ _02058_ _02165_ _02164_ vssd1 vssd1 vccd1 vccd1 _02166_ sky130_fd_sc_hd__a21oi_1
XFILLER_0_12_561 vssd1 vssd1 vccd1 vccd1 sky130_fd_sc_hd__fill_2
XFILLER_0_101_257 vssd1 vssd1 vccd1 vccd1 sky130_fd_sc_hd__fill_2
X_09997_ _04091_ _04101_ _04102_ vssd1 vssd1 vccd1 vccd1 _04103_ sky130_fd_sc_hd__and3b_1
XFILLER_0_86_80 vssd1 vssd1 vccd1 vccd1 sky130_fd_sc_hd__decap_4
X_08948_ _03051_ _03059_ vssd1 vssd1 vccd1 vccd1 _03061_ sky130_fd_sc_hd__xnor2_2
X_08879_ _02842_ _02845_ _02989_ _02990_ vssd1 vssd1 vccd1 vccd1 _02992_ sky130_fd_sc_hd__a211oi_2
X_10910_ _05000_ _05008_ vssd1 vssd1 vccd1 vccd1 _05010_ sky130_fd_sc_hd__xnor2_1
XFILLER_0_79_561 vssd1 vssd1 vccd1 vccd1 sky130_fd_sc_hd__decap_8
X_11890_ temp1\[30\] net616 net609 net209 _05920_ vssd1 vssd1 vccd1 vccd1 _05921_
+ sky130_fd_sc_hd__a221o_1
X_10841_ _04791_ _04793_ _04940_ _04941_ vssd1 vssd1 vccd1 vccd1 _04942_ sky130_fd_sc_hd__o211ai_4
XFILLER_0_39_436 vssd1 vssd1 vccd1 vccd1 sky130_fd_sc_hd__fill_1
X_10772_ net800 net790 net965 net960 vssd1 vssd1 vccd1 vccd1 _04873_ sky130_fd_sc_hd__and4_1
XFILLER_0_39_447 vssd1 vssd1 vccd1 vccd1 sky130_fd_sc_hd__fill_1
X_12511_ _00677_ net562 _06252_ vssd1 vssd1 vccd1 vccd1 _00506_ sky130_fd_sc_hd__o21ai_1
XFILLER_0_109_335 vssd1 vssd1 vccd1 vccd1 sky130_fd_sc_hd__fill_1
XFILLER_0_94_586 vssd1 vssd1 vccd1 vccd1 sky130_fd_sc_hd__fill_2
XFILLER_0_82_726 vssd1 vssd1 vccd1 vccd1 sky130_ef_sc_hd__decap_12
XFILLER_0_67_789 vssd1 vssd1 vccd1 vccd1 sky130_fd_sc_hd__fill_1
XFILLER_0_81_225 vssd1 vssd1 vccd1 vccd1 sky130_ef_sc_hd__decap_12
X_12442_ temp1\[15\] _06213_ net571 vssd1 vssd1 vccd1 vccd1 _00476_ sky130_fd_sc_hd__mux2_1
XFILLER_0_35_642 vssd1 vssd1 vccd1 vccd1 sky130_ef_sc_hd__decap_12
XFILLER_0_124_327 vssd1 vssd1 vccd1 vccd1 sky130_ef_sc_hd__decap_12
XFILLER_0_81_269 vssd1 vssd1 vccd1 vccd1 sky130_fd_sc_hd__decap_4
XFILLER_0_34_130 vssd1 vssd1 vccd1 vccd1 sky130_fd_sc_hd__fill_1
XFILLER_0_34_141 vssd1 vssd1 vccd1 vccd1 sky130_fd_sc_hd__fill_1
XFILLER_0_50_634 vssd1 vssd1 vccd1 vccd1 sky130_fd_sc_hd__fill_1
X_12373_ net1557 _00960_ net663 vssd1 vssd1 vccd1 vccd1 _00425_ sky130_fd_sc_hd__mux2_1
XFILLER_0_50_645 vssd1 vssd1 vccd1 vccd1 sky130_fd_sc_hd__decap_3
X_11324_ _05289_ _05292_ _05419_ _05420_ vssd1 vssd1 vccd1 vccd1 _05421_ sky130_fd_sc_hd__a211o_2
XFILLER_0_120_533 vssd1 vssd1 vccd1 vccd1 sky130_ef_sc_hd__decap_12
X_11255_ _05350_ _05351_ vssd1 vssd1 vccd1 vccd1 _05352_ sky130_fd_sc_hd__nand2b_1
XFILLER_0_66_17 vssd1 vssd1 vccd1 vccd1 sky130_fd_sc_hd__fill_1
X_10206_ _04309_ _04310_ vssd1 vssd1 vccd1 vccd1 _04311_ sky130_fd_sc_hd__nand2_2
X_11186_ _05163_ _05165_ vssd1 vssd1 vccd1 vccd1 _05284_ sky130_fd_sc_hd__or2_1
X_10137_ _04240_ _04241_ vssd1 vssd1 vccd1 vccd1 _04242_ sky130_fd_sc_hd__or2_1
XFILLER_0_89_303 vssd1 vssd1 vccd1 vccd1 sky130_fd_sc_hd__fill_1
X_10068_ net902 net893 net926 vssd1 vssd1 vccd1 vccd1 _04174_ sky130_fd_sc_hd__nand3_2
XFILLER_0_82_27 vssd1 vssd1 vccd1 vccd1 sky130_fd_sc_hd__fill_1
XFILLER_0_58_701 vssd1 vssd1 vccd1 vccd1 sky130_fd_sc_hd__decap_4
XFILLER_0_85_553 vssd1 vssd1 vccd1 vccd1 sky130_fd_sc_hd__fill_1
X_12709_ clknet_leaf_9_clk_i net1437 net1190 vssd1 vssd1 vccd1 vccd1 net441 sky130_fd_sc_hd__dfrtp_1
XFILLER_0_57_277 vssd1 vssd1 vccd1 vccd1 sky130_fd_sc_hd__decap_3
XFILLER_0_127_154 vssd1 vssd1 vccd1 vccd1 sky130_fd_sc_hd__fill_2
XFILLER_0_115_305 vssd1 vssd1 vccd1 vccd1 sky130_ef_sc_hd__decap_12
XFILLER_0_26_631 vssd1 vssd1 vccd1 vccd1 sky130_fd_sc_hd__fill_2
XFILLER_0_38_491 vssd1 vssd1 vccd1 vccd1 sky130_ef_sc_hd__decap_12
XFILLER_0_128_699 vssd1 vssd1 vccd1 vccd1 sky130_fd_sc_hd__fill_1
XFILLER_0_122_77 vssd1 vssd1 vccd1 vccd1 sky130_fd_sc_hd__decap_6
XFILLER_0_115_349 vssd1 vssd1 vccd1 vccd1 sky130_ef_sc_hd__decap_12
Xhold226 l0\[17\] vssd1 vssd1 vccd1 vccd1 net1441 sky130_fd_sc_hd__dlygate4sd3_1
Xhold215 _00086_ vssd1 vssd1 vccd1 vccd1 net1430 sky130_fd_sc_hd__dlygate4sd3_1
Xhold204 y2my0\[0\] vssd1 vssd1 vccd1 vccd1 net1419 sky130_fd_sc_hd__dlygate4sd3_1
XFILLER_0_40_122 vssd1 vssd1 vccd1 vccd1 sky130_fd_sc_hd__fill_1
XFILLER_0_123_393 vssd1 vssd1 vccd1 vccd1 sky130_ef_sc_hd__decap_12
Xhold259 posx\[3\] vssd1 vssd1 vccd1 vccd1 net1474 sky130_fd_sc_hd__dlygate4sd3_1
Xhold237 l0\[27\] vssd1 vssd1 vccd1 vccd1 net1452 sky130_fd_sc_hd__dlygate4sd3_1
X_09920_ net902 net893 net931 net927 vssd1 vssd1 vccd1 vccd1 _04027_ sky130_fd_sc_hd__nand4_2
Xhold248 y2my0\[2\] vssd1 vssd1 vccd1 vccd1 net1463 sky130_fd_sc_hd__dlygate4sd3_1
Xfanout706 mul1.b\[29\] vssd1 vssd1 vccd1 vccd1 net706 sky130_fd_sc_hd__clkbuf_4
Xfanout728 net733 vssd1 vssd1 vccd1 vccd1 net728 sky130_fd_sc_hd__dlymetal6s2s_1
X_09851_ net1062 net737 vssd1 vssd1 vccd1 vccd1 _03958_ sky130_fd_sc_hd__nand2_1
XTAP_520 vssd1 vccd1 sky130_fd_sc_hd__tapvpwrvgnd_1
XTAP_531 vssd1 vccd1 sky130_fd_sc_hd__tapvpwrvgnd_1
XTAP_542 vssd1 vccd1 sky130_fd_sc_hd__tapvpwrvgnd_1
Xfanout739 mul1.b\[23\] vssd1 vssd1 vccd1 vccd1 net739 sky130_fd_sc_hd__buf_4
Xfanout717 net718 vssd1 vssd1 vccd1 vccd1 net717 sky130_fd_sc_hd__buf_2
X_09782_ _03887_ _03888_ vssd1 vssd1 vccd1 vccd1 _03890_ sky130_fd_sc_hd__xnor2_4
X_08802_ _02907_ _02915_ vssd1 vssd1 vccd1 vccd1 _02916_ sky130_fd_sc_hd__and2_1
XFILLER_0_56_50 vssd1 vssd1 vccd1 vccd1 sky130_fd_sc_hd__fill_2
XTAP_553 vssd1 vccd1 sky130_fd_sc_hd__tapvpwrvgnd_1
XTAP_564 vssd1 vccd1 sky130_fd_sc_hd__tapvpwrvgnd_1
XTAP_575 vssd1 vccd1 sky130_fd_sc_hd__tapvpwrvgnd_1
X_06994_ _01111_ _01112_ _01117_ vssd1 vssd1 vccd1 vccd1 _01119_ sky130_fd_sc_hd__a21o_1
X_08733_ _02846_ _02823_ vssd1 vssd1 vccd1 vccd1 _02847_ sky130_fd_sc_hd__and2b_1
XFILLER_0_56_83 vssd1 vssd1 vccd1 vccd1 sky130_fd_sc_hd__fill_1
XFILLER_0_56_72 vssd1 vssd1 vccd1 vccd1 sky130_fd_sc_hd__fill_1
XTAP_586 vssd1 vccd1 sky130_fd_sc_hd__tapvpwrvgnd_1
XTAP_597 vssd1 vccd1 sky130_fd_sc_hd__tapvpwrvgnd_1
XFILLER_0_22_3 vssd1 vssd1 vccd1 vccd1 sky130_ef_sc_hd__decap_12
XFILLER_0_95_306 vssd1 vssd1 vccd1 vccd1 sky130_fd_sc_hd__fill_1
X_08664_ _02776_ _02777_ _02778_ vssd1 vssd1 vccd1 vccd1 _02779_ sky130_fd_sc_hd__nand3_1
X_08595_ _02567_ _02569_ vssd1 vssd1 vccd1 vccd1 _02710_ sky130_fd_sc_hd__nand2_1
XTAP_1719 vssd1 vccd1 sky130_fd_sc_hd__tapvpwrvgnd_1
XTAP_1708 vssd1 vccd1 sky130_fd_sc_hd__tapvpwrvgnd_1
XFILLER_0_95_317 vssd1 vssd1 vccd1 vccd1 sky130_fd_sc_hd__decap_4
XFILLER_0_48_211 vssd1 vssd1 vccd1 vccd1 sky130_fd_sc_hd__decap_8
X_07615_ _01734_ _01735_ _01385_ _01389_ vssd1 vssd1 vccd1 vccd1 _01739_ sky130_fd_sc_hd__o211a_1
X_07546_ net1129 net798 net788 net1137 vssd1 vssd1 vccd1 vccd1 _01670_ sky130_fd_sc_hd__a22oi_1
XFILLER_0_118_121 vssd1 vssd1 vccd1 vccd1 sky130_ef_sc_hd__decap_12
XFILLER_0_91_501 vssd1 vssd1 vccd1 vccd1 sky130_fd_sc_hd__decap_3
XFILLER_0_118_165 vssd1 vssd1 vccd1 vccd1 sky130_ef_sc_hd__decap_12
XFILLER_0_106_305 vssd1 vssd1 vccd1 vccd1 sky130_fd_sc_hd__decap_3
X_09216_ _03321_ _03325_ _03326_ vssd1 vssd1 vccd1 vccd1 _03327_ sky130_fd_sc_hd__and3_1
XFILLER_0_8_363 vssd1 vssd1 vccd1 vccd1 sky130_fd_sc_hd__fill_1
X_07477_ _01595_ _01601_ vssd1 vssd1 vccd1 vccd1 _01602_ sky130_fd_sc_hd__nand2b_1
XFILLER_0_29_491 vssd1 vssd1 vccd1 vccd1 sky130_fd_sc_hd__fill_1
XFILLER_0_106_338 vssd1 vssd1 vccd1 vccd1 sky130_fd_sc_hd__decap_8
XFILLER_0_106_327 vssd1 vssd1 vccd1 vccd1 sky130_fd_sc_hd__decap_6
X_06428_ _00722_ _00726_ _00730_ vssd1 vssd1 vccd1 vccd1 _00731_ sky130_fd_sc_hd__o21ba_2
XFILLER_0_8_396 vssd1 vssd1 vccd1 vccd1 sky130_fd_sc_hd__fill_2
XFILLER_0_16_141 vssd1 vssd1 vccd1 vccd1 sky130_fd_sc_hd__fill_1
X_09147_ _03098_ _03100_ vssd1 vssd1 vccd1 vccd1 _03259_ sky130_fd_sc_hd__and2b_2
X_06359_ _00630_ _00669_ _00629_ vssd1 vssd1 vccd1 vccd1 _00671_ sky130_fd_sc_hd__a21o_1
XFILLER_0_17_697 vssd1 vssd1 vccd1 vccd1 sky130_fd_sc_hd__fill_1
XFILLER_0_31_100 vssd1 vssd1 vccd1 vccd1 sky130_ef_sc_hd__decap_12
X_09078_ net1017 net818 net1009 net825 vssd1 vssd1 vccd1 vccd1 _03190_ sky130_fd_sc_hd__a22o_1
XFILLER_0_102_533 vssd1 vssd1 vccd1 vccd1 sky130_ef_sc_hd__decap_12
X_08029_ _02112_ _02114_ _02147_ _02148_ vssd1 vssd1 vccd1 vccd1 _02149_ sky130_fd_sc_hd__nor4_1
XFILLER_0_32_689 vssd1 vssd1 vccd1 vccd1 sky130_fd_sc_hd__fill_1
Xmax_cap490 _02942_ vssd1 vssd1 vccd1 vccd1 net490 sky130_fd_sc_hd__clkbuf_1
XFILLER_0_31_188 vssd1 vssd1 vccd1 vccd1 sky130_fd_sc_hd__fill_1
X_11040_ _04982_ _05020_ net1750 _05138_ vssd1 vssd1 vccd1 vccd1 _05139_ sky130_fd_sc_hd__a211oi_2
X_12991_ clknet_leaf_43_clk_i _00377_ net1157 vssd1 vssd1 vccd1 vccd1 x2mx1\[12\]
+ sky130_fd_sc_hd__dfrtp_1
XFILLER_0_99_667 vssd1 vssd1 vccd1 vccd1 sky130_fd_sc_hd__decap_4
X_11942_ net91 net621 net595 net59 vssd1 vssd1 vccd1 vccd1 _05961_ sky130_fd_sc_hd__a22o_1
X_11873_ net237 net600 net580 net141 _05906_ vssd1 vssd1 vccd1 vccd1 _05907_ sky130_fd_sc_hd__a221o_1
X_10824_ _04721_ _04724_ _04924_ vssd1 vssd1 vccd1 vccd1 _04925_ sky130_fd_sc_hd__a21oi_1
XFILLER_0_67_553 vssd1 vssd1 vccd1 vccd1 sky130_fd_sc_hd__decap_6
XFILLER_0_55_704 vssd1 vssd1 vccd1 vccd1 sky130_fd_sc_hd__fill_1
XFILLER_0_94_394 vssd1 vssd1 vccd1 vccd1 sky130_fd_sc_hd__decap_4
X_10755_ net1005 net999 net751 net743 vssd1 vssd1 vccd1 vccd1 _04856_ sky130_fd_sc_hd__nand4_2
XFILLER_0_54_236 vssd1 vssd1 vccd1 vccd1 sky130_ef_sc_hd__decap_12
XFILLER_0_54_214 vssd1 vssd1 vccd1 vccd1 sky130_fd_sc_hd__fill_2
XFILLER_0_82_589 vssd1 vssd1 vccd1 vccd1 sky130_fd_sc_hd__decap_4
X_10686_ _04784_ _04785_ _04786_ vssd1 vssd1 vccd1 vccd1 _04788_ sky130_fd_sc_hd__o21a_1
X_12425_ _00846_ net612 _02407_ net574 vssd1 vssd1 vccd1 vccd1 _06205_ sky130_fd_sc_hd__a22o_1
X_12356_ net1510 _00867_ net657 vssd1 vssd1 vccd1 vccd1 _00408_ sky130_fd_sc_hd__mux2_1
Xoutput309 net309 vssd1 vssd1 vccd1 vccd1 div_mstream_o[76] sky130_fd_sc_hd__clkbuf_4
XFILLER_0_105_393 vssd1 vssd1 vccd1 vccd1 sky130_fd_sc_hd__decap_3
XFILLER_0_77_27 vssd1 vssd1 vccd1 vccd1 sky130_fd_sc_hd__decap_8
XFILLER_0_50_486 vssd1 vssd1 vccd1 vccd1 sky130_fd_sc_hd__fill_1
XFILLER_0_50_475 vssd1 vssd1 vccd1 vccd1 sky130_fd_sc_hd__fill_1
X_11307_ _05403_ vssd1 vssd1 vccd1 vccd1 _05404_ sky130_fd_sc_hd__inv_2
XFILLER_0_120_363 vssd1 vssd1 vccd1 vccd1 sky130_fd_sc_hd__fill_1
X_12287_ net1635 _00840_ net675 vssd1 vssd1 vccd1 vccd1 _00339_ sky130_fd_sc_hd__mux2_1
X_11238_ _04961_ _05334_ vssd1 vssd1 vccd1 vccd1 _05335_ sky130_fd_sc_hd__nand2_1
X_11169_ net1019 net1027 net713 net708 vssd1 vssd1 vccd1 vccd1 _05267_ sky130_fd_sc_hd__and4_1
XFILLER_0_93_15 vssd1 vssd1 vccd1 vccd1 sky130_ef_sc_hd__decap_12
XFILLER_0_117_55 vssd1 vssd1 vccd1 vccd1 sky130_fd_sc_hd__fill_1
XFILLER_0_89_111 vssd1 vssd1 vccd1 vccd1 sky130_fd_sc_hd__fill_1
XFILLER_0_26_53 vssd1 vssd1 vccd1 vccd1 sky130_ef_sc_hd__decap_12
X_08380_ net886 net993 vssd1 vssd1 vccd1 vccd1 _02497_ sky130_fd_sc_hd__nand2_1
X_07400_ net880 net1128 vssd1 vssd1 vccd1 vccd1 _01525_ sky130_fd_sc_hd__nand2_1
XFILLER_0_92_309 vssd1 vssd1 vccd1 vccd1 sky130_fd_sc_hd__decap_8
XFILLER_0_46_704 vssd1 vssd1 vccd1 vccd1 sky130_fd_sc_hd__decap_3
X_07331_ _01453_ _01455_ vssd1 vssd1 vccd1 vccd1 _01456_ sky130_fd_sc_hd__nand2_1
XFILLER_0_45_225 vssd1 vssd1 vccd1 vccd1 sky130_fd_sc_hd__decap_8
XFILLER_0_42_85 vssd1 vssd1 vccd1 vccd1 sky130_fd_sc_hd__fill_2
XFILLER_0_128_474 vssd1 vssd1 vccd1 vccd1 sky130_fd_sc_hd__fill_2
XFILLER_0_116_625 vssd1 vssd1 vccd1 vccd1 sky130_ef_sc_hd__decap_12
XFILLER_0_115_113 vssd1 vssd1 vccd1 vccd1 sky130_ef_sc_hd__decap_12
X_07262_ _01385_ _01386_ _01368_ vssd1 vssd1 vccd1 vccd1 _01387_ sky130_fd_sc_hd__a21oi_1
XFILLER_0_116_669 vssd1 vssd1 vccd1 vccd1 sky130_ef_sc_hd__decap_12
X_09001_ _03106_ _03110_ _03105_ vssd1 vssd1 vccd1 vccd1 _03113_ sky130_fd_sc_hd__o21ai_4
XFILLER_0_61_729 vssd1 vssd1 vccd1 vccd1 sky130_fd_sc_hd__decap_3
X_07193_ _01306_ _01317_ vssd1 vssd1 vccd1 vccd1 _01318_ sky130_fd_sc_hd__nand2_1
XFILLER_0_13_111 vssd1 vssd1 vccd1 vccd1 sky130_fd_sc_hd__fill_1
XFILLER_0_41_486 vssd1 vssd1 vccd1 vccd1 sky130_fd_sc_hd__decap_8
XFILLER_0_6_41 vssd1 vssd1 vccd1 vccd1 sky130_ef_sc_hd__decap_12
XFILLER_0_111_385 vssd1 vssd1 vccd1 vccd1 sky130_fd_sc_hd__decap_6
X_09903_ _03845_ _03848_ _04007_ _04008_ vssd1 vssd1 vccd1 vccd1 _04010_ sky130_fd_sc_hd__a211oi_1
Xfanout503 _05930_ vssd1 vssd1 vccd1 vccd1 net503 sky130_fd_sc_hd__clkbuf_2
Xfanout514 net515 vssd1 vssd1 vccd1 vccd1 net514 sky130_fd_sc_hd__buf_4
Xfanout547 net548 vssd1 vssd1 vccd1 vccd1 net547 sky130_fd_sc_hd__buf_1
X_09834_ _03931_ _03938_ _03939_ vssd1 vssd1 vccd1 vccd1 _03941_ sky130_fd_sc_hd__nand3_2
Xfanout536 net538 vssd1 vssd1 vccd1 vccd1 net536 sky130_fd_sc_hd__buf_4
XFILLER_0_6_85 vssd1 vssd1 vccd1 vccd1 sky130_fd_sc_hd__fill_2
XTAP_350 vssd1 vccd1 sky130_fd_sc_hd__tapvpwrvgnd_1
Xfanout525 _01014_ vssd1 vssd1 vccd1 vccd1 net525 sky130_fd_sc_hd__buf_4
Xfanout569 _06237_ vssd1 vssd1 vccd1 vccd1 net569 sky130_fd_sc_hd__buf_2
Xfanout558 _06271_ vssd1 vssd1 vccd1 vccd1 net558 sky130_fd_sc_hd__clkbuf_4
XTAP_394 vssd1 vccd1 sky130_fd_sc_hd__tapvpwrvgnd_1
XTAP_372 vssd1 vccd1 sky130_fd_sc_hd__tapvpwrvgnd_1
XTAP_383 vssd1 vccd1 sky130_fd_sc_hd__tapvpwrvgnd_1
XTAP_361 vssd1 vccd1 sky130_fd_sc_hd__tapvpwrvgnd_1
X_09765_ _03867_ _03868_ _03870_ _03872_ vssd1 vssd1 vccd1 vccd1 _03873_ sky130_fd_sc_hd__a22oi_1
X_06977_ _01099_ _01100_ _01101_ vssd1 vssd1 vccd1 vccd1 _01102_ sky130_fd_sc_hd__nand3_2
XTAP_2217 vssd1 vccd1 sky130_fd_sc_hd__tapvpwrvgnd_1
XTAP_2206 vssd1 vccd1 sky130_fd_sc_hd__tapvpwrvgnd_1
X_08716_ _02828_ _02829_ vssd1 vssd1 vccd1 vccd1 _02830_ sky130_fd_sc_hd__nor2_1
X_09696_ net1028 net777 net767 net1037 vssd1 vssd1 vccd1 vccd1 _03804_ sky130_fd_sc_hd__a22o_1
XTAP_2239 vssd1 vccd1 sky130_fd_sc_hd__tapvpwrvgnd_1
XTAP_2228 vssd1 vccd1 sky130_fd_sc_hd__tapvpwrvgnd_1
XTAP_1505 vssd1 vccd1 sky130_fd_sc_hd__tapvpwrvgnd_1
X_08647_ _02759_ _02760_ net861 net1002 vssd1 vssd1 vccd1 vccd1 _02762_ sky130_fd_sc_hd__and4bb_1
XPHY_12 vssd1 vssd1 vccd1 vccd1 sky130_fd_sc_hd__decap_3
XFILLER_0_95_147 vssd1 vssd1 vccd1 vccd1 sky130_fd_sc_hd__decap_8
XTAP_1538 vssd1 vccd1 sky130_fd_sc_hd__tapvpwrvgnd_1
XTAP_1527 vssd1 vccd1 sky130_fd_sc_hd__tapvpwrvgnd_1
XTAP_1516 vssd1 vccd1 sky130_fd_sc_hd__tapvpwrvgnd_1
XPHY_23 vssd1 vssd1 vccd1 vccd1 sky130_fd_sc_hd__decap_3
XPHY_34 vssd1 vssd1 vccd1 vccd1 sky130_fd_sc_hd__decap_3
XPHY_45 vssd1 vssd1 vccd1 vccd1 sky130_fd_sc_hd__decap_3
XPHY_56 vssd1 vssd1 vccd1 vccd1 sky130_fd_sc_hd__decap_3
X_08578_ _02692_ vssd1 vssd1 vccd1 vccd1 _02693_ sky130_fd_sc_hd__inv_2
XFILLER_0_95_169 vssd1 vssd1 vccd1 vccd1 sky130_fd_sc_hd__decap_4
XTAP_1549 vssd1 vccd1 sky130_fd_sc_hd__tapvpwrvgnd_1
XFILLER_0_76_350 vssd1 vssd1 vccd1 vccd1 sky130_fd_sc_hd__fill_1
XFILLER_0_49_575 vssd1 vssd1 vccd1 vccd1 sky130_fd_sc_hd__decap_3
XPHY_89 vssd1 vssd1 vccd1 vccd1 sky130_fd_sc_hd__decap_3
XPHY_67 vssd1 vssd1 vccd1 vccd1 sky130_fd_sc_hd__decap_3
XPHY_78 vssd1 vssd1 vccd1 vccd1 sky130_fd_sc_hd__decap_3
XFILLER_0_119_441 vssd1 vssd1 vccd1 vccd1 sky130_fd_sc_hd__decap_6
XFILLER_0_64_523 vssd1 vssd1 vccd1 vccd1 sky130_fd_sc_hd__decap_3
X_07529_ _01606_ _01615_ vssd1 vssd1 vccd1 vccd1 _01654_ sky130_fd_sc_hd__xnor2_1
XFILLER_0_119_485 vssd1 vssd1 vccd1 vccd1 sky130_ef_sc_hd__decap_12
X_10540_ _04409_ _04412_ _04640_ _04641_ vssd1 vssd1 vccd1 vccd1 _04643_ sky130_fd_sc_hd__a211o_1
XFILLER_0_8_160 vssd1 vssd1 vccd1 vccd1 sky130_fd_sc_hd__decap_3
X_10471_ net1005 net760 _04572_ _04573_ vssd1 vssd1 vccd1 vccd1 _04574_ sky130_fd_sc_hd__nand4_2
XFILLER_0_121_105 vssd1 vssd1 vccd1 vccd1 sky130_fd_sc_hd__decap_6
X_12210_ x2mx1\[15\] net602 net584 temp1\[15\] vssd1 vssd1 vccd1 vccd1 _06160_ sky130_fd_sc_hd__a22o_1
XFILLER_0_121_149 vssd1 vssd1 vccd1 vccd1 sky130_ef_sc_hd__decap_12
X_13190_ clknet_leaf_20_clk_i _00576_ net1179 vssd1 vssd1 vccd1 vccd1 l1\[19\] sky130_fd_sc_hd__dfrtp_1
X_12141_ y2my0\[26\] net587 net534 x2mx1\[26\] _06111_ vssd1 vssd1 vccd1 vccd1 _06112_
+ sky130_fd_sc_hd__a221o_1
X_12072_ x0mx2\[9\] net629 net590 y1my2\[9\] vssd1 vssd1 vccd1 vccd1 _06060_ sky130_fd_sc_hd__a22o_1
X_11023_ _05120_ _05121_ net783 net957 vssd1 vssd1 vccd1 vccd1 _05122_ sky130_fd_sc_hd__and4bb_1
XFILLER_0_99_442 vssd1 vssd1 vccd1 vccd1 sky130_fd_sc_hd__decap_3
X_12974_ clknet_leaf_31_clk_i _00360_ net1168 vssd1 vssd1 vccd1 vccd1 y1my2\[27\]
+ sky130_fd_sc_hd__dfrtp_1
X_11925_ net1340 _05948_ net478 vssd1 vssd1 vccd1 vccd1 _00224_ sky130_fd_sc_hd__mux2_1
Xclkbuf_leaf_1_clk_i clknet_3_2__leaf_clk_i vssd1 vssd1 vccd1 vccd1 clknet_leaf_1_clk_i
+ sky130_fd_sc_hd__clkbuf_16
XFILLER_0_86_169 vssd1 vssd1 vccd1 vccd1 sky130_fd_sc_hd__fill_1
X_11856_ net653 _00935_ net475 _05892_ vssd1 vssd1 vccd1 vccd1 _05893_ sky130_fd_sc_hd__a211o_1
X_10807_ _04903_ _04907_ vssd1 vssd1 vccd1 vccd1 _04908_ sky130_fd_sc_hd__and2b_1
X_11787_ net652 _00882_ net474 _05833_ vssd1 vssd1 vccd1 vccd1 _05834_ sky130_fd_sc_hd__a211o_1
XFILLER_0_103_57 vssd1 vssd1 vccd1 vccd1 sky130_ef_sc_hd__decap_12
XFILLER_0_82_331 vssd1 vssd1 vccd1 vccd1 sky130_fd_sc_hd__decap_8
X_10738_ net836 net936 vssd1 vssd1 vccd1 vccd1 _04839_ sky130_fd_sc_hd__nand2_1
XFILLER_0_82_397 vssd1 vssd1 vccd1 vccd1 sky130_ef_sc_hd__decap_12
XFILLER_0_70_537 vssd1 vssd1 vccd1 vccd1 sky130_fd_sc_hd__fill_1
XFILLER_0_43_729 vssd1 vssd1 vccd1 vccd1 sky130_fd_sc_hd__fill_1
XFILLER_0_12_77 vssd1 vssd1 vccd1 vccd1 sky130_fd_sc_hd__decap_6
XFILLER_0_113_617 vssd1 vssd1 vccd1 vccd1 sky130_ef_sc_hd__decap_12
XFILLER_0_88_15 vssd1 vssd1 vccd1 vccd1 sky130_ef_sc_hd__decap_12
X_10669_ _04632_ _04634_ vssd1 vssd1 vccd1 vccd1 _04771_ sky130_fd_sc_hd__nand2_1
X_12408_ net1457 _00973_ net685 vssd1 vssd1 vccd1 vccd1 _00460_ sky130_fd_sc_hd__mux2_1
X_12339_ net1622 _00946_ net672 vssd1 vssd1 vccd1 vccd1 _00391_ sky130_fd_sc_hd__mux2_1
X_06900_ net871 net862 net1095 net1103 vssd1 vssd1 vccd1 vccd1 _01025_ sky130_fd_sc_hd__and4_1
X_07880_ _01905_ _01907_ _02000_ vssd1 vssd1 vccd1 vccd1 _02001_ sky130_fd_sc_hd__a21o_1
XFILLER_0_128_65 vssd1 vssd1 vccd1 vccd1 sky130_ef_sc_hd__decap_12
X_06831_ net1414 net1371 net647 vssd1 vssd1 vccd1 vccd1 _00105_ sky130_fd_sc_hd__mux2_1
X_09550_ _03656_ _03657_ _03652_ vssd1 vssd1 vccd1 vccd1 _03659_ sky130_fd_sc_hd__a21o_1
X_06762_ net1377 net1367 net637 vssd1 vssd1 vccd1 vccd1 _00036_ sky130_fd_sc_hd__mux2_1
X_09481_ _03461_ _03464_ vssd1 vssd1 vccd1 vccd1 _03590_ sky130_fd_sc_hd__nor2_1
X_08501_ _02489_ _02490_ vssd1 vssd1 vccd1 vccd1 _02617_ sky130_fd_sc_hd__nand2_1
X_08432_ net1140 net727 net723 net1148 vssd1 vssd1 vccd1 vccd1 _02548_ sky130_fd_sc_hd__a22oi_1
X_06693_ _00915_ _00916_ vssd1 vssd1 vccd1 vccd1 _00917_ sky130_fd_sc_hd__nor2_2
X_08363_ _02470_ _02477_ _02478_ vssd1 vssd1 vccd1 vccd1 _02480_ sky130_fd_sc_hd__nand3_1
X_08294_ _01955_ _01956_ _02409_ _02410_ vssd1 vssd1 vccd1 vccd1 _02411_ sky130_fd_sc_hd__a211o_1
X_07314_ _01426_ _01437_ _01438_ vssd1 vssd1 vccd1 vccd1 _01439_ sky130_fd_sc_hd__nand3_1
XFILLER_0_116_433 vssd1 vssd1 vccd1 vccd1 sky130_ef_sc_hd__decap_12
X_07245_ net1041 net899 net890 net1049 vssd1 vssd1 vccd1 vccd1 _01370_ sky130_fd_sc_hd__a22oi_1
XFILLER_0_46_589 vssd1 vssd1 vccd1 vccd1 sky130_fd_sc_hd__decap_4
XFILLER_0_6_642 vssd1 vssd1 vccd1 vccd1 sky130_fd_sc_hd__fill_2
XFILLER_0_116_477 vssd1 vssd1 vccd1 vccd1 sky130_ef_sc_hd__decap_12
XFILLER_0_103_105 vssd1 vssd1 vccd1 vccd1 sky130_fd_sc_hd__decap_6
X_07176_ _01295_ _01300_ vssd1 vssd1 vccd1 vccd1 _01301_ sky130_fd_sc_hd__xor2_1
XFILLER_0_111_193 vssd1 vssd1 vccd1 vccd1 sky130_ef_sc_hd__decap_12
X_09817_ _03761_ _03766_ _03923_ vssd1 vssd1 vccd1 vccd1 _03924_ sky130_fd_sc_hd__o21a_1
X_09748_ net883 net945 _03704_ _03705_ net940 vssd1 vssd1 vccd1 vccd1 _03856_ sky130_fd_sc_hd__a32o_1
XTAP_2025 vssd1 vccd1 sky130_fd_sc_hd__tapvpwrvgnd_1
XTAP_2014 vssd1 vccd1 sky130_fd_sc_hd__tapvpwrvgnd_1
XTAP_2003 vssd1 vccd1 sky130_fd_sc_hd__tapvpwrvgnd_1
XTAP_2058 vssd1 vccd1 sky130_fd_sc_hd__tapvpwrvgnd_1
XTAP_2047 vssd1 vccd1 sky130_fd_sc_hd__tapvpwrvgnd_1
XTAP_2036 vssd1 vccd1 sky130_fd_sc_hd__tapvpwrvgnd_1
X_09679_ _03784_ _03785_ _03774_ vssd1 vssd1 vccd1 vccd1 _03787_ sky130_fd_sc_hd__a21boi_1
XTAP_1313 vssd1 vccd1 sky130_fd_sc_hd__tapvpwrvgnd_1
XTAP_1302 vssd1 vccd1 sky130_fd_sc_hd__tapvpwrvgnd_1
X_11710_ _05768_ _05769_ vssd1 vssd1 vccd1 vccd1 _05770_ sky130_fd_sc_hd__or2_1
XTAP_2069 vssd1 vccd1 sky130_fd_sc_hd__tapvpwrvgnd_1
X_12690_ clknet_leaf_14_clk_i _00076_ net1184 vssd1 vssd1 vccd1 vccd1 net420 sky130_fd_sc_hd__dfrtp_1
XTAP_1357 vssd1 vccd1 sky130_fd_sc_hd__tapvpwrvgnd_1
XTAP_1346 vssd1 vccd1 sky130_fd_sc_hd__tapvpwrvgnd_1
XTAP_1335 vssd1 vccd1 sky130_fd_sc_hd__tapvpwrvgnd_1
XTAP_1324 vssd1 vccd1 sky130_fd_sc_hd__tapvpwrvgnd_1
XFILLER_0_65_810 vssd1 vssd1 vccd1 vccd1 sky130_fd_sc_hd__decap_3
XTAP_1368 vssd1 vccd1 sky130_fd_sc_hd__tapvpwrvgnd_1
XTAP_1379 vssd1 vccd1 sky130_fd_sc_hd__tapvpwrvgnd_1
XFILLER_0_65_821 vssd1 vssd1 vccd1 vccd1 sky130_fd_sc_hd__decap_6
X_11641_ _04954_ _04956_ _05567_ vssd1 vssd1 vccd1 vccd1 _05735_ sky130_fd_sc_hd__mux2_1
XFILLER_0_126_219 vssd1 vssd1 vccd1 vccd1 sky130_fd_sc_hd__fill_1
XFILLER_0_107_411 vssd1 vssd1 vccd1 vccd1 sky130_fd_sc_hd__decap_3
X_11572_ _05665_ _05666_ vssd1 vssd1 vccd1 vccd1 _05667_ sky130_fd_sc_hd__nand2b_1
Xinput19 div_sstream_i[25] vssd1 vssd1 vccd1 vccd1 net19 sky130_fd_sc_hd__buf_4
XFILLER_0_119_293 vssd1 vssd1 vccd1 vccd1 sky130_ef_sc_hd__decap_12
X_10523_ _04394_ _04625_ vssd1 vssd1 vccd1 vccd1 _04626_ sky130_fd_sc_hd__nor2_1
XFILLER_0_64_375 vssd1 vssd1 vccd1 vccd1 sky130_fd_sc_hd__decap_4
XFILLER_0_107_488 vssd1 vssd1 vccd1 vccd1 sky130_fd_sc_hd__fill_1
XFILLER_0_24_228 vssd1 vssd1 vccd1 vccd1 sky130_fd_sc_hd__fill_2
X_10454_ _04555_ _04556_ _04550_ vssd1 vssd1 vccd1 vccd1 _04557_ sky130_fd_sc_hd__a21o_1
XFILLER_0_122_469 vssd1 vssd1 vccd1 vccd1 sky130_fd_sc_hd__decap_6
X_10385_ _04488_ _04487_ _04486_ vssd1 vssd1 vccd1 vccd1 _04489_ sky130_fd_sc_hd__nand3b_1
XFILLER_0_58_29 vssd1 vssd1 vccd1 vccd1 sky130_fd_sc_hd__decap_6
X_13173_ clknet_leaf_23_clk_i _00559_ net1174 vssd1 vssd1 vccd1 vccd1 l1\[2\] sky130_fd_sc_hd__dfrtp_1
X_12124_ x0mx2\[22\] net632 net592 y1my2\[22\] vssd1 vssd1 vccd1 vccd1 _06099_ sky130_fd_sc_hd__a22o_1
X_12055_ mul1.a\[4\] _06047_ net513 vssd1 vssd1 vccd1 vccd1 _00255_ sky130_fd_sc_hd__mux2_1
X_11006_ net996 net735 _05102_ _05103_ vssd1 vssd1 vccd1 vccd1 _05105_ sky130_fd_sc_hd__a22o_1
XFILLER_0_90_27 vssd1 vssd1 vccd1 vccd1 sky130_fd_sc_hd__fill_1
X_12957_ clknet_leaf_44_clk_i _00343_ net1155 vssd1 vssd1 vccd1 vccd1 y1my2\[10\]
+ sky130_fd_sc_hd__dfrtp_1
XFILLER_0_75_629 vssd1 vssd1 vccd1 vccd1 sky130_fd_sc_hd__fill_1
X_11908_ net133 net659 net502 net229 _05935_ vssd1 vssd1 vccd1 vccd1 _05936_ sky130_fd_sc_hd__a221o_1
X_12888_ clknet_leaf_32_clk_i _00274_ vssd1 vssd1 vccd1 vccd1 mul1.a\[23\] sky130_fd_sc_hd__dfxtp_2
XFILLER_0_68_670 vssd1 vssd1 vccd1 vccd1 sky130_fd_sc_hd__fill_2
XFILLER_0_56_821 vssd1 vssd1 vccd1 vccd1 sky130_fd_sc_hd__fill_1
X_11839_ net44 net687 net678 net72 vssd1 vssd1 vccd1 vccd1 _05878_ sky130_fd_sc_hd__a22o_1
XFILLER_0_128_3 vssd1 vssd1 vccd1 vccd1 sky130_ef_sc_hd__decap_12
XTAP_1891 vssd1 vccd1 sky130_fd_sc_hd__tapvpwrvgnd_1
XTAP_1880 vssd1 vccd1 sky130_fd_sc_hd__tapvpwrvgnd_1
XFILLER_0_28_545 vssd1 vssd1 vccd1 vccd1 sky130_fd_sc_hd__fill_1
XFILLER_0_125_230 vssd1 vssd1 vccd1 vccd1 sky130_fd_sc_hd__fill_1
XFILLER_0_70_312 vssd1 vssd1 vccd1 vccd1 sky130_fd_sc_hd__fill_1
XFILLER_0_28_589 vssd1 vssd1 vccd1 vccd1 sky130_fd_sc_hd__decap_6
XFILLER_0_99_69 vssd1 vssd1 vccd1 vccd1 sky130_ef_sc_hd__decap_12
XFILLER_0_70_323 vssd1 vssd1 vccd1 vccd1 sky130_fd_sc_hd__fill_2
XFILLER_0_55_397 vssd1 vssd1 vccd1 vccd1 sky130_fd_sc_hd__fill_1
XFILLER_0_43_559 vssd1 vssd1 vccd1 vccd1 sky130_fd_sc_hd__fill_1
XFILLER_0_113_447 vssd1 vssd1 vccd1 vccd1 sky130_fd_sc_hd__fill_1
XFILLER_0_3_623 vssd1 vssd1 vccd1 vccd1 sky130_fd_sc_hd__fill_1
X_07030_ _01153_ _01154_ vssd1 vssd1 vccd1 vccd1 _01155_ sky130_fd_sc_hd__nor2_1
XFILLER_0_2_133 vssd1 vssd1 vccd1 vccd1 sky130_fd_sc_hd__fill_1
XFILLER_0_100_119 vssd1 vssd1 vccd1 vccd1 sky130_ef_sc_hd__decap_12
X_08981_ _03091_ _03092_ _02944_ net1749 vssd1 vssd1 vccd1 vccd1 _03094_ sky130_fd_sc_hd__a211oi_2
X_07932_ _02049_ _02050_ _02051_ vssd1 vssd1 vccd1 vccd1 _02053_ sky130_fd_sc_hd__nand3_1
X_07863_ _01870_ _01872_ _01982_ vssd1 vssd1 vccd1 vccd1 _01984_ sky130_fd_sc_hd__nor3_1
X_06814_ net1508 net1403 net648 vssd1 vssd1 vccd1 vccd1 _00088_ sky130_fd_sc_hd__mux2_1
X_09602_ net923 net915 net926 vssd1 vssd1 vccd1 vccd1 _03711_ sky130_fd_sc_hd__o21ai_1
X_09533_ net1039 net1047 net777 net767 vssd1 vssd1 vccd1 vccd1 _03642_ sky130_fd_sc_hd__and4_1
XFILLER_0_78_401 vssd1 vssd1 vccd1 vccd1 sky130_fd_sc_hd__decap_4
X_07794_ net920 net912 net1001 net994 vssd1 vssd1 vccd1 vccd1 _01916_ sky130_fd_sc_hd__nand4_1
XFILLER_0_64_83 vssd1 vssd1 vccd1 vccd1 sky130_fd_sc_hd__fill_1
X_06745_ _00956_ _00957_ _00958_ vssd1 vssd1 vccd1 vccd1 _00961_ sky130_fd_sc_hd__a21bo_2
X_09464_ _03571_ _03572_ _03408_ _03410_ vssd1 vssd1 vccd1 vccd1 _03574_ sky130_fd_sc_hd__a211o_2
XFILLER_0_78_489 vssd1 vssd1 vccd1 vccd1 sky130_fd_sc_hd__fill_2
X_06676_ _00900_ _00902_ vssd1 vssd1 vccd1 vccd1 _00903_ sky130_fd_sc_hd__xnor2_4
XFILLER_0_109_709 vssd1 vssd1 vccd1 vccd1 sky130_ef_sc_hd__decap_12
X_08415_ _02391_ _02393_ _02530_ _02531_ vssd1 vssd1 vccd1 vccd1 _02532_ sky130_fd_sc_hd__a211oi_2
X_09395_ _03361_ _03368_ _03367_ vssd1 vssd1 vccd1 vccd1 _03505_ sky130_fd_sc_hd__a21o_1
XFILLER_0_19_501 vssd1 vssd1 vccd1 vccd1 sky130_fd_sc_hd__decap_3
X_08346_ _02322_ _02325_ _02460_ _02461_ vssd1 vssd1 vccd1 vccd1 _02463_ sky130_fd_sc_hd__o211ai_4
XFILLER_0_19_567 vssd1 vssd1 vccd1 vccd1 sky130_fd_sc_hd__fill_2
X_08277_ _02270_ _02272_ _02393_ _02394_ vssd1 vssd1 vccd1 vccd1 _02395_ sky130_fd_sc_hd__o211ai_4
XFILLER_0_34_559 vssd1 vssd1 vccd1 vccd1 sky130_ef_sc_hd__decap_12
X_07228_ _01345_ _01350_ _01351_ vssd1 vssd1 vccd1 vccd1 _01353_ sky130_fd_sc_hd__nand3_2
XFILLER_0_14_250 vssd1 vssd1 vccd1 vccd1 sky130_fd_sc_hd__fill_2
X_07159_ net880 net1103 vssd1 vssd1 vccd1 vccd1 _01284_ sky130_fd_sc_hd__nand2_1
XFILLER_0_100_642 vssd1 vssd1 vccd1 vccd1 sky130_fd_sc_hd__fill_2
X_10170_ net1046 net738 vssd1 vssd1 vccd1 vccd1 _04275_ sky130_fd_sc_hd__nand2_1
Xfanout1117 mul1.a\[4\] vssd1 vssd1 vccd1 vccd1 net1117 sky130_fd_sc_hd__clkbuf_2
Xfanout1106 net1107 vssd1 vssd1 vccd1 vccd1 net1106 sky130_fd_sc_hd__clkbuf_4
Xfanout1128 net1129 vssd1 vssd1 vccd1 vccd1 net1128 sky130_fd_sc_hd__clkbuf_4
Xfanout1139 net1142 vssd1 vssd1 vccd1 vccd1 net1139 sky130_fd_sc_hd__clkbuf_4
X_12811_ clknet_leaf_51_clk_i _00197_ vssd1 vssd1 vccd1 vccd1 sub1.a_i\[10\] sky130_fd_sc_hd__dfxtp_1
XTAP_1132 vssd1 vccd1 sky130_fd_sc_hd__tapvpwrvgnd_1
XTAP_1121 vssd1 vccd1 sky130_fd_sc_hd__tapvpwrvgnd_1
XTAP_1110 vssd1 vccd1 sky130_fd_sc_hd__tapvpwrvgnd_1
X_12742_ clknet_leaf_0_clk_i _00128_ vssd1 vssd1 vccd1 vccd1 add1.a_i\[5\] sky130_fd_sc_hd__dfxtp_1
X_12673_ clknet_leaf_19_clk_i net1250 net1178 vssd1 vssd1 vccd1 vccd1 net401 sky130_fd_sc_hd__dfrtp_1
XTAP_1165 vssd1 vccd1 sky130_fd_sc_hd__tapvpwrvgnd_1
XTAP_1154 vssd1 vccd1 sky130_fd_sc_hd__tapvpwrvgnd_1
XTAP_1143 vssd1 vccd1 sky130_fd_sc_hd__tapvpwrvgnd_1
XTAP_1198 vssd1 vccd1 sky130_fd_sc_hd__tapvpwrvgnd_1
XTAP_1176 vssd1 vccd1 sky130_fd_sc_hd__tapvpwrvgnd_1
XTAP_1187 vssd1 vccd1 sky130_fd_sc_hd__tapvpwrvgnd_1
X_11624_ _05716_ _05717_ vssd1 vssd1 vccd1 vccd1 _05718_ sky130_fd_sc_hd__xnor2_1
XFILLER_0_108_742 vssd1 vssd1 vccd1 vccd1 sky130_ef_sc_hd__decap_12
XFILLER_0_71_109 vssd1 vssd1 vccd1 vccd1 sky130_fd_sc_hd__decap_3
XFILLER_0_65_673 vssd1 vssd1 vccd1 vccd1 sky130_fd_sc_hd__fill_2
XFILLER_0_108_786 vssd1 vssd1 vccd1 vccd1 sky130_fd_sc_hd__fill_1
X_11555_ _05497_ _05501_ _05648_ _05649_ vssd1 vssd1 vccd1 vccd1 _05650_ sky130_fd_sc_hd__a211oi_1
X_10506_ net1062 net715 net710 net1070 vssd1 vssd1 vccd1 vccd1 _04609_ sky130_fd_sc_hd__a22oi_1
X_11486_ _05471_ _05473_ _05580_ vssd1 vssd1 vccd1 vccd1 _05581_ sky130_fd_sc_hd__o21bai_1
X_13225_ net507 vssd1 vssd1 vccd1 vccd1 net280 sky130_fd_sc_hd__clkbuf_1
XFILLER_0_122_233 vssd1 vssd1 vccd1 vccd1 sky130_ef_sc_hd__decap_12
XFILLER_0_80_698 vssd1 vssd1 vccd1 vccd1 sky130_fd_sc_hd__fill_2
X_10437_ _04430_ _04538_ _04539_ vssd1 vssd1 vccd1 vccd1 _04540_ sky130_fd_sc_hd__or3_1
XFILLER_0_52_389 vssd1 vssd1 vccd1 vccd1 sky130_fd_sc_hd__decap_8
XFILLER_0_122_277 vssd1 vssd1 vccd1 vccd1 sky130_ef_sc_hd__decap_12
XFILLER_0_20_220 vssd1 vssd1 vccd1 vccd1 sky130_fd_sc_hd__fill_1
X_13156_ clknet_leaf_13_clk_i _00542_ net1188 vssd1 vssd1 vccd1 vccd1 l0\[17\] sky130_fd_sc_hd__dfrtp_1
X_10368_ net753 _04471_ _04470_ vssd1 vssd1 vccd1 vccd1 _04472_ sky130_fd_sc_hd__a21bo_1
XTAP_905 vssd1 vccd1 sky130_fd_sc_hd__tapvpwrvgnd_1
XTAP_916 vssd1 vccd1 sky130_fd_sc_hd__tapvpwrvgnd_1
X_10299_ net1046 net738 _04272_ _04273_ net753 vssd1 vssd1 vccd1 vccd1 _04403_ sky130_fd_sc_hd__a32o_1
XTAP_949 vssd1 vccd1 sky130_fd_sc_hd__tapvpwrvgnd_1
X_13087_ clknet_leaf_43_clk_i _00473_ vssd1 vssd1 vccd1 vccd1 temp1\[12\] sky130_fd_sc_hd__dfxtp_1
XTAP_938 vssd1 vccd1 sky130_fd_sc_hd__tapvpwrvgnd_1
XTAP_927 vssd1 vccd1 sky130_fd_sc_hd__tapvpwrvgnd_1
X_12107_ mul1.a\[17\] _06086_ net516 vssd1 vssd1 vccd1 vccd1 _00268_ sky130_fd_sc_hd__mux2_1
X_12038_ _00810_ _05752_ _06032_ _06031_ vssd1 vssd1 vccd1 vccd1 _06035_ sky130_fd_sc_hd__a31o_1
Xclkbuf_leaf_34_clk_i clknet_3_4__leaf_clk_i vssd1 vssd1 vccd1 vccd1 clknet_leaf_34_clk_i
+ sky130_fd_sc_hd__clkbuf_16
XFILLER_0_18_65 vssd1 vssd1 vccd1 vccd1 sky130_ef_sc_hd__decap_12
XFILLER_0_125_55 vssd1 vssd1 vccd1 vccd1 sky130_fd_sc_hd__fill_1
X_06530_ _00654_ _00787_ vssd1 vssd1 vccd1 vccd1 _00788_ sky130_fd_sc_hd__xnor2_4
X_06461_ _00757_ _00758_ vssd1 vssd1 vccd1 vccd1 _00759_ sky130_fd_sc_hd__xnor2_4
Xclkbuf_leaf_49_clk_i clknet_3_1__leaf_clk_i vssd1 vssd1 vccd1 vccd1 clknet_leaf_49_clk_i
+ sky130_fd_sc_hd__clkbuf_16
X_08200_ _02315_ _02316_ _02311_ vssd1 vssd1 vccd1 vccd1 _02318_ sky130_fd_sc_hd__a21o_1
X_06392_ net545 _00699_ vssd1 vssd1 vccd1 vccd1 net315 sky130_fd_sc_hd__nor2_1
X_09180_ _03282_ _03290_ vssd1 vssd1 vccd1 vccd1 _03291_ sky130_fd_sc_hd__nand2_1
XFILLER_0_44_813 vssd1 vssd1 vccd1 vccd1 sky130_fd_sc_hd__decap_4
XFILLER_0_44_802 vssd1 vssd1 vccd1 vccd1 sky130_fd_sc_hd__fill_2
X_08131_ _02131_ _02133_ _02132_ vssd1 vssd1 vccd1 vccd1 _02250_ sky130_fd_sc_hd__a21bo_1
XFILLER_0_50_85 vssd1 vssd1 vccd1 vccd1 sky130_fd_sc_hd__decap_8
X_08062_ net1114 net1122 net772 net763 vssd1 vssd1 vccd1 vccd1 _02181_ sky130_fd_sc_hd__and4_1
XFILLER_0_70_197 vssd1 vssd1 vccd1 vccd1 sky130_fd_sc_hd__fill_1
X_07013_ _01133_ _01135_ _01099_ _01102_ vssd1 vssd1 vccd1 vccd1 _01138_ sky130_fd_sc_hd__o211a_1
Xclkbuf_3_4__f_clk_i clknet_0_clk_i vssd1 vssd1 vccd1 vccd1 clknet_3_4__leaf_clk_i
+ sky130_fd_sc_hd__clkbuf_16
X_08964_ _02922_ _02930_ _02929_ vssd1 vssd1 vccd1 vccd1 _03077_ sky130_fd_sc_hd__a21bo_1
XFILLER_0_52_3 vssd1 vssd1 vccd1 vccd1 sky130_fd_sc_hd__fill_1
Xinput209 v2x[30] vssd1 vssd1 vccd1 vccd1 net209 sky130_fd_sc_hd__buf_1
X_07915_ _02016_ _02033_ _02034_ vssd1 vssd1 vccd1 vccd1 _02036_ sky130_fd_sc_hd__nand3_2
X_08895_ _02998_ _03006_ vssd1 vssd1 vccd1 vccd1 _03008_ sky130_fd_sc_hd__or2_1
XFILLER_0_75_82 vssd1 vssd1 vccd1 vccd1 sky130_fd_sc_hd__fill_2
X_07846_ net1106 net805 _01881_ _01882_ net822 vssd1 vssd1 vccd1 vccd1 _01967_ sky130_fd_sc_hd__a32o_1
X_07777_ _01815_ _01816_ _01817_ vssd1 vssd1 vccd1 vccd1 _01899_ sky130_fd_sc_hd__o21ba_1
X_09516_ _03623_ _03624_ _03452_ _03455_ vssd1 vssd1 vccd1 vccd1 _03625_ sky130_fd_sc_hd__o211ai_2
XFILLER_0_94_713 vssd1 vssd1 vccd1 vccd1 sky130_ef_sc_hd__decap_12
X_06728_ net1588 _00946_ net635 vssd1 vssd1 vccd1 vccd1 _00029_ sky130_fd_sc_hd__mux2_1
XPHY_215 vssd1 vssd1 vccd1 vccd1 sky130_fd_sc_hd__decap_3
XPHY_204 vssd1 vssd1 vccd1 vccd1 sky130_fd_sc_hd__decap_3
XFILLER_0_91_81 vssd1 vssd1 vccd1 vccd1 sky130_fd_sc_hd__decap_8
X_09447_ _03553_ _03554_ _03389_ _03393_ vssd1 vssd1 vccd1 vccd1 _03557_ sky130_fd_sc_hd__o211a_1
XPHY_259 vssd1 vssd1 vccd1 vccd1 sky130_fd_sc_hd__decap_3
XPHY_248 vssd1 vssd1 vccd1 vccd1 sky130_fd_sc_hd__decap_3
XPHY_237 vssd1 vssd1 vccd1 vccd1 sky130_fd_sc_hd__decap_3
XPHY_226 vssd1 vssd1 vccd1 vccd1 sky130_fd_sc_hd__decap_3
X_06659_ _00883_ _00886_ _00884_ vssd1 vssd1 vccd1 vccd1 _00888_ sky130_fd_sc_hd__a21o_2
X_09378_ net1031 net793 vssd1 vssd1 vccd1 vccd1 _03488_ sky130_fd_sc_hd__nand2_1
XFILLER_0_117_561 vssd1 vssd1 vccd1 vccd1 sky130_ef_sc_hd__decap_12
XFILLER_0_105_701 vssd1 vssd1 vccd1 vccd1 sky130_fd_sc_hd__decap_3
X_08329_ net1075 net1084 net796 net787 vssd1 vssd1 vccd1 vccd1 _02446_ sky130_fd_sc_hd__nand4_2
XFILLER_0_46_172 vssd1 vssd1 vccd1 vccd1 sky130_ef_sc_hd__decap_12
X_11340_ _05434_ _05435_ _05303_ _05305_ vssd1 vssd1 vccd1 vccd1 _05437_ sky130_fd_sc_hd__a211o_1
XFILLER_0_104_244 vssd1 vssd1 vccd1 vccd1 sky130_fd_sc_hd__fill_1
XFILLER_0_34_378 vssd1 vssd1 vccd1 vccd1 sky130_fd_sc_hd__fill_1
XFILLER_0_120_737 vssd1 vssd1 vccd1 vccd1 sky130_ef_sc_hd__decap_12
X_13010_ clknet_leaf_29_clk_i _00396_ net1168 vssd1 vssd1 vccd1 vccd1 x2mx1\[31\]
+ sky130_fd_sc_hd__dfrtp_1
X_11271_ _05362_ _05367_ vssd1 vssd1 vccd1 vccd1 _05368_ sky130_fd_sc_hd__nand2_1
X_10222_ _04317_ _04324_ _04325_ vssd1 vssd1 vccd1 vccd1 _04327_ sky130_fd_sc_hd__nand3_1
X_10153_ _04255_ _04256_ _04245_ vssd1 vssd1 vccd1 vccd1 _04258_ sky130_fd_sc_hd__a21oi_2
Xhold8 _00115_ vssd1 vssd1 vccd1 vccd1 net1223 sky130_fd_sc_hd__dlygate4sd3_1
X_10084_ _04186_ _04187_ _04188_ vssd1 vssd1 vccd1 vccd1 _04190_ sky130_fd_sc_hd__a21bo_1
X_10986_ _05083_ _05084_ vssd1 vssd1 vccd1 vccd1 _05085_ sky130_fd_sc_hd__or2_1
XFILLER_0_128_837 vssd1 vssd1 vccd1 vccd1 sky130_fd_sc_hd__decap_4
X_12725_ clknet_leaf_8_clk_i _00111_ net1194 vssd1 vssd1 vccd1 vccd1 net344 sky130_fd_sc_hd__dfrtp_1
XFILLER_0_84_267 vssd1 vssd1 vccd1 vccd1 sky130_ef_sc_hd__decap_12
X_12656_ clknet_leaf_21_clk_i _00042_ net1175 vssd1 vssd1 vccd1 vccd1 net382 sky130_fd_sc_hd__dfrtp_1
X_12587_ net1522 net30 net554 vssd1 vssd1 vccd1 vccd1 _00562_ sky130_fd_sc_hd__mux2_1
XFILLER_0_25_334 vssd1 vssd1 vccd1 vccd1 sky130_fd_sc_hd__fill_2
X_11607_ _05699_ _05700_ vssd1 vssd1 vccd1 vccd1 _05701_ sky130_fd_sc_hd__xnor2_1
XFILLER_0_108_572 vssd1 vssd1 vccd1 vccd1 sky130_ef_sc_hd__decap_12
XFILLER_0_123_553 vssd1 vssd1 vccd1 vccd1 sky130_fd_sc_hd__decap_6
Xhold408 posx\[2\] vssd1 vssd1 vccd1 vccd1 net1623 sky130_fd_sc_hd__dlygate4sd3_1
XFILLER_0_111_57 vssd1 vssd1 vccd1 vccd1 sky130_ef_sc_hd__decap_12
XFILLER_0_80_484 vssd1 vssd1 vccd1 vccd1 sky130_ef_sc_hd__decap_12
XFILLER_0_20_77 vssd1 vssd1 vccd1 vccd1 sky130_fd_sc_hd__decap_6
X_11538_ net975 net733 net721 net983 vssd1 vssd1 vccd1 vccd1 _05633_ sky130_fd_sc_hd__a22oi_1
XFILLER_0_123_597 vssd1 vssd1 vccd1 vccd1 sky130_ef_sc_hd__decap_12
XFILLER_0_96_15 vssd1 vssd1 vccd1 vccd1 sky130_ef_sc_hd__decap_12
XFILLER_0_52_197 vssd1 vssd1 vccd1 vccd1 sky130_fd_sc_hd__fill_1
X_11469_ net1541 _05564_ net525 vssd1 vssd1 vccd1 vccd1 _00152_ sky130_fd_sc_hd__mux2_1
Xhold419 x2mx1\[29\] vssd1 vssd1 vccd1 vccd1 net1634 sky130_fd_sc_hd__dlygate4sd3_1
XFILLER_0_111_759 vssd1 vssd1 vccd1 vccd1 sky130_fd_sc_hd__fill_1
X_13139_ clknet_leaf_15_clk_i _00525_ net1183 vssd1 vssd1 vccd1 vccd1 l0\[0\] sky130_fd_sc_hd__dfrtp_1
XTAP_702 vssd1 vccd1 sky130_fd_sc_hd__tapvpwrvgnd_1
XTAP_713 vssd1 vccd1 sky130_fd_sc_hd__tapvpwrvgnd_1
XTAP_724 vssd1 vccd1 sky130_fd_sc_hd__tapvpwrvgnd_1
XTAP_735 vssd1 vccd1 sky130_fd_sc_hd__tapvpwrvgnd_1
XTAP_746 vssd1 vccd1 sky130_fd_sc_hd__tapvpwrvgnd_1
XTAP_757 vssd1 vccd1 sky130_fd_sc_hd__tapvpwrvgnd_1
XTAP_768 vssd1 vccd1 sky130_fd_sc_hd__tapvpwrvgnd_1
X_07700_ _01821_ _01822_ _01820_ vssd1 vssd1 vccd1 vccd1 _01823_ sky130_fd_sc_hd__a21o_1
XTAP_779 vssd1 vccd1 sky130_fd_sc_hd__tapvpwrvgnd_1
X_08680_ _02791_ _02793_ _02649_ _02652_ vssd1 vssd1 vccd1 vccd1 _02795_ sky130_fd_sc_hd__a211oi_2
X_07631_ _01325_ _01405_ _01403_ vssd1 vssd1 vccd1 vccd1 _01755_ sky130_fd_sc_hd__a21o_1
X_07562_ _01685_ vssd1 vssd1 vccd1 vccd1 _01686_ sky130_fd_sc_hd__inv_2
X_06513_ det_t\[23\] net529 vssd1 vssd1 vccd1 vccd1 net267 sky130_fd_sc_hd__and2_1
X_09301_ _03410_ _03411_ vssd1 vssd1 vccd1 vccd1 _03412_ sky130_fd_sc_hd__nor2_2
XFILLER_0_88_573 vssd1 vssd1 vccd1 vccd1 sky130_fd_sc_hd__fill_1
XFILLER_0_48_426 vssd1 vssd1 vccd1 vccd1 sky130_fd_sc_hd__fill_2
XFILLER_0_119_837 vssd1 vssd1 vccd1 vccd1 sky130_fd_sc_hd__decap_3
XFILLER_0_76_757 vssd1 vssd1 vccd1 vccd1 sky130_fd_sc_hd__decap_4
XFILLER_0_0_65 vssd1 vssd1 vccd1 vccd1 sky130_fd_sc_hd__fill_2
X_07493_ net896 net891 net1138 net1145 vssd1 vssd1 vccd1 vccd1 _01618_ sky130_fd_sc_hd__nand4_2
X_06444_ net546 _00744_ vssd1 vssd1 vccd1 vccd1 net322 sky130_fd_sc_hd__nor2_1
XFILLER_0_91_727 vssd1 vssd1 vccd1 vccd1 sky130_fd_sc_hd__fill_1
X_09232_ net818 net1009 net1002 net825 vssd1 vssd1 vccd1 vccd1 _03343_ sky130_fd_sc_hd__a22o_1
XFILLER_0_17_813 vssd1 vssd1 vccd1 vccd1 sky130_fd_sc_hd__fill_1
XFILLER_0_29_651 vssd1 vssd1 vccd1 vccd1 sky130_fd_sc_hd__fill_2
X_09163_ _03272_ _03273_ vssd1 vssd1 vccd1 vccd1 _03274_ sky130_fd_sc_hd__nand2b_1
XFILLER_0_91_749 vssd1 vssd1 vccd1 vccd1 sky130_fd_sc_hd__fill_2
XFILLER_0_56_470 vssd1 vssd1 vccd1 vccd1 sky130_fd_sc_hd__decap_6
X_06375_ add1.a_i\[15\] add1.b_i\[15\] vssd1 vssd1 vccd1 vccd1 _00685_ sky130_fd_sc_hd__or2_1
XFILLER_0_8_589 vssd1 vssd1 vccd1 vccd1 sky130_fd_sc_hd__decap_3
XFILLER_0_8_578 vssd1 vssd1 vccd1 vccd1 sky130_fd_sc_hd__fill_2
X_08114_ net1033 net857 _02230_ _02231_ vssd1 vssd1 vccd1 vccd1 _02233_ sky130_fd_sc_hd__nand4_2
XFILLER_0_114_531 vssd1 vssd1 vccd1 vccd1 sky130_fd_sc_hd__fill_1
X_09094_ _03058_ _03060_ _03204_ vssd1 vssd1 vccd1 vccd1 _03206_ sky130_fd_sc_hd__nor3_1
XFILLER_0_44_698 vssd1 vssd1 vccd1 vccd1 sky130_fd_sc_hd__fill_2
XFILLER_0_44_687 vssd1 vssd1 vccd1 vccd1 sky130_fd_sc_hd__decap_3
X_08045_ _01848_ _01946_ _02055_ vssd1 vssd1 vccd1 vccd1 _02165_ sky130_fd_sc_hd__or3b_1
XFILLER_0_4_795 vssd1 vssd1 vccd1 vccd1 sky130_fd_sc_hd__fill_2
XFILLER_0_101_225 vssd1 vssd1 vccd1 vccd1 sky130_fd_sc_hd__decap_6
X_09996_ _04092_ _04099_ _04100_ vssd1 vssd1 vccd1 vccd1 _04102_ sky130_fd_sc_hd__nand3_2
X_08947_ _03051_ _03059_ vssd1 vssd1 vccd1 vccd1 _03060_ sky130_fd_sc_hd__and2b_1
XFILLER_0_98_304 vssd1 vssd1 vccd1 vccd1 sky130_fd_sc_hd__decap_4
X_08878_ _02989_ _02990_ _02842_ _02845_ vssd1 vssd1 vccd1 vccd1 _02991_ sky130_fd_sc_hd__o211a_1
X_07829_ _01763_ _01852_ _01950_ vssd1 vssd1 vccd1 vccd1 _01951_ sky130_fd_sc_hd__a21oi_1
X_10840_ _04938_ _04939_ _04748_ net1746 vssd1 vssd1 vccd1 vccd1 _04941_ sky130_fd_sc_hd__a211o_1
X_10771_ _04728_ _04730_ vssd1 vssd1 vccd1 vccd1 _04872_ sky130_fd_sc_hd__or2_1
X_12510_ net1258 net562 vssd1 vssd1 vccd1 vccd1 _06252_ sky130_fd_sc_hd__nand2_1
XFILLER_0_82_738 vssd1 vssd1 vccd1 vccd1 sky130_ef_sc_hd__decap_12
X_12441_ _00887_ net613 _03581_ net575 vssd1 vssd1 vccd1 vccd1 _06213_ sky130_fd_sc_hd__a22o_1
XFILLER_0_19_161 vssd1 vssd1 vccd1 vccd1 sky130_fd_sc_hd__decap_6
XFILLER_0_35_610 vssd1 vssd1 vccd1 vccd1 sky130_fd_sc_hd__decap_6
XFILLER_0_124_339 vssd1 vssd1 vccd1 vccd1 sky130_ef_sc_hd__decap_12
XFILLER_0_124_317 vssd1 vssd1 vccd1 vccd1 sky130_fd_sc_hd__decap_4
XFILLER_0_23_805 vssd1 vssd1 vccd1 vccd1 sky130_fd_sc_hd__fill_1
XFILLER_0_35_654 vssd1 vssd1 vccd1 vccd1 sky130_fd_sc_hd__decap_4
XFILLER_0_117_391 vssd1 vssd1 vccd1 vccd1 sky130_fd_sc_hd__fill_1
XFILLER_0_62_473 vssd1 vssd1 vccd1 vccd1 sky130_fd_sc_hd__decap_3
XFILLER_0_62_462 vssd1 vssd1 vccd1 vccd1 sky130_fd_sc_hd__fill_1
X_12372_ net1423 _00951_ net663 vssd1 vssd1 vccd1 vccd1 _00424_ sky130_fd_sc_hd__mux2_1
XFILLER_0_120_501 vssd1 vssd1 vccd1 vccd1 sky130_ef_sc_hd__decap_12
X_11323_ _05237_ _05239_ _05417_ vssd1 vssd1 vccd1 vccd1 _05420_ sky130_fd_sc_hd__and3_1
XFILLER_0_120_545 vssd1 vssd1 vccd1 vccd1 sky130_ef_sc_hd__decap_12
X_11254_ net765 net957 net954 net775 vssd1 vssd1 vccd1 vccd1 _05351_ sky130_fd_sc_hd__a22o_1
XFILLER_0_120_589 vssd1 vssd1 vccd1 vccd1 sky130_ef_sc_hd__decap_12
X_10205_ net884 _04174_ _04175_ vssd1 vssd1 vccd1 vccd1 _04310_ sky130_fd_sc_hd__nand3_2
XFILLER_0_66_29 vssd1 vssd1 vccd1 vccd1 sky130_fd_sc_hd__decap_3
X_11185_ _05153_ _05282_ vssd1 vssd1 vccd1 vccd1 _05283_ sky130_fd_sc_hd__xnor2_1
X_10136_ _04078_ _04083_ _04239_ vssd1 vssd1 vccd1 vccd1 _04241_ sky130_fd_sc_hd__nor3_1
X_10067_ net902 net893 net926 vssd1 vssd1 vccd1 vccd1 _04173_ sky130_fd_sc_hd__and3_1
XFILLER_0_89_337 vssd1 vssd1 vccd1 vccd1 sky130_ef_sc_hd__decap_12
XFILLER_0_15_55 vssd1 vssd1 vccd1 vccd1 sky130_fd_sc_hd__fill_1
XFILLER_0_128_601 vssd1 vssd1 vccd1 vccd1 sky130_ef_sc_hd__decap_12
X_10969_ _04934_ _04936_ _05067_ _05068_ vssd1 vssd1 vccd1 vccd1 _05069_ sky130_fd_sc_hd__a211oi_4
XFILLER_0_57_223 vssd1 vssd1 vccd1 vccd1 sky130_fd_sc_hd__fill_1
XFILLER_0_128_645 vssd1 vssd1 vccd1 vccd1 sky130_ef_sc_hd__decap_12
XFILLER_0_127_111 vssd1 vssd1 vccd1 vccd1 sky130_fd_sc_hd__fill_1
X_12708_ clknet_leaf_9_clk_i net1413 net1190 vssd1 vssd1 vccd1 vccd1 net440 sky130_fd_sc_hd__dfrtp_1
XFILLER_0_85_576 vssd1 vssd1 vccd1 vccd1 sky130_fd_sc_hd__fill_2
XFILLER_0_115_317 vssd1 vssd1 vccd1 vccd1 sky130_ef_sc_hd__decap_12
XFILLER_0_110_3 vssd1 vssd1 vccd1 vccd1 sky130_ef_sc_hd__decap_12
XFILLER_0_25_120 vssd1 vssd1 vccd1 vccd1 sky130_fd_sc_hd__decap_3
X_12639_ clknet_leaf_27_clk_i _00025_ net1171 vssd1 vssd1 vccd1 vccd1 net364 sky130_fd_sc_hd__dfrtp_1
XFILLER_0_31_54 vssd1 vssd1 vccd1 vccd1 sky130_fd_sc_hd__fill_2
XFILLER_0_124_840 vssd1 vssd1 vccd1 vccd1 sky130_fd_sc_hd__fill_2
XFILLER_0_13_315 vssd1 vssd1 vccd1 vccd1 sky130_fd_sc_hd__fill_1
XFILLER_0_26_698 vssd1 vssd1 vccd1 vccd1 sky130_fd_sc_hd__fill_2
XFILLER_0_123_361 vssd1 vssd1 vccd1 vccd1 sky130_ef_sc_hd__decap_12
Xhold216 y2my0\[25\] vssd1 vssd1 vccd1 vccd1 net1431 sky130_fd_sc_hd__dlygate4sd3_1
Xhold205 x0mx2\[30\] vssd1 vssd1 vccd1 vccd1 net1420 sky130_fd_sc_hd__dlygate4sd3_1
Xhold238 l0\[1\] vssd1 vssd1 vccd1 vccd1 net1453 sky130_fd_sc_hd__dlygate4sd3_1
Xhold227 net400 vssd1 vssd1 vccd1 vccd1 net1442 sky130_fd_sc_hd__dlygate4sd3_1
Xhold249 y2my0\[3\] vssd1 vssd1 vccd1 vccd1 net1464 sky130_fd_sc_hd__dlygate4sd3_1
XFILLER_0_40_178 vssd1 vssd1 vccd1 vccd1 sky130_fd_sc_hd__decap_4
XFILLER_0_21_370 vssd1 vssd1 vccd1 vccd1 sky130_fd_sc_hd__fill_2
X_09850_ _03955_ _03956_ vssd1 vssd1 vccd1 vccd1 _03957_ sky130_fd_sc_hd__nor2_1
Xfanout707 mul1.b\[28\] vssd1 vssd1 vccd1 vccd1 net707 sky130_fd_sc_hd__buf_2
Xfanout718 mul1.b\[26\] vssd1 vssd1 vccd1 vccd1 net718 sky130_fd_sc_hd__buf_2
XTAP_510 vssd1 vccd1 sky130_fd_sc_hd__tapvpwrvgnd_1
XTAP_521 vssd1 vccd1 sky130_fd_sc_hd__tapvpwrvgnd_1
XTAP_532 vssd1 vccd1 sky130_fd_sc_hd__tapvpwrvgnd_1
XTAP_543 vssd1 vccd1 sky130_fd_sc_hd__tapvpwrvgnd_1
Xfanout729 net730 vssd1 vssd1 vccd1 vccd1 net729 sky130_fd_sc_hd__buf_2
X_09781_ _03887_ _03888_ vssd1 vssd1 vccd1 vccd1 _03889_ sky130_fd_sc_hd__and2b_1
X_08801_ _02908_ _02913_ vssd1 vssd1 vccd1 vccd1 _02915_ sky130_fd_sc_hd__xnor2_2
XTAP_554 vssd1 vccd1 sky130_fd_sc_hd__tapvpwrvgnd_1
XTAP_565 vssd1 vccd1 sky130_fd_sc_hd__tapvpwrvgnd_1
XTAP_576 vssd1 vccd1 sky130_fd_sc_hd__tapvpwrvgnd_1
X_06993_ _01111_ _01112_ _01117_ vssd1 vssd1 vccd1 vccd1 _01118_ sky130_fd_sc_hd__nand3_2
X_08732_ _02843_ _02844_ vssd1 vssd1 vccd1 vccd1 _02846_ sky130_fd_sc_hd__xnor2_1
XTAP_587 vssd1 vccd1 sky130_fd_sc_hd__tapvpwrvgnd_1
XTAP_598 vssd1 vccd1 sky130_fd_sc_hd__tapvpwrvgnd_1
X_08663_ _02633_ _02634_ _02635_ vssd1 vssd1 vccd1 vccd1 _02778_ sky130_fd_sc_hd__a21bo_1
XFILLER_0_15_3 vssd1 vssd1 vccd1 vccd1 sky130_ef_sc_hd__decap_12
X_08594_ _02705_ _02708_ vssd1 vssd1 vccd1 vccd1 _02709_ sky130_fd_sc_hd__xor2_2
XTAP_1709 vssd1 vccd1 sky130_fd_sc_hd__tapvpwrvgnd_1
X_07614_ _01737_ vssd1 vssd1 vccd1 vccd1 _01738_ sky130_fd_sc_hd__inv_2
X_07545_ _01354_ _01357_ vssd1 vssd1 vccd1 vccd1 _01669_ sky130_fd_sc_hd__or2_1
XFILLER_0_76_587 vssd1 vssd1 vccd1 vccd1 sky130_fd_sc_hd__fill_1
XFILLER_0_48_278 vssd1 vssd1 vccd1 vccd1 sky130_fd_sc_hd__fill_2
XFILLER_0_9_821 vssd1 vssd1 vccd1 vccd1 sky130_ef_sc_hd__decap_12
X_07476_ _01561_ _01589_ _01594_ vssd1 vssd1 vccd1 vccd1 _01601_ sky130_fd_sc_hd__a21o_1
XFILLER_0_36_418 vssd1 vssd1 vccd1 vccd1 sky130_fd_sc_hd__fill_2
XFILLER_0_118_133 vssd1 vssd1 vccd1 vccd1 sky130_fd_sc_hd__decap_6
X_09215_ _03322_ _03323_ _03324_ vssd1 vssd1 vccd1 vccd1 _03326_ sky130_fd_sc_hd__a21bo_1
X_06427_ _00728_ _00729_ vssd1 vssd1 vccd1 vccd1 _00730_ sky130_fd_sc_hd__nand2_1
XFILLER_0_118_177 vssd1 vssd1 vccd1 vccd1 sky130_ef_sc_hd__decap_12
XFILLER_0_8_386 vssd1 vssd1 vccd1 vccd1 sky130_fd_sc_hd__decap_3
X_09146_ _03114_ _03257_ vssd1 vssd1 vccd1 vccd1 _03258_ sky130_fd_sc_hd__xnor2_4
X_06358_ _00630_ _00669_ vssd1 vssd1 vccd1 vccd1 _00670_ sky130_fd_sc_hd__nand2_2
X_09077_ _03021_ _03024_ _03185_ _03186_ vssd1 vssd1 vccd1 vccd1 _03189_ sky130_fd_sc_hd__o211ai_2
XFILLER_0_71_281 vssd1 vssd1 vccd1 vccd1 sky130_fd_sc_hd__fill_2
XFILLER_0_16_186 vssd1 vssd1 vccd1 vccd1 sky130_fd_sc_hd__decap_6
X_06289_ _00603_ vssd1 vssd1 vccd1 vccd1 _00604_ sky130_fd_sc_hd__inv_2
XFILLER_0_102_545 vssd1 vssd1 vccd1 vccd1 sky130_fd_sc_hd__decap_6
X_08028_ _02144_ _02146_ _02033_ _02036_ vssd1 vssd1 vccd1 vccd1 _02148_ sky130_fd_sc_hd__o211a_1
XFILLER_0_102_589 vssd1 vssd1 vccd1 vccd1 sky130_fd_sc_hd__decap_6
Xmax_cap491 _02792_ vssd1 vssd1 vccd1 vccd1 net491 sky130_fd_sc_hd__clkbuf_1
X_09979_ _03917_ _03922_ _04084_ vssd1 vssd1 vccd1 vccd1 _04085_ sky130_fd_sc_hd__o21a_1
XFILLER_0_99_613 vssd1 vssd1 vccd1 vccd1 sky130_fd_sc_hd__decap_3
X_12990_ clknet_leaf_44_clk_i _00376_ net1157 vssd1 vssd1 vccd1 vccd1 x2mx1\[11\]
+ sky130_fd_sc_hd__dfrtp_1
XFILLER_0_87_819 vssd1 vssd1 vccd1 vccd1 sky130_fd_sc_hd__fill_1
X_11941_ net1700 _05960_ net479 vssd1 vssd1 vccd1 vccd1 _00228_ sky130_fd_sc_hd__mux2_1
X_11872_ temp1\[27\] net616 net609 net205 _05905_ vssd1 vssd1 vccd1 vccd1 _05906_
+ sky130_fd_sc_hd__a221o_1
XFILLER_0_95_841 vssd1 vssd1 vccd1 vccd1 sky130_fd_sc_hd__fill_1
X_10823_ _04915_ _04922_ vssd1 vssd1 vccd1 vccd1 _04924_ sky130_fd_sc_hd__xnor2_1
XFILLER_0_39_223 vssd1 vssd1 vccd1 vccd1 sky130_fd_sc_hd__fill_1
XFILLER_0_109_111 vssd1 vssd1 vccd1 vccd1 sky130_fd_sc_hd__fill_1
XFILLER_0_27_407 vssd1 vssd1 vccd1 vccd1 sky130_fd_sc_hd__fill_2
XFILLER_0_39_278 vssd1 vssd1 vccd1 vccd1 sky130_fd_sc_hd__fill_2
X_10754_ _04852_ _04853_ _04683_ _04704_ vssd1 vssd1 vccd1 vccd1 _04855_ sky130_fd_sc_hd__o211a_1
XFILLER_0_125_615 vssd1 vssd1 vccd1 vccd1 sky130_fd_sc_hd__fill_1
X_10685_ _04784_ _04785_ _04786_ vssd1 vssd1 vccd1 vccd1 _04787_ sky130_fd_sc_hd__nor3_1
XFILLER_0_54_248 vssd1 vssd1 vccd1 vccd1 sky130_fd_sc_hd__decap_4
XFILLER_0_106_840 vssd1 vssd1 vccd1 vccd1 sky130_fd_sc_hd__fill_2
XFILLER_0_23_624 vssd1 vssd1 vccd1 vccd1 sky130_fd_sc_hd__fill_2
XFILLER_0_35_484 vssd1 vssd1 vccd1 vccd1 sky130_fd_sc_hd__decap_3
X_12424_ net1732 _06204_ net570 vssd1 vssd1 vccd1 vccd1 _00467_ sky130_fd_sc_hd__mux2_1
XFILLER_0_112_309 vssd1 vssd1 vccd1 vccd1 sky130_ef_sc_hd__decap_12
XFILLER_0_2_518 vssd1 vssd1 vccd1 vccd1 sky130_fd_sc_hd__fill_1
X_12355_ net1523 _00862_ net657 vssd1 vssd1 vccd1 vccd1 _00407_ sky130_fd_sc_hd__mux2_1
X_11306_ _05400_ _05401_ vssd1 vssd1 vccd1 vccd1 _05403_ sky130_fd_sc_hd__xnor2_2
XFILLER_0_22_156 vssd1 vssd1 vccd1 vccd1 sky130_fd_sc_hd__fill_1
XFILLER_0_22_167 vssd1 vssd1 vccd1 vccd1 sky130_ef_sc_hd__decap_12
X_12286_ net1667 net526 net674 vssd1 vssd1 vccd1 vccd1 _00338_ sky130_fd_sc_hd__mux2_1
X_11237_ _05209_ _05333_ vssd1 vssd1 vccd1 vccd1 _05334_ sky130_fd_sc_hd__xor2_1
X_11168_ _05262_ _05263_ _05100_ _05137_ vssd1 vssd1 vccd1 vccd1 _05266_ sky130_fd_sc_hd__a211oi_2
X_10119_ _03920_ _04088_ _04085_ vssd1 vssd1 vccd1 vccd1 _04224_ sky130_fd_sc_hd__a21o_2
XFILLER_0_93_27 vssd1 vssd1 vccd1 vccd1 sky130_ef_sc_hd__decap_12
X_11099_ _05071_ _05073_ vssd1 vssd1 vccd1 vccd1 _05198_ sky130_fd_sc_hd__or2_2
XFILLER_0_89_145 vssd1 vssd1 vccd1 vccd1 sky130_fd_sc_hd__decap_3
XFILLER_0_77_307 vssd1 vssd1 vccd1 vccd1 sky130_fd_sc_hd__fill_2
X_07330_ _01445_ _01453_ _01454_ vssd1 vssd1 vccd1 vccd1 _01455_ sky130_fd_sc_hd__nand3_2
XFILLER_0_85_373 vssd1 vssd1 vccd1 vccd1 sky130_fd_sc_hd__fill_1
XFILLER_0_58_587 vssd1 vssd1 vccd1 vccd1 sky130_fd_sc_hd__fill_1
XFILLER_0_18_429 vssd1 vssd1 vccd1 vccd1 sky130_fd_sc_hd__fill_2
XFILLER_0_42_75 vssd1 vssd1 vccd1 vccd1 sky130_fd_sc_hd__fill_1
XFILLER_0_116_637 vssd1 vssd1 vccd1 vccd1 sky130_fd_sc_hd__decap_6
X_09000_ net1368 _03112_ net522 vssd1 vssd1 vccd1 vccd1 _00135_ sky130_fd_sc_hd__mux2_1
X_07261_ _01382_ _01383_ _01384_ vssd1 vssd1 vccd1 vccd1 _01386_ sky130_fd_sc_hd__a21o_1
XFILLER_0_115_125 vssd1 vssd1 vccd1 vccd1 sky130_ef_sc_hd__decap_12
XFILLER_0_5_334 vssd1 vssd1 vccd1 vccd1 sky130_fd_sc_hd__fill_2
XFILLER_0_14_602 vssd1 vssd1 vccd1 vccd1 sky130_fd_sc_hd__fill_1
X_07192_ _01103_ _01305_ _01304_ _01290_ vssd1 vssd1 vccd1 vccd1 _01317_ sky130_fd_sc_hd__o211ai_1
XFILLER_0_115_169 vssd1 vssd1 vccd1 vccd1 sky130_ef_sc_hd__decap_12
XFILLER_0_124_681 vssd1 vssd1 vccd1 vccd1 sky130_ef_sc_hd__decap_12
XFILLER_0_13_167 vssd1 vssd1 vccd1 vccd1 sky130_fd_sc_hd__fill_1
X_09902_ _04007_ _04008_ vssd1 vssd1 vccd1 vccd1 _04009_ sky130_fd_sc_hd__or2_2
XFILLER_0_6_53 vssd1 vssd1 vccd1 vccd1 sky130_ef_sc_hd__decap_12
Xfanout504 _05930_ vssd1 vssd1 vccd1 vccd1 net504 sky130_fd_sc_hd__clkbuf_4
Xfanout515 net520 vssd1 vssd1 vccd1 vccd1 net515 sky130_fd_sc_hd__clkbuf_4
X_09833_ _03938_ _03939_ _03931_ vssd1 vssd1 vccd1 vccd1 _03940_ sky130_fd_sc_hd__a21o_1
XFILLER_0_67_61 vssd1 vssd1 vccd1 vccd1 sky130_ef_sc_hd__decap_12
Xfanout537 net538 vssd1 vssd1 vccd1 vccd1 net537 sky130_fd_sc_hd__clkbuf_2
XTAP_351 vssd1 vccd1 sky130_fd_sc_hd__tapvpwrvgnd_1
XTAP_340 vssd1 vccd1 sky130_fd_sc_hd__tapvpwrvgnd_1
Xfanout548 _00612_ vssd1 vssd1 vccd1 vccd1 net548 sky130_fd_sc_hd__clkbuf_4
Xfanout559 _06271_ vssd1 vssd1 vccd1 vccd1 net559 sky130_fd_sc_hd__buf_2
XTAP_373 vssd1 vccd1 sky130_fd_sc_hd__tapvpwrvgnd_1
XTAP_384 vssd1 vccd1 sky130_fd_sc_hd__tapvpwrvgnd_1
XTAP_362 vssd1 vccd1 sky130_fd_sc_hd__tapvpwrvgnd_1
X_09764_ _03710_ _03712_ _03871_ vssd1 vssd1 vccd1 vccd1 _03872_ sky130_fd_sc_hd__o21ai_1
XTAP_395 vssd1 vccd1 sky130_fd_sc_hd__tapvpwrvgnd_1
X_06976_ _01034_ _01035_ vssd1 vssd1 vccd1 vccd1 _01101_ sky130_fd_sc_hd__xor2_2
XTAP_2207 vssd1 vccd1 sky130_fd_sc_hd__tapvpwrvgnd_1
X_09695_ _03801_ _03802_ vssd1 vssd1 vccd1 vccd1 _03803_ sky130_fd_sc_hd__xnor2_2
X_08715_ net1123 net1132 net727 net723 vssd1 vssd1 vccd1 vccd1 _02829_ sky130_fd_sc_hd__and4_1
XTAP_2229 vssd1 vccd1 sky130_fd_sc_hd__tapvpwrvgnd_1
XTAP_2218 vssd1 vccd1 sky130_fd_sc_hd__tapvpwrvgnd_1
XFILLER_0_96_638 vssd1 vssd1 vccd1 vccd1 sky130_fd_sc_hd__decap_6
XTAP_1506 vssd1 vccd1 sky130_fd_sc_hd__tapvpwrvgnd_1
X_08646_ net858 net1000 _02759_ _02760_ vssd1 vssd1 vccd1 vccd1 _02761_ sky130_fd_sc_hd__o2bb2a_1
XFILLER_0_68_307 vssd1 vssd1 vccd1 vccd1 sky130_fd_sc_hd__fill_1
XPHY_13 vssd1 vssd1 vccd1 vccd1 sky130_fd_sc_hd__decap_3
XTAP_1539 vssd1 vccd1 sky130_fd_sc_hd__tapvpwrvgnd_1
XTAP_1528 vssd1 vccd1 sky130_fd_sc_hd__tapvpwrvgnd_1
XTAP_1517 vssd1 vccd1 sky130_fd_sc_hd__tapvpwrvgnd_1
XFILLER_0_77_841 vssd1 vssd1 vccd1 vccd1 sky130_fd_sc_hd__fill_1
XPHY_24 vssd1 vssd1 vccd1 vccd1 sky130_fd_sc_hd__decap_3
XPHY_35 vssd1 vssd1 vccd1 vccd1 sky130_fd_sc_hd__decap_3
XPHY_46 vssd1 vssd1 vccd1 vccd1 sky130_fd_sc_hd__decap_3
X_08577_ _02554_ _02690_ _02691_ vssd1 vssd1 vccd1 vccd1 _02692_ sky130_fd_sc_hd__nand3_1
XFILLER_0_95_159 vssd1 vssd1 vccd1 vccd1 sky130_fd_sc_hd__decap_8
XPHY_57 vssd1 vssd1 vccd1 vccd1 sky130_fd_sc_hd__decap_3
XPHY_68 vssd1 vssd1 vccd1 vccd1 sky130_fd_sc_hd__decap_3
XPHY_79 vssd1 vssd1 vccd1 vccd1 sky130_fd_sc_hd__decap_3
X_07528_ _01617_ _01650_ _01651_ _01632_ _01636_ vssd1 vssd1 vccd1 vccd1 _01653_ sky130_fd_sc_hd__o311a_1
XFILLER_0_119_497 vssd1 vssd1 vccd1 vccd1 sky130_fd_sc_hd__decap_6
XFILLER_0_91_354 vssd1 vssd1 vccd1 vccd1 sky130_fd_sc_hd__decap_4
XFILLER_0_9_673 vssd1 vssd1 vccd1 vccd1 sky130_fd_sc_hd__fill_1
X_07459_ _01581_ _01583_ _01552_ vssd1 vssd1 vccd1 vccd1 _01584_ sky130_fd_sc_hd__a21o_1
XFILLER_0_36_259 vssd1 vssd1 vccd1 vccd1 sky130_fd_sc_hd__fill_1
X_10470_ net779 net999 net769 net992 vssd1 vssd1 vccd1 vccd1 _04573_ sky130_fd_sc_hd__nand4_2
XFILLER_0_8_194 vssd1 vssd1 vccd1 vccd1 sky130_fd_sc_hd__fill_2
X_09129_ _03237_ _03238_ _03078_ _03082_ vssd1 vssd1 vccd1 vccd1 _03241_ sky130_fd_sc_hd__o211a_1
XFILLER_0_60_730 vssd1 vssd1 vccd1 vccd1 sky130_fd_sc_hd__fill_1
XFILLER_0_32_421 vssd1 vssd1 vccd1 vccd1 sky130_fd_sc_hd__fill_1
X_12140_ x0mx2\[26\] net631 net592 y1my2\[26\] vssd1 vssd1 vccd1 vccd1 _06111_ sky130_fd_sc_hd__a22o_1
XFILLER_0_13_690 vssd1 vssd1 vccd1 vccd1 sky130_fd_sc_hd__decap_4
XFILLER_0_4_3 vssd1 vssd1 vccd1 vccd1 sky130_ef_sc_hd__decap_12
X_12071_ net1083 _06059_ net514 vssd1 vssd1 vccd1 vccd1 _00259_ sky130_fd_sc_hd__mux2_1
X_11022_ net789 net951 net946 net799 vssd1 vssd1 vccd1 vccd1 _05121_ sky130_fd_sc_hd__a22oi_1
X_12973_ clknet_leaf_30_clk_i _00359_ net1165 vssd1 vssd1 vccd1 vccd1 y1my2\[26\]
+ sky130_fd_sc_hd__dfrtp_1
X_11924_ net149 net659 net502 net245 _05947_ vssd1 vssd1 vccd1 vccd1 _05948_ sky130_fd_sc_hd__a221o_1
XFILLER_0_86_137 vssd1 vssd1 vccd1 vccd1 sky130_fd_sc_hd__decap_3
X_11855_ net106 net671 _05889_ _05891_ vssd1 vssd1 vccd1 vccd1 _05892_ sky130_fd_sc_hd__a211o_1
X_10806_ _04904_ _04905_ vssd1 vssd1 vccd1 vccd1 _04907_ sky130_fd_sc_hd__nor2_1
X_11786_ net223 net599 net579 net127 _05832_ vssd1 vssd1 vccd1 vccd1 _05833_ sky130_fd_sc_hd__a221o_1
X_10737_ net844 net934 net928 net853 vssd1 vssd1 vccd1 vccd1 _04838_ sky130_fd_sc_hd__a22o_1
XFILLER_0_103_69 vssd1 vssd1 vccd1 vccd1 sky130_ef_sc_hd__decap_12
XFILLER_0_82_376 vssd1 vssd1 vccd1 vccd1 sky130_fd_sc_hd__fill_1
XFILLER_0_113_629 vssd1 vssd1 vccd1 vccd1 sky130_ef_sc_hd__decap_12
XFILLER_0_88_27 vssd1 vssd1 vccd1 vccd1 sky130_fd_sc_hd__fill_1
X_10668_ _04619_ _04768_ vssd1 vssd1 vccd1 vccd1 _04770_ sky130_fd_sc_hd__xnor2_1
X_12407_ net1519 _00970_ net686 vssd1 vssd1 vccd1 vccd1 _00459_ sky130_fd_sc_hd__mux2_1
XFILLER_0_35_281 vssd1 vssd1 vccd1 vccd1 sky130_fd_sc_hd__fill_2
XFILLER_0_112_139 vssd1 vssd1 vccd1 vccd1 sky130_fd_sc_hd__fill_1
XFILLER_0_106_681 vssd1 vssd1 vccd1 vccd1 sky130_fd_sc_hd__decap_4
X_10599_ _04535_ _04539_ _04698_ vssd1 vssd1 vccd1 vccd1 _04701_ sky130_fd_sc_hd__nor3_2
XFILLER_0_2_348 vssd1 vssd1 vccd1 vccd1 sky130_fd_sc_hd__fill_1
XFILLER_0_50_273 vssd1 vssd1 vccd1 vccd1 sky130_fd_sc_hd__fill_1
X_12338_ net1641 _00940_ net671 vssd1 vssd1 vccd1 vccd1 _00390_ sky130_fd_sc_hd__mux2_1
XFILLER_0_121_673 vssd1 vssd1 vccd1 vccd1 sky130_ef_sc_hd__decap_12
X_12269_ net1357 net46 net690 vssd1 vssd1 vccd1 vccd1 _00323_ sky130_fd_sc_hd__mux2_1
XFILLER_0_128_77 vssd1 vssd1 vccd1 vccd1 sky130_fd_sc_hd__decap_6
X_06830_ net1338 net1324 net649 vssd1 vssd1 vccd1 vccd1 _00104_ sky130_fd_sc_hd__mux2_1
X_06761_ net1389 l1\[0\] net637 vssd1 vssd1 vccd1 vccd1 _00035_ sky130_fd_sc_hd__mux2_1
X_09480_ _03424_ _03466_ _03465_ vssd1 vssd1 vccd1 vccd1 _03589_ sky130_fd_sc_hd__a21bo_1
X_08500_ _02614_ _02615_ vssd1 vssd1 vccd1 vccd1 _02616_ sky130_fd_sc_hd__nand2_1
X_06692_ sub1.a_i\[21\] sub1.b_i\[21\] vssd1 vssd1 vccd1 vccd1 _00916_ sky130_fd_sc_hd__and2b_1
X_08431_ net1140 net734 _02430_ _02429_ vssd1 vssd1 vccd1 vccd1 _02547_ sky130_fd_sc_hd__a31o_1
XFILLER_0_77_126 vssd1 vssd1 vccd1 vccd1 sky130_fd_sc_hd__fill_1
XFILLER_0_59_841 vssd1 vssd1 vccd1 vccd1 sky130_fd_sc_hd__fill_1
XFILLER_0_53_63 vssd1 vssd1 vccd1 vccd1 sky130_fd_sc_hd__decap_3
XFILLER_0_53_41 vssd1 vssd1 vccd1 vccd1 sky130_fd_sc_hd__fill_2
X_08362_ _02477_ _02478_ _02470_ vssd1 vssd1 vccd1 vccd1 _02479_ sky130_fd_sc_hd__a21o_1
XFILLER_0_19_727 vssd1 vssd1 vccd1 vccd1 sky130_fd_sc_hd__fill_1
XFILLER_0_116_401 vssd1 vssd1 vccd1 vccd1 sky130_ef_sc_hd__decap_12
XFILLER_0_46_546 vssd1 vssd1 vccd1 vccd1 sky130_ef_sc_hd__decap_12
X_08293_ _02057_ _02164_ vssd1 vssd1 vccd1 vccd1 _02410_ sky130_fd_sc_hd__or2_1
XFILLER_0_18_237 vssd1 vssd1 vccd1 vccd1 sky130_fd_sc_hd__fill_2
X_07313_ _01287_ _01425_ _01424_ vssd1 vssd1 vccd1 vccd1 _01438_ sky130_fd_sc_hd__a21o_1
XFILLER_0_116_445 vssd1 vssd1 vccd1 vccd1 sky130_ef_sc_hd__decap_12
XFILLER_0_61_505 vssd1 vssd1 vccd1 vccd1 sky130_fd_sc_hd__decap_3
X_07244_ net882 net1057 vssd1 vssd1 vccd1 vccd1 _01369_ sky130_fd_sc_hd__nand2_1
XFILLER_0_27_782 vssd1 vssd1 vccd1 vccd1 sky130_fd_sc_hd__fill_2
XFILLER_0_116_489 vssd1 vssd1 vccd1 vccd1 sky130_ef_sc_hd__decap_12
XFILLER_0_82_3 vssd1 vssd1 vccd1 vccd1 sky130_ef_sc_hd__decap_12
X_07175_ net854 net1126 _01298_ _01296_ vssd1 vssd1 vccd1 vccd1 _01300_ sky130_fd_sc_hd__a31o_1
XFILLER_0_42_752 vssd1 vssd1 vccd1 vccd1 sky130_fd_sc_hd__decap_4
XFILLER_0_111_161 vssd1 vssd1 vccd1 vccd1 sky130_fd_sc_hd__decap_6
X_09816_ _03918_ _03921_ vssd1 vssd1 vccd1 vccd1 _03923_ sky130_fd_sc_hd__xor2_1
X_09747_ _03697_ _03698_ vssd1 vssd1 vccd1 vccd1 _03855_ sky130_fd_sc_hd__nand2_2
X_06959_ _01074_ _01076_ _01075_ vssd1 vssd1 vccd1 vccd1 _01084_ sky130_fd_sc_hd__o21bai_1
XTAP_2015 vssd1 vccd1 sky130_fd_sc_hd__tapvpwrvgnd_1
XTAP_2004 vssd1 vccd1 sky130_fd_sc_hd__tapvpwrvgnd_1
XTAP_2059 vssd1 vccd1 sky130_fd_sc_hd__tapvpwrvgnd_1
XTAP_2048 vssd1 vccd1 sky130_fd_sc_hd__tapvpwrvgnd_1
XTAP_2037 vssd1 vccd1 sky130_fd_sc_hd__tapvpwrvgnd_1
XTAP_2026 vssd1 vccd1 sky130_fd_sc_hd__tapvpwrvgnd_1
X_09678_ _03774_ _03784_ _03785_ vssd1 vssd1 vccd1 vccd1 _03786_ sky130_fd_sc_hd__and3b_1
XTAP_1314 vssd1 vccd1 sky130_fd_sc_hd__tapvpwrvgnd_1
XTAP_1303 vssd1 vccd1 sky130_fd_sc_hd__tapvpwrvgnd_1
X_08629_ net1024 net832 _02742_ _02743_ vssd1 vssd1 vccd1 vccd1 _02744_ sky130_fd_sc_hd__o2bb2a_1
XTAP_1347 vssd1 vccd1 sky130_fd_sc_hd__tapvpwrvgnd_1
XTAP_1336 vssd1 vccd1 sky130_fd_sc_hd__tapvpwrvgnd_1
XTAP_1325 vssd1 vccd1 sky130_fd_sc_hd__tapvpwrvgnd_1
XFILLER_0_77_671 vssd1 vssd1 vccd1 vccd1 sky130_fd_sc_hd__fill_1
XTAP_1369 vssd1 vccd1 sky130_fd_sc_hd__tapvpwrvgnd_1
XTAP_1358 vssd1 vccd1 sky130_fd_sc_hd__tapvpwrvgnd_1
XFILLER_0_49_373 vssd1 vssd1 vccd1 vccd1 sky130_fd_sc_hd__fill_2
X_11640_ _05732_ _05733_ vssd1 vssd1 vccd1 vccd1 _05734_ sky130_fd_sc_hd__xnor2_1
XFILLER_0_37_502 vssd1 vssd1 vccd1 vccd1 sky130_fd_sc_hd__fill_2
XFILLER_0_37_513 vssd1 vssd1 vccd1 vccd1 sky130_fd_sc_hd__fill_2
XFILLER_0_119_261 vssd1 vssd1 vccd1 vccd1 sky130_ef_sc_hd__decap_12
XFILLER_0_92_630 vssd1 vssd1 vccd1 vccd1 sky130_fd_sc_hd__fill_1
X_11571_ _05554_ _05556_ vssd1 vssd1 vccd1 vccd1 _05666_ sky130_fd_sc_hd__or2_1
XFILLER_0_37_535 vssd1 vssd1 vccd1 vccd1 sky130_fd_sc_hd__fill_1
XFILLER_0_107_434 vssd1 vssd1 vccd1 vccd1 sky130_fd_sc_hd__fill_2
XFILLER_0_107_423 vssd1 vssd1 vccd1 vccd1 sky130_fd_sc_hd__decap_3
X_10522_ _04622_ _04623_ vssd1 vssd1 vccd1 vccd1 _04625_ sky130_fd_sc_hd__xnor2_1
XFILLER_0_91_184 vssd1 vssd1 vccd1 vccd1 sky130_fd_sc_hd__decap_8
X_10453_ _04553_ _04554_ _04454_ _04455_ vssd1 vssd1 vccd1 vccd1 _04556_ sky130_fd_sc_hd__a211o_1
XFILLER_0_60_560 vssd1 vssd1 vccd1 vccd1 sky130_fd_sc_hd__fill_1
X_10384_ net785 net991 vssd1 vssd1 vccd1 vccd1 _04488_ sky130_fd_sc_hd__nand2_1
XFILLER_0_60_571 vssd1 vssd1 vccd1 vccd1 sky130_fd_sc_hd__decap_4
X_13172_ clknet_leaf_22_clk_i _00558_ net1176 vssd1 vssd1 vccd1 vccd1 l1\[1\] sky130_fd_sc_hd__dfrtp_1
XFILLER_0_103_673 vssd1 vssd1 vccd1 vccd1 sky130_ef_sc_hd__decap_12
X_12123_ net982 _06098_ net519 vssd1 vssd1 vccd1 vccd1 _00272_ sky130_fd_sc_hd__mux2_1
X_12054_ _00828_ _05752_ _06032_ _06046_ vssd1 vssd1 vccd1 vccd1 _06047_ sky130_fd_sc_hd__a31o_1
XFILLER_0_74_29 vssd1 vssd1 vccd1 vccd1 sky130_ef_sc_hd__decap_12
X_11005_ net996 net735 _05102_ _05103_ vssd1 vssd1 vccd1 vccd1 _05104_ sky130_fd_sc_hd__nand4_2
Xfanout890 net891 vssd1 vssd1 vccd1 vccd1 net890 sky130_fd_sc_hd__clkbuf_4
XFILLER_0_87_402 vssd1 vssd1 vccd1 vccd1 sky130_fd_sc_hd__fill_2
XFILLER_0_99_295 vssd1 vssd1 vccd1 vccd1 sky130_ef_sc_hd__decap_12
XFILLER_0_59_126 vssd1 vssd1 vccd1 vccd1 sky130_fd_sc_hd__fill_2
X_12956_ clknet_leaf_53_clk_i _00342_ net1155 vssd1 vssd1 vccd1 vccd1 y1my2\[9\] sky130_fd_sc_hd__dfrtp_1
XFILLER_0_87_457 vssd1 vssd1 vccd1 vccd1 sky130_fd_sc_hd__fill_1
X_11907_ net13 net549 net624 net197 _05934_ vssd1 vssd1 vccd1 vccd1 _05935_ sky130_fd_sc_hd__a221o_1
X_12887_ clknet_leaf_32_clk_i _00273_ vssd1 vssd1 vccd1 vccd1 mul1.a\[22\] sky130_fd_sc_hd__dfxtp_2
XTAP_1870 vssd1 vccd1 sky130_fd_sc_hd__tapvpwrvgnd_1
XFILLER_0_56_811 vssd1 vssd1 vccd1 vccd1 sky130_fd_sc_hd__fill_1
X_11838_ temp1\[22\] net615 net610 net200 vssd1 vssd1 vccd1 vccd1 _05877_ sky130_fd_sc_hd__a22o_1
XFILLER_0_23_55 vssd1 vssd1 vccd1 vccd1 sky130_fd_sc_hd__fill_1
XTAP_1892 vssd1 vccd1 sky130_fd_sc_hd__tapvpwrvgnd_1
XTAP_1881 vssd1 vccd1 sky130_fd_sc_hd__tapvpwrvgnd_1
XFILLER_0_7_418 vssd1 vssd1 vccd1 vccd1 sky130_fd_sc_hd__fill_1
XFILLER_0_23_77 vssd1 vssd1 vccd1 vccd1 sky130_fd_sc_hd__fill_2
XFILLER_0_99_15 vssd1 vssd1 vccd1 vccd1 sky130_ef_sc_hd__decap_12
XFILLER_0_43_516 vssd1 vssd1 vccd1 vccd1 sky130_ef_sc_hd__decap_12
X_11769_ net652 _00867_ net474 _05818_ vssd1 vssd1 vccd1 vccd1 _05819_ sky130_fd_sc_hd__a211o_1
XFILLER_0_15_207 vssd1 vssd1 vccd1 vccd1 sky130_fd_sc_hd__fill_1
XFILLER_0_82_195 vssd1 vssd1 vccd1 vccd1 sky130_fd_sc_hd__fill_1
XFILLER_0_82_184 vssd1 vssd1 vccd1 vccd1 sky130_fd_sc_hd__decap_3
XFILLER_0_130_89 vssd1 vssd1 vccd1 vccd1 sky130_fd_sc_hd__fill_1
XFILLER_0_100_109 vssd1 vssd1 vccd1 vccd1 sky130_fd_sc_hd__decap_6
X_08980_ _02944_ _02946_ _03091_ _03092_ vssd1 vssd1 vccd1 vccd1 _03093_ sky130_fd_sc_hd__o211a_1
X_07931_ _02049_ _02050_ _02051_ vssd1 vssd1 vccd1 vccd1 _02052_ sky130_fd_sc_hd__and3_1
XFILLER_0_48_63 vssd1 vssd1 vccd1 vccd1 sky130_fd_sc_hd__fill_1
X_07862_ _01870_ _01872_ _01982_ vssd1 vssd1 vccd1 vccd1 _01983_ sky130_fd_sc_hd__o21a_1
X_06813_ net1401 l0\[20\] net645 vssd1 vssd1 vccd1 vccd1 _00087_ sky130_fd_sc_hd__mux2_1
X_09601_ net923 net915 net926 vssd1 vssd1 vccd1 vccd1 _03710_ sky130_fd_sc_hd__and3_1
X_09532_ net1039 net777 net767 net1047 vssd1 vssd1 vccd1 vccd1 _03641_ sky130_fd_sc_hd__a22o_1
X_07793_ net912 net1001 net994 net920 vssd1 vssd1 vccd1 vccd1 _01915_ sky130_fd_sc_hd__a22o_1
XFILLER_0_3_98 vssd1 vssd1 vccd1 vccd1 sky130_fd_sc_hd__fill_2
X_06744_ net1350 _00960_ net636 vssd1 vssd1 vccd1 vccd1 _00031_ sky130_fd_sc_hd__mux2_1
X_09463_ _03408_ _03410_ _03571_ _03572_ vssd1 vssd1 vccd1 vccd1 _03573_ sky130_fd_sc_hd__o211ai_2
X_06675_ _00888_ _00891_ _00895_ _00901_ _00894_ vssd1 vssd1 vccd1 vccd1 _00902_ sky130_fd_sc_hd__a311o_2
X_09394_ _03353_ _03356_ vssd1 vssd1 vccd1 vccd1 _03504_ sky130_fd_sc_hd__nand2_1
X_08414_ _02527_ _02529_ _02427_ vssd1 vssd1 vccd1 vccd1 _02531_ sky130_fd_sc_hd__a21oi_1
XFILLER_0_108_209 vssd1 vssd1 vccd1 vccd1 sky130_fd_sc_hd__decap_6
X_08345_ _02460_ _02461_ _02322_ _02325_ vssd1 vssd1 vccd1 vccd1 _02462_ sky130_fd_sc_hd__a211o_1
XFILLER_0_58_192 vssd1 vssd1 vccd1 vccd1 sky130_fd_sc_hd__decap_4
XFILLER_0_116_253 vssd1 vssd1 vccd1 vccd1 sky130_ef_sc_hd__decap_12
X_08276_ _02391_ _02392_ _02291_ vssd1 vssd1 vccd1 vccd1 _02394_ sky130_fd_sc_hd__a21o_1
XFILLER_0_61_313 vssd1 vssd1 vccd1 vccd1 sky130_fd_sc_hd__decap_8
XFILLER_0_34_549 vssd1 vssd1 vccd1 vccd1 sky130_fd_sc_hd__fill_1
X_07227_ _01350_ _01351_ _01345_ vssd1 vssd1 vccd1 vccd1 _01352_ sky130_fd_sc_hd__a21o_1
XFILLER_0_104_448 vssd1 vssd1 vccd1 vccd1 sky130_fd_sc_hd__fill_1
XFILLER_0_14_273 vssd1 vssd1 vccd1 vccd1 sky130_fd_sc_hd__decap_4
X_07158_ net1095 _01018_ _01282_ vssd1 vssd1 vccd1 vccd1 _01283_ sky130_fd_sc_hd__a21bo_1
Xclkbuf_leaf_0_clk_i clknet_3_3__leaf_clk_i vssd1 vssd1 vccd1 vccd1 clknet_leaf_0_clk_i
+ sky130_fd_sc_hd__clkbuf_16
X_07089_ net1049 _01213_ _01212_ vssd1 vssd1 vccd1 vccd1 _01214_ sky130_fd_sc_hd__a21bo_1
Xfanout1107 net1110 vssd1 vssd1 vccd1 vccd1 net1107 sky130_fd_sc_hd__clkbuf_4
XFILLER_0_100_654 vssd1 vssd1 vccd1 vccd1 sky130_ef_sc_hd__decap_12
Xfanout1129 net1130 vssd1 vssd1 vccd1 vccd1 net1129 sky130_fd_sc_hd__clkbuf_4
Xfanout1118 net1120 vssd1 vssd1 vccd1 vccd1 net1118 sky130_fd_sc_hd__buf_2
XFILLER_0_100_698 vssd1 vssd1 vccd1 vccd1 sky130_fd_sc_hd__fill_2
X_12810_ clknet_leaf_54_clk_i _00196_ vssd1 vssd1 vccd1 vccd1 sub1.a_i\[9\] sky130_fd_sc_hd__dfxtp_2
XFILLER_0_69_413 vssd1 vssd1 vccd1 vccd1 sky130_fd_sc_hd__decap_4
XTAP_1122 vssd1 vccd1 sky130_fd_sc_hd__tapvpwrvgnd_1
XTAP_1111 vssd1 vccd1 sky130_fd_sc_hd__tapvpwrvgnd_1
XTAP_1100 vssd1 vccd1 sky130_fd_sc_hd__tapvpwrvgnd_1
X_12741_ clknet_leaf_0_clk_i _00127_ vssd1 vssd1 vccd1 vccd1 add1.a_i\[4\] sky130_fd_sc_hd__dfxtp_1
XFILLER_0_96_287 vssd1 vssd1 vccd1 vccd1 sky130_ef_sc_hd__decap_12
X_12672_ clknet_leaf_20_clk_i _00058_ net1179 vssd1 vssd1 vccd1 vccd1 net400 sky130_fd_sc_hd__dfrtp_1
XTAP_1155 vssd1 vccd1 sky130_fd_sc_hd__tapvpwrvgnd_1
XTAP_1144 vssd1 vccd1 sky130_fd_sc_hd__tapvpwrvgnd_1
XTAP_1133 vssd1 vccd1 sky130_fd_sc_hd__tapvpwrvgnd_1
XTAP_1199 vssd1 vccd1 sky130_fd_sc_hd__tapvpwrvgnd_1
XTAP_1188 vssd1 vccd1 sky130_fd_sc_hd__tapvpwrvgnd_1
XTAP_1166 vssd1 vccd1 sky130_fd_sc_hd__tapvpwrvgnd_1
XTAP_1177 vssd1 vccd1 sky130_fd_sc_hd__tapvpwrvgnd_1
X_11623_ net782 net934 vssd1 vssd1 vccd1 vccd1 _05717_ sky130_fd_sc_hd__nand2_1
XFILLER_0_52_302 vssd1 vssd1 vccd1 vccd1 sky130_fd_sc_hd__decap_6
XFILLER_0_25_516 vssd1 vssd1 vccd1 vccd1 sky130_fd_sc_hd__fill_2
XFILLER_0_108_754 vssd1 vssd1 vccd1 vccd1 sky130_fd_sc_hd__fill_2
X_11554_ _05629_ _05646_ _05647_ vssd1 vssd1 vccd1 vccd1 _05649_ sky130_fd_sc_hd__nor3_1
X_10505_ _04605_ _04606_ _04468_ _04506_ vssd1 vssd1 vccd1 vccd1 _04608_ sky130_fd_sc_hd__a211oi_2
X_11485_ _05578_ _05579_ vssd1 vssd1 vccd1 vccd1 _05580_ sky130_fd_sc_hd__xor2_1
X_13224_ net507 vssd1 vssd1 vccd1 vccd1 net279 sky130_fd_sc_hd__clkbuf_1
XFILLER_0_122_245 vssd1 vssd1 vccd1 vccd1 sky130_fd_sc_hd__decap_6
XFILLER_0_100_15 vssd1 vssd1 vccd1 vccd1 sky130_ef_sc_hd__decap_12
X_10436_ _04530_ _04536_ _04537_ vssd1 vssd1 vccd1 vccd1 _04539_ sky130_fd_sc_hd__and3_2
XFILLER_0_122_289 vssd1 vssd1 vccd1 vccd1 sky130_ef_sc_hd__decap_12
XFILLER_0_110_429 vssd1 vssd1 vccd1 vccd1 sky130_fd_sc_hd__fill_2
X_13155_ clknet_leaf_12_clk_i _00541_ net1187 vssd1 vssd1 vccd1 vccd1 l0\[16\] sky130_fd_sc_hd__dfrtp_1
X_10367_ net1022 net1029 net744 vssd1 vssd1 vccd1 vccd1 _04471_ sky130_fd_sc_hd__and3_1
XTAP_906 vssd1 vccd1 sky130_fd_sc_hd__tapvpwrvgnd_1
XTAP_917 vssd1 vccd1 sky130_fd_sc_hd__tapvpwrvgnd_1
X_10298_ _04249_ _04251_ vssd1 vssd1 vccd1 vccd1 _04402_ sky130_fd_sc_hd__nand2_1
X_13086_ clknet_leaf_1_clk_i _00472_ vssd1 vssd1 vccd1 vccd1 temp1\[11\] sky130_fd_sc_hd__dfxtp_1
XTAP_939 vssd1 vccd1 sky130_fd_sc_hd__tapvpwrvgnd_1
XTAP_928 vssd1 vccd1 sky130_fd_sc_hd__tapvpwrvgnd_1
X_12106_ _00897_ _06085_ net501 vssd1 vssd1 vccd1 vccd1 _06086_ sky130_fd_sc_hd__mux2_1
XFILLER_0_109_57 vssd1 vssd1 vccd1 vccd1 sky130_ef_sc_hd__decap_12
X_12037_ _05752_ _06032_ vssd1 vssd1 vccd1 vccd1 _06034_ sky130_fd_sc_hd__nand2_1
XFILLER_0_18_77 vssd1 vssd1 vccd1 vccd1 sky130_fd_sc_hd__decap_6
X_12939_ clknet_leaf_10_clk_i _00325_ net1192 vssd1 vssd1 vccd1 vccd1 posy\[1\] sky130_fd_sc_hd__dfrtp_1
X_06460_ _00752_ _00753_ _00751_ vssd1 vssd1 vccd1 vccd1 _00758_ sky130_fd_sc_hd__o21a_1
XFILLER_0_47_107 vssd1 vssd1 vccd1 vccd1 sky130_fd_sc_hd__decap_4
X_08130_ _02245_ _02246_ _02247_ vssd1 vssd1 vccd1 vccd1 _02249_ sky130_fd_sc_hd__nand3_1
X_06391_ _00697_ _00698_ vssd1 vssd1 vccd1 vccd1 _00699_ sky130_fd_sc_hd__xor2_4
XFILLER_0_28_343 vssd1 vssd1 vccd1 vccd1 sky130_fd_sc_hd__fill_2
XFILLER_0_83_471 vssd1 vssd1 vccd1 vccd1 sky130_fd_sc_hd__decap_6
XFILLER_0_71_633 vssd1 vssd1 vccd1 vccd1 sky130_fd_sc_hd__fill_1
XFILLER_0_55_173 vssd1 vssd1 vccd1 vccd1 sky130_fd_sc_hd__fill_1
XFILLER_0_114_746 vssd1 vssd1 vccd1 vccd1 sky130_fd_sc_hd__fill_1
X_08061_ net1114 net772 net763 net1122 vssd1 vssd1 vccd1 vccd1 _02180_ sky130_fd_sc_hd__a22o_1
XFILLER_0_71_655 vssd1 vssd1 vccd1 vccd1 sky130_fd_sc_hd__fill_1
XFILLER_0_114_757 vssd1 vssd1 vccd1 vccd1 sky130_fd_sc_hd__fill_2
XFILLER_0_113_223 vssd1 vssd1 vccd1 vccd1 sky130_fd_sc_hd__fill_1
X_07012_ _01136_ vssd1 vssd1 vccd1 vccd1 _01137_ sky130_fd_sc_hd__inv_2
XFILLER_0_59_40 vssd1 vssd1 vccd1 vccd1 sky130_fd_sc_hd__decap_8
XFILLER_0_59_73 vssd1 vssd1 vccd1 vccd1 sky130_fd_sc_hd__decap_4
X_08963_ _03066_ _03073_ _03074_ vssd1 vssd1 vccd1 vccd1 _03076_ sky130_fd_sc_hd__nand3_2
X_07914_ _02016_ _02033_ _02034_ vssd1 vssd1 vccd1 vccd1 _02035_ sky130_fd_sc_hd__and3_1
X_08894_ _02998_ _03006_ vssd1 vssd1 vccd1 vccd1 _03007_ sky130_fd_sc_hd__nand2_1
X_07845_ net795 _01863_ _01864_ _01861_ vssd1 vssd1 vccd1 vccd1 _01966_ sky130_fd_sc_hd__o2bb2ai_1
XFILLER_0_78_221 vssd1 vssd1 vccd1 vccd1 sky130_fd_sc_hd__decap_6
X_07776_ _01808_ _01810_ vssd1 vssd1 vccd1 vccd1 _01898_ sky130_fd_sc_hd__nand2_1
X_09515_ _03621_ _03622_ _03611_ vssd1 vssd1 vccd1 vccd1 _03624_ sky130_fd_sc_hd__a21oi_1
X_06727_ _00943_ _00945_ vssd1 vssd1 vccd1 vccd1 _00946_ sky130_fd_sc_hd__xnor2_4
XPHY_216 vssd1 vssd1 vccd1 vccd1 sky130_fd_sc_hd__decap_3
XPHY_205 vssd1 vssd1 vccd1 vccd1 sky130_fd_sc_hd__decap_3
XFILLER_0_94_725 vssd1 vssd1 vccd1 vccd1 sky130_ef_sc_hd__decap_12
XFILLER_0_93_213 vssd1 vssd1 vccd1 vccd1 sky130_fd_sc_hd__fill_1
X_09446_ _03389_ _03393_ _03553_ _03554_ vssd1 vssd1 vccd1 vccd1 _03556_ sky130_fd_sc_hd__a211oi_4
XPHY_249 vssd1 vssd1 vccd1 vccd1 sky130_fd_sc_hd__decap_3
XPHY_238 vssd1 vssd1 vccd1 vccd1 sky130_fd_sc_hd__decap_3
XPHY_227 vssd1 vssd1 vccd1 vccd1 sky130_fd_sc_hd__decap_3
XFILLER_0_59_490 vssd1 vssd1 vccd1 vccd1 sky130_fd_sc_hd__decap_3
X_06658_ net1726 _00887_ net634 vssd1 vssd1 vccd1 vccd1 _00018_ sky130_fd_sc_hd__mux2_1
X_09377_ net1017 net810 net802 net1009 vssd1 vssd1 vccd1 vccd1 _03487_ sky130_fd_sc_hd__nand4_1
X_06589_ sub1.a_i\[5\] sub1.b_i\[5\] vssd1 vssd1 vccd1 vccd1 _00829_ sky130_fd_sc_hd__and2b_1
X_08328_ net1075 net796 net787 net1084 vssd1 vssd1 vccd1 vccd1 _02445_ sky130_fd_sc_hd__a22o_1
XFILLER_0_46_184 vssd1 vssd1 vccd1 vccd1 sky130_ef_sc_hd__decap_12
XFILLER_0_117_573 vssd1 vssd1 vccd1 vccd1 sky130_ef_sc_hd__decap_12
XFILLER_0_105_724 vssd1 vssd1 vccd1 vccd1 sky130_fd_sc_hd__decap_4
XFILLER_0_104_212 vssd1 vssd1 vccd1 vccd1 sky130_fd_sc_hd__fill_2
X_08259_ _02373_ _02374_ _02375_ vssd1 vssd1 vccd1 vccd1 _02377_ sky130_fd_sc_hd__a21o_1
XFILLER_0_61_198 vssd1 vssd1 vccd1 vccd1 sky130_fd_sc_hd__decap_6
X_11270_ _05365_ _05366_ vssd1 vssd1 vccd1 vccd1 _05367_ sky130_fd_sc_hd__xnor2_1
XFILLER_0_120_749 vssd1 vssd1 vccd1 vccd1 sky130_fd_sc_hd__decap_6
X_10221_ _04324_ _04325_ _04317_ vssd1 vssd1 vccd1 vccd1 _04326_ sky130_fd_sc_hd__a21o_1
X_10152_ _04245_ _04255_ _04256_ vssd1 vssd1 vccd1 vccd1 _04257_ sky130_fd_sc_hd__and3_2
Xoutput290 net290 vssd1 vssd1 vccd1 vccd1 div_mstream_o[44] sky130_fd_sc_hd__clkbuf_4
X_10083_ _04188_ _04187_ _04186_ vssd1 vssd1 vccd1 vccd1 _04189_ sky130_fd_sc_hd__nand3b_1
Xhold9 l0\[26\] vssd1 vssd1 vccd1 vccd1 net1224 sky130_fd_sc_hd__dlygate4sd3_1
X_12724_ clknet_leaf_8_clk_i net1491 net1194 vssd1 vssd1 vccd1 vccd1 net343 sky130_fd_sc_hd__dfrtp_1
XFILLER_0_85_714 vssd1 vssd1 vccd1 vccd1 sky130_ef_sc_hd__decap_12
X_10985_ net816 net935 net930 net824 vssd1 vssd1 vccd1 vccd1 _05084_ sky130_fd_sc_hd__a22oi_1
XFILLER_0_57_449 vssd1 vssd1 vccd1 vccd1 sky130_fd_sc_hd__decap_4
XFILLER_0_84_279 vssd1 vssd1 vccd1 vccd1 sky130_fd_sc_hd__fill_2
XFILLER_0_72_408 vssd1 vssd1 vccd1 vccd1 sky130_ef_sc_hd__decap_12
X_12655_ clknet_leaf_21_clk_i net1584 net1175 vssd1 vssd1 vccd1 vccd1 net381 sky130_fd_sc_hd__dfrtp_1
XFILLER_0_37_151 vssd1 vssd1 vccd1 vccd1 sky130_ef_sc_hd__decap_12
XFILLER_0_127_359 vssd1 vssd1 vccd1 vccd1 sky130_fd_sc_hd__fill_2
X_11606_ _05575_ _05583_ _05581_ vssd1 vssd1 vccd1 vccd1 _05700_ sky130_fd_sc_hd__o21a_1
X_12586_ net1398 net29 net554 vssd1 vssd1 vccd1 vccd1 _00561_ sky130_fd_sc_hd__mux2_1
XFILLER_0_108_584 vssd1 vssd1 vccd1 vccd1 sky130_fd_sc_hd__decap_4
XFILLER_0_92_290 vssd1 vssd1 vccd1 vccd1 sky130_fd_sc_hd__decap_6
XFILLER_0_52_121 vssd1 vssd1 vccd1 vccd1 sky130_fd_sc_hd__fill_1
X_11537_ _05465_ _05467_ vssd1 vssd1 vccd1 vccd1 _05632_ sky130_fd_sc_hd__nor2_1
XFILLER_0_111_69 vssd1 vssd1 vccd1 vccd1 sky130_ef_sc_hd__decap_12
XFILLER_0_80_496 vssd1 vssd1 vccd1 vccd1 sky130_fd_sc_hd__decap_8
XFILLER_0_80_474 vssd1 vssd1 vccd1 vccd1 sky130_fd_sc_hd__fill_2
XFILLER_0_53_688 vssd1 vssd1 vccd1 vccd1 sky130_fd_sc_hd__fill_1
Xhold409 sub1.a_i\[16\] vssd1 vssd1 vccd1 vccd1 net1624 sky130_fd_sc_hd__dlygate4sd3_1
XFILLER_0_111_727 vssd1 vssd1 vccd1 vccd1 sky130_fd_sc_hd__fill_1
X_11468_ temp1\[29\] _05563_ net542 vssd1 vssd1 vccd1 vccd1 _05564_ sky130_fd_sc_hd__mux2_1
XFILLER_0_0_413 vssd1 vssd1 vccd1 vccd1 sky130_fd_sc_hd__fill_1
XFILLER_0_21_541 vssd1 vssd1 vccd1 vccd1 sky130_fd_sc_hd__fill_2
XFILLER_0_96_27 vssd1 vssd1 vccd1 vccd1 sky130_fd_sc_hd__fill_1
X_10419_ _04369_ _04371_ _04520_ vssd1 vssd1 vccd1 vccd1 _04523_ sky130_fd_sc_hd__and3_1
XFILLER_0_0_435 vssd1 vssd1 vccd1 vccd1 sky130_fd_sc_hd__fill_2
X_11399_ _05480_ _05493_ vssd1 vssd1 vccd1 vccd1 _05495_ sky130_fd_sc_hd__nor2_1
X_13138_ clknet_3_6__leaf_clk_i _00524_ vssd1 vssd1 vccd1 vccd1 det_t\[31\] sky130_fd_sc_hd__dfxtp_1
XTAP_703 vssd1 vccd1 sky130_fd_sc_hd__tapvpwrvgnd_1
XFILLER_0_29_32 vssd1 vssd1 vccd1 vccd1 sky130_fd_sc_hd__fill_2
XTAP_714 vssd1 vccd1 sky130_fd_sc_hd__tapvpwrvgnd_1
XTAP_725 vssd1 vccd1 sky130_fd_sc_hd__tapvpwrvgnd_1
XTAP_736 vssd1 vccd1 sky130_fd_sc_hd__tapvpwrvgnd_1
XTAP_747 vssd1 vccd1 sky130_fd_sc_hd__tapvpwrvgnd_1
XTAP_758 vssd1 vccd1 sky130_fd_sc_hd__tapvpwrvgnd_1
X_13069_ clknet_leaf_31_clk_i _00455_ net1168 vssd1 vssd1 vccd1 vccd1 y2my0\[26\]
+ sky130_fd_sc_hd__dfrtp_1
XTAP_769 vssd1 vccd1 sky130_fd_sc_hd__tapvpwrvgnd_1
XFILLER_0_45_53 vssd1 vssd1 vccd1 vccd1 sky130_fd_sc_hd__decap_3
X_07630_ _01752_ _01753_ vssd1 vssd1 vccd1 vccd1 _01754_ sky130_fd_sc_hd__nand2b_1
X_07561_ net1105 net1113 net820 net813 vssd1 vssd1 vccd1 vccd1 _01685_ sky130_fd_sc_hd__and4_1
X_06512_ det_t\[22\] net529 vssd1 vssd1 vccd1 vccd1 net266 sky130_fd_sc_hd__and2_1
X_09300_ _03408_ _03409_ _03266_ vssd1 vssd1 vccd1 vccd1 _03411_ sky130_fd_sc_hd__o21a_1
XFILLER_0_119_827 vssd1 vssd1 vccd1 vccd1 sky130_fd_sc_hd__fill_1
X_07492_ _01609_ _01610_ vssd1 vssd1 vccd1 vccd1 _01617_ sky130_fd_sc_hd__xor2_1
XFILLER_0_75_279 vssd1 vssd1 vccd1 vccd1 sky130_fd_sc_hd__fill_1
X_09231_ _03209_ _03216_ _03215_ vssd1 vssd1 vccd1 vccd1 _03342_ sky130_fd_sc_hd__a21o_1
XFILLER_0_63_419 vssd1 vssd1 vccd1 vccd1 sky130_fd_sc_hd__decap_6
X_06443_ _00742_ _00743_ vssd1 vssd1 vccd1 vccd1 _00744_ sky130_fd_sc_hd__or2_4
X_09162_ _03117_ _03119_ vssd1 vssd1 vccd1 vccd1 _03273_ sky130_fd_sc_hd__or2_1
X_06374_ add1.a_i\[15\] add1.b_i\[15\] vssd1 vssd1 vccd1 vccd1 _00684_ sky130_fd_sc_hd__nand2_1
XFILLER_0_44_611 vssd1 vssd1 vccd1 vccd1 sky130_fd_sc_hd__decap_6
X_08113_ net1033 net857 _02230_ _02231_ vssd1 vssd1 vccd1 vccd1 _02232_ sky130_fd_sc_hd__a22o_1
XFILLER_0_44_666 vssd1 vssd1 vccd1 vccd1 sky130_fd_sc_hd__decap_8
XFILLER_0_28_195 vssd1 vssd1 vccd1 vccd1 sky130_fd_sc_hd__fill_1
X_09093_ _03058_ _03060_ _03204_ vssd1 vssd1 vccd1 vccd1 _03205_ sky130_fd_sc_hd__o21a_2
XFILLER_0_4_741 vssd1 vssd1 vccd1 vccd1 sky130_fd_sc_hd__fill_2
XFILLER_0_114_587 vssd1 vssd1 vccd1 vccd1 sky130_fd_sc_hd__fill_1
X_08044_ _02162_ _02163_ vssd1 vssd1 vccd1 vccd1 _02164_ sky130_fd_sc_hd__xor2_2
X_09995_ _04099_ _04100_ _04092_ vssd1 vssd1 vccd1 vccd1 _04101_ sky130_fd_sc_hd__a21o_1
X_08946_ _03052_ _03057_ vssd1 vssd1 vccd1 vccd1 _03059_ sky130_fd_sc_hd__xnor2_2
X_08877_ _02987_ net465 _02882_ _02886_ vssd1 vssd1 vccd1 vccd1 _02990_ sky130_fd_sc_hd__o211a_1
XFILLER_0_98_338 vssd1 vssd1 vccd1 vccd1 sky130_fd_sc_hd__decap_4
X_07828_ _01752_ _01753_ _01850_ _01403_ vssd1 vssd1 vccd1 vccd1 _01950_ sky130_fd_sc_hd__and4b_1
XFILLER_0_79_541 vssd1 vssd1 vccd1 vccd1 sky130_fd_sc_hd__decap_3
X_07759_ net1091 net822 net814 net1098 vssd1 vssd1 vccd1 vccd1 _01881_ sky130_fd_sc_hd__a22o_1
X_10770_ _04869_ _04870_ vssd1 vssd1 vccd1 vccd1 _04871_ sky130_fd_sc_hd__and2_1
XFILLER_0_109_315 vssd1 vssd1 vccd1 vccd1 sky130_fd_sc_hd__fill_1
XFILLER_0_81_205 vssd1 vssd1 vccd1 vccd1 sky130_fd_sc_hd__fill_2
X_09429_ _03535_ _03538_ vssd1 vssd1 vccd1 vccd1 _03539_ sky130_fd_sc_hd__xor2_1
XFILLER_0_54_419 vssd1 vssd1 vccd1 vccd1 sky130_fd_sc_hd__fill_1
XFILLER_0_109_348 vssd1 vssd1 vccd1 vccd1 sky130_fd_sc_hd__fill_1
XFILLER_0_81_216 vssd1 vssd1 vccd1 vccd1 sky130_fd_sc_hd__decap_8
XFILLER_0_47_471 vssd1 vssd1 vccd1 vccd1 sky130_fd_sc_hd__decap_4
XFILLER_0_35_622 vssd1 vssd1 vccd1 vccd1 sky130_fd_sc_hd__fill_2
X_12440_ temp1\[14\] _06212_ net571 vssd1 vssd1 vccd1 vccd1 _00475_ sky130_fd_sc_hd__mux2_1
X_12371_ net1443 _00946_ net661 vssd1 vssd1 vccd1 vccd1 _00423_ sky130_fd_sc_hd__mux2_1
Xclkbuf_leaf_33_clk_i clknet_3_4__leaf_clk_i vssd1 vssd1 vccd1 vccd1 clknet_leaf_33_clk_i
+ sky130_fd_sc_hd__clkbuf_16
XFILLER_0_23_839 vssd1 vssd1 vccd1 vccd1 sky130_fd_sc_hd__fill_1
XFILLER_0_34_154 vssd1 vssd1 vccd1 vccd1 sky130_fd_sc_hd__decap_3
XFILLER_0_120_513 vssd1 vssd1 vccd1 vccd1 sky130_ef_sc_hd__decap_12
XFILLER_0_15_390 vssd1 vssd1 vccd1 vccd1 sky130_fd_sc_hd__fill_2
X_11322_ _05418_ vssd1 vssd1 vccd1 vccd1 _05419_ sky130_fd_sc_hd__inv_2
X_11253_ net775 net765 net957 net954 vssd1 vssd1 vccd1 vccd1 _05350_ sky130_fd_sc_hd__and4_1
XFILLER_0_120_557 vssd1 vssd1 vccd1 vccd1 sky130_ef_sc_hd__decap_12
X_10204_ net884 net927 _04174_ _04175_ vssd1 vssd1 vccd1 vccd1 _04309_ sky130_fd_sc_hd__a22o_1
Xclkbuf_leaf_48_clk_i clknet_3_1__leaf_clk_i vssd1 vssd1 vccd1 vccd1 clknet_leaf_48_clk_i
+ sky130_fd_sc_hd__clkbuf_16
XFILLER_0_101_782 vssd1 vssd1 vccd1 vccd1 sky130_fd_sc_hd__fill_2
X_11184_ _05279_ _05280_ vssd1 vssd1 vccd1 vccd1 _05282_ sky130_fd_sc_hd__xnor2_1
X_10135_ _04078_ _04083_ _04239_ vssd1 vssd1 vccd1 vccd1 _04240_ sky130_fd_sc_hd__o21a_1
X_10066_ _04003_ _04006_ _04169_ _04170_ vssd1 vssd1 vccd1 vccd1 _04172_ sky130_fd_sc_hd__a211oi_4
XFILLER_0_82_29 vssd1 vssd1 vccd1 vccd1 sky130_ef_sc_hd__decap_12
XFILLER_0_128_613 vssd1 vssd1 vccd1 vccd1 sky130_ef_sc_hd__decap_12
XFILLER_0_97_393 vssd1 vssd1 vccd1 vccd1 sky130_fd_sc_hd__decap_8
X_10968_ net453 _05066_ _04893_ _04938_ vssd1 vssd1 vccd1 vccd1 _05068_ sky130_fd_sc_hd__o211a_1
X_12707_ clknet_leaf_12_clk_i net1225 net1190 vssd1 vssd1 vccd1 vccd1 net439 sky130_fd_sc_hd__dfrtp_1
XFILLER_0_128_668 vssd1 vssd1 vccd1 vccd1 sky130_fd_sc_hd__fill_2
XFILLER_0_128_657 vssd1 vssd1 vccd1 vccd1 sky130_fd_sc_hd__decap_8
XFILLER_0_73_739 vssd1 vssd1 vccd1 vccd1 sky130_fd_sc_hd__decap_8
X_10899_ _04997_ _04998_ vssd1 vssd1 vccd1 vccd1 _04999_ sky130_fd_sc_hd__and2_1
X_12638_ clknet_leaf_26_clk_i _00024_ net1171 vssd1 vssd1 vccd1 vccd1 net363 sky130_fd_sc_hd__dfrtp_1
XFILLER_0_115_329 vssd1 vssd1 vccd1 vccd1 sky130_fd_sc_hd__decap_6
XFILLER_0_14_806 vssd1 vssd1 vccd1 vccd1 sky130_fd_sc_hd__decap_6
X_12569_ net1467 net14 net560 vssd1 vssd1 vccd1 vccd1 _00545_ sky130_fd_sc_hd__mux2_1
XFILLER_0_53_463 vssd1 vssd1 vccd1 vccd1 sky130_fd_sc_hd__fill_2
XFILLER_0_103_3 vssd1 vssd1 vccd1 vccd1 sky130_ef_sc_hd__decap_12
Xhold206 l0\[23\] vssd1 vssd1 vccd1 vccd1 net1421 sky130_fd_sc_hd__dlygate4sd3_1
Xhold217 net421 vssd1 vssd1 vccd1 vccd1 net1432 sky130_fd_sc_hd__dlygate4sd3_1
XFILLER_0_79_9 vssd1 vssd1 vccd1 vccd1 sky130_ef_sc_hd__decap_12
XFILLER_0_123_373 vssd1 vssd1 vccd1 vccd1 sky130_ef_sc_hd__decap_12
Xhold228 x0mx2\[26\] vssd1 vssd1 vccd1 vccd1 net1443 sky130_fd_sc_hd__dlygate4sd3_1
Xhold239 y2my0\[14\] vssd1 vssd1 vccd1 vccd1 net1454 sky130_fd_sc_hd__dlygate4sd3_1
XFILLER_0_41_669 vssd1 vssd1 vccd1 vccd1 sky130_fd_sc_hd__decap_3
XTAP_500 vssd1 vccd1 sky130_fd_sc_hd__tapvpwrvgnd_1
X_08800_ _02913_ _02908_ vssd1 vssd1 vccd1 vccd1 _02914_ sky130_fd_sc_hd__and2b_1
Xfanout719 mul1.b\[26\] vssd1 vssd1 vccd1 vccd1 net719 sky130_fd_sc_hd__clkbuf_4
XTAP_511 vssd1 vccd1 sky130_fd_sc_hd__tapvpwrvgnd_1
XTAP_522 vssd1 vccd1 sky130_fd_sc_hd__tapvpwrvgnd_1
XTAP_533 vssd1 vccd1 sky130_fd_sc_hd__tapvpwrvgnd_1
Xfanout708 net709 vssd1 vssd1 vccd1 vccd1 net708 sky130_fd_sc_hd__clkbuf_4
X_09780_ _03671_ _03729_ _03728_ vssd1 vssd1 vccd1 vccd1 _03888_ sky130_fd_sc_hd__a21bo_2
XFILLER_0_56_41 vssd1 vssd1 vccd1 vccd1 sky130_fd_sc_hd__decap_3
XFILLER_0_0_298 vssd1 vssd1 vccd1 vccd1 sky130_fd_sc_hd__fill_1
XTAP_544 vssd1 vccd1 sky130_fd_sc_hd__tapvpwrvgnd_1
XTAP_555 vssd1 vccd1 sky130_fd_sc_hd__tapvpwrvgnd_1
XTAP_566 vssd1 vccd1 sky130_fd_sc_hd__tapvpwrvgnd_1
X_06992_ _01113_ _01116_ vssd1 vssd1 vccd1 vccd1 _01117_ sky130_fd_sc_hd__xnor2_2
X_08731_ _02843_ _02844_ vssd1 vssd1 vccd1 vccd1 _02845_ sky130_fd_sc_hd__or2_1
XTAP_577 vssd1 vccd1 sky130_fd_sc_hd__tapvpwrvgnd_1
XTAP_588 vssd1 vccd1 sky130_fd_sc_hd__tapvpwrvgnd_1
XTAP_599 vssd1 vccd1 sky130_fd_sc_hd__tapvpwrvgnd_1
X_08662_ _02773_ _02774_ _02775_ vssd1 vssd1 vccd1 vccd1 _02777_ sky130_fd_sc_hd__nand3_1
XFILLER_0_56_85 vssd1 vssd1 vccd1 vccd1 sky130_ef_sc_hd__decap_12
X_07613_ _01385_ _01389_ _01734_ _01735_ vssd1 vssd1 vccd1 vccd1 _01737_ sky130_fd_sc_hd__a211oi_2
X_08593_ net773 _02707_ _02706_ vssd1 vssd1 vccd1 vccd1 _02708_ sky130_fd_sc_hd__a21bo_1
XFILLER_0_76_544 vssd1 vssd1 vccd1 vccd1 sky130_fd_sc_hd__fill_1
XFILLER_0_49_747 vssd1 vssd1 vccd1 vccd1 sky130_fd_sc_hd__fill_1
X_07544_ net1699 _01668_ net523 vssd1 vssd1 vccd1 vccd1 _00123_ sky130_fd_sc_hd__mux2_1
XFILLER_0_9_833 vssd1 vssd1 vccd1 vccd1 sky130_fd_sc_hd__fill_1
XFILLER_0_8_321 vssd1 vssd1 vccd1 vccd1 sky130_fd_sc_hd__fill_2
X_07475_ _01598_ _01599_ vssd1 vssd1 vccd1 vccd1 _01600_ sky130_fd_sc_hd__nor2_1
X_09214_ _03324_ _03323_ _03322_ vssd1 vssd1 vccd1 vccd1 _03325_ sky130_fd_sc_hd__nand3b_1
X_06426_ add1.a_i\[22\] add1.b_i\[22\] vssd1 vssd1 vccd1 vccd1 _00729_ sky130_fd_sc_hd__nand2_1
XFILLER_0_118_189 vssd1 vssd1 vccd1 vccd1 sky130_fd_sc_hd__decap_6
XFILLER_0_106_318 vssd1 vssd1 vccd1 vccd1 sky130_fd_sc_hd__decap_4
XFILLER_0_115_841 vssd1 vssd1 vccd1 vccd1 sky130_fd_sc_hd__fill_1
X_09145_ _03255_ _03256_ vssd1 vssd1 vccd1 vccd1 _03257_ sky130_fd_sc_hd__nor2_2
X_06357_ _00633_ _00667_ _00632_ vssd1 vssd1 vccd1 vccd1 _00669_ sky130_fd_sc_hd__a21o_1
X_09076_ _03021_ _03024_ _03185_ _03186_ vssd1 vssd1 vccd1 vccd1 _03188_ sky130_fd_sc_hd__o211a_1
XFILLER_0_71_293 vssd1 vssd1 vccd1 vccd1 sky130_fd_sc_hd__decap_8
X_06288_ state\[2\] state\[4\] state\[3\] vssd1 vssd1 vccd1 vccd1 _00603_ sky130_fd_sc_hd__or3b_2
XFILLER_0_31_113 vssd1 vssd1 vccd1 vccd1 sky130_fd_sc_hd__decap_3
X_08027_ _02033_ _02036_ _02144_ _02146_ vssd1 vssd1 vccd1 vccd1 _02147_ sky130_fd_sc_hd__a211oi_4
XFILLER_0_32_669 vssd1 vssd1 vccd1 vccd1 sky130_fd_sc_hd__decap_4
XFILLER_0_97_81 vssd1 vssd1 vccd1 vccd1 sky130_ef_sc_hd__decap_12
Xmax_cap492 _02384_ vssd1 vssd1 vccd1 vccd1 net492 sky130_fd_sc_hd__buf_1
X_09978_ _04079_ _04082_ vssd1 vssd1 vccd1 vccd1 _04084_ sky130_fd_sc_hd__xor2_1
X_08929_ _03040_ _03041_ vssd1 vssd1 vccd1 vccd1 _03042_ sky130_fd_sc_hd__nand2b_1
XFILLER_0_99_636 vssd1 vssd1 vccd1 vccd1 sky130_fd_sc_hd__fill_1
X_11940_ net153 net656 net502 net249 _05959_ vssd1 vssd1 vccd1 vccd1 _05960_ sky130_fd_sc_hd__a221o_1
XFILLER_0_98_168 vssd1 vssd1 vccd1 vccd1 sky130_fd_sc_hd__fill_2
XFILLER_0_79_360 vssd1 vssd1 vccd1 vccd1 sky130_fd_sc_hd__decap_8
X_11871_ net77 net679 net671 net109 vssd1 vssd1 vccd1 vccd1 _05905_ sky130_fd_sc_hd__a22o_1
X_10822_ _04915_ _04922_ vssd1 vssd1 vccd1 vccd1 _04923_ sky130_fd_sc_hd__nand2_1
XFILLER_0_67_566 vssd1 vssd1 vccd1 vccd1 sky130_fd_sc_hd__decap_8
X_10753_ _04683_ _04704_ _04852_ _04853_ vssd1 vssd1 vccd1 vccd1 _04854_ sky130_fd_sc_hd__a211oi_2
XFILLER_0_94_385 vssd1 vssd1 vccd1 vccd1 sky130_fd_sc_hd__fill_1
XFILLER_0_48_791 vssd1 vssd1 vccd1 vccd1 sky130_fd_sc_hd__fill_1
XFILLER_0_109_167 vssd1 vssd1 vccd1 vccd1 sky130_fd_sc_hd__fill_1
X_10684_ _04640_ _04643_ vssd1 vssd1 vccd1 vccd1 _04786_ sky130_fd_sc_hd__and2b_1
XFILLER_0_82_547 vssd1 vssd1 vccd1 vccd1 sky130_fd_sc_hd__fill_2
X_12423_ _00840_ net612 _02284_ net574 vssd1 vssd1 vccd1 vccd1 _06204_ sky130_fd_sc_hd__a22o_1
X_12354_ net1570 _00855_ net657 vssd1 vssd1 vccd1 vccd1 _00406_ sky130_fd_sc_hd__mux2_1
XFILLER_0_120_321 vssd1 vssd1 vccd1 vccd1 sky130_ef_sc_hd__decap_12
XFILLER_0_105_373 vssd1 vssd1 vccd1 vccd1 sky130_fd_sc_hd__decap_8
X_11305_ _05400_ _05401_ vssd1 vssd1 vccd1 vccd1 _05402_ sky130_fd_sc_hd__nand2_1
XFILLER_0_11_809 vssd1 vssd1 vccd1 vccd1 sky130_ef_sc_hd__decap_12
X_12285_ net1670 _00828_ net674 vssd1 vssd1 vccd1 vccd1 _00337_ sky130_fd_sc_hd__mux2_1
XFILLER_0_22_179 vssd1 vssd1 vccd1 vccd1 sky130_fd_sc_hd__decap_4
XFILLER_0_120_365 vssd1 vssd1 vccd1 vccd1 sky130_ef_sc_hd__decap_12
X_11236_ _05331_ _05332_ vssd1 vssd1 vccd1 vccd1 _05333_ sky130_fd_sc_hd__xor2_1
X_11167_ _05100_ _05137_ _05262_ _05263_ vssd1 vssd1 vccd1 vccd1 _05265_ sky130_fd_sc_hd__o211ai_4
XFILLER_0_93_39 vssd1 vssd1 vccd1 vccd1 sky130_ef_sc_hd__decap_12
X_10118_ net1544 _04223_ net524 vssd1 vssd1 vccd1 vccd1 _00142_ sky130_fd_sc_hd__mux2_1
XFILLER_0_89_113 vssd1 vssd1 vccd1 vccd1 sky130_fd_sc_hd__decap_3
X_11098_ _05195_ _05196_ vssd1 vssd1 vccd1 vccd1 _05197_ sky130_fd_sc_hd__nand2_1
XFILLER_0_117_57 vssd1 vssd1 vccd1 vccd1 sky130_ef_sc_hd__decap_12
X_10049_ _04012_ _04020_ _04019_ vssd1 vssd1 vccd1 vccd1 _04155_ sky130_fd_sc_hd__a21bo_1
XFILLER_0_89_157 vssd1 vssd1 vccd1 vccd1 sky130_fd_sc_hd__decap_3
XFILLER_0_77_319 vssd1 vssd1 vccd1 vccd1 sky130_fd_sc_hd__fill_2
XFILLER_0_26_77 vssd1 vssd1 vccd1 vccd1 sky130_fd_sc_hd__decap_3
XFILLER_0_73_503 vssd1 vssd1 vccd1 vccd1 sky130_fd_sc_hd__fill_1
XFILLER_0_128_454 vssd1 vssd1 vccd1 vccd1 sky130_ef_sc_hd__decap_12
X_07260_ _01382_ _01383_ _01384_ vssd1 vssd1 vccd1 vccd1 _01385_ sky130_fd_sc_hd__nand3_2
XFILLER_0_115_137 vssd1 vssd1 vccd1 vccd1 sky130_ef_sc_hd__decap_12
X_07191_ _01310_ _01314_ vssd1 vssd1 vccd1 vccd1 _01316_ sky130_fd_sc_hd__xor2_1
XFILLER_0_13_113 vssd1 vssd1 vccd1 vccd1 sky130_ef_sc_hd__decap_12
XFILLER_0_124_693 vssd1 vssd1 vccd1 vccd1 sky130_fd_sc_hd__decap_6
XFILLER_0_13_157 vssd1 vssd1 vccd1 vccd1 sky130_fd_sc_hd__decap_3
XFILLER_0_41_455 vssd1 vssd1 vccd1 vccd1 sky130_fd_sc_hd__decap_3
XFILLER_0_123_181 vssd1 vssd1 vccd1 vccd1 sky130_ef_sc_hd__decap_12
X_09901_ _04005_ _04006_ _03992_ vssd1 vssd1 vccd1 vccd1 _04008_ sky130_fd_sc_hd__a21oi_1
XFILLER_0_6_65 vssd1 vssd1 vccd1 vccd1 sky130_fd_sc_hd__decap_8
Xfanout505 _05930_ vssd1 vssd1 vccd1 vccd1 net505 sky130_fd_sc_hd__clkbuf_2
Xfanout527 net529 vssd1 vssd1 vccd1 vccd1 net527 sky130_fd_sc_hd__clkbuf_2
X_09832_ _03936_ _03937_ _03932_ vssd1 vssd1 vccd1 vccd1 _03939_ sky130_fd_sc_hd__a21o_1
XFILLER_0_67_73 vssd1 vssd1 vccd1 vccd1 sky130_fd_sc_hd__fill_1
Xfanout538 net539 vssd1 vssd1 vccd1 vccd1 net538 sky130_fd_sc_hd__clkbuf_4
XTAP_341 vssd1 vccd1 sky130_fd_sc_hd__tapvpwrvgnd_1
XTAP_330 vssd1 vccd1 sky130_fd_sc_hd__tapvpwrvgnd_1
Xfanout516 net520 vssd1 vssd1 vccd1 vccd1 net516 sky130_fd_sc_hd__buf_4
XFILLER_0_67_95 vssd1 vssd1 vccd1 vccd1 sky130_ef_sc_hd__decap_12
X_09763_ net924 net916 net907 net926 vssd1 vssd1 vccd1 vccd1 _03871_ sky130_fd_sc_hd__o211a_1
XTAP_374 vssd1 vccd1 sky130_fd_sc_hd__tapvpwrvgnd_1
XTAP_385 vssd1 vccd1 sky130_fd_sc_hd__tapvpwrvgnd_1
XTAP_363 vssd1 vccd1 sky130_fd_sc_hd__tapvpwrvgnd_1
XTAP_352 vssd1 vccd1 sky130_fd_sc_hd__tapvpwrvgnd_1
Xfanout549 net553 vssd1 vssd1 vccd1 vccd1 net549 sky130_fd_sc_hd__clkbuf_4
X_08714_ net1123 net727 net723 net1131 vssd1 vssd1 vccd1 vccd1 _02828_ sky130_fd_sc_hd__a22oi_1
XTAP_396 vssd1 vccd1 sky130_fd_sc_hd__tapvpwrvgnd_1
X_06975_ _01097_ _01098_ _01083_ vssd1 vssd1 vccd1 vccd1 _01100_ sky130_fd_sc_hd__a21o_1
XTAP_2208 vssd1 vccd1 sky130_fd_sc_hd__tapvpwrvgnd_1
X_09694_ net1070 net737 vssd1 vssd1 vccd1 vccd1 _03802_ sky130_fd_sc_hd__nand2_1
XTAP_2219 vssd1 vccd1 sky130_fd_sc_hd__tapvpwrvgnd_1
X_08645_ net877 net869 net993 net987 vssd1 vssd1 vccd1 vccd1 _02760_ sky130_fd_sc_hd__and4_1
X_08576_ _02417_ _02553_ vssd1 vssd1 vccd1 vccd1 _02691_ sky130_fd_sc_hd__or2_1
XTAP_1529 vssd1 vccd1 sky130_fd_sc_hd__tapvpwrvgnd_1
XTAP_1518 vssd1 vccd1 sky130_fd_sc_hd__tapvpwrvgnd_1
XTAP_1507 vssd1 vccd1 sky130_fd_sc_hd__tapvpwrvgnd_1
XPHY_14 vssd1 vssd1 vccd1 vccd1 sky130_fd_sc_hd__decap_3
XPHY_25 vssd1 vssd1 vccd1 vccd1 sky130_fd_sc_hd__decap_3
XPHY_36 vssd1 vssd1 vccd1 vccd1 sky130_fd_sc_hd__decap_3
XPHY_47 vssd1 vssd1 vccd1 vccd1 sky130_fd_sc_hd__decap_3
X_07527_ _01635_ _01650_ _01651_ _01617_ vssd1 vssd1 vccd1 vccd1 _01652_ sky130_fd_sc_hd__o31a_1
XPHY_58 vssd1 vssd1 vccd1 vccd1 sky130_fd_sc_hd__decap_3
XPHY_69 vssd1 vssd1 vccd1 vccd1 sky130_fd_sc_hd__decap_3
XFILLER_0_76_385 vssd1 vssd1 vccd1 vccd1 sky130_fd_sc_hd__decap_4
XFILLER_0_64_503 vssd1 vssd1 vccd1 vccd1 sky130_fd_sc_hd__decap_3
X_07458_ _01575_ _01582_ vssd1 vssd1 vccd1 vccd1 _01583_ sky130_fd_sc_hd__nand2_1
X_06409_ add1.a_i\[20\] add1.b_i\[20\] vssd1 vssd1 vccd1 vccd1 _00714_ sky130_fd_sc_hd__nand2_1
XFILLER_0_51_208 vssd1 vssd1 vccd1 vccd1 sky130_fd_sc_hd__decap_8
X_07389_ _01473_ _01479_ _01478_ vssd1 vssd1 vccd1 vccd1 _01514_ sky130_fd_sc_hd__a21o_1
X_09128_ _03078_ _03082_ _03237_ _03238_ vssd1 vssd1 vccd1 vccd1 _03240_ sky130_fd_sc_hd__a211oi_4
XFILLER_0_17_485 vssd1 vssd1 vccd1 vccd1 sky130_fd_sc_hd__fill_1
XFILLER_0_115_693 vssd1 vssd1 vccd1 vccd1 sky130_fd_sc_hd__fill_2
XFILLER_0_115_671 vssd1 vssd1 vccd1 vccd1 sky130_fd_sc_hd__fill_1
XFILLER_0_60_753 vssd1 vssd1 vccd1 vccd1 sky130_fd_sc_hd__decap_3
XFILLER_0_102_321 vssd1 vssd1 vccd1 vccd1 sky130_ef_sc_hd__decap_12
X_09059_ net1035 net802 net793 net1044 vssd1 vssd1 vccd1 vccd1 _03171_ sky130_fd_sc_hd__a22oi_1
X_12070_ _00852_ _06058_ net499 vssd1 vssd1 vccd1 vccd1 _06059_ sky130_fd_sc_hd__mux2_1
XFILLER_0_102_398 vssd1 vssd1 vccd1 vccd1 sky130_fd_sc_hd__decap_3
X_11021_ net799 net789 net951 net946 vssd1 vssd1 vccd1 vccd1 _05120_ sky130_fd_sc_hd__and4_1
XFILLER_0_99_422 vssd1 vssd1 vccd1 vccd1 sky130_fd_sc_hd__fill_1
X_12972_ clknet_leaf_34_clk_i _00358_ net1165 vssd1 vssd1 vccd1 vccd1 y1my2\[25\]
+ sky130_fd_sc_hd__dfrtp_1
XFILLER_0_87_606 vssd1 vssd1 vccd1 vccd1 sky130_fd_sc_hd__fill_2
X_11923_ net30 net549 net624 net213 _05946_ vssd1 vssd1 vccd1 vccd1 _05947_ sky130_fd_sc_hd__a221o_1
X_11854_ net234 net600 net580 net138 _05890_ vssd1 vssd1 vccd1 vccd1 _05891_ sky130_fd_sc_hd__a221o_1
XFILLER_0_95_650 vssd1 vssd1 vccd1 vccd1 sky130_ef_sc_hd__decap_12
XFILLER_0_86_149 vssd1 vssd1 vccd1 vccd1 sky130_ef_sc_hd__decap_12
X_10805_ _04905_ vssd1 vssd1 vccd1 vccd1 _04906_ sky130_fd_sc_hd__inv_2
XFILLER_0_67_352 vssd1 vssd1 vccd1 vccd1 sky130_ef_sc_hd__decap_12
XFILLER_0_103_15 vssd1 vssd1 vccd1 vccd1 sky130_ef_sc_hd__decap_12
X_11785_ temp1\[14\] net614 net665 net95 _05831_ vssd1 vssd1 vccd1 vccd1 _05832_ sky130_fd_sc_hd__a221o_1
X_10736_ net853 net844 net933 net928 vssd1 vssd1 vccd1 vccd1 _04837_ sky130_fd_sc_hd__nand4_2
X_10667_ _04619_ _04768_ vssd1 vssd1 vccd1 vccd1 _04769_ sky130_fd_sc_hd__nor2_1
XFILLER_0_42_208 vssd1 vssd1 vccd1 vccd1 sky130_fd_sc_hd__fill_1
X_12406_ net1511 _00965_ net686 vssd1 vssd1 vccd1 vccd1 _00458_ sky130_fd_sc_hd__mux2_1
X_10598_ _04535_ _04539_ _04698_ vssd1 vssd1 vccd1 vccd1 _04700_ sky130_fd_sc_hd__o21ai_2
XFILLER_0_121_641 vssd1 vssd1 vccd1 vccd1 sky130_ef_sc_hd__decap_12
XFILLER_0_105_181 vssd1 vssd1 vccd1 vccd1 sky130_fd_sc_hd__decap_4
X_12337_ net1652 _00935_ net673 vssd1 vssd1 vccd1 vccd1 _00389_ sky130_fd_sc_hd__mux2_1
XFILLER_0_121_685 vssd1 vssd1 vccd1 vccd1 sky130_ef_sc_hd__decap_12
X_12268_ net1222 net45 net690 vssd1 vssd1 vccd1 vccd1 _00322_ sky130_fd_sc_hd__mux2_1
XFILLER_0_120_195 vssd1 vssd1 vccd1 vccd1 sky130_fd_sc_hd__fill_1
X_11219_ _05315_ _05316_ _05193_ _05195_ vssd1 vssd1 vccd1 vccd1 _05317_ sky130_fd_sc_hd__o211a_1
X_12199_ _00867_ net510 net467 y1my2\[11\] _06152_ vssd1 vssd1 vccd1 vccd1 _06153_
+ sky130_fd_sc_hd__a221o_1
XFILLER_0_37_21 vssd1 vssd1 vccd1 vccd1 sky130_fd_sc_hd__fill_1
XFILLER_0_128_89 vssd1 vssd1 vccd1 vccd1 sky130_fd_sc_hd__fill_1
XFILLER_0_37_54 vssd1 vssd1 vccd1 vccd1 sky130_fd_sc_hd__fill_2
XFILLER_0_37_65 vssd1 vssd1 vccd1 vccd1 sky130_fd_sc_hd__decap_3
Xinput190 v2x[13] vssd1 vssd1 vccd1 vccd1 net190 sky130_fd_sc_hd__buf_1
X_06760_ net1543 _00973_ net636 vssd1 vssd1 vccd1 vccd1 _00034_ sky130_fd_sc_hd__mux2_1
X_06691_ sub1.b_i\[21\] sub1.a_i\[21\] vssd1 vssd1 vccd1 vccd1 _00915_ sky130_fd_sc_hd__and2b_1
X_08430_ _02460_ _02463_ vssd1 vssd1 vccd1 vccd1 _02546_ sky130_fd_sc_hd__nand2_1
XFILLER_0_129_763 vssd1 vssd1 vccd1 vccd1 sky130_fd_sc_hd__fill_2
X_08361_ _02474_ _02475_ _02476_ vssd1 vssd1 vccd1 vccd1 _02478_ sky130_fd_sc_hd__a21o_1
XFILLER_0_18_205 vssd1 vssd1 vccd1 vccd1 sky130_fd_sc_hd__decap_3
XFILLER_0_129_774 vssd1 vssd1 vccd1 vccd1 sky130_fd_sc_hd__fill_1
XFILLER_0_116_413 vssd1 vssd1 vccd1 vccd1 sky130_fd_sc_hd__decap_6
X_08292_ _02281_ _02402_ vssd1 vssd1 vccd1 vccd1 _02409_ sky130_fd_sc_hd__or2_1
XFILLER_0_46_558 vssd1 vssd1 vccd1 vccd1 sky130_fd_sc_hd__fill_1
X_07312_ _01430_ _01435_ vssd1 vssd1 vccd1 vccd1 _01437_ sky130_fd_sc_hd__xor2_1
X_07243_ _01358_ _01366_ vssd1 vssd1 vccd1 vccd1 _01368_ sky130_fd_sc_hd__xor2_1
XFILLER_0_5_110 vssd1 vssd1 vccd1 vccd1 sky130_fd_sc_hd__fill_2
XFILLER_0_116_457 vssd1 vssd1 vccd1 vccd1 sky130_ef_sc_hd__decap_12
XFILLER_0_73_399 vssd1 vssd1 vccd1 vccd1 sky130_ef_sc_hd__decap_12
XFILLER_0_14_444 vssd1 vssd1 vccd1 vccd1 sky130_fd_sc_hd__decap_3
X_07174_ _01296_ _01298_ vssd1 vssd1 vccd1 vccd1 _01299_ sky130_fd_sc_hd__and2b_1
XFILLER_0_75_3 vssd1 vssd1 vccd1 vccd1 sky130_ef_sc_hd__decap_12
XFILLER_0_78_83 vssd1 vssd1 vccd1 vccd1 sky130_fd_sc_hd__fill_1
XFILLER_0_78_61 vssd1 vssd1 vccd1 vccd1 sky130_fd_sc_hd__fill_1
X_09815_ _03918_ _03921_ vssd1 vssd1 vccd1 vccd1 _03922_ sky130_fd_sc_hd__and2_1
X_09746_ _03852_ _03853_ vssd1 vssd1 vccd1 vccd1 _03854_ sky130_fd_sc_hd__and2b_2
X_06958_ _01080_ _01082_ _01079_ vssd1 vssd1 vccd1 vccd1 _01083_ sky130_fd_sc_hd__a21o_1
XTAP_2016 vssd1 vccd1 sky130_fd_sc_hd__tapvpwrvgnd_1
XTAP_2005 vssd1 vccd1 sky130_fd_sc_hd__tapvpwrvgnd_1
X_09677_ _03775_ _03782_ _03783_ vssd1 vssd1 vccd1 vccd1 _03785_ sky130_fd_sc_hd__nand3_1
XFILLER_0_69_617 vssd1 vssd1 vccd1 vccd1 sky130_fd_sc_hd__fill_2
XTAP_2049 vssd1 vccd1 sky130_fd_sc_hd__tapvpwrvgnd_1
XTAP_2038 vssd1 vccd1 sky130_fd_sc_hd__tapvpwrvgnd_1
XTAP_2027 vssd1 vccd1 sky130_fd_sc_hd__tapvpwrvgnd_1
X_08628_ net1016 net852 net843 net1008 vssd1 vssd1 vccd1 vccd1 _02743_ sky130_fd_sc_hd__and4_1
XTAP_1304 vssd1 vccd1 sky130_fd_sc_hd__tapvpwrvgnd_1
X_06889_ net1172 _01013_ vssd1 vssd1 vccd1 vccd1 _01014_ sky130_fd_sc_hd__and2_1
XTAP_1348 vssd1 vccd1 sky130_fd_sc_hd__tapvpwrvgnd_1
XTAP_1337 vssd1 vccd1 sky130_fd_sc_hd__tapvpwrvgnd_1
XTAP_1326 vssd1 vccd1 sky130_fd_sc_hd__tapvpwrvgnd_1
XTAP_1315 vssd1 vccd1 sky130_fd_sc_hd__tapvpwrvgnd_1
X_08559_ _02425_ _02665_ _02664_ vssd1 vssd1 vccd1 vccd1 _02674_ sky130_fd_sc_hd__a21boi_1
XTAP_1359 vssd1 vccd1 sky130_fd_sc_hd__tapvpwrvgnd_1
XFILLER_0_92_642 vssd1 vssd1 vccd1 vccd1 sky130_fd_sc_hd__fill_2
XFILLER_0_64_344 vssd1 vssd1 vccd1 vccd1 sky130_fd_sc_hd__fill_1
XFILLER_0_37_558 vssd1 vssd1 vccd1 vccd1 sky130_fd_sc_hd__fill_2
X_11570_ _05663_ _05664_ vssd1 vssd1 vccd1 vccd1 _05665_ sky130_fd_sc_hd__nand2_1
XFILLER_0_119_273 vssd1 vssd1 vccd1 vccd1 sky130_fd_sc_hd__decap_6
X_10521_ _04622_ _04623_ vssd1 vssd1 vccd1 vccd1 _04624_ sky130_fd_sc_hd__and2_1
XFILLER_0_64_355 vssd1 vssd1 vccd1 vccd1 sky130_fd_sc_hd__decap_8
XFILLER_0_52_517 vssd1 vssd1 vccd1 vccd1 sky130_fd_sc_hd__fill_2
XFILLER_0_9_493 vssd1 vssd1 vccd1 vccd1 sky130_fd_sc_hd__decap_3
XFILLER_0_24_208 vssd1 vssd1 vccd1 vccd1 sky130_fd_sc_hd__fill_2
X_10452_ _04454_ _04455_ _04553_ _04554_ vssd1 vssd1 vccd1 vccd1 _04555_ sky130_fd_sc_hd__o211ai_4
XFILLER_0_33_753 vssd1 vssd1 vccd1 vccd1 sky130_fd_sc_hd__fill_2
XFILLER_0_103_641 vssd1 vssd1 vccd1 vccd1 sky130_fd_sc_hd__decap_6
X_10383_ net803 net792 net984 net976 vssd1 vssd1 vccd1 vccd1 _04487_ sky130_fd_sc_hd__nand4_1
X_13171_ clknet_leaf_22_clk_i _00557_ net1174 vssd1 vssd1 vccd1 vccd1 l1\[0\] sky130_fd_sc_hd__dfrtp_1
XFILLER_0_103_685 vssd1 vssd1 vccd1 vccd1 sky130_ef_sc_hd__decap_12
X_12122_ _00918_ _06097_ net500 vssd1 vssd1 vccd1 vccd1 _06098_ sky130_fd_sc_hd__mux2_1
XFILLER_0_102_195 vssd1 vssd1 vccd1 vccd1 sky130_fd_sc_hd__fill_1
XFILLER_0_102_173 vssd1 vssd1 vccd1 vccd1 sky130_ef_sc_hd__decap_12
X_12053_ y2my0\[4\] net582 net531 x2mx1\[4\] _06045_ vssd1 vssd1 vccd1 vccd1 _06046_
+ sky130_fd_sc_hd__a221o_1
X_11004_ net982 net750 net742 net989 vssd1 vssd1 vccd1 vccd1 _05103_ sky130_fd_sc_hd__a22o_1
Xfanout891 mul1.b\[4\] vssd1 vssd1 vccd1 vccd1 net891 sky130_fd_sc_hd__clkbuf_4
Xfanout880 net881 vssd1 vssd1 vccd1 vccd1 net880 sky130_fd_sc_hd__clkbuf_4
XFILLER_0_99_252 vssd1 vssd1 vccd1 vccd1 sky130_ef_sc_hd__decap_12
X_12955_ clknet_leaf_44_clk_i _00341_ net1156 vssd1 vssd1 vccd1 vccd1 y1my2\[8\] sky130_fd_sc_hd__dfrtp_1
X_11906_ net101 net620 net594 net69 vssd1 vssd1 vccd1 vccd1 _05934_ sky130_fd_sc_hd__a22o_1
XFILLER_0_90_29 vssd1 vssd1 vccd1 vccd1 sky130_ef_sc_hd__decap_12
XFILLER_0_87_447 vssd1 vssd1 vccd1 vccd1 sky130_fd_sc_hd__fill_1
X_12886_ clknet_leaf_33_clk_i _00272_ vssd1 vssd1 vccd1 vccd1 mul1.a\[21\] sky130_fd_sc_hd__dfxtp_2
XTAP_1860 vssd1 vccd1 sky130_fd_sc_hd__tapvpwrvgnd_1
XFILLER_0_68_661 vssd1 vssd1 vccd1 vccd1 sky130_fd_sc_hd__decap_4
XFILLER_0_56_801 vssd1 vssd1 vccd1 vccd1 sky130_fd_sc_hd__fill_1
X_11837_ net1296 _05876_ net481 vssd1 vssd1 vccd1 vccd1 _00208_ sky130_fd_sc_hd__mux2_1
XTAP_1893 vssd1 vccd1 sky130_fd_sc_hd__tapvpwrvgnd_1
XTAP_1882 vssd1 vccd1 sky130_fd_sc_hd__tapvpwrvgnd_1
XTAP_1871 vssd1 vccd1 sky130_fd_sc_hd__tapvpwrvgnd_1
XFILLER_0_83_642 vssd1 vssd1 vccd1 vccd1 sky130_ef_sc_hd__decap_12
XFILLER_0_67_182 vssd1 vssd1 vccd1 vccd1 sky130_fd_sc_hd__decap_8
X_11768_ net220 net599 net579 net124 _05817_ vssd1 vssd1 vccd1 vccd1 _05818_ sky130_fd_sc_hd__a221o_1
XFILLER_0_99_27 vssd1 vssd1 vccd1 vccd1 sky130_ef_sc_hd__decap_12
XFILLER_0_83_664 vssd1 vssd1 vccd1 vccd1 sky130_fd_sc_hd__decap_8
X_10719_ _04818_ _04819_ vssd1 vssd1 vccd1 vccd1 _04820_ sky130_fd_sc_hd__nand2_1
XFILLER_0_82_141 vssd1 vssd1 vccd1 vccd1 sky130_fd_sc_hd__fill_2
XFILLER_0_126_755 vssd1 vssd1 vccd1 vccd1 sky130_fd_sc_hd__fill_1
XFILLER_0_113_405 vssd1 vssd1 vccd1 vccd1 sky130_ef_sc_hd__decap_12
XFILLER_0_43_528 vssd1 vssd1 vccd1 vccd1 sky130_fd_sc_hd__decap_4
X_11699_ net1150 net596 vssd1 vssd1 vccd1 vccd1 _05760_ sky130_fd_sc_hd__and2b_2
XFILLER_0_130_57 vssd1 vssd1 vccd1 vccd1 sky130_fd_sc_hd__decap_4
XFILLER_0_3_614 vssd1 vssd1 vccd1 vccd1 sky130_fd_sc_hd__fill_2
XFILLER_0_24_764 vssd1 vssd1 vccd1 vccd1 sky130_fd_sc_hd__fill_2
XFILLER_0_113_449 vssd1 vssd1 vccd1 vccd1 sky130_ef_sc_hd__decap_12
XFILLER_0_51_583 vssd1 vssd1 vccd1 vccd1 sky130_ef_sc_hd__decap_12
XFILLER_0_23_252 vssd1 vssd1 vccd1 vccd1 sky130_fd_sc_hd__fill_2
X_07930_ _01855_ _01941_ _01940_ vssd1 vssd1 vccd1 vccd1 _02051_ sky130_fd_sc_hd__a21o_1
X_07861_ _01957_ _01980_ vssd1 vssd1 vccd1 vccd1 _01982_ sky130_fd_sc_hd__xnor2_1
X_06812_ net431 net1429 net645 vssd1 vssd1 vccd1 vccd1 _00086_ sky130_fd_sc_hd__mux2_1
X_07792_ net906 net1010 vssd1 vssd1 vccd1 vccd1 _01914_ sky130_fd_sc_hd__and2_1
X_09600_ net915 net931 _03540_ _03541_ vssd1 vssd1 vccd1 vccd1 _03709_ sky130_fd_sc_hd__a31o_1
XFILLER_0_3_55 vssd1 vssd1 vccd1 vccd1 sky130_fd_sc_hd__fill_1
X_09531_ _03638_ _03639_ vssd1 vssd1 vccd1 vccd1 _03640_ sky130_fd_sc_hd__xnor2_2
X_06743_ _00956_ _00959_ vssd1 vssd1 vccd1 vccd1 _00960_ sky130_fd_sc_hd__xnor2_4
Xwire12 _02154_ vssd1 vssd1 vccd1 vccd1 net1753 sky130_fd_sc_hd__buf_1
XFILLER_0_64_96 vssd1 vssd1 vccd1 vccd1 sky130_fd_sc_hd__decap_3
XFILLER_0_64_85 vssd1 vssd1 vccd1 vccd1 sky130_fd_sc_hd__decap_3
X_09462_ _03568_ _03569_ _03423_ vssd1 vssd1 vccd1 vccd1 _03572_ sky130_fd_sc_hd__o21ai_1
X_06674_ sub1.a_i\[17\] _00595_ sub1.a_i\[16\] _00594_ vssd1 vssd1 vccd1 vccd1 _00901_
+ sky130_fd_sc_hd__o211a_1
X_09393_ _03333_ _03336_ _03500_ _03501_ vssd1 vssd1 vccd1 vccd1 _03503_ sky130_fd_sc_hd__a211oi_2
X_08413_ _02427_ _02527_ _02529_ vssd1 vssd1 vccd1 vccd1 _02530_ sky130_fd_sc_hd__and3_2
XFILLER_0_65_108 vssd1 vssd1 vccd1 vccd1 sky130_fd_sc_hd__decap_4
X_08344_ _02457_ _02458_ _02346_ _02349_ vssd1 vssd1 vccd1 vccd1 _02461_ sky130_fd_sc_hd__o211ai_4
XFILLER_0_80_73 vssd1 vssd1 vccd1 vccd1 sky130_fd_sc_hd__decap_8
XFILLER_0_117_722 vssd1 vssd1 vccd1 vccd1 sky130_fd_sc_hd__decap_6
XFILLER_0_116_221 vssd1 vssd1 vccd1 vccd1 sky130_ef_sc_hd__decap_12
XFILLER_0_74_686 vssd1 vssd1 vccd1 vccd1 sky130_fd_sc_hd__decap_4
X_08275_ _02291_ _02391_ _02392_ vssd1 vssd1 vccd1 vccd1 _02393_ sky130_fd_sc_hd__nand3_4
XFILLER_0_116_265 vssd1 vssd1 vccd1 vccd1 sky130_ef_sc_hd__decap_12
XFILLER_0_61_358 vssd1 vssd1 vccd1 vccd1 sky130_fd_sc_hd__decap_4
X_07226_ _01348_ _01349_ _01235_ _01236_ vssd1 vssd1 vccd1 vccd1 _01351_ sky130_fd_sc_hd__o211ai_2
XFILLER_0_15_753 vssd1 vssd1 vccd1 vccd1 sky130_fd_sc_hd__fill_1
XFILLER_0_15_797 vssd1 vssd1 vccd1 vccd1 sky130_ef_sc_hd__decap_12
X_07157_ net895 net1088 net1095 net887 vssd1 vssd1 vccd1 vccd1 _01282_ sky130_fd_sc_hd__a22o_1
XFILLER_0_42_572 vssd1 vssd1 vccd1 vccd1 sky130_fd_sc_hd__decap_4
XFILLER_0_42_583 vssd1 vssd1 vccd1 vccd1 sky130_fd_sc_hd__decap_4
Xoutput450 net691 vssd1 vssd1 vccd1 vccd1 sstream_o sky130_fd_sc_hd__clkbuf_4
X_07088_ net899 net890 net1057 vssd1 vssd1 vccd1 vccd1 _01213_ sky130_fd_sc_hd__and3_1
Xfanout1108 net1110 vssd1 vssd1 vccd1 vccd1 net1108 sky130_fd_sc_hd__buf_2
XFILLER_0_100_666 vssd1 vssd1 vccd1 vccd1 sky130_ef_sc_hd__decap_12
Xfanout1119 net1120 vssd1 vssd1 vccd1 vccd1 net1119 sky130_fd_sc_hd__buf_2
X_09729_ net985 _03675_ _03836_ vssd1 vssd1 vccd1 vccd1 _03837_ sky130_fd_sc_hd__a21bo_1
XTAP_1123 vssd1 vccd1 sky130_fd_sc_hd__tapvpwrvgnd_1
XTAP_1112 vssd1 vccd1 sky130_fd_sc_hd__tapvpwrvgnd_1
XTAP_1101 vssd1 vccd1 sky130_fd_sc_hd__tapvpwrvgnd_1
X_12740_ clknet_leaf_0_clk_i _00126_ vssd1 vssd1 vccd1 vccd1 add1.a_i\[3\] sky130_fd_sc_hd__dfxtp_1
X_12671_ clknet_leaf_20_clk_i net1221 net1179 vssd1 vssd1 vccd1 vccd1 net399 sky130_fd_sc_hd__dfrtp_1
XTAP_1156 vssd1 vccd1 sky130_fd_sc_hd__tapvpwrvgnd_1
XTAP_1145 vssd1 vccd1 sky130_fd_sc_hd__tapvpwrvgnd_1
XTAP_1134 vssd1 vccd1 sky130_fd_sc_hd__tapvpwrvgnd_1
XFILLER_0_96_299 vssd1 vssd1 vccd1 vccd1 sky130_fd_sc_hd__fill_2
XFILLER_0_65_620 vssd1 vssd1 vccd1 vccd1 sky130_fd_sc_hd__fill_1
XTAP_1189 vssd1 vccd1 sky130_fd_sc_hd__tapvpwrvgnd_1
XTAP_1167 vssd1 vccd1 sky130_fd_sc_hd__tapvpwrvgnd_1
XTAP_1178 vssd1 vccd1 sky130_fd_sc_hd__tapvpwrvgnd_1
X_11622_ net757 net947 vssd1 vssd1 vccd1 vccd1 _05716_ sky130_fd_sc_hd__nand2_1
XFILLER_0_107_221 vssd1 vssd1 vccd1 vccd1 sky130_fd_sc_hd__decap_3
XFILLER_0_80_601 vssd1 vssd1 vccd1 vccd1 sky130_ef_sc_hd__decap_12
XFILLER_0_108_777 vssd1 vssd1 vccd1 vccd1 sky130_fd_sc_hd__fill_1
XFILLER_0_107_243 vssd1 vssd1 vccd1 vccd1 sky130_fd_sc_hd__fill_1
XFILLER_0_80_645 vssd1 vssd1 vccd1 vccd1 sky130_fd_sc_hd__fill_1
XFILLER_0_64_163 vssd1 vssd1 vccd1 vccd1 sky130_fd_sc_hd__decap_6
X_11553_ _05646_ _05647_ _05629_ vssd1 vssd1 vccd1 vccd1 _05648_ sky130_fd_sc_hd__o21a_1
XFILLER_0_37_388 vssd1 vssd1 vccd1 vccd1 sky130_fd_sc_hd__decap_4
X_10504_ _04468_ _04506_ _04605_ _04606_ vssd1 vssd1 vccd1 vccd1 _04607_ sky130_fd_sc_hd__o211a_1
X_11484_ net762 net952 vssd1 vssd1 vccd1 vccd1 _05579_ sky130_fd_sc_hd__nand2_1
X_13223_ net507 vssd1 vssd1 vccd1 vccd1 net278 sky130_fd_sc_hd__clkbuf_1
XFILLER_0_100_27 vssd1 vssd1 vccd1 vccd1 sky130_fd_sc_hd__fill_1
X_10435_ _04536_ _04537_ _04530_ vssd1 vssd1 vccd1 vccd1 _04538_ sky130_fd_sc_hd__a21oi_1
XFILLER_0_110_419 vssd1 vssd1 vccd1 vccd1 sky130_fd_sc_hd__fill_1
X_13154_ clknet_leaf_14_clk_i _00540_ net1189 vssd1 vssd1 vccd1 vccd1 l0\[15\] sky130_fd_sc_hd__dfrtp_1
X_10366_ net1021 net753 net744 net1029 vssd1 vssd1 vccd1 vccd1 _04470_ sky130_fd_sc_hd__a22o_1
X_12105_ y2my0\[17\] net585 net533 x2mx1\[17\] _06084_ vssd1 vssd1 vccd1 vccd1 _06085_
+ sky130_fd_sc_hd__a221o_1
XTAP_907 vssd1 vccd1 sky130_fd_sc_hd__tapvpwrvgnd_1
X_10297_ _04276_ _04284_ _04283_ vssd1 vssd1 vccd1 vccd1 _04401_ sky130_fd_sc_hd__a21o_1
XTAP_929 vssd1 vccd1 sky130_fd_sc_hd__tapvpwrvgnd_1
X_13085_ clknet_leaf_0_clk_i _00471_ vssd1 vssd1 vccd1 vccd1 temp1\[10\] sky130_fd_sc_hd__dfxtp_1
XTAP_918 vssd1 vccd1 sky130_fd_sc_hd__tapvpwrvgnd_1
X_12036_ net631 net534 net592 vssd1 vssd1 vccd1 vccd1 _06033_ sky130_fd_sc_hd__or3_1
XFILLER_0_109_69 vssd1 vssd1 vccd1 vccd1 sky130_ef_sc_hd__decap_12
XFILLER_0_88_701 vssd1 vssd1 vccd1 vccd1 sky130_ef_sc_hd__decap_12
XFILLER_0_125_57 vssd1 vssd1 vccd1 vccd1 sky130_ef_sc_hd__decap_12
X_12938_ clknet_leaf_6_clk_i _00324_ net1196 vssd1 vssd1 vccd1 vccd1 posy\[0\] sky130_fd_sc_hd__dfrtp_1
XFILLER_0_87_222 vssd1 vssd1 vccd1 vccd1 sky130_fd_sc_hd__fill_2
X_12869_ clknet_leaf_50_clk_i _00255_ vssd1 vssd1 vccd1 vccd1 mul1.a\[4\] sky130_fd_sc_hd__dfxtp_4
XTAP_1690 vssd1 vccd1 sky130_fd_sc_hd__tapvpwrvgnd_1
X_06390_ add1.a_i\[16\] add1.b_i\[16\] _00691_ vssd1 vssd1 vccd1 vccd1 _00698_ sky130_fd_sc_hd__a21o_1
XFILLER_0_114_736 vssd1 vssd1 vccd1 vccd1 sky130_fd_sc_hd__fill_1
X_08060_ _02177_ _02178_ vssd1 vssd1 vccd1 vccd1 _02179_ sky130_fd_sc_hd__or2_1
XFILLER_0_70_188 vssd1 vssd1 vccd1 vccd1 sky130_fd_sc_hd__decap_8
X_07011_ _01099_ _01102_ _01133_ _01135_ vssd1 vssd1 vccd1 vccd1 _01136_ sky130_fd_sc_hd__a211oi_2
XFILLER_0_113_279 vssd1 vssd1 vccd1 vccd1 sky130_fd_sc_hd__fill_1
X_08962_ _03073_ _03074_ _03066_ vssd1 vssd1 vccd1 vccd1 _03075_ sky130_fd_sc_hd__a21o_1
X_08893_ _03003_ _03004_ vssd1 vssd1 vccd1 vccd1 _03006_ sky130_fd_sc_hd__xor2_1
X_07913_ _02030_ _02031_ _02032_ vssd1 vssd1 vccd1 vccd1 _02034_ sky130_fd_sc_hd__a21o_1
X_07844_ _01963_ _01964_ vssd1 vssd1 vccd1 vccd1 _01965_ sky130_fd_sc_hd__or2_1
XFILLER_0_38_3 vssd1 vssd1 vccd1 vccd1 sky130_ef_sc_hd__decap_12
X_07775_ _01797_ _01799_ _01894_ _01895_ vssd1 vssd1 vccd1 vccd1 _01897_ sky130_fd_sc_hd__o211a_1
X_09514_ _03611_ _03621_ _03622_ vssd1 vssd1 vccd1 vccd1 _03623_ sky130_fd_sc_hd__and3_1
X_06726_ _00937_ _00944_ vssd1 vssd1 vccd1 vccd1 _00945_ sky130_fd_sc_hd__nor2_2
XPHY_206 vssd1 vssd1 vccd1 vccd1 sky130_fd_sc_hd__decap_3
XFILLER_0_94_737 vssd1 vssd1 vccd1 vccd1 sky130_ef_sc_hd__decap_12
XFILLER_0_78_266 vssd1 vssd1 vccd1 vccd1 sky130_fd_sc_hd__decap_3
X_09445_ _03534_ _03551_ _03552_ vssd1 vssd1 vccd1 vccd1 _03555_ sky130_fd_sc_hd__nand3_1
X_06657_ _00883_ _00886_ vssd1 vssd1 vccd1 vccd1 _00887_ sky130_fd_sc_hd__xor2_4
XPHY_239 vssd1 vssd1 vccd1 vccd1 sky130_fd_sc_hd__decap_3
XPHY_228 vssd1 vssd1 vccd1 vccd1 sky130_fd_sc_hd__decap_3
XFILLER_0_109_508 vssd1 vssd1 vccd1 vccd1 sky130_ef_sc_hd__decap_12
XPHY_217 vssd1 vssd1 vccd1 vccd1 sky130_fd_sc_hd__decap_3
X_09376_ net1017 net802 net1009 net810 vssd1 vssd1 vccd1 vccd1 _03486_ sky130_fd_sc_hd__a22o_1
XFILLER_0_46_141 vssd1 vssd1 vccd1 vccd1 sky130_fd_sc_hd__decap_4
X_06588_ net1713 _00828_ net634 vssd1 vssd1 vccd1 vccd1 _00007_ sky130_fd_sc_hd__mux2_1
XFILLER_0_117_541 vssd1 vssd1 vccd1 vccd1 sky130_ef_sc_hd__decap_12
X_08327_ net1075 net805 _02332_ _02333_ net821 vssd1 vssd1 vccd1 vccd1 _02444_ sky130_fd_sc_hd__a32o_1
XFILLER_0_117_585 vssd1 vssd1 vccd1 vccd1 sky130_ef_sc_hd__decap_12
X_08258_ _02373_ _02374_ _02375_ vssd1 vssd1 vccd1 vccd1 _02376_ sky130_fd_sc_hd__nand3_4
XFILLER_0_62_645 vssd1 vssd1 vccd1 vccd1 sky130_fd_sc_hd__decap_4
XFILLER_0_7_794 vssd1 vssd1 vccd1 vccd1 sky130_fd_sc_hd__fill_1
XFILLER_0_15_561 vssd1 vssd1 vccd1 vccd1 sky130_fd_sc_hd__fill_2
X_07209_ _01332_ _01333_ vssd1 vssd1 vccd1 vccd1 _01334_ sky130_fd_sc_hd__nand2_1
X_08189_ _02304_ _02305_ vssd1 vssd1 vccd1 vccd1 _02307_ sky130_fd_sc_hd__xor2_1
X_10220_ _04322_ _04323_ _04318_ vssd1 vssd1 vccd1 vccd1 _04325_ sky130_fd_sc_hd__a21o_1
Xoutput280 net280 vssd1 vssd1 vccd1 vccd1 div_mstream_o[35] sky130_fd_sc_hd__clkbuf_4
X_10151_ _04246_ _04253_ _04254_ vssd1 vssd1 vccd1 vccd1 _04256_ sky130_fd_sc_hd__nand3_4
Xoutput291 net291 vssd1 vssd1 vccd1 vccd1 div_mstream_o[45] sky130_fd_sc_hd__clkbuf_4
XFILLER_0_100_474 vssd1 vssd1 vccd1 vccd1 sky130_fd_sc_hd__fill_2
X_10082_ net860 net945 vssd1 vssd1 vccd1 vccd1 _04188_ sky130_fd_sc_hd__nand2_1
X_10984_ net824 net816 net935 net930 vssd1 vssd1 vccd1 vccd1 _05083_ sky130_fd_sc_hd__and4_1
X_12723_ clknet_leaf_8_clk_i _00109_ net1193 vssd1 vssd1 vccd1 vccd1 net342 sky130_fd_sc_hd__dfrtp_1
XFILLER_0_85_726 vssd1 vssd1 vccd1 vccd1 sky130_fd_sc_hd__fill_2
XFILLER_0_29_108 vssd1 vssd1 vccd1 vccd1 sky130_fd_sc_hd__decap_4
XFILLER_0_38_631 vssd1 vssd1 vccd1 vccd1 sky130_fd_sc_hd__fill_2
X_12654_ clknet_leaf_21_clk_i _00040_ net1174 vssd1 vssd1 vccd1 vccd1 net380 sky130_fd_sc_hd__dfrtp_1
XFILLER_0_65_494 vssd1 vssd1 vccd1 vccd1 sky130_fd_sc_hd__decap_8
XFILLER_0_37_163 vssd1 vssd1 vccd1 vccd1 sky130_fd_sc_hd__decap_4
X_11605_ _05654_ _05655_ _05658_ vssd1 vssd1 vccd1 vccd1 _05699_ sky130_fd_sc_hd__a21bo_1
X_12585_ net1439 net27 net554 vssd1 vssd1 vccd1 vccd1 _00560_ sky130_fd_sc_hd__mux2_1
X_11536_ net997 net717 _05528_ _05527_ vssd1 vssd1 vccd1 vccd1 _05631_ sky130_fd_sc_hd__a31o_1
XFILLER_0_25_347 vssd1 vssd1 vccd1 vccd1 sky130_fd_sc_hd__fill_1
XFILLER_0_52_177 vssd1 vssd1 vccd1 vccd1 sky130_fd_sc_hd__fill_2
XFILLER_0_52_166 vssd1 vssd1 vccd1 vccd1 sky130_fd_sc_hd__decap_4
XFILLER_0_40_306 vssd1 vssd1 vccd1 vccd1 sky130_fd_sc_hd__fill_2
X_11467_ _05561_ _05562_ vssd1 vssd1 vccd1 vccd1 _05563_ sky130_fd_sc_hd__xnor2_2
XFILLER_0_33_391 vssd1 vssd1 vccd1 vccd1 sky130_fd_sc_hd__fill_1
X_10418_ _04521_ vssd1 vssd1 vccd1 vccd1 _04522_ sky130_fd_sc_hd__inv_2
X_11398_ _05480_ _05493_ vssd1 vssd1 vccd1 vccd1 _05494_ sky130_fd_sc_hd__and2_1
X_13137_ clknet_leaf_4_clk_i _00523_ vssd1 vssd1 vccd1 vccd1 det_t\[30\] sky130_fd_sc_hd__dfxtp_1
X_10349_ net851 net841 net947 net942 vssd1 vssd1 vccd1 vccd1 _04453_ sky130_fd_sc_hd__nand4_2
XTAP_704 vssd1 vccd1 sky130_fd_sc_hd__tapvpwrvgnd_1
XTAP_715 vssd1 vccd1 sky130_fd_sc_hd__tapvpwrvgnd_1
X_13068_ clknet_leaf_30_clk_i _00454_ net1166 vssd1 vssd1 vccd1 vccd1 y2my0\[25\]
+ sky130_fd_sc_hd__dfrtp_1
XFILLER_0_29_55 vssd1 vssd1 vccd1 vccd1 sky130_fd_sc_hd__fill_1
XTAP_726 vssd1 vccd1 sky130_fd_sc_hd__tapvpwrvgnd_1
XTAP_737 vssd1 vccd1 sky130_fd_sc_hd__tapvpwrvgnd_1
XTAP_748 vssd1 vccd1 sky130_fd_sc_hd__tapvpwrvgnd_1
XTAP_759 vssd1 vccd1 sky130_fd_sc_hd__tapvpwrvgnd_1
X_12019_ net23 net552 net626 net207 _06018_ vssd1 vssd1 vccd1 vccd1 _06019_ sky130_fd_sc_hd__a221o_1
X_07560_ net1104 net820 net813 net1113 vssd1 vssd1 vccd1 vccd1 _01684_ sky130_fd_sc_hd__a22o_1
X_06511_ det_t\[21\] net528 vssd1 vssd1 vccd1 vccd1 net265 sky130_fd_sc_hd__and2_1
X_09230_ _03180_ _03183_ _03337_ _03338_ vssd1 vssd1 vccd1 vccd1 _03341_ sky130_fd_sc_hd__o211ai_2
XFILLER_0_75_225 vssd1 vssd1 vccd1 vccd1 sky130_fd_sc_hd__fill_2
X_07491_ _01587_ _01605_ _01607_ _01613_ vssd1 vssd1 vccd1 vccd1 _01616_ sky130_fd_sc_hd__a211o_1
XFILLER_0_91_729 vssd1 vssd1 vccd1 vccd1 sky130_ef_sc_hd__decap_12
X_06442_ _00740_ _00741_ vssd1 vssd1 vccd1 vccd1 _00743_ sky130_fd_sc_hd__nor2_1
XFILLER_0_28_141 vssd1 vssd1 vccd1 vccd1 sky130_fd_sc_hd__decap_8
X_06373_ net545 _00683_ vssd1 vssd1 vccd1 vccd1 net311 sky130_fd_sc_hd__nor2_1
X_09161_ _03270_ _03271_ vssd1 vssd1 vccd1 vccd1 _03272_ sky130_fd_sc_hd__or2_1
XFILLER_0_43_100 vssd1 vssd1 vccd1 vccd1 sky130_fd_sc_hd__decap_4
X_09092_ _03194_ _03202_ vssd1 vssd1 vccd1 vccd1 _03204_ sky130_fd_sc_hd__xor2_1
X_08112_ net1015 net1024 net875 net865 vssd1 vssd1 vccd1 vccd1 _02231_ sky130_fd_sc_hd__nand4_2
XFILLER_0_56_494 vssd1 vssd1 vccd1 vccd1 sky130_fd_sc_hd__decap_3
XFILLER_0_114_533 vssd1 vssd1 vccd1 vccd1 sky130_ef_sc_hd__decap_12
X_08043_ _01945_ _02054_ _02053_ vssd1 vssd1 vccd1 vccd1 _02163_ sky130_fd_sc_hd__o21ai_2
XFILLER_0_43_177 vssd1 vssd1 vccd1 vccd1 sky130_fd_sc_hd__decap_8
XFILLER_0_9_98 vssd1 vssd1 vccd1 vccd1 sky130_fd_sc_hd__decap_3
XFILLER_0_101_216 vssd1 vssd1 vccd1 vccd1 sky130_fd_sc_hd__fill_2
XFILLER_0_101_81 vssd1 vssd1 vccd1 vccd1 sky130_ef_sc_hd__decap_12
X_09994_ _04097_ _04098_ _04093_ vssd1 vssd1 vccd1 vccd1 _04100_ sky130_fd_sc_hd__a21o_1
XFILLER_0_86_61 vssd1 vssd1 vccd1 vccd1 sky130_fd_sc_hd__decap_3
X_08945_ _03057_ _03052_ vssd1 vssd1 vccd1 vccd1 _03058_ sky130_fd_sc_hd__and2b_1
X_08876_ _02882_ _02886_ _02987_ net464 vssd1 vssd1 vccd1 vccd1 _02989_ sky130_fd_sc_hd__a211oi_2
X_07827_ _01946_ _01948_ vssd1 vssd1 vccd1 vccd1 _01949_ sky130_fd_sc_hd__xnor2_2
X_07758_ net1106 net805 vssd1 vssd1 vccd1 vccd1 _01880_ sky130_fd_sc_hd__nand2_1
XFILLER_0_67_726 vssd1 vssd1 vccd1 vccd1 sky130_fd_sc_hd__fill_2
XFILLER_0_67_715 vssd1 vssd1 vccd1 vccd1 sky130_fd_sc_hd__fill_1
X_06709_ sub1.b_i\[24\] sub1.a_i\[24\] vssd1 vssd1 vccd1 vccd1 _00930_ sky130_fd_sc_hd__and2b_1
X_07689_ _01809_ _01810_ _01716_ _01719_ vssd1 vssd1 vccd1 vccd1 _01812_ sky130_fd_sc_hd__a211o_1
XFILLER_0_39_428 vssd1 vssd1 vccd1 vccd1 sky130_fd_sc_hd__fill_1
X_09428_ net939 _03537_ _03536_ vssd1 vssd1 vccd1 vccd1 _03538_ sky130_fd_sc_hd__a21bo_1
XFILLER_0_125_809 vssd1 vssd1 vccd1 vccd1 sky130_ef_sc_hd__decap_12
X_09359_ net1080 net746 vssd1 vssd1 vccd1 vccd1 _03469_ sky130_fd_sc_hd__nand2_1
XFILLER_0_94_589 vssd1 vssd1 vccd1 vccd1 sky130_fd_sc_hd__fill_2
X_12370_ net1487 _00940_ net661 vssd1 vssd1 vccd1 vccd1 _00422_ sky130_fd_sc_hd__mux2_1
XFILLER_0_117_393 vssd1 vssd1 vccd1 vccd1 sky130_ef_sc_hd__decap_12
XFILLER_0_50_615 vssd1 vssd1 vccd1 vccd1 sky130_ef_sc_hd__decap_12
XFILLER_0_22_317 vssd1 vssd1 vccd1 vccd1 sky130_fd_sc_hd__decap_4
X_11321_ _05237_ _05239_ _05417_ vssd1 vssd1 vccd1 vccd1 _05418_ sky130_fd_sc_hd__a21o_1
XFILLER_0_35_689 vssd1 vssd1 vccd1 vccd1 sky130_fd_sc_hd__decap_3
XFILLER_0_120_525 vssd1 vssd1 vccd1 vccd1 sky130_fd_sc_hd__decap_6
X_11252_ _05347_ _05348_ vssd1 vssd1 vccd1 vccd1 _05349_ sky130_fd_sc_hd__or2_1
XFILLER_0_120_569 vssd1 vssd1 vccd1 vccd1 sky130_ef_sc_hd__decap_12
X_10203_ _04145_ _04148_ _04305_ _04306_ vssd1 vssd1 vccd1 vccd1 _04308_ sky130_fd_sc_hd__o211ai_4
X_11183_ _05279_ _05280_ vssd1 vssd1 vccd1 vccd1 _05281_ sky130_fd_sc_hd__nand2_1
XFILLER_0_30_383 vssd1 vssd1 vccd1 vccd1 sky130_fd_sc_hd__decap_4
X_10134_ _04234_ _04238_ vssd1 vssd1 vccd1 vccd1 _04239_ sky130_fd_sc_hd__xnor2_1
X_10065_ _04169_ _04170_ _04003_ _04006_ vssd1 vssd1 vccd1 vccd1 _04171_ sky130_fd_sc_hd__o211a_1
XFILLER_0_106_15 vssd1 vssd1 vccd1 vccd1 sky130_ef_sc_hd__decap_12
XFILLER_0_15_57 vssd1 vssd1 vccd1 vccd1 sky130_ef_sc_hd__decap_12
XFILLER_0_85_545 vssd1 vssd1 vccd1 vccd1 sky130_fd_sc_hd__decap_8
X_10967_ _04893_ _04938_ net453 _05066_ vssd1 vssd1 vccd1 vccd1 _05067_ sky130_fd_sc_hd__a211oi_4
XFILLER_0_128_625 vssd1 vssd1 vccd1 vccd1 sky130_ef_sc_hd__decap_12
XFILLER_0_127_113 vssd1 vssd1 vccd1 vccd1 sky130_ef_sc_hd__decap_12
X_12706_ clknet_leaf_13_clk_i net1254 net1190 vssd1 vssd1 vccd1 vccd1 net437 sky130_fd_sc_hd__dfrtp_1
XFILLER_0_57_247 vssd1 vssd1 vccd1 vccd1 sky130_fd_sc_hd__fill_1
X_10898_ _04988_ _04996_ vssd1 vssd1 vccd1 vccd1 _04998_ sky130_fd_sc_hd__nand2_1
XFILLER_0_26_623 vssd1 vssd1 vccd1 vccd1 sky130_fd_sc_hd__fill_1
X_12637_ clknet_leaf_26_clk_i _00023_ net1171 vssd1 vssd1 vccd1 vccd1 net362 sky130_fd_sc_hd__dfrtp_1
XFILLER_0_127_179 vssd1 vssd1 vccd1 vccd1 sky130_fd_sc_hd__fill_2
XFILLER_0_25_111 vssd1 vssd1 vccd1 vccd1 sky130_fd_sc_hd__fill_1
X_12568_ net1429 net12 net560 vssd1 vssd1 vccd1 vccd1 _00544_ sky130_fd_sc_hd__mux2_1
XFILLER_0_80_261 vssd1 vssd1 vccd1 vccd1 sky130_ef_sc_hd__decap_12
XFILLER_0_14_829 vssd1 vssd1 vccd1 vccd1 sky130_fd_sc_hd__fill_1
XFILLER_0_41_615 vssd1 vssd1 vccd1 vccd1 sky130_fd_sc_hd__fill_1
X_12499_ _00793_ net562 _06246_ vssd1 vssd1 vccd1 vccd1 _00500_ sky130_fd_sc_hd__o21ai_1
XFILLER_0_111_503 vssd1 vssd1 vccd1 vccd1 sky130_fd_sc_hd__fill_1
Xhold207 _00090_ vssd1 vssd1 vccd1 vccd1 net1422 sky130_fd_sc_hd__dlygate4sd3_1
X_11519_ net712 _05613_ _05612_ vssd1 vssd1 vccd1 vccd1 _05614_ sky130_fd_sc_hd__a21bo_1
XFILLER_0_123_385 vssd1 vssd1 vccd1 vccd1 sky130_fd_sc_hd__decap_6
Xhold229 add1.a_i\[11\] vssd1 vssd1 vccd1 vccd1 net1444 sky130_fd_sc_hd__dlygate4sd3_1
Xhold218 x0mx2\[31\] vssd1 vssd1 vccd1 vccd1 net1433 sky130_fd_sc_hd__dlygate4sd3_1
XTAP_501 vssd1 vccd1 sky130_fd_sc_hd__tapvpwrvgnd_1
XTAP_512 vssd1 vccd1 sky130_fd_sc_hd__tapvpwrvgnd_1
XTAP_523 vssd1 vccd1 sky130_fd_sc_hd__tapvpwrvgnd_1
XTAP_534 vssd1 vccd1 sky130_fd_sc_hd__tapvpwrvgnd_1
Xfanout709 mul1.b\[28\] vssd1 vssd1 vccd1 vccd1 net709 sky130_fd_sc_hd__buf_2
XTAP_545 vssd1 vccd1 sky130_fd_sc_hd__tapvpwrvgnd_1
XTAP_556 vssd1 vccd1 sky130_fd_sc_hd__tapvpwrvgnd_1
XTAP_567 vssd1 vccd1 sky130_fd_sc_hd__tapvpwrvgnd_1
X_06991_ _01114_ _01115_ vssd1 vssd1 vccd1 vccd1 _01116_ sky130_fd_sc_hd__nor2_1
X_08730_ net1148 net716 vssd1 vssd1 vccd1 vccd1 _02844_ sky130_fd_sc_hd__nand2_1
XTAP_578 vssd1 vccd1 sky130_fd_sc_hd__tapvpwrvgnd_1
XTAP_589 vssd1 vccd1 sky130_fd_sc_hd__tapvpwrvgnd_1
X_08661_ _02774_ _02775_ _02773_ vssd1 vssd1 vccd1 vccd1 _02776_ sky130_fd_sc_hd__a21o_1
X_07612_ _01713_ _01732_ _01733_ vssd1 vssd1 vccd1 vccd1 _01736_ sky130_fd_sc_hd__nand3_2
X_08592_ net1085 net1092 net764 vssd1 vssd1 vccd1 vccd1 _02707_ sky130_fd_sc_hd__and3_1
XFILLER_0_49_726 vssd1 vssd1 vccd1 vccd1 sky130_fd_sc_hd__fill_2
XFILLER_0_76_512 vssd1 vssd1 vccd1 vccd1 sky130_fd_sc_hd__decap_6
XFILLER_0_72_85 vssd1 vssd1 vccd1 vccd1 sky130_fd_sc_hd__decap_6
X_07543_ temp1\[0\] _01667_ net540 vssd1 vssd1 vccd1 vccd1 _01668_ sky130_fd_sc_hd__mux2_1
X_07474_ net881 net1145 _01596_ _01597_ vssd1 vssd1 vccd1 vccd1 _01599_ sky130_fd_sc_hd__o2bb2a_1
X_09213_ net1044 net784 vssd1 vssd1 vccd1 vccd1 _03324_ sky130_fd_sc_hd__nand2_1
XFILLER_0_76_589 vssd1 vssd1 vccd1 vccd1 sky130_ef_sc_hd__decap_12
X_06425_ add1.a_i\[22\] add1.b_i\[22\] vssd1 vssd1 vccd1 vccd1 _00728_ sky130_fd_sc_hd__or2_1
X_09144_ _03253_ _03254_ _03093_ _03095_ vssd1 vssd1 vccd1 vccd1 _03256_ sky130_fd_sc_hd__a211oi_1
XFILLER_0_72_784 vssd1 vssd1 vccd1 vccd1 sky130_fd_sc_hd__fill_2
XFILLER_0_71_250 vssd1 vssd1 vccd1 vccd1 sky130_fd_sc_hd__decap_6
X_06356_ _00633_ _00667_ vssd1 vssd1 vccd1 vccd1 _00668_ sky130_fd_sc_hd__nand2_2
XFILLER_0_44_475 vssd1 vssd1 vccd1 vccd1 sky130_fd_sc_hd__fill_1
XFILLER_0_114_363 vssd1 vssd1 vccd1 vccd1 sky130_fd_sc_hd__fill_1
X_09075_ _03185_ _03186_ _03021_ _03024_ vssd1 vssd1 vccd1 vccd1 _03187_ sky130_fd_sc_hd__a211oi_2
XFILLER_0_44_497 vssd1 vssd1 vccd1 vccd1 sky130_fd_sc_hd__decap_3
X_06287_ _00602_ vssd1 vssd1 vccd1 vccd1 net333 sky130_fd_sc_hd__inv_2
X_08026_ _02142_ _02143_ _02125_ vssd1 vssd1 vccd1 vccd1 _02146_ sky130_fd_sc_hd__a21oi_2
XFILLER_0_31_147 vssd1 vssd1 vccd1 vccd1 sky130_fd_sc_hd__decap_6
Xmax_cap460 _02656_ vssd1 vssd1 vccd1 vccd1 net460 sky130_fd_sc_hd__clkbuf_2
Xmax_cap493 net1754 vssd1 vssd1 vccd1 vccd1 net493 sky130_fd_sc_hd__clkbuf_1
X_09977_ _04079_ _04082_ vssd1 vssd1 vccd1 vccd1 _04083_ sky130_fd_sc_hd__and2_1
X_08928_ _02892_ _02895_ _02894_ vssd1 vssd1 vccd1 vccd1 _03041_ sky130_fd_sc_hd__o21ai_1
X_08859_ _02970_ _02971_ vssd1 vssd1 vccd1 vccd1 _02972_ sky130_fd_sc_hd__nor2_1
XFILLER_0_99_648 vssd1 vssd1 vccd1 vccd1 sky130_fd_sc_hd__fill_1
XFILLER_0_86_309 vssd1 vssd1 vccd1 vccd1 sky130_ef_sc_hd__decap_12
X_11870_ net1298 _05904_ net482 vssd1 vssd1 vccd1 vccd1 _00213_ sky130_fd_sc_hd__mux2_1
XFILLER_0_79_383 vssd1 vssd1 vccd1 vccd1 sky130_fd_sc_hd__fill_1
X_10821_ _04920_ _04921_ vssd1 vssd1 vccd1 vccd1 _04922_ sky130_fd_sc_hd__and2_1
XFILLER_0_67_512 vssd1 vssd1 vccd1 vccd1 sky130_fd_sc_hd__decap_4
XFILLER_0_39_225 vssd1 vssd1 vccd1 vccd1 sky130_fd_sc_hd__fill_1
XFILLER_0_109_113 vssd1 vssd1 vccd1 vccd1 sky130_ef_sc_hd__decap_12
X_10752_ _04849_ _04851_ _04828_ vssd1 vssd1 vccd1 vccd1 _04853_ sky130_fd_sc_hd__o21a_1
XFILLER_0_39_236 vssd1 vssd1 vccd1 vccd1 sky130_fd_sc_hd__decap_4
XFILLER_0_82_526 vssd1 vssd1 vccd1 vccd1 sky130_fd_sc_hd__decap_6
XFILLER_0_54_206 vssd1 vssd1 vccd1 vccd1 sky130_fd_sc_hd__decap_8
XFILLER_0_125_617 vssd1 vssd1 vccd1 vccd1 sky130_ef_sc_hd__decap_12
X_10683_ _04636_ _04639_ _04782_ _04783_ vssd1 vssd1 vccd1 vccd1 _04785_ sky130_fd_sc_hd__a211oi_4
X_12422_ net1696 _06203_ net570 vssd1 vssd1 vccd1 vccd1 _00466_ sky130_fd_sc_hd__mux2_1
XFILLER_0_62_250 vssd1 vssd1 vccd1 vccd1 sky130_fd_sc_hd__fill_2
XFILLER_0_23_615 vssd1 vssd1 vccd1 vccd1 sky130_fd_sc_hd__fill_1
XFILLER_0_22_114 vssd1 vssd1 vccd1 vccd1 sky130_ef_sc_hd__decap_12
X_12353_ net1473 _00852_ net657 vssd1 vssd1 vccd1 vccd1 _00405_ sky130_fd_sc_hd__mux2_1
X_11304_ _05275_ _05276_ _05277_ _05274_ vssd1 vssd1 vccd1 vccd1 _05401_ sky130_fd_sc_hd__o31ai_2
X_12284_ net1680 _00823_ net676 vssd1 vssd1 vccd1 vccd1 _00336_ sky130_fd_sc_hd__mux2_1
XFILLER_0_120_333 vssd1 vssd1 vccd1 vccd1 sky130_ef_sc_hd__decap_12
X_11235_ net807 net934 vssd1 vssd1 vccd1 vccd1 _05332_ sky130_fd_sc_hd__nand2_1
XFILLER_0_120_377 vssd1 vssd1 vccd1 vccd1 sky130_ef_sc_hd__decap_12
X_11166_ _05100_ _05137_ _05262_ _05263_ vssd1 vssd1 vccd1 vccd1 _05264_ sky130_fd_sc_hd__o211a_1
X_11097_ _05193_ _05194_ _05037_ _05040_ vssd1 vssd1 vccd1 vccd1 _05196_ sky130_fd_sc_hd__a211o_1
X_10117_ temp1\[19\] _04222_ net543 vssd1 vssd1 vccd1 vccd1 _04223_ sky130_fd_sc_hd__mux2_1
X_10048_ _04152_ _04153_ vssd1 vssd1 vccd1 vccd1 _04154_ sky130_fd_sc_hd__nor2_2
XFILLER_0_117_69 vssd1 vssd1 vccd1 vccd1 sky130_ef_sc_hd__decap_12
Xhold90 sub1.a_i\[12\] vssd1 vssd1 vccd1 vccd1 net1305 sky130_fd_sc_hd__dlygate4sd3_1
XFILLER_0_98_670 vssd1 vssd1 vccd1 vccd1 sky130_ef_sc_hd__decap_12
XFILLER_0_85_353 vssd1 vssd1 vccd1 vccd1 sky130_fd_sc_hd__decap_3
X_11999_ net18 net552 net626 net202 _06003_ vssd1 vssd1 vccd1 vccd1 _06004_ sky130_fd_sc_hd__a221o_1
XFILLER_0_85_386 vssd1 vssd1 vccd1 vccd1 sky130_fd_sc_hd__decap_6
XFILLER_0_45_217 vssd1 vssd1 vccd1 vccd1 sky130_fd_sc_hd__decap_3
XFILLER_0_128_477 vssd1 vssd1 vccd1 vccd1 sky130_ef_sc_hd__decap_12
XFILLER_0_128_466 vssd1 vssd1 vccd1 vccd1 sky130_fd_sc_hd__decap_8
XFILLER_0_115_105 vssd1 vssd1 vccd1 vccd1 sky130_fd_sc_hd__decap_6
XFILLER_0_6_826 vssd1 vssd1 vccd1 vccd1 sky130_ef_sc_hd__decap_12
XFILLER_0_26_475 vssd1 vssd1 vccd1 vccd1 sky130_fd_sc_hd__fill_1
X_07190_ _01310_ _01314_ vssd1 vssd1 vccd1 vccd1 _01315_ sky130_fd_sc_hd__nand2_1
XFILLER_0_115_149 vssd1 vssd1 vccd1 vccd1 sky130_ef_sc_hd__decap_12
XFILLER_0_13_125 vssd1 vssd1 vccd1 vccd1 sky130_ef_sc_hd__decap_12
XFILLER_0_41_434 vssd1 vssd1 vccd1 vccd1 sky130_fd_sc_hd__fill_2
XFILLER_0_123_193 vssd1 vssd1 vccd1 vccd1 sky130_ef_sc_hd__decap_12
X_09900_ _03992_ _04005_ _04006_ vssd1 vssd1 vccd1 vccd1 _04007_ sky130_fd_sc_hd__and3_1
XFILLER_0_1_531 vssd1 vssd1 vccd1 vccd1 sky130_fd_sc_hd__fill_2
XFILLER_0_13_169 vssd1 vssd1 vccd1 vccd1 sky130_fd_sc_hd__fill_1
XFILLER_0_21_191 vssd1 vssd1 vccd1 vccd1 sky130_fd_sc_hd__decap_4
Xfanout528 net529 vssd1 vssd1 vccd1 vccd1 net528 sky130_fd_sc_hd__clkbuf_2
X_09831_ _03932_ _03936_ _03937_ vssd1 vssd1 vccd1 vccd1 _03938_ sky130_fd_sc_hd__nand3_2
XTAP_342 vssd1 vccd1 sky130_fd_sc_hd__tapvpwrvgnd_1
XTAP_331 vssd1 vccd1 sky130_fd_sc_hd__tapvpwrvgnd_1
XTAP_320 vssd1 vccd1 sky130_fd_sc_hd__tapvpwrvgnd_1
Xfanout517 net518 vssd1 vssd1 vccd1 vccd1 net517 sky130_fd_sc_hd__clkbuf_4
Xfanout539 _05755_ vssd1 vssd1 vccd1 vccd1 net539 sky130_fd_sc_hd__buf_4
X_09762_ _03869_ vssd1 vssd1 vccd1 vccd1 _03870_ sky130_fd_sc_hd__inv_2
XTAP_375 vssd1 vccd1 sky130_fd_sc_hd__tapvpwrvgnd_1
XTAP_364 vssd1 vccd1 sky130_fd_sc_hd__tapvpwrvgnd_1
XTAP_353 vssd1 vccd1 sky130_fd_sc_hd__tapvpwrvgnd_1
X_06974_ _01083_ _01097_ _01098_ vssd1 vssd1 vccd1 vccd1 _01099_ sky130_fd_sc_hd__nand3_2
X_08713_ net1122 net734 _02702_ _02701_ vssd1 vssd1 vccd1 vccd1 _02827_ sky130_fd_sc_hd__a31o_1
XTAP_397 vssd1 vccd1 sky130_fd_sc_hd__tapvpwrvgnd_1
XTAP_386 vssd1 vccd1 sky130_fd_sc_hd__tapvpwrvgnd_1
X_09693_ _03799_ _03800_ vssd1 vssd1 vccd1 vccd1 _03801_ sky130_fd_sc_hd__nor2_1
XFILLER_0_83_51 vssd1 vssd1 vccd1 vccd1 sky130_fd_sc_hd__decap_4
Xclkbuf_leaf_32_clk_i clknet_3_4__leaf_clk_i vssd1 vssd1 vccd1 vccd1 clknet_leaf_32_clk_i
+ sky130_fd_sc_hd__clkbuf_16
XTAP_2209 vssd1 vccd1 sky130_fd_sc_hd__tapvpwrvgnd_1
X_08644_ net869 net993 net987 net877 vssd1 vssd1 vccd1 vccd1 _02759_ sky130_fd_sc_hd__a22oi_1
X_08575_ _02551_ _02689_ vssd1 vssd1 vccd1 vccd1 _02690_ sky130_fd_sc_hd__xor2_1
XFILLER_0_89_681 vssd1 vssd1 vccd1 vccd1 sky130_fd_sc_hd__fill_1
XTAP_1519 vssd1 vccd1 sky130_fd_sc_hd__tapvpwrvgnd_1
XTAP_1508 vssd1 vccd1 sky130_fd_sc_hd__tapvpwrvgnd_1
XPHY_15 vssd1 vssd1 vccd1 vccd1 sky130_fd_sc_hd__decap_3
XPHY_26 vssd1 vssd1 vccd1 vccd1 sky130_fd_sc_hd__decap_3
XPHY_37 vssd1 vssd1 vccd1 vccd1 sky130_fd_sc_hd__decap_3
XFILLER_0_49_567 vssd1 vssd1 vccd1 vccd1 sky130_fd_sc_hd__decap_8
X_07526_ _01618_ _01634_ _01637_ _01648_ vssd1 vssd1 vccd1 vccd1 _01651_ sky130_fd_sc_hd__a22o_1
XPHY_48 vssd1 vssd1 vccd1 vccd1 sky130_fd_sc_hd__decap_3
XPHY_59 vssd1 vssd1 vccd1 vccd1 sky130_fd_sc_hd__decap_3
XFILLER_0_91_301 vssd1 vssd1 vccd1 vccd1 sky130_fd_sc_hd__fill_1
Xclkbuf_leaf_47_clk_i clknet_3_1__leaf_clk_i vssd1 vssd1 vccd1 vccd1 clknet_leaf_47_clk_i
+ sky130_fd_sc_hd__clkbuf_16
XFILLER_0_107_617 vssd1 vssd1 vccd1 vccd1 sky130_ef_sc_hd__decap_12
XFILLER_0_91_323 vssd1 vssd1 vccd1 vccd1 sky130_fd_sc_hd__fill_2
X_07457_ _01554_ _01580_ vssd1 vssd1 vccd1 vccd1 _01582_ sky130_fd_sc_hd__xnor2_1
X_06408_ net546 _00713_ vssd1 vssd1 vccd1 vccd1 net317 sky130_fd_sc_hd__nor2_1
XFILLER_0_91_389 vssd1 vssd1 vccd1 vccd1 sky130_fd_sc_hd__decap_3
XFILLER_0_91_378 vssd1 vssd1 vccd1 vccd1 sky130_fd_sc_hd__decap_4
X_07388_ _01482_ _01494_ _01493_ vssd1 vssd1 vccd1 vccd1 _01513_ sky130_fd_sc_hd__o21ai_1
X_09127_ _03218_ _03235_ _03236_ vssd1 vssd1 vccd1 vccd1 _03239_ sky130_fd_sc_hd__nand3_1
X_06339_ add1.a_i\[1\] add1.b_i\[1\] vssd1 vssd1 vccd1 vccd1 _00651_ sky130_fd_sc_hd__or2_1
X_09058_ net1035 net810 _03030_ _03031_ vssd1 vssd1 vccd1 vccd1 _03170_ sky130_fd_sc_hd__a31oi_2
XFILLER_0_102_333 vssd1 vssd1 vccd1 vccd1 sky130_fd_sc_hd__decap_4
X_08009_ net1015 net882 _02126_ _02127_ vssd1 vssd1 vccd1 vccd1 _02129_ sky130_fd_sc_hd__o2bb2a_1
XFILLER_0_13_670 vssd1 vssd1 vccd1 vccd1 sky130_fd_sc_hd__fill_2
XFILLER_0_130_697 vssd1 vssd1 vccd1 vccd1 sky130_fd_sc_hd__decap_3
X_11020_ net807 net945 _04963_ _04962_ vssd1 vssd1 vccd1 vccd1 _05119_ sky130_fd_sc_hd__a31oi_2
X_12971_ clknet_leaf_32_clk_i _00357_ net1166 vssd1 vssd1 vccd1 vccd1 y1my2\[24\]
+ sky130_fd_sc_hd__dfrtp_1
X_11922_ net117 net620 net594 net85 vssd1 vssd1 vccd1 vccd1 _05946_ sky130_fd_sc_hd__a22o_1
XFILLER_0_86_128 vssd1 vssd1 vccd1 vccd1 sky130_fd_sc_hd__fill_1
XFILLER_0_68_821 vssd1 vssd1 vccd1 vccd1 sky130_fd_sc_hd__fill_1
X_11853_ net46 net688 net679 net74 vssd1 vssd1 vccd1 vccd1 _05890_ sky130_fd_sc_hd__a22o_1
XFILLER_0_79_191 vssd1 vssd1 vccd1 vccd1 sky130_ef_sc_hd__decap_12
X_10804_ net1078 net699 net695 net1070 vssd1 vssd1 vccd1 vccd1 _04905_ sky130_fd_sc_hd__and4b_1
XFILLER_0_67_342 vssd1 vssd1 vccd1 vccd1 sky130_fd_sc_hd__decap_4
XFILLER_0_95_673 vssd1 vssd1 vccd1 vccd1 sky130_ef_sc_hd__decap_12
X_11784_ net63 net674 net608 net191 vssd1 vssd1 vccd1 vccd1 _05831_ sky130_fd_sc_hd__a22o_1
XFILLER_0_103_27 vssd1 vssd1 vccd1 vccd1 sky130_ef_sc_hd__decap_12
XFILLER_0_82_323 vssd1 vssd1 vccd1 vccd1 sky130_fd_sc_hd__fill_2
XFILLER_0_55_559 vssd1 vssd1 vccd1 vccd1 sky130_fd_sc_hd__fill_1
X_10735_ net853 net844 net928 vssd1 vssd1 vccd1 vccd1 _04836_ sky130_fd_sc_hd__and3_1
XFILLER_0_125_447 vssd1 vssd1 vccd1 vccd1 sky130_fd_sc_hd__fill_1
X_10666_ _04766_ _04767_ vssd1 vssd1 vccd1 vccd1 _04768_ sky130_fd_sc_hd__or2_1
XFILLER_0_113_609 vssd1 vssd1 vccd1 vccd1 sky130_fd_sc_hd__decap_6
X_12405_ net1493 _00960_ net685 vssd1 vssd1 vccd1 vccd1 _00457_ sky130_fd_sc_hd__mux2_1
XFILLER_0_88_29 vssd1 vssd1 vccd1 vccd1 sky130_ef_sc_hd__decap_12
X_10597_ _04535_ _04539_ _04698_ vssd1 vssd1 vccd1 vccd1 _04699_ sky130_fd_sc_hd__o21a_1
XFILLER_0_121_653 vssd1 vssd1 vccd1 vccd1 sky130_ef_sc_hd__decap_12
X_12336_ net1633 _00928_ net671 vssd1 vssd1 vccd1 vccd1 _00388_ sky130_fd_sc_hd__mux2_1
XFILLER_0_120_141 vssd1 vssd1 vccd1 vccd1 sky130_ef_sc_hd__decap_12
X_12267_ net1576 net44 net690 vssd1 vssd1 vccd1 vccd1 _00321_ sky130_fd_sc_hd__mux2_1
XFILLER_0_121_697 vssd1 vssd1 vccd1 vccd1 sky130_ef_sc_hd__decap_12
X_11218_ _05313_ _05314_ _05157_ _05160_ vssd1 vssd1 vccd1 vccd1 _05316_ sky130_fd_sc_hd__o211a_1
X_12198_ x2mx1\[11\] net603 net583 temp1\[11\] vssd1 vssd1 vccd1 vccd1 _06152_ sky130_fd_sc_hd__a22o_1
X_11149_ net782 net952 _05244_ _05245_ vssd1 vssd1 vccd1 vccd1 _05247_ sky130_fd_sc_hd__o2bb2a_1
Xinput180 v1y[4] vssd1 vssd1 vccd1 vccd1 net180 sky130_fd_sc_hd__buf_1
X_06690_ _00911_ _00912_ _00909_ vssd1 vssd1 vccd1 vccd1 _00914_ sky130_fd_sc_hd__o21ai_4
Xinput191 v2x[14] vssd1 vssd1 vccd1 vccd1 net191 sky130_fd_sc_hd__buf_1
X_08360_ _02474_ _02475_ _02476_ vssd1 vssd1 vccd1 vccd1 _02477_ sky130_fd_sc_hd__nand3_1
XFILLER_0_77_139 vssd1 vssd1 vccd1 vccd1 sky130_fd_sc_hd__decap_4
X_07311_ _01430_ _01435_ vssd1 vssd1 vccd1 vccd1 _01436_ sky130_fd_sc_hd__nand2_1
XFILLER_0_85_183 vssd1 vssd1 vccd1 vccd1 sky130_ef_sc_hd__decap_12
X_08291_ net1361 _02408_ net522 vssd1 vssd1 vccd1 vccd1 _00130_ sky130_fd_sc_hd__mux2_1
X_07242_ _01358_ _01366_ vssd1 vssd1 vccd1 vccd1 _01367_ sky130_fd_sc_hd__nand2_1
XFILLER_0_116_469 vssd1 vssd1 vccd1 vccd1 sky130_fd_sc_hd__decap_6
X_07173_ net871 net1111 net1118 net862 vssd1 vssd1 vccd1 vccd1 _01298_ sky130_fd_sc_hd__a22o_1
XFILLER_0_14_434 vssd1 vssd1 vccd1 vccd1 sky130_fd_sc_hd__fill_1
XFILLER_0_42_765 vssd1 vssd1 vccd1 vccd1 sky130_fd_sc_hd__fill_1
XFILLER_0_2_840 vssd1 vssd1 vccd1 vccd1 sky130_fd_sc_hd__fill_2
XFILLER_0_68_3 vssd1 vssd1 vccd1 vccd1 sky130_ef_sc_hd__decap_12
X_09814_ _03919_ _03920_ vssd1 vssd1 vccd1 vccd1 _03921_ sky130_fd_sc_hd__nor2_1
XFILLER_0_10_673 vssd1 vssd1 vccd1 vccd1 sky130_fd_sc_hd__decap_4
X_09745_ _03685_ _03688_ _03849_ _03851_ vssd1 vssd1 vccd1 vccd1 _03853_ sky130_fd_sc_hd__a211o_1
X_06957_ _01020_ _01022_ vssd1 vssd1 vccd1 vccd1 _01082_ sky130_fd_sc_hd__xnor2_1
XTAP_2006 vssd1 vccd1 sky130_fd_sc_hd__tapvpwrvgnd_1
X_09676_ _03782_ _03783_ _03775_ vssd1 vssd1 vccd1 vccd1 _03784_ sky130_fd_sc_hd__a21o_1
X_06888_ net1 _00609_ _00988_ _01004_ state\[0\] vssd1 vssd1 vccd1 vccd1 _01013_ sky130_fd_sc_hd__o221a_1
XTAP_2039 vssd1 vccd1 sky130_fd_sc_hd__tapvpwrvgnd_1
XTAP_2028 vssd1 vccd1 sky130_fd_sc_hd__tapvpwrvgnd_1
XTAP_2017 vssd1 vccd1 sky130_fd_sc_hd__tapvpwrvgnd_1
X_08627_ net1016 net843 net1008 net852 vssd1 vssd1 vccd1 vccd1 _02742_ sky130_fd_sc_hd__a22oi_1
XTAP_1305 vssd1 vccd1 sky130_fd_sc_hd__tapvpwrvgnd_1
XTAP_1338 vssd1 vccd1 sky130_fd_sc_hd__tapvpwrvgnd_1
XTAP_1327 vssd1 vccd1 sky130_fd_sc_hd__tapvpwrvgnd_1
XTAP_1316 vssd1 vccd1 sky130_fd_sc_hd__tapvpwrvgnd_1
XFILLER_0_68_139 vssd1 vssd1 vccd1 vccd1 sky130_fd_sc_hd__fill_1
XTAP_1349 vssd1 vccd1 sky130_fd_sc_hd__tapvpwrvgnd_1
X_08558_ net1615 _02673_ net523 vssd1 vssd1 vccd1 vccd1 _00132_ sky130_fd_sc_hd__mux2_1
X_08489_ net1034 net832 _02603_ _02604_ vssd1 vssd1 vccd1 vccd1 _02605_ sky130_fd_sc_hd__a22o_1
X_07509_ _01632_ _01633_ vssd1 vssd1 vccd1 vccd1 _01634_ sky130_fd_sc_hd__nand2_1
X_10520_ _04391_ _04392_ _04393_ _04390_ _04389_ vssd1 vssd1 vccd1 vccd1 _04623_ sky130_fd_sc_hd__o32ai_2
X_10451_ net834 net947 _04551_ _04552_ vssd1 vssd1 vccd1 vccd1 _04554_ sky130_fd_sc_hd__a22o_1
X_13170_ clknet_leaf_9_clk_i _00556_ net1192 vssd1 vssd1 vccd1 vccd1 l0\[31\] sky130_fd_sc_hd__dfrtp_1
X_10382_ net792 net984 net976 net803 vssd1 vssd1 vccd1 vccd1 _04486_ sky130_fd_sc_hd__a22o_1
XFILLER_0_32_253 vssd1 vssd1 vccd1 vccd1 sky130_fd_sc_hd__decap_4
XFILLER_0_102_141 vssd1 vssd1 vccd1 vccd1 sky130_fd_sc_hd__decap_3
X_12121_ y2my0\[21\] net589 net535 x2mx1\[21\] _06096_ vssd1 vssd1 vccd1 vccd1 _06097_
+ sky130_fd_sc_hd__a221o_1
Xhold390 net443 vssd1 vssd1 vccd1 vccd1 net1605 sky130_fd_sc_hd__dlygate4sd3_1
XFILLER_0_103_697 vssd1 vssd1 vccd1 vccd1 sky130_fd_sc_hd__decap_8
XFILLER_0_102_185 vssd1 vssd1 vccd1 vccd1 sky130_fd_sc_hd__decap_6
X_12052_ x0mx2\[4\] net628 net590 y1my2\[4\] vssd1 vssd1 vccd1 vccd1 _06045_ sky130_fd_sc_hd__a22o_1
X_11003_ net989 net982 net750 net742 vssd1 vssd1 vccd1 vccd1 _05102_ sky130_fd_sc_hd__nand4_2
Xfanout870 mul1.b\[7\] vssd1 vssd1 vccd1 vccd1 net870 sky130_fd_sc_hd__buf_2
Xfanout892 net893 vssd1 vssd1 vccd1 vccd1 net892 sky130_fd_sc_hd__buf_2
Xfanout881 net886 vssd1 vssd1 vccd1 vccd1 net881 sky130_fd_sc_hd__buf_2
XFILLER_0_99_264 vssd1 vssd1 vccd1 vccd1 sky130_fd_sc_hd__decap_6
X_12954_ clknet_leaf_53_clk_i _00340_ net1155 vssd1 vssd1 vccd1 vccd1 y1my2\[7\] sky130_fd_sc_hd__dfrtp_1
X_11905_ net1695 _05933_ net477 vssd1 vssd1 vccd1 vccd1 _00219_ sky130_fd_sc_hd__mux2_1
XFILLER_0_114_15 vssd1 vssd1 vccd1 vccd1 sky130_ef_sc_hd__decap_12
X_12885_ clknet_leaf_37_clk_i _00271_ vssd1 vssd1 vccd1 vccd1 mul1.a\[20\] sky130_fd_sc_hd__dfxtp_2
XTAP_1861 vssd1 vccd1 sky130_fd_sc_hd__tapvpwrvgnd_1
XTAP_1850 vssd1 vccd1 sky130_fd_sc_hd__tapvpwrvgnd_1
X_11836_ net167 net471 _05875_ vssd1 vssd1 vccd1 vccd1 _05876_ sky130_fd_sc_hd__o21a_1
XFILLER_0_126_701 vssd1 vssd1 vccd1 vccd1 sky130_ef_sc_hd__decap_12
XTAP_1894 vssd1 vccd1 sky130_fd_sc_hd__tapvpwrvgnd_1
XTAP_1883 vssd1 vccd1 sky130_fd_sc_hd__tapvpwrvgnd_1
XTAP_1872 vssd1 vccd1 sky130_fd_sc_hd__tapvpwrvgnd_1
X_11767_ temp1\[11\] net614 net665 net92 _05816_ vssd1 vssd1 vccd1 vccd1 _05817_ sky130_fd_sc_hd__a221o_1
XFILLER_0_23_57 vssd1 vssd1 vccd1 vccd1 sky130_ef_sc_hd__decap_12
X_10718_ _03584_ _03585_ _03587_ _04379_ _04815_ vssd1 vssd1 vccd1 vccd1 _04819_ sky130_fd_sc_hd__a311o_4
XFILLER_0_83_654 vssd1 vssd1 vccd1 vccd1 sky130_fd_sc_hd__fill_1
XFILLER_0_55_345 vssd1 vssd1 vccd1 vccd1 sky130_fd_sc_hd__decap_3
XFILLER_0_125_244 vssd1 vssd1 vccd1 vccd1 sky130_fd_sc_hd__decap_3
XFILLER_0_99_39 vssd1 vssd1 vccd1 vccd1 sky130_ef_sc_hd__decap_12
X_11698_ net1151 _00989_ vssd1 vssd1 vccd1 vccd1 _05759_ sky130_fd_sc_hd__nor2_4
XFILLER_0_125_266 vssd1 vssd1 vccd1 vccd1 sky130_fd_sc_hd__fill_1
XFILLER_0_113_417 vssd1 vssd1 vccd1 vccd1 sky130_ef_sc_hd__decap_12
X_10649_ _04750_ vssd1 vssd1 vccd1 vccd1 _04751_ sky130_fd_sc_hd__inv_2
XFILLER_0_82_197 vssd1 vssd1 vccd1 vccd1 sky130_ef_sc_hd__decap_12
XFILLER_0_2_114 vssd1 vssd1 vccd1 vccd1 sky130_fd_sc_hd__fill_2
XFILLER_0_121_461 vssd1 vssd1 vccd1 vccd1 sky130_ef_sc_hd__decap_12
XFILLER_0_51_595 vssd1 vssd1 vccd1 vccd1 sky130_fd_sc_hd__decap_8
X_12319_ net1666 _00840_ net666 vssd1 vssd1 vccd1 vccd1 _00371_ sky130_fd_sc_hd__mux2_1
X_07860_ _01980_ _01957_ vssd1 vssd1 vccd1 vccd1 _01981_ sky130_fd_sc_hd__and2b_1
X_06811_ net1516 net1466 net643 vssd1 vssd1 vccd1 vccd1 _00085_ sky130_fd_sc_hd__mux2_1
X_07791_ _01909_ _01912_ vssd1 vssd1 vccd1 vccd1 _01913_ sky130_fd_sc_hd__xnor2_2
X_09530_ net1080 net737 vssd1 vssd1 vccd1 vccd1 _03639_ sky130_fd_sc_hd__nand2_1
X_06742_ _00957_ _00958_ vssd1 vssd1 vccd1 vccd1 _00959_ sky130_fd_sc_hd__nand2_2
X_09461_ _03423_ _03568_ _03569_ vssd1 vssd1 vccd1 vccd1 _03571_ sky130_fd_sc_hd__or3_1
Xwire13 _02264_ vssd1 vssd1 vccd1 vccd1 net1754 sky130_fd_sc_hd__buf_1
X_06673_ _00898_ _00899_ vssd1 vssd1 vccd1 vccd1 _00900_ sky130_fd_sc_hd__nand2b_2
X_09392_ _03500_ _03501_ _03333_ _03336_ vssd1 vssd1 vccd1 vccd1 _03502_ sky130_fd_sc_hd__o211a_1
XFILLER_0_80_41 vssd1 vssd1 vccd1 vccd1 sky130_ef_sc_hd__decap_12
X_08412_ _02525_ _02526_ _02386_ _02389_ vssd1 vssd1 vccd1 vccd1 _02529_ sky130_fd_sc_hd__a211o_1
XFILLER_0_129_561 vssd1 vssd1 vccd1 vccd1 sky130_ef_sc_hd__decap_12
XFILLER_0_129_550 vssd1 vssd1 vccd1 vccd1 sky130_fd_sc_hd__decap_8
X_08343_ _02346_ _02349_ _02457_ _02458_ vssd1 vssd1 vccd1 vccd1 _02460_ sky130_fd_sc_hd__a211o_2
XFILLER_0_74_643 vssd1 vssd1 vccd1 vccd1 sky130_fd_sc_hd__fill_1
XFILLER_0_74_621 vssd1 vssd1 vccd1 vccd1 sky130_fd_sc_hd__decap_8
X_08274_ _02389_ _02390_ _02266_ _02268_ vssd1 vssd1 vccd1 vccd1 _02392_ sky130_fd_sc_hd__o211ai_4
XFILLER_0_34_507 vssd1 vssd1 vccd1 vccd1 sky130_ef_sc_hd__decap_12
XFILLER_0_116_233 vssd1 vssd1 vccd1 vccd1 sky130_ef_sc_hd__decap_12
XFILLER_0_74_698 vssd1 vssd1 vccd1 vccd1 sky130_fd_sc_hd__fill_2
X_07225_ _01235_ _01236_ _01348_ _01349_ vssd1 vssd1 vccd1 vccd1 _01350_ sky130_fd_sc_hd__a211o_2
XFILLER_0_27_570 vssd1 vssd1 vccd1 vccd1 sky130_ef_sc_hd__decap_12
XFILLER_0_34_529 vssd1 vssd1 vccd1 vccd1 sky130_fd_sc_hd__decap_3
XFILLER_0_116_277 vssd1 vssd1 vccd1 vccd1 sky130_ef_sc_hd__decap_12
XFILLER_0_104_417 vssd1 vssd1 vccd1 vccd1 sky130_fd_sc_hd__decap_3
XFILLER_0_61_337 vssd1 vssd1 vccd1 vccd1 sky130_fd_sc_hd__fill_1
XFILLER_0_6_475 vssd1 vssd1 vccd1 vccd1 sky130_fd_sc_hd__fill_1
XFILLER_0_14_253 vssd1 vssd1 vccd1 vccd1 sky130_fd_sc_hd__fill_1
XFILLER_0_14_264 vssd1 vssd1 vccd1 vccd1 sky130_fd_sc_hd__decap_3
X_07156_ _01072_ _01279_ _01280_ vssd1 vssd1 vccd1 vccd1 _01281_ sky130_fd_sc_hd__nand3_1
X_07087_ net899 net1049 net1057 net890 vssd1 vssd1 vccd1 vccd1 _01212_ sky130_fd_sc_hd__a22o_1
XFILLER_0_30_735 vssd1 vssd1 vccd1 vccd1 sky130_fd_sc_hd__fill_1
Xoutput440 net440 vssd1 vssd1 vccd1 vccd1 mstream_o[91] sky130_fd_sc_hd__clkbuf_4
XFILLER_0_100_612 vssd1 vssd1 vccd1 vccd1 sky130_fd_sc_hd__fill_1
XFILLER_0_100_678 vssd1 vssd1 vccd1 vccd1 sky130_ef_sc_hd__decap_12
Xfanout1109 net1110 vssd1 vssd1 vccd1 vccd1 net1109 sky130_fd_sc_hd__dlymetal6s2s_1
X_09728_ net817 net991 net985 net826 vssd1 vssd1 vccd1 vccd1 _03836_ sky130_fd_sc_hd__a22o_1
X_07989_ _02099_ _02107_ vssd1 vssd1 vccd1 vccd1 _02109_ sky130_fd_sc_hd__xnor2_1
X_09659_ _03762_ _03765_ vssd1 vssd1 vccd1 vccd1 _03767_ sky130_fd_sc_hd__xor2_1
XFILLER_0_96_245 vssd1 vssd1 vccd1 vccd1 sky130_fd_sc_hd__fill_1
XTAP_1113 vssd1 vccd1 sky130_fd_sc_hd__tapvpwrvgnd_1
XTAP_1102 vssd1 vccd1 sky130_fd_sc_hd__tapvpwrvgnd_1
X_12670_ clknet_leaf_19_clk_i _00056_ net1178 vssd1 vssd1 vccd1 vccd1 net398 sky130_fd_sc_hd__dfrtp_1
XTAP_1146 vssd1 vccd1 sky130_fd_sc_hd__tapvpwrvgnd_1
XTAP_1135 vssd1 vccd1 sky130_fd_sc_hd__tapvpwrvgnd_1
XTAP_1124 vssd1 vccd1 sky130_fd_sc_hd__tapvpwrvgnd_1
XFILLER_0_108_701 vssd1 vssd1 vccd1 vccd1 sky130_fd_sc_hd__fill_1
XTAP_1168 vssd1 vccd1 sky130_fd_sc_hd__tapvpwrvgnd_1
XTAP_1179 vssd1 vccd1 sky130_fd_sc_hd__tapvpwrvgnd_1
XTAP_1157 vssd1 vccd1 sky130_fd_sc_hd__tapvpwrvgnd_1
X_11621_ _05713_ _05714_ vssd1 vssd1 vccd1 vccd1 _05715_ sky130_fd_sc_hd__xnor2_1
XFILLER_0_65_665 vssd1 vssd1 vccd1 vccd1 sky130_fd_sc_hd__decap_6
XFILLER_0_80_613 vssd1 vssd1 vccd1 vccd1 sky130_fd_sc_hd__fill_1
X_11552_ _05644_ _05645_ _05535_ _05538_ vssd1 vssd1 vccd1 vccd1 _05647_ sky130_fd_sc_hd__a211oi_1
XFILLER_0_107_277 vssd1 vssd1 vccd1 vccd1 sky130_fd_sc_hd__decap_3
XFILLER_0_107_266 vssd1 vssd1 vccd1 vccd1 sky130_fd_sc_hd__decap_6
X_10503_ _04565_ _04566_ _04602_ _04603_ vssd1 vssd1 vccd1 vccd1 _04606_ sky130_fd_sc_hd__a2bb2o_1
X_11483_ _05576_ _05577_ vssd1 vssd1 vccd1 vccd1 _05578_ sky130_fd_sc_hd__nor2_1
X_13222_ net507 vssd1 vssd1 vccd1 vccd1 net277 sky130_fd_sc_hd__clkbuf_1
X_10434_ _04533_ _04534_ _04432_ vssd1 vssd1 vccd1 vccd1 _04537_ sky130_fd_sc_hd__a21o_1
X_13153_ clknet_leaf_12_clk_i _00539_ net1186 vssd1 vssd1 vccd1 vccd1 l0\[14\] sky130_fd_sc_hd__dfrtp_1
X_10365_ _04466_ _04467_ _04331_ _04352_ vssd1 vssd1 vccd1 vccd1 _04469_ sky130_fd_sc_hd__a211oi_1
XFILLER_0_33_595 vssd1 vssd1 vccd1 vccd1 sky130_fd_sc_hd__fill_2
X_12104_ x0mx2\[17\] net630 net591 y1my2\[17\] vssd1 vssd1 vccd1 vccd1 _06084_ sky130_fd_sc_hd__a22o_1
XTAP_908 vssd1 vccd1 sky130_fd_sc_hd__tapvpwrvgnd_1
X_10296_ _04237_ _04398_ vssd1 vssd1 vccd1 vccd1 _04400_ sky130_fd_sc_hd__xnor2_2
X_13084_ clknet_leaf_57_clk_i _00470_ vssd1 vssd1 vccd1 vccd1 temp1\[9\] sky130_fd_sc_hd__dfxtp_1
XTAP_919 vssd1 vccd1 sky130_fd_sc_hd__tapvpwrvgnd_1
XFILLER_0_109_15 vssd1 vssd1 vccd1 vccd1 sky130_ef_sc_hd__decap_12
X_12035_ net628 net533 net591 vssd1 vssd1 vccd1 vccd1 _06032_ sky130_fd_sc_hd__nor3_4
XFILLER_0_88_713 vssd1 vssd1 vccd1 vccd1 sky130_ef_sc_hd__decap_12
X_12937_ clknet_leaf_7_clk_i _00323_ net1195 vssd1 vssd1 vccd1 vccd1 posx\[8\] sky130_fd_sc_hd__dfrtp_1
XFILLER_0_88_757 vssd1 vssd1 vccd1 vccd1 sky130_fd_sc_hd__fill_1
XFILLER_0_34_45 vssd1 vssd1 vccd1 vccd1 sky130_fd_sc_hd__fill_2
XFILLER_0_125_69 vssd1 vssd1 vccd1 vccd1 sky130_ef_sc_hd__decap_12
X_12868_ clknet_leaf_48_clk_i _00254_ vssd1 vssd1 vccd1 vccd1 mul1.a\[3\] sky130_fd_sc_hd__dfxtp_4
X_11819_ net228 net601 net581 net132 _05860_ vssd1 vssd1 vccd1 vccd1 _05861_ sky130_fd_sc_hd__a221o_1
XFILLER_0_126_3 vssd1 vssd1 vccd1 vccd1 sky130_ef_sc_hd__decap_12
XTAP_1691 vssd1 vccd1 sky130_fd_sc_hd__tapvpwrvgnd_1
XTAP_1680 vssd1 vccd1 sky130_fd_sc_hd__tapvpwrvgnd_1
XFILLER_0_56_643 vssd1 vssd1 vccd1 vccd1 sky130_fd_sc_hd__fill_1
X_12799_ clknet_leaf_23_clk_i _00185_ vssd1 vssd1 vccd1 vccd1 add1.b_i\[30\] sky130_fd_sc_hd__dfxtp_1
XFILLER_0_126_531 vssd1 vssd1 vccd1 vccd1 sky130_fd_sc_hd__fill_1
XFILLER_0_55_197 vssd1 vssd1 vccd1 vccd1 sky130_fd_sc_hd__decap_3
XFILLER_0_113_225 vssd1 vssd1 vccd1 vccd1 sky130_ef_sc_hd__decap_12
XFILLER_0_24_573 vssd1 vssd1 vccd1 vccd1 sky130_fd_sc_hd__decap_4
X_07010_ _01120_ _01121_ _01132_ vssd1 vssd1 vccd1 vccd1 _01135_ sky130_fd_sc_hd__a21oi_1
XFILLER_0_11_201 vssd1 vssd1 vccd1 vccd1 sky130_fd_sc_hd__decap_3
XFILLER_0_122_781 vssd1 vssd1 vccd1 vccd1 sky130_ef_sc_hd__decap_12
XFILLER_0_11_245 vssd1 vssd1 vccd1 vccd1 sky130_fd_sc_hd__fill_2
XFILLER_0_12_757 vssd1 vssd1 vccd1 vccd1 sky130_fd_sc_hd__decap_3
XFILLER_0_59_97 vssd1 vssd1 vccd1 vccd1 sky130_fd_sc_hd__decap_4
X_08961_ _03070_ _03071_ _03072_ vssd1 vssd1 vccd1 vccd1 _03074_ sky130_fd_sc_hd__a21o_1
X_08892_ _03003_ _03004_ vssd1 vssd1 vccd1 vccd1 _03005_ sky130_fd_sc_hd__nand2b_1
X_07912_ _02030_ _02031_ _02032_ vssd1 vssd1 vccd1 vccd1 _02033_ sky130_fd_sc_hd__nand3_4
X_07843_ _01857_ _01962_ vssd1 vssd1 vccd1 vccd1 _01964_ sky130_fd_sc_hd__and2_1
XFILLER_0_79_735 vssd1 vssd1 vccd1 vccd1 sky130_ef_sc_hd__decap_12
X_07774_ _01894_ _01895_ _01797_ _01799_ vssd1 vssd1 vccd1 vccd1 _01896_ sky130_fd_sc_hd__a211oi_2
X_09513_ _03612_ _03619_ _03620_ vssd1 vssd1 vccd1 vccd1 _03622_ sky130_fd_sc_hd__nand3_1
XFILLER_0_91_51 vssd1 vssd1 vccd1 vccd1 sky130_fd_sc_hd__decap_4
X_06725_ _00936_ _00939_ vssd1 vssd1 vccd1 vccd1 _00944_ sky130_fd_sc_hd__nor2_1
XPHY_207 vssd1 vssd1 vccd1 vccd1 sky130_fd_sc_hd__decap_3
X_09444_ _03534_ _03551_ _03552_ vssd1 vssd1 vccd1 vccd1 _03554_ sky130_fd_sc_hd__and3_1
XFILLER_0_66_418 vssd1 vssd1 vccd1 vccd1 sky130_fd_sc_hd__fill_2
XFILLER_0_66_407 vssd1 vssd1 vccd1 vccd1 sky130_fd_sc_hd__decap_6
X_06656_ _00884_ _00885_ vssd1 vssd1 vccd1 vccd1 _00886_ sky130_fd_sc_hd__nor2_2
XPHY_229 vssd1 vssd1 vccd1 vccd1 sky130_fd_sc_hd__decap_3
XPHY_218 vssd1 vssd1 vccd1 vccd1 sky130_fd_sc_hd__decap_3
XFILLER_0_94_749 vssd1 vssd1 vccd1 vccd1 sky130_fd_sc_hd__decap_6
XFILLER_0_78_289 vssd1 vssd1 vccd1 vccd1 sky130_ef_sc_hd__decap_12
X_09375_ net1017 net810 _03343_ _03344_ net1002 vssd1 vssd1 vccd1 vccd1 _03485_ sky130_fd_sc_hd__a32o_1
X_06587_ _00824_ _00827_ vssd1 vssd1 vccd1 vccd1 _00828_ sky130_fd_sc_hd__xor2_4
XFILLER_0_117_553 vssd1 vssd1 vccd1 vccd1 sky130_fd_sc_hd__decap_6
X_08326_ _02313_ _02315_ vssd1 vssd1 vccd1 vccd1 _02443_ sky130_fd_sc_hd__nand2_1
XFILLER_0_74_484 vssd1 vssd1 vccd1 vccd1 sky130_fd_sc_hd__fill_1
XFILLER_0_61_101 vssd1 vssd1 vccd1 vccd1 sky130_fd_sc_hd__decap_8
XFILLER_0_34_304 vssd1 vssd1 vccd1 vccd1 sky130_fd_sc_hd__decap_4
XFILLER_0_35_838 vssd1 vssd1 vccd1 vccd1 sky130_fd_sc_hd__fill_2
XFILLER_0_74_495 vssd1 vssd1 vccd1 vccd1 sky130_fd_sc_hd__fill_2
X_08257_ _02244_ _02252_ _02251_ vssd1 vssd1 vccd1 vccd1 _02375_ sky130_fd_sc_hd__a21bo_1
XFILLER_0_46_197 vssd1 vssd1 vccd1 vccd1 sky130_fd_sc_hd__fill_1
XFILLER_0_117_597 vssd1 vssd1 vccd1 vccd1 sky130_ef_sc_hd__decap_12
X_08188_ _02304_ _02305_ vssd1 vssd1 vccd1 vccd1 _02306_ sky130_fd_sc_hd__nand2b_1
X_07208_ _01260_ _01331_ vssd1 vssd1 vccd1 vccd1 _01333_ sky130_fd_sc_hd__or2_1
XFILLER_0_104_269 vssd1 vssd1 vccd1 vccd1 sky130_fd_sc_hd__fill_1
X_07139_ _01191_ _01193_ _01262_ vssd1 vssd1 vccd1 vccd1 _01264_ sky130_fd_sc_hd__and3_1
XFILLER_0_42_381 vssd1 vssd1 vccd1 vccd1 sky130_fd_sc_hd__decap_3
Xoutput270 net270 vssd1 vssd1 vccd1 vccd1 div_mstream_o[26] sky130_fd_sc_hd__clkbuf_4
X_10150_ _04253_ _04254_ _04246_ vssd1 vssd1 vccd1 vccd1 _04255_ sky130_fd_sc_hd__a21o_1
XFILLER_0_30_587 vssd1 vssd1 vccd1 vccd1 sky130_fd_sc_hd__fill_1
Xoutput292 net292 vssd1 vssd1 vccd1 vccd1 div_mstream_o[46] sky130_fd_sc_hd__clkbuf_4
Xoutput281 net281 vssd1 vssd1 vccd1 vccd1 div_mstream_o[36] sky130_fd_sc_hd__clkbuf_4
X_10081_ net879 net868 net942 net936 vssd1 vssd1 vccd1 vccd1 _04187_ sky130_fd_sc_hd__nand4_1
XFILLER_0_69_223 vssd1 vssd1 vccd1 vccd1 sky130_fd_sc_hd__fill_1
X_10983_ net1693 _05082_ net525 vssd1 vssd1 vccd1 vccd1 _00148_ sky130_fd_sc_hd__mux2_1
X_12722_ clknet_leaf_8_clk_i net1532 net1193 vssd1 vssd1 vccd1 vccd1 net341 sky130_fd_sc_hd__dfrtp_1
XFILLER_0_69_278 vssd1 vssd1 vccd1 vccd1 sky130_fd_sc_hd__fill_2
XFILLER_0_85_749 vssd1 vssd1 vccd1 vccd1 sky130_fd_sc_hd__decap_3
XFILLER_0_37_131 vssd1 vssd1 vccd1 vccd1 sky130_fd_sc_hd__decap_3
XFILLER_0_38_643 vssd1 vssd1 vccd1 vccd1 sky130_fd_sc_hd__fill_1
X_12653_ clknet_leaf_22_clk_i _00039_ net1174 vssd1 vssd1 vccd1 vccd1 net379 sky130_fd_sc_hd__dfrtp_1
XFILLER_0_53_613 vssd1 vssd1 vccd1 vccd1 sky130_fd_sc_hd__decap_3
X_11604_ _05587_ _05697_ vssd1 vssd1 vccd1 vccd1 _05698_ sky130_fd_sc_hd__xnor2_1
XFILLER_0_38_676 vssd1 vssd1 vccd1 vccd1 sky130_fd_sc_hd__fill_1
X_12584_ net1262 net24 net554 vssd1 vssd1 vccd1 vccd1 _00559_ sky130_fd_sc_hd__mux2_1
XFILLER_0_80_421 vssd1 vssd1 vccd1 vccd1 sky130_fd_sc_hd__decap_6
XFILLER_0_53_646 vssd1 vssd1 vccd1 vccd1 sky130_fd_sc_hd__decap_3
X_11535_ _05524_ _05533_ _05531_ vssd1 vssd1 vccd1 vccd1 _05630_ sky130_fd_sc_hd__a21o_1
XFILLER_0_25_337 vssd1 vssd1 vccd1 vccd1 sky130_fd_sc_hd__fill_1
XFILLER_0_111_729 vssd1 vssd1 vccd1 vccd1 sky130_ef_sc_hd__decap_12
X_11466_ _05445_ _05448_ vssd1 vssd1 vccd1 vccd1 _05562_ sky130_fd_sc_hd__nand2_1
XFILLER_0_96_29 vssd1 vssd1 vccd1 vccd1 sky130_ef_sc_hd__decap_12
X_10417_ _04369_ _04371_ _04520_ vssd1 vssd1 vccd1 vccd1 _04521_ sky130_fd_sc_hd__a21o_1
X_11397_ _05490_ _05491_ vssd1 vssd1 vccd1 vccd1 _05493_ sky130_fd_sc_hd__xnor2_1
X_13136_ clknet_leaf_4_clk_i _00522_ vssd1 vssd1 vccd1 vccd1 det_t\[29\] sky130_fd_sc_hd__dfxtp_1
X_10348_ net841 net947 net942 net851 vssd1 vssd1 vccd1 vccd1 _04452_ sky130_fd_sc_hd__a22o_1
XFILLER_0_0_459 vssd1 vssd1 vccd1 vccd1 sky130_fd_sc_hd__decap_4
XTAP_705 vssd1 vccd1 sky130_fd_sc_hd__tapvpwrvgnd_1
XFILLER_0_29_23 vssd1 vssd1 vccd1 vccd1 sky130_fd_sc_hd__fill_2
XTAP_716 vssd1 vccd1 sky130_fd_sc_hd__tapvpwrvgnd_1
X_10279_ _04081_ _04243_ _04240_ vssd1 vssd1 vccd1 vccd1 _04383_ sky130_fd_sc_hd__a21o_1
X_13067_ clknet_leaf_31_clk_i _00453_ net1166 vssd1 vssd1 vccd1 vccd1 y2my0\[24\]
+ sky130_fd_sc_hd__dfrtp_1
XTAP_727 vssd1 vccd1 sky130_fd_sc_hd__tapvpwrvgnd_1
XTAP_738 vssd1 vccd1 sky130_fd_sc_hd__tapvpwrvgnd_1
XTAP_749 vssd1 vccd1 sky130_fd_sc_hd__tapvpwrvgnd_1
X_12018_ net111 net623 net597 net79 vssd1 vssd1 vccd1 vccd1 _06018_ sky130_fd_sc_hd__a22o_1
X_06510_ det_t\[20\] net528 vssd1 vssd1 vccd1 vccd1 net264 sky130_fd_sc_hd__and2_1
XFILLER_0_88_587 vssd1 vssd1 vccd1 vccd1 sky130_fd_sc_hd__fill_1
XFILLER_0_76_727 vssd1 vssd1 vccd1 vccd1 sky130_ef_sc_hd__decap_12
X_07490_ _01587_ _01612_ vssd1 vssd1 vccd1 vccd1 _01615_ sky130_fd_sc_hd__xnor2_1
XFILLER_0_75_237 vssd1 vssd1 vccd1 vccd1 sky130_fd_sc_hd__decap_4
XFILLER_0_61_21 vssd1 vssd1 vccd1 vccd1 sky130_fd_sc_hd__fill_1
X_06441_ add1.a_i\[23\] add1.b_i\[23\] _00731_ _00739_ _00741_ vssd1 vssd1 vccd1 vccd1
+ _00742_ sky130_fd_sc_hd__o221a_2
XFILLER_0_0_57 vssd1 vssd1 vccd1 vccd1 sky130_fd_sc_hd__fill_1
XFILLER_0_75_248 vssd1 vssd1 vccd1 vccd1 sky130_fd_sc_hd__fill_1
X_09160_ net1141 net705 _03268_ _03269_ vssd1 vssd1 vccd1 vccd1 _03271_ sky130_fd_sc_hd__o2bb2a_1
XFILLER_0_90_218 vssd1 vssd1 vccd1 vccd1 sky130_fd_sc_hd__fill_1
X_06372_ _00681_ _00682_ vssd1 vssd1 vccd1 vccd1 _00683_ sky130_fd_sc_hd__nand2_4
XFILLER_0_114_501 vssd1 vssd1 vccd1 vccd1 sky130_ef_sc_hd__decap_12
XFILLER_0_83_281 vssd1 vssd1 vccd1 vccd1 sky130_ef_sc_hd__decap_12
X_09091_ _03194_ _03202_ vssd1 vssd1 vccd1 vccd1 _03203_ sky130_fd_sc_hd__or2_1
X_08111_ net1015 net875 net865 net1024 vssd1 vssd1 vccd1 vccd1 _02230_ sky130_fd_sc_hd__a22o_1
XFILLER_0_114_545 vssd1 vssd1 vccd1 vccd1 sky130_ef_sc_hd__decap_12
XFILLER_0_71_476 vssd1 vssd1 vccd1 vccd1 sky130_fd_sc_hd__decap_4
X_08042_ _02159_ _02160_ vssd1 vssd1 vccd1 vccd1 _02162_ sky130_fd_sc_hd__xnor2_2
XFILLER_0_43_167 vssd1 vssd1 vccd1 vccd1 sky130_fd_sc_hd__fill_1
XFILLER_0_9_55 vssd1 vssd1 vccd1 vccd1 sky130_fd_sc_hd__fill_1
XFILLER_0_4_732 vssd1 vssd1 vccd1 vccd1 sky130_fd_sc_hd__fill_1
XFILLER_0_71_487 vssd1 vssd1 vccd1 vccd1 sky130_fd_sc_hd__decap_3
XFILLER_0_114_589 vssd1 vssd1 vccd1 vccd1 sky130_ef_sc_hd__decap_12
XFILLER_0_102_729 vssd1 vssd1 vccd1 vccd1 sky130_ef_sc_hd__decap_12
XFILLER_0_101_93 vssd1 vssd1 vccd1 vccd1 sky130_ef_sc_hd__decap_12
X_09993_ _04093_ _04097_ _04098_ vssd1 vssd1 vccd1 vccd1 _04099_ sky130_fd_sc_hd__nand3_2
XFILLER_0_110_784 vssd1 vssd1 vccd1 vccd1 sky130_fd_sc_hd__fill_2
X_08944_ _03055_ _03056_ vssd1 vssd1 vccd1 vccd1 _03057_ sky130_fd_sc_hd__or2_1
XFILLER_0_50_3 vssd1 vssd1 vccd1 vccd1 sky130_ef_sc_hd__decap_12
X_08875_ _02965_ _02966_ _02985_ _02986_ vssd1 vssd1 vccd1 vccd1 _02988_ sky130_fd_sc_hd__nor4_1
X_07826_ _01752_ _01849_ _01848_ vssd1 vssd1 vccd1 vccd1 _01948_ sky130_fd_sc_hd__a21bo_1
X_07757_ _01806_ _01812_ _01811_ vssd1 vssd1 vccd1 vccd1 _01879_ sky130_fd_sc_hd__a21o_1
X_06708_ sub1.a_i\[24\] sub1.b_i\[24\] vssd1 vssd1 vccd1 vccd1 _00929_ sky130_fd_sc_hd__and2b_1
XFILLER_0_67_749 vssd1 vssd1 vccd1 vccd1 sky130_fd_sc_hd__fill_1
X_07688_ _01716_ _01719_ _01809_ _01810_ vssd1 vssd1 vccd1 vccd1 _01811_ sky130_fd_sc_hd__o211a_1
XFILLER_0_82_708 vssd1 vssd1 vccd1 vccd1 sky130_ef_sc_hd__decap_12
X_09427_ net907 net901 net937 vssd1 vssd1 vccd1 vccd1 _03537_ sky130_fd_sc_hd__and3_1
X_06639_ _00870_ _00871_ vssd1 vssd1 vccd1 vccd1 _00872_ sky130_fd_sc_hd__xnor2_4
X_09358_ _03465_ _03466_ _03424_ vssd1 vssd1 vccd1 vccd1 _03468_ sky130_fd_sc_hd__a21oi_1
XFILLER_0_117_361 vssd1 vssd1 vccd1 vccd1 sky130_ef_sc_hd__decap_12
X_08309_ _02326_ _02329_ _02424_ vssd1 vssd1 vccd1 vccd1 _02426_ sky130_fd_sc_hd__and3_1
XFILLER_0_47_495 vssd1 vssd1 vccd1 vccd1 sky130_fd_sc_hd__decap_8
X_09289_ _03339_ _03340_ _03398_ _03399_ vssd1 vssd1 vccd1 vccd1 _03400_ sky130_fd_sc_hd__nor4_1
X_11320_ _05407_ _05415_ vssd1 vssd1 vccd1 vccd1 _05417_ sky130_fd_sc_hd__xnor2_1
XFILLER_0_50_627 vssd1 vssd1 vccd1 vccd1 sky130_fd_sc_hd__fill_1
X_11251_ net982 net735 _05344_ _05346_ vssd1 vssd1 vccd1 vccd1 _05348_ sky130_fd_sc_hd__a22oi_1
XFILLER_0_31_841 vssd1 vssd1 vccd1 vccd1 sky130_fd_sc_hd__fill_1
X_10202_ _04305_ _04306_ _04145_ _04148_ vssd1 vssd1 vccd1 vccd1 _04307_ sky130_fd_sc_hd__a211o_1
X_11182_ _05149_ _05155_ vssd1 vssd1 vccd1 vccd1 _05280_ sky130_fd_sc_hd__or2_1
XFILLER_0_30_373 vssd1 vssd1 vccd1 vccd1 sky130_fd_sc_hd__fill_1
XFILLER_0_100_250 vssd1 vssd1 vccd1 vccd1 sky130_fd_sc_hd__fill_2
X_10133_ _04235_ _04236_ vssd1 vssd1 vccd1 vccd1 _04238_ sky130_fd_sc_hd__nor2_1
X_10064_ _04167_ _04168_ _04155_ vssd1 vssd1 vccd1 vccd1 _04170_ sky130_fd_sc_hd__a21oi_2
XFILLER_0_89_318 vssd1 vssd1 vccd1 vccd1 sky130_fd_sc_hd__decap_6
XFILLER_0_106_27 vssd1 vssd1 vccd1 vccd1 sky130_fd_sc_hd__fill_1
XFILLER_0_58_705 vssd1 vssd1 vccd1 vccd1 sky130_fd_sc_hd__fill_1
X_10966_ _05022_ _05023_ _05063_ _05064_ vssd1 vssd1 vccd1 vccd1 _05066_ sky130_fd_sc_hd__o22a_1
XFILLER_0_15_69 vssd1 vssd1 vccd1 vccd1 sky130_ef_sc_hd__decap_12
XFILLER_0_128_637 vssd1 vssd1 vccd1 vccd1 sky130_fd_sc_hd__decap_6
X_12705_ clknet_leaf_12_clk_i _00091_ net1190 vssd1 vssd1 vccd1 vccd1 net436 sky130_fd_sc_hd__dfrtp_1
X_10897_ _04988_ _04996_ vssd1 vssd1 vccd1 vccd1 _04997_ sky130_fd_sc_hd__or2_1
XFILLER_0_127_125 vssd1 vssd1 vccd1 vccd1 sky130_ef_sc_hd__decap_12
XFILLER_0_122_15 vssd1 vssd1 vccd1 vccd1 sky130_ef_sc_hd__decap_12
XFILLER_0_72_207 vssd1 vssd1 vccd1 vccd1 sky130_fd_sc_hd__fill_1
X_12636_ clknet_leaf_27_clk_i _00022_ net1171 vssd1 vssd1 vccd1 vccd1 net360 sky130_fd_sc_hd__dfrtp_1
XFILLER_0_31_35 vssd1 vssd1 vccd1 vccd1 sky130_fd_sc_hd__fill_1
XFILLER_0_38_473 vssd1 vssd1 vccd1 vccd1 sky130_fd_sc_hd__decap_3
XFILLER_0_127_169 vssd1 vssd1 vccd1 vccd1 sky130_fd_sc_hd__fill_2
XFILLER_0_65_281 vssd1 vssd1 vccd1 vccd1 sky130_fd_sc_hd__fill_2
XFILLER_0_53_421 vssd1 vssd1 vccd1 vccd1 sky130_fd_sc_hd__fill_1
XFILLER_0_31_57 vssd1 vssd1 vccd1 vccd1 sky130_fd_sc_hd__decap_6
X_12567_ net1466 net11 net560 vssd1 vssd1 vccd1 vccd1 _00543_ sky130_fd_sc_hd__mux2_1
XFILLER_0_81_785 vssd1 vssd1 vccd1 vccd1 sky130_fd_sc_hd__decap_3
XFILLER_0_26_668 vssd1 vssd1 vccd1 vccd1 sky130_fd_sc_hd__fill_1
X_12498_ net1259 net562 vssd1 vssd1 vccd1 vccd1 _06246_ sky130_fd_sc_hd__nand2_1
XFILLER_0_80_295 vssd1 vssd1 vccd1 vccd1 sky130_fd_sc_hd__fill_1
XFILLER_0_80_273 vssd1 vssd1 vccd1 vccd1 sky130_fd_sc_hd__decap_4
Xhold208 x0mx2\[27\] vssd1 vssd1 vccd1 vccd1 net1423 sky130_fd_sc_hd__dlygate4sd3_1
X_11518_ net1003 net996 net708 vssd1 vssd1 vccd1 vccd1 _05613_ sky130_fd_sc_hd__and3_1
X_11449_ _05423_ _05425_ _05543_ _05544_ vssd1 vssd1 vccd1 vccd1 _05545_ sky130_fd_sc_hd__o211a_1
Xhold219 net364 vssd1 vssd1 vccd1 vccd1 net1434 sky130_fd_sc_hd__dlygate4sd3_1
XFILLER_0_111_559 vssd1 vssd1 vccd1 vccd1 sky130_fd_sc_hd__fill_1
X_13119_ clknet_leaf_2_clk_i _00505_ vssd1 vssd1 vccd1 vccd1 det_t\[12\] sky130_fd_sc_hd__dfxtp_1
XTAP_502 vssd1 vccd1 sky130_fd_sc_hd__tapvpwrvgnd_1
XTAP_513 vssd1 vccd1 sky130_fd_sc_hd__tapvpwrvgnd_1
XTAP_524 vssd1 vccd1 sky130_fd_sc_hd__tapvpwrvgnd_1
XTAP_535 vssd1 vccd1 sky130_fd_sc_hd__tapvpwrvgnd_1
XTAP_546 vssd1 vccd1 sky130_fd_sc_hd__tapvpwrvgnd_1
XTAP_557 vssd1 vccd1 sky130_fd_sc_hd__tapvpwrvgnd_1
X_06990_ net897 net888 net1065 net1073 vssd1 vssd1 vccd1 vccd1 _01115_ sky130_fd_sc_hd__and4_1
XTAP_579 vssd1 vccd1 sky130_fd_sc_hd__tapvpwrvgnd_1
XTAP_568 vssd1 vccd1 sky130_fd_sc_hd__tapvpwrvgnd_1
X_08660_ net924 net916 net955 net949 vssd1 vssd1 vccd1 vccd1 _02775_ sky130_fd_sc_hd__nand4_1
XFILLER_0_89_841 vssd1 vssd1 vccd1 vccd1 sky130_fd_sc_hd__fill_1
X_07611_ _01713_ _01732_ _01733_ vssd1 vssd1 vccd1 vccd1 _01735_ sky130_fd_sc_hd__and3_1
X_08591_ net1085 net773 net764 net1092 vssd1 vssd1 vccd1 vccd1 _02706_ sky130_fd_sc_hd__a22o_1
XFILLER_0_76_524 vssd1 vssd1 vccd1 vccd1 sky130_fd_sc_hd__fill_2
XFILLER_0_72_64 vssd1 vssd1 vccd1 vccd1 sky130_ef_sc_hd__decap_12
X_07542_ _01665_ _01666_ vssd1 vssd1 vccd1 vccd1 _01667_ sky130_fd_sc_hd__and2_1
XFILLER_0_119_615 vssd1 vssd1 vccd1 vccd1 sky130_fd_sc_hd__fill_1
XFILLER_0_8_312 vssd1 vssd1 vccd1 vccd1 sky130_fd_sc_hd__fill_2
X_07473_ _01596_ _01597_ net881 net1145 vssd1 vssd1 vccd1 vccd1 _01598_ sky130_fd_sc_hd__and4bb_1
X_06424_ net546 _00727_ vssd1 vssd1 vccd1 vccd1 net319 sky130_fd_sc_hd__nor2_1
X_09212_ net1031 net1035 net802 net793 vssd1 vssd1 vccd1 vccd1 _03323_ sky130_fd_sc_hd__nand4_1
XFILLER_0_127_670 vssd1 vssd1 vccd1 vccd1 sky130_fd_sc_hd__fill_2
X_09143_ _03093_ _03095_ _03253_ _03254_ vssd1 vssd1 vccd1 vccd1 _03255_ sky130_fd_sc_hd__o211a_1
X_06355_ _00663_ _00665_ _00635_ vssd1 vssd1 vccd1 vccd1 _00667_ sky130_fd_sc_hd__a21o_1
X_09074_ _03182_ _03184_ _03046_ _03050_ vssd1 vssd1 vccd1 vccd1 _03186_ sky130_fd_sc_hd__a211o_1
XFILLER_0_13_830 vssd1 vssd1 vccd1 vccd1 sky130_fd_sc_hd__decap_6
X_06286_ net653 _00601_ vssd1 vssd1 vccd1 vccd1 _00602_ sky130_fd_sc_hd__nor2_1
X_08025_ _02125_ _02142_ _02143_ vssd1 vssd1 vccd1 vccd1 _02145_ sky130_fd_sc_hd__nand3_2
XFILLER_0_13_841 vssd1 vssd1 vccd1 vccd1 sky130_fd_sc_hd__fill_1
XFILLER_0_102_559 vssd1 vssd1 vccd1 vccd1 sky130_fd_sc_hd__fill_1
Xmax_cap461 net1753 vssd1 vssd1 vccd1 vccd1 net461 sky130_fd_sc_hd__buf_1
Xmax_cap494 _02149_ vssd1 vssd1 vccd1 vccd1 net494 sky130_fd_sc_hd__buf_1
XFILLER_0_110_581 vssd1 vssd1 vccd1 vccd1 sky130_fd_sc_hd__decap_6
X_09976_ _04080_ _04081_ vssd1 vssd1 vccd1 vccd1 _04082_ sky130_fd_sc_hd__nor2_1
X_08927_ _03038_ _03039_ vssd1 vssd1 vccd1 vccd1 _03040_ sky130_fd_sc_hd__or2_1
X_08858_ net1115 net1124 net727 net723 vssd1 vssd1 vccd1 vccd1 _02971_ sky130_fd_sc_hd__and4_1
XFILLER_0_99_605 vssd1 vssd1 vccd1 vccd1 sky130_fd_sc_hd__decap_8
X_07809_ _01927_ _01928_ _01831_ _01835_ vssd1 vssd1 vccd1 vccd1 _01931_ sky130_fd_sc_hd__o211a_1
X_08789_ _02764_ _02766_ _02901_ vssd1 vssd1 vccd1 vccd1 _02903_ sky130_fd_sc_hd__nand3_2
XFILLER_0_67_502 vssd1 vssd1 vccd1 vccd1 sky130_fd_sc_hd__fill_2
X_10820_ _04918_ _04919_ _04710_ _04712_ vssd1 vssd1 vccd1 vccd1 _04921_ sky130_fd_sc_hd__o211ai_1
XFILLER_0_39_215 vssd1 vssd1 vccd1 vccd1 sky130_fd_sc_hd__decap_8
X_10751_ _04828_ _04849_ _04851_ vssd1 vssd1 vccd1 vccd1 _04852_ sky130_fd_sc_hd__nor3_1
XFILLER_0_109_125 vssd1 vssd1 vccd1 vccd1 sky130_ef_sc_hd__decap_12
XFILLER_0_94_365 vssd1 vssd1 vccd1 vccd1 sky130_ef_sc_hd__decap_12
XFILLER_0_125_629 vssd1 vssd1 vccd1 vccd1 sky130_ef_sc_hd__decap_12
XFILLER_0_109_169 vssd1 vssd1 vccd1 vccd1 sky130_ef_sc_hd__decap_12
XFILLER_0_94_398 vssd1 vssd1 vccd1 vccd1 sky130_fd_sc_hd__fill_1
X_10682_ _04782_ _04783_ _04636_ _04639_ vssd1 vssd1 vccd1 vccd1 _04784_ sky130_fd_sc_hd__o211a_1
X_12421_ net526 net612 _02168_ net574 vssd1 vssd1 vccd1 vccd1 _06203_ sky130_fd_sc_hd__a22o_1
XFILLER_0_124_139 vssd1 vssd1 vccd1 vccd1 sky130_fd_sc_hd__fill_1
XFILLER_0_118_681 vssd1 vssd1 vccd1 vccd1 sky130_ef_sc_hd__decap_12
XFILLER_0_106_821 vssd1 vssd1 vccd1 vccd1 sky130_fd_sc_hd__fill_1
XFILLER_0_106_810 vssd1 vssd1 vccd1 vccd1 sky130_fd_sc_hd__fill_2
XFILLER_0_62_284 vssd1 vssd1 vccd1 vccd1 sky130_fd_sc_hd__decap_3
X_12352_ net1418 _00846_ net657 vssd1 vssd1 vccd1 vccd1 _00404_ sky130_fd_sc_hd__mux2_1
XFILLER_0_35_476 vssd1 vssd1 vccd1 vccd1 sky130_fd_sc_hd__decap_8
XFILLER_0_120_301 vssd1 vssd1 vccd1 vccd1 sky130_fd_sc_hd__decap_6
X_12283_ net1674 _00818_ net676 vssd1 vssd1 vccd1 vccd1 _00335_ sky130_fd_sc_hd__mux2_1
XFILLER_0_22_126 vssd1 vssd1 vccd1 vccd1 sky130_fd_sc_hd__decap_6
X_11303_ _05395_ _05398_ vssd1 vssd1 vccd1 vccd1 _05400_ sky130_fd_sc_hd__xnor2_2
XFILLER_0_120_345 vssd1 vssd1 vccd1 vccd1 sky130_ef_sc_hd__decap_12
X_11234_ _05329_ _05330_ vssd1 vssd1 vccd1 vccd1 _05331_ sky130_fd_sc_hd__and2b_1
XFILLER_0_31_693 vssd1 vssd1 vccd1 vccd1 sky130_fd_sc_hd__decap_8
XFILLER_0_120_389 vssd1 vssd1 vccd1 vccd1 sky130_ef_sc_hd__decap_12
X_11165_ _05260_ _05261_ _05224_ vssd1 vssd1 vccd1 vccd1 _05263_ sky130_fd_sc_hd__o21ai_4
X_10116_ _04220_ _04221_ vssd1 vssd1 vccd1 vccd1 _04222_ sky130_fd_sc_hd__xnor2_4
X_11096_ _05037_ _05040_ _05193_ _05194_ vssd1 vssd1 vccd1 vccd1 _05195_ sky130_fd_sc_hd__o211ai_2
XFILLER_0_117_15 vssd1 vssd1 vccd1 vccd1 sky130_ef_sc_hd__decap_12
X_10047_ _04116_ _04150_ _04151_ vssd1 vssd1 vccd1 vccd1 _04153_ sky130_fd_sc_hd__and3_1
XFILLER_0_89_137 vssd1 vssd1 vccd1 vccd1 sky130_fd_sc_hd__decap_8
Xhold80 add1.b_i\[21\] vssd1 vssd1 vccd1 vccd1 net1295 sky130_fd_sc_hd__dlygate4sd3_1
Xhold91 sub1.b_i\[19\] vssd1 vssd1 vccd1 vccd1 net1306 sky130_fd_sc_hd__dlygate4sd3_1
XFILLER_0_98_682 vssd1 vssd1 vccd1 vccd1 sky130_fd_sc_hd__decap_8
XFILLER_0_85_310 vssd1 vssd1 vccd1 vccd1 sky130_ef_sc_hd__decap_12
X_11998_ net106 net622 net596 net74 vssd1 vssd1 vccd1 vccd1 _06003_ sky130_fd_sc_hd__a22o_1
XFILLER_0_97_181 vssd1 vssd1 vccd1 vccd1 sky130_ef_sc_hd__decap_12
X_10949_ _05047_ _05048_ vssd1 vssd1 vccd1 vccd1 _05049_ sky130_fd_sc_hd__and2_1
XFILLER_0_42_67 vssd1 vssd1 vccd1 vccd1 sky130_fd_sc_hd__decap_8
XFILLER_0_128_489 vssd1 vssd1 vccd1 vccd1 sky130_ef_sc_hd__decap_12
XFILLER_0_6_838 vssd1 vssd1 vccd1 vccd1 sky130_fd_sc_hd__decap_4
X_12619_ clknet_leaf_49_clk_i _00005_ net1159 vssd1 vssd1 vccd1 vccd1 net372 sky130_fd_sc_hd__dfrtp_4
XFILLER_0_26_465 vssd1 vssd1 vccd1 vccd1 sky130_fd_sc_hd__fill_1
XFILLER_0_81_571 vssd1 vssd1 vccd1 vccd1 sky130_fd_sc_hd__decap_8
XFILLER_0_123_161 vssd1 vssd1 vccd1 vccd1 sky130_fd_sc_hd__decap_6
XFILLER_0_13_137 vssd1 vssd1 vccd1 vccd1 sky130_ef_sc_hd__decap_12
XFILLER_0_10_811 vssd1 vssd1 vccd1 vccd1 sky130_fd_sc_hd__fill_1
Xfanout529 net530 vssd1 vssd1 vccd1 vccd1 net529 sky130_fd_sc_hd__buf_2
Xfanout507 net293 vssd1 vssd1 vccd1 vccd1 net507 sky130_fd_sc_hd__buf_2
X_09830_ _03933_ _03934_ _03935_ vssd1 vssd1 vccd1 vccd1 _03937_ sky130_fd_sc_hd__a21bo_1
XTAP_332 vssd1 vccd1 sky130_fd_sc_hd__tapvpwrvgnd_1
XTAP_321 vssd1 vccd1 sky130_fd_sc_hd__tapvpwrvgnd_1
XTAP_310 vssd1 vccd1 sky130_fd_sc_hd__tapvpwrvgnd_1
Xfanout518 net519 vssd1 vssd1 vccd1 vccd1 net518 sky130_fd_sc_hd__clkbuf_4
X_09761_ net923 net915 net907 net926 vssd1 vssd1 vccd1 vccd1 _03869_ sky130_fd_sc_hd__o31ai_4
XTAP_376 vssd1 vccd1 sky130_fd_sc_hd__tapvpwrvgnd_1
XTAP_365 vssd1 vccd1 sky130_fd_sc_hd__tapvpwrvgnd_1
XTAP_354 vssd1 vccd1 sky130_fd_sc_hd__tapvpwrvgnd_1
XTAP_343 vssd1 vccd1 sky130_fd_sc_hd__tapvpwrvgnd_1
X_06973_ _01090_ _01091_ _01096_ vssd1 vssd1 vccd1 vccd1 _01098_ sky130_fd_sc_hd__a21o_1
X_08712_ _02680_ _02682_ vssd1 vssd1 vccd1 vccd1 _02826_ sky130_fd_sc_hd__nand2_1
XTAP_398 vssd1 vccd1 sky130_fd_sc_hd__tapvpwrvgnd_1
XTAP_387 vssd1 vccd1 sky130_fd_sc_hd__tapvpwrvgnd_1
X_09692_ net1053 net1062 net752 net744 vssd1 vssd1 vccd1 vccd1 _03800_ sky130_fd_sc_hd__and4_1
X_08643_ _02628_ _02629_ _02630_ vssd1 vssd1 vccd1 vccd1 _02758_ sky130_fd_sc_hd__o21ba_1
XFILLER_0_13_3 vssd1 vssd1 vccd1 vccd1 sky130_ef_sc_hd__decap_12
XFILLER_0_107_81 vssd1 vssd1 vccd1 vccd1 sky130_ef_sc_hd__decap_12
X_08574_ _02677_ _02688_ vssd1 vssd1 vccd1 vccd1 _02689_ sky130_fd_sc_hd__xnor2_1
XTAP_1509 vssd1 vccd1 sky130_fd_sc_hd__tapvpwrvgnd_1
XFILLER_0_49_502 vssd1 vssd1 vccd1 vccd1 sky130_fd_sc_hd__fill_2
XPHY_16 vssd1 vssd1 vccd1 vccd1 sky130_fd_sc_hd__decap_3
XPHY_27 vssd1 vssd1 vccd1 vccd1 sky130_fd_sc_hd__decap_3
XPHY_38 vssd1 vssd1 vccd1 vccd1 sky130_fd_sc_hd__decap_3
X_07525_ _01645_ _01649_ vssd1 vssd1 vccd1 vccd1 _01650_ sky130_fd_sc_hd__nor2_1
XPHY_49 vssd1 vssd1 vccd1 vccd1 sky130_fd_sc_hd__decap_3
XFILLER_0_76_365 vssd1 vssd1 vccd1 vccd1 sky130_fd_sc_hd__fill_1
XFILLER_0_9_621 vssd1 vssd1 vccd1 vccd1 sky130_fd_sc_hd__fill_1
XFILLER_0_36_218 vssd1 vssd1 vccd1 vccd1 sky130_fd_sc_hd__fill_1
XFILLER_0_91_335 vssd1 vssd1 vccd1 vccd1 sky130_fd_sc_hd__fill_1
XFILLER_0_76_398 vssd1 vssd1 vccd1 vccd1 sky130_fd_sc_hd__decap_4
X_07456_ _01554_ _01580_ vssd1 vssd1 vccd1 vccd1 _01581_ sky130_fd_sc_hd__nand2b_1
XFILLER_0_107_629 vssd1 vssd1 vccd1 vccd1 sky130_ef_sc_hd__decap_12
X_06407_ _00710_ _00711_ vssd1 vssd1 vccd1 vccd1 _00713_ sky130_fd_sc_hd__xnor2_4
X_07387_ _01497_ _01503_ _01502_ vssd1 vssd1 vccd1 vccd1 _01512_ sky130_fd_sc_hd__a21o_1
XFILLER_0_106_139 vssd1 vssd1 vccd1 vccd1 sky130_fd_sc_hd__fill_1
X_09126_ _03218_ _03235_ _03236_ vssd1 vssd1 vccd1 vccd1 _03238_ sky130_fd_sc_hd__and3_1
XFILLER_0_45_785 vssd1 vssd1 vccd1 vccd1 sky130_fd_sc_hd__decap_4
X_06338_ add1.a_i\[1\] add1.b_i\[1\] vssd1 vssd1 vccd1 vccd1 _00650_ sky130_fd_sc_hd__nor2_1
XFILLER_0_115_673 vssd1 vssd1 vccd1 vccd1 sky130_ef_sc_hd__decap_12
X_09057_ net802 _03013_ _03014_ _03015_ vssd1 vssd1 vccd1 vccd1 _03169_ sky130_fd_sc_hd__a22o_1
X_08008_ _02126_ _02127_ net1015 net882 vssd1 vssd1 vccd1 vccd1 _02128_ sky130_fd_sc_hd__and4bb_1
XFILLER_0_32_468 vssd1 vssd1 vccd1 vccd1 sky130_fd_sc_hd__decap_3
XFILLER_0_40_490 vssd1 vssd1 vccd1 vccd1 sky130_fd_sc_hd__decap_3
XFILLER_0_102_389 vssd1 vssd1 vccd1 vccd1 sky130_fd_sc_hd__decap_6
XFILLER_0_12_192 vssd1 vssd1 vccd1 vccd1 sky130_fd_sc_hd__decap_4
X_09959_ temp1\[18\] _04065_ net541 vssd1 vssd1 vccd1 vccd1 _04066_ sky130_fd_sc_hd__mux2_1
X_12970_ clknet_leaf_33_clk_i _00356_ net1165 vssd1 vssd1 vccd1 vccd1 y1my2\[23\]
+ sky130_fd_sc_hd__dfrtp_1
X_11921_ net1612 _05945_ net477 vssd1 vssd1 vccd1 vccd1 _00223_ sky130_fd_sc_hd__mux2_1
X_11852_ temp1\[24\] net616 net609 net202 vssd1 vssd1 vccd1 vccd1 _05889_ sky130_fd_sc_hd__a22o_1
X_10803_ net1070 net699 net694 net1078 vssd1 vssd1 vccd1 vccd1 _04904_ sky130_fd_sc_hd__o2bb2a_1
XFILLER_0_95_685 vssd1 vssd1 vccd1 vccd1 sky130_ef_sc_hd__decap_12
X_11783_ net1284 _05830_ net479 vssd1 vssd1 vccd1 vccd1 _00200_ sky130_fd_sc_hd__mux2_1
XFILLER_0_103_39 vssd1 vssd1 vccd1 vccd1 sky130_ef_sc_hd__decap_12
XFILLER_0_94_195 vssd1 vssd1 vccd1 vccd1 sky130_fd_sc_hd__fill_1
XFILLER_0_82_313 vssd1 vssd1 vccd1 vccd1 sky130_fd_sc_hd__fill_1
XFILLER_0_67_387 vssd1 vssd1 vccd1 vccd1 sky130_fd_sc_hd__decap_4
X_10734_ _04833_ _04834_ vssd1 vssd1 vccd1 vccd1 _04835_ sky130_fd_sc_hd__xnor2_1
XFILLER_0_12_15 vssd1 vssd1 vccd1 vccd1 sky130_ef_sc_hd__decap_12
XFILLER_0_27_218 vssd1 vssd1 vccd1 vccd1 sky130_fd_sc_hd__decap_6
X_10665_ _04615_ _04621_ _04765_ vssd1 vssd1 vccd1 vccd1 _04767_ sky130_fd_sc_hd__nor3_1
XFILLER_0_36_774 vssd1 vssd1 vccd1 vccd1 sky130_fd_sc_hd__fill_2
X_12404_ net1395 _00951_ net685 vssd1 vssd1 vccd1 vccd1 _00456_ sky130_fd_sc_hd__mux2_1
XFILLER_0_112_109 vssd1 vssd1 vccd1 vccd1 sky130_ef_sc_hd__decap_12
XFILLER_0_105_161 vssd1 vssd1 vccd1 vccd1 sky130_fd_sc_hd__decap_6
X_10596_ _04689_ _04697_ vssd1 vssd1 vccd1 vccd1 _04698_ sky130_fd_sc_hd__xor2_2
XFILLER_0_50_232 vssd1 vssd1 vccd1 vccd1 sky130_ef_sc_hd__decap_12
XFILLER_0_2_307 vssd1 vssd1 vccd1 vccd1 sky130_fd_sc_hd__fill_1
X_12335_ net1625 _00923_ net670 vssd1 vssd1 vccd1 vccd1 _00387_ sky130_fd_sc_hd__mux2_1
XFILLER_0_23_446 vssd1 vssd1 vccd1 vccd1 sky130_fd_sc_hd__fill_2
XFILLER_0_51_799 vssd1 vssd1 vccd1 vccd1 sky130_fd_sc_hd__fill_2
XFILLER_0_121_665 vssd1 vssd1 vccd1 vccd1 sky130_fd_sc_hd__decap_6
XFILLER_0_120_153 vssd1 vssd1 vccd1 vccd1 sky130_ef_sc_hd__decap_12
X_12266_ net1416 net43 net690 vssd1 vssd1 vccd1 vccd1 _00320_ sky130_fd_sc_hd__mux2_1
XFILLER_0_120_197 vssd1 vssd1 vccd1 vccd1 sky130_ef_sc_hd__decap_12
X_11217_ _05157_ _05160_ _05313_ _05314_ vssd1 vssd1 vccd1 vccd1 _05315_ sky130_fd_sc_hd__a211oi_2
X_12197_ net844 _06151_ net514 vssd1 vssd1 vccd1 vccd1 _00293_ sky130_fd_sc_hd__mux2_1
X_11148_ _05244_ _05245_ net782 net952 vssd1 vssd1 vccd1 vccd1 _05246_ sky130_fd_sc_hd__and4bb_1
X_11079_ _05175_ _05176_ _05052_ _05054_ vssd1 vssd1 vccd1 vccd1 _05178_ sky130_fd_sc_hd__a211oi_2
Xinput181 v1y[5] vssd1 vssd1 vccd1 vccd1 net181 sky130_fd_sc_hd__buf_1
Xinput170 v1y[24] vssd1 vssd1 vccd1 vccd1 net170 sky130_fd_sc_hd__buf_1
Xinput192 v2x[15] vssd1 vssd1 vccd1 vccd1 net192 sky130_fd_sc_hd__buf_1
X_07310_ net854 net1135 _01433_ _01431_ vssd1 vssd1 vccd1 vccd1 _01435_ sky130_fd_sc_hd__a31o_1
XFILLER_0_128_253 vssd1 vssd1 vccd1 vccd1 sky130_fd_sc_hd__fill_1
XFILLER_0_128_242 vssd1 vssd1 vccd1 vccd1 sky130_fd_sc_hd__fill_2
XFILLER_0_86_696 vssd1 vssd1 vccd1 vccd1 sky130_fd_sc_hd__fill_1
XFILLER_0_85_195 vssd1 vssd1 vccd1 vccd1 sky130_fd_sc_hd__decap_6
XFILLER_0_73_335 vssd1 vssd1 vccd1 vccd1 sky130_fd_sc_hd__fill_1
X_08290_ temp1\[7\] _02407_ net540 vssd1 vssd1 vccd1 vccd1 _02408_ sky130_fd_sc_hd__mux2_1
X_07241_ _01359_ _01364_ vssd1 vssd1 vccd1 vccd1 _01366_ sky130_fd_sc_hd__xor2_1
XFILLER_0_54_560 vssd1 vssd1 vccd1 vccd1 sky130_fd_sc_hd__fill_2
X_07172_ net854 net1126 vssd1 vssd1 vccd1 vccd1 _01297_ sky130_fd_sc_hd__nand2_1
XFILLER_0_26_251 vssd1 vssd1 vccd1 vccd1 sky130_fd_sc_hd__fill_1
XFILLER_0_112_643 vssd1 vssd1 vccd1 vccd1 sky130_fd_sc_hd__fill_1
XFILLER_0_78_41 vssd1 vssd1 vccd1 vccd1 sky130_ef_sc_hd__decap_12
XFILLER_0_78_85 vssd1 vssd1 vccd1 vccd1 sky130_fd_sc_hd__fill_2
X_09813_ net1125 net700 net695 net1117 vssd1 vssd1 vccd1 vccd1 _03920_ sky130_fd_sc_hd__and4b_2
Xclkbuf_3_7__f_clk_i clknet_0_clk_i vssd1 vssd1 vccd1 vccd1 clknet_3_7__leaf_clk_i
+ sky130_fd_sc_hd__clkbuf_16
X_09744_ _03849_ _03851_ _03685_ _03688_ vssd1 vssd1 vccd1 vccd1 _03852_ sky130_fd_sc_hd__o211a_1
X_06956_ _01079_ _01080_ vssd1 vssd1 vccd1 vccd1 _01081_ sky130_fd_sc_hd__nand2b_1
X_06887_ last net48 _01012_ vssd1 vssd1 vccd1 vccd1 _00122_ sky130_fd_sc_hd__mux2_1
XTAP_2007 vssd1 vccd1 sky130_fd_sc_hd__tapvpwrvgnd_1
X_09675_ _03780_ _03781_ _03776_ vssd1 vssd1 vccd1 vccd1 _03783_ sky130_fd_sc_hd__a21o_1
XTAP_2029 vssd1 vccd1 sky130_fd_sc_hd__tapvpwrvgnd_1
XTAP_2018 vssd1 vccd1 sky130_fd_sc_hd__tapvpwrvgnd_1
X_08626_ _02737_ _02740_ vssd1 vssd1 vccd1 vccd1 _02741_ sky130_fd_sc_hd__xor2_1
XFILLER_0_77_641 vssd1 vssd1 vccd1 vccd1 sky130_fd_sc_hd__decap_6
XTAP_1339 vssd1 vccd1 sky130_fd_sc_hd__tapvpwrvgnd_1
XTAP_1328 vssd1 vccd1 sky130_fd_sc_hd__tapvpwrvgnd_1
XTAP_1317 vssd1 vccd1 sky130_fd_sc_hd__tapvpwrvgnd_1
XTAP_1306 vssd1 vccd1 sky130_fd_sc_hd__tapvpwrvgnd_1
X_08557_ temp1\[9\] _02672_ net540 vssd1 vssd1 vccd1 vccd1 _02673_ sky130_fd_sc_hd__mux2_1
XFILLER_0_37_505 vssd1 vssd1 vccd1 vccd1 sky130_fd_sc_hd__decap_8
X_08488_ net1016 net1024 mul1.b\[9\] net840 vssd1 vssd1 vccd1 vccd1 _02604_ sky130_fd_sc_hd__nand4_2
XFILLER_0_77_696 vssd1 vssd1 vccd1 vccd1 sky130_fd_sc_hd__decap_3
X_07508_ _01619_ _01631_ vssd1 vssd1 vccd1 vccd1 _01633_ sky130_fd_sc_hd__or2_1
XFILLER_0_37_527 vssd1 vssd1 vccd1 vccd1 sky130_fd_sc_hd__decap_8
XFILLER_0_52_508 vssd1 vssd1 vccd1 vccd1 sky130_fd_sc_hd__decap_3
X_07439_ net896 net1119 net1128 net887 vssd1 vssd1 vccd1 vccd1 _01564_ sky130_fd_sc_hd__a22o_1
XFILLER_0_92_699 vssd1 vssd1 vccd1 vccd1 sky130_fd_sc_hd__fill_1
X_10450_ net834 net947 _04551_ _04552_ vssd1 vssd1 vccd1 vccd1 _04553_ sky130_fd_sc_hd__nand4_4
X_09109_ net901 net892 net955 vssd1 vssd1 vccd1 vccd1 _03221_ sky130_fd_sc_hd__and3_1
XFILLER_0_17_295 vssd1 vssd1 vccd1 vccd1 sky130_fd_sc_hd__fill_1
X_10381_ net809 net976 _04334_ _04335_ net965 vssd1 vssd1 vccd1 vccd1 _04485_ sky130_fd_sc_hd__a32o_1
X_12120_ x0mx2\[21\] net632 net592 y1my2\[21\] vssd1 vssd1 vccd1 vccd1 _06096_ sky130_fd_sc_hd__a22o_1
Xhold380 add1.b_i\[4\] vssd1 vssd1 vccd1 vccd1 net1595 sky130_fd_sc_hd__dlygate4sd3_1
XFILLER_0_2_3 vssd1 vssd1 vccd1 vccd1 sky130_ef_sc_hd__decap_12
XFILLER_0_13_490 vssd1 vssd1 vccd1 vccd1 sky130_fd_sc_hd__fill_1
X_12051_ net1121 _06044_ net513 vssd1 vssd1 vccd1 vccd1 _00254_ sky130_fd_sc_hd__mux2_1
X_11002_ _05098_ _05099_ vssd1 vssd1 vccd1 vccd1 _05101_ sky130_fd_sc_hd__xor2_1
Xhold391 l1\[6\] vssd1 vssd1 vccd1 vccd1 net1606 sky130_fd_sc_hd__dlygate4sd3_1
Xfanout860 net861 vssd1 vssd1 vccd1 vccd1 net860 sky130_fd_sc_hd__clkbuf_2
Xfanout893 net894 vssd1 vssd1 vccd1 vccd1 net893 sky130_fd_sc_hd__buf_2
Xfanout882 net886 vssd1 vssd1 vccd1 vccd1 net882 sky130_fd_sc_hd__buf_2
Xfanout871 net872 vssd1 vssd1 vccd1 vccd1 net871 sky130_fd_sc_hd__buf_2
X_12953_ clknet_leaf_52_clk_i _00339_ net1152 vssd1 vssd1 vccd1 vccd1 y1my2\[6\] sky130_fd_sc_hd__dfrtp_1
X_11904_ net122 net659 net502 net218 _05932_ vssd1 vssd1 vccd1 vccd1 _05933_ sky130_fd_sc_hd__a221o_1
XFILLER_0_87_449 vssd1 vssd1 vccd1 vccd1 sky130_fd_sc_hd__decap_8
XFILLER_0_68_641 vssd1 vssd1 vccd1 vccd1 sky130_fd_sc_hd__decap_3
X_12884_ clknet_leaf_37_clk_i _00270_ vssd1 vssd1 vccd1 vccd1 mul1.a\[19\] sky130_fd_sc_hd__dfxtp_2
XFILLER_0_114_27 vssd1 vssd1 vccd1 vccd1 sky130_fd_sc_hd__fill_1
XTAP_1851 vssd1 vccd1 sky130_fd_sc_hd__tapvpwrvgnd_1
XTAP_1840 vssd1 vccd1 sky130_fd_sc_hd__tapvpwrvgnd_1
X_11835_ net654 _00918_ net475 _05874_ vssd1 vssd1 vccd1 vccd1 _05875_ sky130_fd_sc_hd__a211o_1
XTAP_1884 vssd1 vccd1 sky130_fd_sc_hd__tapvpwrvgnd_1
XTAP_1862 vssd1 vccd1 sky130_fd_sc_hd__tapvpwrvgnd_1
XTAP_1873 vssd1 vccd1 sky130_fd_sc_hd__tapvpwrvgnd_1
XFILLER_0_55_335 vssd1 vssd1 vccd1 vccd1 sky130_fd_sc_hd__fill_1
X_11766_ net60 net674 net608 net188 vssd1 vssd1 vccd1 vccd1 _05816_ sky130_fd_sc_hd__a22o_1
XFILLER_0_23_69 vssd1 vssd1 vccd1 vccd1 sky130_fd_sc_hd__decap_8
XFILLER_0_126_713 vssd1 vssd1 vccd1 vccd1 sky130_ef_sc_hd__decap_12
XTAP_1895 vssd1 vccd1 sky130_fd_sc_hd__tapvpwrvgnd_1
X_10717_ _04378_ _04815_ _04816_ _04817_ _04810_ vssd1 vssd1 vccd1 vccd1 _04818_ sky130_fd_sc_hd__o2111a_1
XFILLER_0_55_368 vssd1 vssd1 vccd1 vccd1 sky130_fd_sc_hd__fill_1
XFILLER_0_130_37 vssd1 vssd1 vccd1 vccd1 sky130_fd_sc_hd__decap_3
XFILLER_0_126_757 vssd1 vssd1 vccd1 vccd1 sky130_ef_sc_hd__decap_12
XFILLER_0_82_176 vssd1 vssd1 vccd1 vccd1 sky130_fd_sc_hd__decap_3
X_11697_ _00614_ _00999_ _05756_ _05757_ vssd1 vssd1 vccd1 vccd1 _05758_ sky130_fd_sc_hd__o31a_1
XFILLER_0_113_429 vssd1 vssd1 vccd1 vccd1 sky130_ef_sc_hd__decap_12
X_10648_ _04644_ _04647_ vssd1 vssd1 vccd1 vccd1 _04750_ sky130_fd_sc_hd__or2_1
XFILLER_0_70_338 vssd1 vssd1 vccd1 vccd1 sky130_fd_sc_hd__decap_6
XFILLER_0_3_627 vssd1 vssd1 vccd1 vccd1 sky130_fd_sc_hd__fill_1
X_10579_ _04429_ _04680_ vssd1 vssd1 vccd1 vccd1 _04681_ sky130_fd_sc_hd__xnor2_2
Xclkbuf_leaf_31_clk_i clknet_3_4__leaf_clk_i vssd1 vssd1 vccd1 vccd1 clknet_leaf_31_clk_i
+ sky130_fd_sc_hd__clkbuf_16
X_12318_ net1671 net526 net665 vssd1 vssd1 vccd1 vccd1 _00370_ sky130_fd_sc_hd__mux2_1
XFILLER_0_121_473 vssd1 vssd1 vccd1 vccd1 sky130_ef_sc_hd__decap_12
X_12249_ x2mx1\[28\] net606 net588 temp1\[28\] vssd1 vssd1 vccd1 vccd1 _06186_ sky130_fd_sc_hd__a22o_1
Xclkbuf_leaf_46_clk_i clknet_3_1__leaf_clk_i vssd1 vssd1 vccd1 vccd1 clknet_leaf_46_clk_i
+ sky130_fd_sc_hd__clkbuf_16
XFILLER_0_48_88 vssd1 vssd1 vccd1 vccd1 sky130_fd_sc_hd__fill_2
X_06810_ net1521 net1441 net643 vssd1 vssd1 vccd1 vccd1 _00084_ sky130_fd_sc_hd__mux2_1
X_07790_ _01910_ _01911_ vssd1 vssd1 vccd1 vccd1 _01912_ sky130_fd_sc_hd__nor2_1
X_06741_ sub1.b_i\[28\] sub1.a_i\[28\] vssd1 vssd1 vccd1 vccd1 _00958_ sky130_fd_sc_hd__nand2b_1
XFILLER_0_3_57 vssd1 vssd1 vccd1 vccd1 sky130_fd_sc_hd__decap_4
X_09460_ _03423_ _03568_ _03569_ vssd1 vssd1 vccd1 vccd1 _03570_ sky130_fd_sc_hd__nor3_1
XFILLER_0_78_416 vssd1 vssd1 vccd1 vccd1 sky130_fd_sc_hd__decap_4
XFILLER_0_78_405 vssd1 vssd1 vccd1 vccd1 sky130_fd_sc_hd__fill_1
Xwire14 _01839_ vssd1 vssd1 vccd1 vccd1 net1755 sky130_fd_sc_hd__buf_1
X_08411_ _02527_ vssd1 vssd1 vccd1 vccd1 _02528_ sky130_fd_sc_hd__inv_2
X_06672_ sub1.a_i\[18\] sub1.b_i\[18\] vssd1 vssd1 vccd1 vccd1 _00899_ sky130_fd_sc_hd__nand2b_1
X_09391_ _03498_ _03499_ _03357_ _03360_ vssd1 vssd1 vccd1 vccd1 _03501_ sky130_fd_sc_hd__a211oi_2
XFILLER_0_86_460 vssd1 vssd1 vccd1 vccd1 sky130_fd_sc_hd__fill_2
X_08342_ _02458_ vssd1 vssd1 vccd1 vccd1 _02459_ sky130_fd_sc_hd__inv_2
XFILLER_0_80_53 vssd1 vssd1 vccd1 vccd1 sky130_fd_sc_hd__decap_4
XFILLER_0_129_573 vssd1 vssd1 vccd1 vccd1 sky130_ef_sc_hd__decap_12
X_08273_ _02266_ _02268_ _02389_ _02390_ vssd1 vssd1 vccd1 vccd1 _02391_ sky130_fd_sc_hd__a211o_2
XFILLER_0_116_245 vssd1 vssd1 vccd1 vccd1 sky130_fd_sc_hd__decap_6
X_07224_ net830 net1104 _01346_ _01347_ vssd1 vssd1 vccd1 vccd1 _01349_ sky130_fd_sc_hd__o2bb2a_1
XFILLER_0_27_582 vssd1 vssd1 vccd1 vccd1 sky130_fd_sc_hd__decap_3
XFILLER_0_34_519 vssd1 vssd1 vccd1 vccd1 sky130_fd_sc_hd__decap_3
XFILLER_0_89_51 vssd1 vssd1 vccd1 vccd1 sky130_fd_sc_hd__decap_4
XFILLER_0_80_3 vssd1 vssd1 vccd1 vccd1 sky130_ef_sc_hd__decap_12
XFILLER_0_14_221 vssd1 vssd1 vccd1 vccd1 sky130_fd_sc_hd__decap_4
XFILLER_0_116_289 vssd1 vssd1 vccd1 vccd1 sky130_ef_sc_hd__decap_12
XFILLER_0_14_243 vssd1 vssd1 vccd1 vccd1 sky130_fd_sc_hd__fill_1
X_07155_ _01069_ _01071_ _01070_ vssd1 vssd1 vccd1 vccd1 _01280_ sky130_fd_sc_hd__a21o_1
XFILLER_0_30_714 vssd1 vssd1 vccd1 vccd1 sky130_fd_sc_hd__fill_1
X_07086_ net882 net1066 vssd1 vssd1 vccd1 vccd1 _01211_ sky130_fd_sc_hd__nand2_1
Xoutput441 net441 vssd1 vssd1 vccd1 vccd1 mstream_o[92] sky130_fd_sc_hd__clkbuf_4
Xoutput430 net430 vssd1 vssd1 vccd1 vccd1 mstream_o[82] sky130_fd_sc_hd__clkbuf_4
XFILLER_0_1_192 vssd1 vssd1 vccd1 vccd1 sky130_fd_sc_hd__fill_2
X_07988_ _02099_ _02107_ vssd1 vssd1 vccd1 vccd1 _02108_ sky130_fd_sc_hd__and2_1
X_09727_ _03694_ _03701_ _03700_ vssd1 vssd1 vccd1 vccd1 _03835_ sky130_fd_sc_hd__a21o_1
X_06939_ _01062_ _01063_ vssd1 vssd1 vccd1 vccd1 _01064_ sky130_fd_sc_hd__nand2b_1
XFILLER_0_97_725 vssd1 vssd1 vccd1 vccd1 sky130_fd_sc_hd__decap_3
X_09658_ _03762_ _03765_ vssd1 vssd1 vccd1 vccd1 _03766_ sky130_fd_sc_hd__and2_1
XTAP_1114 vssd1 vccd1 sky130_fd_sc_hd__tapvpwrvgnd_1
XTAP_1103 vssd1 vccd1 sky130_fd_sc_hd__tapvpwrvgnd_1
X_08609_ _02722_ _02723_ _02715_ vssd1 vssd1 vccd1 vccd1 _02724_ sky130_fd_sc_hd__a21o_1
X_09589_ net859 net962 _03696_ _03697_ vssd1 vssd1 vccd1 vccd1 _03698_ sky130_fd_sc_hd__nand4_2
XFILLER_0_65_600 vssd1 vssd1 vccd1 vccd1 sky130_fd_sc_hd__fill_1
XTAP_1147 vssd1 vccd1 sky130_fd_sc_hd__tapvpwrvgnd_1
XTAP_1136 vssd1 vccd1 sky130_fd_sc_hd__tapvpwrvgnd_1
XTAP_1125 vssd1 vccd1 sky130_fd_sc_hd__tapvpwrvgnd_1
XTAP_1169 vssd1 vccd1 sky130_fd_sc_hd__tapvpwrvgnd_1
XTAP_1158 vssd1 vccd1 sky130_fd_sc_hd__tapvpwrvgnd_1
X_11620_ _05457_ _05566_ _05456_ vssd1 vssd1 vccd1 vccd1 _05714_ sky130_fd_sc_hd__a21bo_1
X_11551_ _05535_ _05538_ _05644_ _05645_ vssd1 vssd1 vccd1 vccd1 _05646_ sky130_fd_sc_hd__o211a_1
XFILLER_0_80_636 vssd1 vssd1 vccd1 vccd1 sky130_fd_sc_hd__decap_8
X_10502_ _04565_ _04566_ _04602_ _04603_ vssd1 vssd1 vccd1 vccd1 _04605_ sky130_fd_sc_hd__or4bb_1
XFILLER_0_123_727 vssd1 vssd1 vccd1 vccd1 sky130_fd_sc_hd__fill_1
X_11482_ net776 net771 net946 net943 vssd1 vssd1 vccd1 vccd1 _05577_ sky130_fd_sc_hd__and4_1
X_13221_ net507 vssd1 vssd1 vccd1 vccd1 net276 sky130_fd_sc_hd__clkbuf_1
XFILLER_0_100_29 vssd1 vssd1 vccd1 vccd1 sky130_ef_sc_hd__decap_12
X_10433_ _04432_ _04533_ _04534_ vssd1 vssd1 vccd1 vccd1 _04536_ sky130_fd_sc_hd__nand3_1
X_13152_ clknet_leaf_13_clk_i _00538_ net1189 vssd1 vssd1 vccd1 vccd1 l0\[13\] sky130_fd_sc_hd__dfrtp_1
X_10364_ _04331_ _04352_ _04466_ _04467_ vssd1 vssd1 vccd1 vccd1 _04468_ sky130_fd_sc_hd__o211a_1
X_12103_ net1023 _06083_ net516 vssd1 vssd1 vccd1 vccd1 _00267_ sky130_fd_sc_hd__mux2_1
X_10295_ _04237_ _04398_ vssd1 vssd1 vccd1 vccd1 _04399_ sky130_fd_sc_hd__nor2_1
X_13083_ clknet_leaf_0_clk_i _00469_ vssd1 vssd1 vccd1 vccd1 temp1\[8\] sky130_fd_sc_hd__dfxtp_1
XTAP_909 vssd1 vccd1 sky130_fd_sc_hd__tapvpwrvgnd_1
XFILLER_0_109_27 vssd1 vssd1 vccd1 vccd1 sky130_ef_sc_hd__decap_12
X_12034_ y2my0\[0\] net582 net531 x2mx1\[0\] _06030_ vssd1 vssd1 vccd1 vccd1 _06031_
+ sky130_fd_sc_hd__a221o_1
Xfanout690 net691 vssd1 vssd1 vccd1 vccd1 net690 sky130_fd_sc_hd__clkbuf_2
XFILLER_0_125_15 vssd1 vssd1 vccd1 vccd1 sky130_ef_sc_hd__decap_12
XFILLER_0_88_725 vssd1 vssd1 vccd1 vccd1 sky130_ef_sc_hd__decap_12
X_12936_ clknet_leaf_7_clk_i _00322_ net1193 vssd1 vssd1 vccd1 vccd1 posx\[7\] sky130_fd_sc_hd__dfrtp_1
X_12867_ clknet_leaf_48_clk_i _00253_ vssd1 vssd1 vccd1 vccd1 mul1.a\[2\] sky130_fd_sc_hd__dfxtp_1
X_11818_ net41 net687 net678 net68 vssd1 vssd1 vccd1 vccd1 _05860_ sky130_fd_sc_hd__a22o_1
XFILLER_0_95_290 vssd1 vssd1 vccd1 vccd1 sky130_fd_sc_hd__decap_6
XTAP_1692 vssd1 vccd1 sky130_fd_sc_hd__tapvpwrvgnd_1
XTAP_1670 vssd1 vccd1 sky130_fd_sc_hd__tapvpwrvgnd_1
XTAP_1681 vssd1 vccd1 sky130_fd_sc_hd__tapvpwrvgnd_1
XFILLER_0_56_655 vssd1 vssd1 vccd1 vccd1 sky130_fd_sc_hd__decap_4
XFILLER_0_55_121 vssd1 vssd1 vccd1 vccd1 sky130_fd_sc_hd__fill_1
X_12798_ clknet_leaf_23_clk_i _00184_ vssd1 vssd1 vccd1 vccd1 add1.b_i\[29\] sky130_fd_sc_hd__dfxtp_1
XFILLER_0_50_67 vssd1 vssd1 vccd1 vccd1 sky130_ef_sc_hd__decap_12
XFILLER_0_50_45 vssd1 vssd1 vccd1 vccd1 sky130_fd_sc_hd__decap_3
X_11749_ temp1\[8\] net611 net668 net120 _05801_ vssd1 vssd1 vccd1 vccd1 _05802_ sky130_fd_sc_hd__a221o_1
XFILLER_0_126_587 vssd1 vssd1 vccd1 vccd1 sky130_fd_sc_hd__fill_1
XFILLER_0_119_3 vssd1 vssd1 vccd1 vccd1 sky130_ef_sc_hd__decap_12
XFILLER_0_113_237 vssd1 vssd1 vccd1 vccd1 sky130_ef_sc_hd__decap_12
XFILLER_0_3_479 vssd1 vssd1 vccd1 vccd1 sky130_fd_sc_hd__fill_2
XFILLER_0_122_793 vssd1 vssd1 vccd1 vccd1 sky130_ef_sc_hd__decap_12
XFILLER_0_121_281 vssd1 vssd1 vccd1 vccd1 sky130_ef_sc_hd__decap_12
X_08960_ _03070_ _03071_ _03072_ vssd1 vssd1 vccd1 vccd1 _03073_ sky130_fd_sc_hd__nand3_1
X_08891_ _02857_ _02860_ _02859_ vssd1 vssd1 vccd1 vccd1 _03004_ sky130_fd_sc_hd__o21ai_1
X_07911_ _01913_ _01921_ _01920_ vssd1 vssd1 vccd1 vccd1 _02032_ sky130_fd_sc_hd__a21bo_1
XFILLER_0_45_6 vssd1 vssd1 vccd1 vccd1 sky130_ef_sc_hd__decap_12
XFILLER_0_75_53 vssd1 vssd1 vccd1 vccd1 sky130_fd_sc_hd__decap_3
X_07842_ _01857_ _01962_ vssd1 vssd1 vccd1 vccd1 _01963_ sky130_fd_sc_hd__nor2_1
X_09512_ _03619_ _03620_ _03612_ vssd1 vssd1 vccd1 vccd1 _03621_ sky130_fd_sc_hd__a21o_1
X_07773_ _01892_ _01893_ _01879_ vssd1 vssd1 vccd1 vccd1 _01895_ sky130_fd_sc_hd__a21o_1
XFILLER_0_79_747 vssd1 vssd1 vccd1 vccd1 sky130_fd_sc_hd__fill_2
X_06724_ _00941_ _00942_ vssd1 vssd1 vccd1 vccd1 _00943_ sky130_fd_sc_hd__nand2_2
X_09443_ _03551_ _03552_ _03534_ vssd1 vssd1 vccd1 vccd1 _03553_ sky130_fd_sc_hd__a21oi_2
X_06655_ sub1.a_i\[15\] sub1.b_i\[15\] vssd1 vssd1 vccd1 vccd1 _00885_ sky130_fd_sc_hd__and2b_1
XFILLER_0_115_81 vssd1 vssd1 vccd1 vccd1 sky130_ef_sc_hd__decap_12
XPHY_219 vssd1 vssd1 vccd1 vccd1 sky130_fd_sc_hd__decap_3
XPHY_208 vssd1 vssd1 vccd1 vccd1 sky130_fd_sc_hd__decap_3
X_09374_ _03323_ _03325_ vssd1 vssd1 vccd1 vccd1 _03484_ sky130_fd_sc_hd__nand2_1
X_08325_ _02432_ _02440_ vssd1 vssd1 vccd1 vccd1 _02442_ sky130_fd_sc_hd__xnor2_1
XFILLER_0_46_121 vssd1 vssd1 vccd1 vccd1 sky130_fd_sc_hd__decap_4
X_06586_ _00825_ _00826_ vssd1 vssd1 vccd1 vccd1 _00827_ sky130_fd_sc_hd__nor2_2
XFILLER_0_104_204 vssd1 vssd1 vccd1 vccd1 sky130_fd_sc_hd__decap_8
X_08256_ _02364_ _02371_ _02372_ vssd1 vssd1 vccd1 vccd1 _02374_ sky130_fd_sc_hd__nand3_2
XFILLER_0_6_262 vssd1 vssd1 vccd1 vccd1 sky130_fd_sc_hd__fill_1
XFILLER_0_27_390 vssd1 vssd1 vccd1 vccd1 sky130_fd_sc_hd__fill_2
XFILLER_0_105_749 vssd1 vssd1 vccd1 vccd1 sky130_ef_sc_hd__decap_12
X_08187_ _02181_ _02183_ vssd1 vssd1 vccd1 vccd1 _02305_ sky130_fd_sc_hd__or2_1
XFILLER_0_15_541 vssd1 vssd1 vccd1 vccd1 sky130_fd_sc_hd__decap_4
X_07207_ _01260_ _01331_ vssd1 vssd1 vccd1 vccd1 _01332_ sky130_fd_sc_hd__nand2_1
X_07138_ _01191_ _01193_ _01262_ vssd1 vssd1 vccd1 vccd1 _01263_ sky130_fd_sc_hd__a21oi_1
XFILLER_0_42_360 vssd1 vssd1 vccd1 vccd1 sky130_fd_sc_hd__decap_4
XFILLER_0_30_533 vssd1 vssd1 vccd1 vccd1 sky130_ef_sc_hd__decap_12
XFILLER_0_42_393 vssd1 vssd1 vccd1 vccd1 sky130_ef_sc_hd__decap_12
Xoutput271 net271 vssd1 vssd1 vccd1 vccd1 div_mstream_o[27] sky130_fd_sc_hd__clkbuf_4
Xoutput260 net260 vssd1 vssd1 vccd1 vccd1 div_mstream_o[17] sky130_fd_sc_hd__clkbuf_4
X_07069_ _01191_ _01192_ _01047_ _01051_ vssd1 vssd1 vccd1 vccd1 _01194_ sky130_fd_sc_hd__a211o_1
Xoutput293 net508 vssd1 vssd1 vccd1 vccd1 div_mstream_o[47] sky130_fd_sc_hd__clkbuf_4
Xoutput282 net282 vssd1 vssd1 vccd1 vccd1 div_mstream_o[37] sky130_fd_sc_hd__clkbuf_4
X_10080_ net868 net942 net936 net879 vssd1 vssd1 vccd1 vccd1 _04186_ sky130_fd_sc_hd__a22o_1
X_10982_ temp1\[25\] _05081_ net542 vssd1 vssd1 vccd1 vccd1 _05082_ sky130_fd_sc_hd__mux2_1
X_12721_ clknet_leaf_8_clk_i net1525 net1193 vssd1 vssd1 vccd1 vccd1 net340 sky130_fd_sc_hd__dfrtp_1
XFILLER_0_84_205 vssd1 vssd1 vccd1 vccd1 sky130_fd_sc_hd__fill_2
X_12652_ clknet_leaf_23_clk_i _00038_ net1174 vssd1 vssd1 vccd1 vccd1 net378 sky130_fd_sc_hd__dfrtp_1
X_11603_ _05565_ _05568_ _05605_ vssd1 vssd1 vccd1 vccd1 _05697_ sky130_fd_sc_hd__o21ai_1
XFILLER_0_80_400 vssd1 vssd1 vccd1 vccd1 sky130_fd_sc_hd__decap_4
XFILLER_0_65_474 vssd1 vssd1 vccd1 vccd1 sky130_fd_sc_hd__decap_4
XFILLER_0_25_305 vssd1 vssd1 vccd1 vccd1 sky130_fd_sc_hd__fill_1
X_12583_ net1367 net13 net554 vssd1 vssd1 vccd1 vccd1 _00558_ sky130_fd_sc_hd__mux2_1
XFILLER_0_92_271 vssd1 vssd1 vccd1 vccd1 sky130_fd_sc_hd__fill_1
XFILLER_0_53_658 vssd1 vssd1 vccd1 vccd1 sky130_fd_sc_hd__fill_1
X_11534_ _05516_ _05627_ vssd1 vssd1 vccd1 vccd1 _05629_ sky130_fd_sc_hd__xor2_1
XFILLER_0_37_187 vssd1 vssd1 vccd1 vccd1 sky130_fd_sc_hd__decap_4
XFILLER_0_37_198 vssd1 vssd1 vccd1 vccd1 sky130_fd_sc_hd__fill_2
XFILLER_0_105_9 vssd1 vssd1 vccd1 vccd1 sky130_ef_sc_hd__decap_12
XFILLER_0_52_146 vssd1 vssd1 vccd1 vccd1 sky130_fd_sc_hd__decap_4
X_11465_ _05558_ _05560_ vssd1 vssd1 vccd1 vccd1 _05561_ sky130_fd_sc_hd__or2_1
X_10416_ _04383_ _04519_ vssd1 vssd1 vccd1 vccd1 _04520_ sky130_fd_sc_hd__xnor2_1
XFILLER_0_21_522 vssd1 vssd1 vccd1 vccd1 sky130_fd_sc_hd__fill_1
XFILLER_0_21_533 vssd1 vssd1 vccd1 vccd1 sky130_fd_sc_hd__decap_8
X_11396_ _05490_ _05491_ vssd1 vssd1 vccd1 vccd1 _05492_ sky130_fd_sc_hd__and2b_1
X_13135_ clknet_leaf_4_clk_i _00521_ vssd1 vssd1 vccd1 vccd1 det_t\[28\] sky130_fd_sc_hd__dfxtp_1
XFILLER_0_103_281 vssd1 vssd1 vccd1 vccd1 sky130_fd_sc_hd__fill_2
X_10347_ _04449_ _04450_ vssd1 vssd1 vccd1 vccd1 _04451_ sky130_fd_sc_hd__xor2_1
XTAP_706 vssd1 vccd1 sky130_fd_sc_hd__tapvpwrvgnd_1
X_13066_ clknet_leaf_34_clk_i _00452_ net1165 vssd1 vssd1 vccd1 vccd1 y2my0\[23\]
+ sky130_fd_sc_hd__dfrtp_1
XFILLER_0_29_57 vssd1 vssd1 vccd1 vccd1 sky130_fd_sc_hd__decap_6
XTAP_717 vssd1 vccd1 sky130_fd_sc_hd__tapvpwrvgnd_1
XTAP_728 vssd1 vccd1 sky130_fd_sc_hd__tapvpwrvgnd_1
X_10278_ net1649 _04382_ net524 vssd1 vssd1 vccd1 vccd1 _00143_ sky130_fd_sc_hd__mux2_1
XTAP_739 vssd1 vccd1 sky130_fd_sc_hd__tapvpwrvgnd_1
X_12017_ net1328 _06017_ net483 vssd1 vssd1 vccd1 vccd1 _00247_ sky130_fd_sc_hd__mux2_1
Xmax_cap1 _03405_ vssd1 vssd1 vccd1 vccd1 net1742 sky130_fd_sc_hd__clkbuf_1
X_12919_ clknet_leaf_32_clk_i _00305_ vssd1 vssd1 vccd1 vccd1 mul1.b\[22\] sky130_fd_sc_hd__dfxtp_1
XFILLER_0_119_808 vssd1 vssd1 vccd1 vccd1 sky130_fd_sc_hd__decap_4
XFILLER_0_76_739 vssd1 vssd1 vccd1 vccd1 sky130_fd_sc_hd__decap_4
X_06440_ add1.a_i\[24\] add1.b_i\[24\] vssd1 vssd1 vccd1 vccd1 _00741_ sky130_fd_sc_hd__xor2_1
XFILLER_0_48_419 vssd1 vssd1 vccd1 vccd1 sky130_fd_sc_hd__fill_1
XTAP_2190 vssd1 vccd1 sky130_fd_sc_hd__tapvpwrvgnd_1
XFILLER_0_118_307 vssd1 vssd1 vccd1 vccd1 sky130_fd_sc_hd__fill_1
XFILLER_0_61_55 vssd1 vssd1 vccd1 vccd1 sky130_fd_sc_hd__fill_1
XFILLER_0_8_527 vssd1 vssd1 vccd1 vccd1 sky130_fd_sc_hd__decap_4
XFILLER_0_127_841 vssd1 vssd1 vccd1 vccd1 sky130_fd_sc_hd__fill_1
X_06371_ _00618_ _00676_ _00680_ vssd1 vssd1 vccd1 vccd1 _00682_ sky130_fd_sc_hd__nand3_1
XFILLER_0_83_293 vssd1 vssd1 vccd1 vccd1 sky130_fd_sc_hd__decap_4
X_09090_ _03199_ _03200_ vssd1 vssd1 vccd1 vccd1 _03202_ sky130_fd_sc_hd__xor2_1
X_08110_ net1043 net857 _02118_ _02119_ net874 vssd1 vssd1 vccd1 vccd1 _02229_ sky130_fd_sc_hd__a32o_1
XFILLER_0_43_113 vssd1 vssd1 vccd1 vccd1 sky130_fd_sc_hd__decap_4
XFILLER_0_114_513 vssd1 vssd1 vccd1 vccd1 sky130_ef_sc_hd__decap_12
X_08041_ _02159_ _02160_ vssd1 vssd1 vccd1 vccd1 _02161_ sky130_fd_sc_hd__nand2_1
XFILLER_0_114_557 vssd1 vssd1 vccd1 vccd1 sky130_ef_sc_hd__decap_12
XFILLER_0_3_232 vssd1 vssd1 vccd1 vccd1 sky130_fd_sc_hd__fill_2
X_09992_ _04094_ _04095_ _04096_ vssd1 vssd1 vccd1 vccd1 _04098_ sky130_fd_sc_hd__a21bo_1
XFILLER_0_86_41 vssd1 vssd1 vccd1 vccd1 sky130_ef_sc_hd__decap_12
X_08943_ net861 net988 _03053_ _03054_ vssd1 vssd1 vccd1 vccd1 _03056_ sky130_fd_sc_hd__o2bb2a_1
XFILLER_0_86_85 vssd1 vssd1 vccd1 vccd1 sky130_fd_sc_hd__fill_1
XFILLER_0_43_3 vssd1 vssd1 vccd1 vccd1 sky130_fd_sc_hd__decap_4
X_08874_ _02965_ _02966_ _02985_ _02986_ vssd1 vssd1 vccd1 vccd1 _02987_ sky130_fd_sc_hd__o22a_1
XFILLER_0_99_809 vssd1 vssd1 vccd1 vccd1 sky130_fd_sc_hd__fill_2
X_07825_ _01752_ _01850_ vssd1 vssd1 vccd1 vccd1 _01947_ sky130_fd_sc_hd__nand2_1
XFILLER_0_79_533 vssd1 vssd1 vccd1 vccd1 sky130_fd_sc_hd__decap_8
X_07756_ _01776_ _01779_ _01874_ _01876_ vssd1 vssd1 vccd1 vccd1 _01878_ sky130_fd_sc_hd__a211o_2
X_06707_ net1484 _00928_ net635 vssd1 vssd1 vccd1 vccd1 _00026_ sky130_fd_sc_hd__mux2_1
X_09426_ net901 net939 net937 net907 vssd1 vssd1 vccd1 vccd1 _03536_ sky130_fd_sc_hd__a22o_1
X_07687_ net1066 net856 _01807_ _01808_ vssd1 vssd1 vccd1 vccd1 _01810_ sky130_fd_sc_hd__nand4_1
XFILLER_0_59_290 vssd1 vssd1 vccd1 vccd1 sky130_fd_sc_hd__decap_8
X_06638_ _00863_ _00866_ _00864_ vssd1 vssd1 vccd1 vccd1 _00871_ sky130_fd_sc_hd__a21oi_4
X_09357_ _03424_ _03465_ _03466_ vssd1 vssd1 vccd1 vccd1 _03467_ sky130_fd_sc_hd__and3_1
XFILLER_0_75_783 vssd1 vssd1 vccd1 vccd1 sky130_fd_sc_hd__fill_1
XFILLER_0_62_400 vssd1 vssd1 vccd1 vccd1 sky130_fd_sc_hd__fill_1
X_06569_ _00808_ _00812_ vssd1 vssd1 vccd1 vccd1 _00813_ sky130_fd_sc_hd__xor2_4
XFILLER_0_90_720 vssd1 vssd1 vccd1 vccd1 sky130_ef_sc_hd__decap_12
X_09288_ _03396_ _03397_ _03240_ net488 vssd1 vssd1 vccd1 vccd1 _03399_ sky130_fd_sc_hd__a211oi_2
X_08308_ _02326_ _02329_ _02424_ vssd1 vssd1 vccd1 vccd1 _02425_ sky130_fd_sc_hd__a21oi_2
XFILLER_0_117_373 vssd1 vssd1 vccd1 vccd1 sky130_ef_sc_hd__decap_12
X_08239_ _02354_ _02355_ _02240_ _02243_ vssd1 vssd1 vccd1 vccd1 _02357_ sky130_fd_sc_hd__a211o_1
XFILLER_0_34_135 vssd1 vssd1 vccd1 vccd1 sky130_fd_sc_hd__decap_4
XFILLER_0_34_146 vssd1 vssd1 vccd1 vccd1 sky130_fd_sc_hd__decap_8
XFILLER_0_105_557 vssd1 vssd1 vccd1 vccd1 sky130_fd_sc_hd__decap_3
XFILLER_0_43_680 vssd1 vssd1 vccd1 vccd1 sky130_fd_sc_hd__fill_1
X_11250_ _05345_ net735 net982 _05344_ vssd1 vssd1 vccd1 vccd1 _05347_ sky130_fd_sc_hd__and4b_1
XFILLER_0_101_741 vssd1 vssd1 vccd1 vccd1 sky130_fd_sc_hd__decap_8
X_10201_ _04302_ _04304_ _04169_ _04172_ vssd1 vssd1 vccd1 vccd1 _04306_ sky130_fd_sc_hd__a211o_1
X_11181_ _05275_ _05278_ vssd1 vssd1 vccd1 vccd1 _05279_ sky130_fd_sc_hd__xnor2_1
XFILLER_0_101_785 vssd1 vssd1 vccd1 vccd1 sky130_fd_sc_hd__decap_4
X_10132_ _04236_ vssd1 vssd1 vccd1 vccd1 _04237_ sky130_fd_sc_hd__inv_2
XFILLER_0_100_295 vssd1 vssd1 vccd1 vccd1 sky130_fd_sc_hd__decap_3
XFILLER_0_100_262 vssd1 vssd1 vccd1 vccd1 sky130_ef_sc_hd__decap_12
X_10063_ _04155_ _04167_ _04168_ vssd1 vssd1 vccd1 vccd1 _04169_ sky130_fd_sc_hd__and3_2
XFILLER_0_15_15 vssd1 vssd1 vccd1 vccd1 sky130_ef_sc_hd__decap_12
X_12704_ clknet_leaf_13_clk_i net1422 net1188 vssd1 vssd1 vccd1 vccd1 net435 sky130_fd_sc_hd__dfrtp_1
X_10965_ _05022_ _05023_ _05063_ _05064_ vssd1 vssd1 vccd1 vccd1 _05065_ sky130_fd_sc_hd__nor4_1
X_10896_ _04993_ _04994_ vssd1 vssd1 vccd1 vccd1 _04996_ sky130_fd_sc_hd__xor2_1
XFILLER_0_127_137 vssd1 vssd1 vccd1 vccd1 sky130_ef_sc_hd__decap_12
XFILLER_0_122_27 vssd1 vssd1 vccd1 vccd1 sky130_fd_sc_hd__fill_1
XFILLER_0_109_841 vssd1 vssd1 vccd1 vccd1 sky130_fd_sc_hd__fill_1
X_12635_ clknet_leaf_27_clk_i _00021_ net1171 vssd1 vssd1 vccd1 vccd1 net359 sky130_fd_sc_hd__dfrtp_1
XFILLER_0_93_580 vssd1 vssd1 vccd1 vccd1 sky130_fd_sc_hd__decap_6
X_12566_ net1441 net10 net560 vssd1 vssd1 vccd1 vccd1 _00542_ sky130_fd_sc_hd__mux2_1
XFILLER_0_53_433 vssd1 vssd1 vccd1 vccd1 sky130_fd_sc_hd__fill_1
XFILLER_0_124_811 vssd1 vssd1 vccd1 vccd1 sky130_fd_sc_hd__fill_1
X_11517_ net996 net712 net708 net1003 vssd1 vssd1 vccd1 vccd1 _05612_ sky130_fd_sc_hd__a22o_1
XFILLER_0_41_617 vssd1 vssd1 vccd1 vccd1 sky130_fd_sc_hd__fill_1
X_12497_ net1240 net562 _06245_ vssd1 vssd1 vccd1 vccd1 _00499_ sky130_fd_sc_hd__a21o_1
XFILLER_0_25_179 vssd1 vssd1 vccd1 vccd1 sky130_fd_sc_hd__decap_4
XFILLER_0_111_505 vssd1 vssd1 vccd1 vccd1 sky130_ef_sc_hd__decap_12
Xhold209 net395 vssd1 vssd1 vccd1 vccd1 net1424 sky130_fd_sc_hd__dlygate4sd3_1
X_11448_ _05541_ _05542_ _05376_ _05379_ vssd1 vssd1 vccd1 vccd1 _05544_ sky130_fd_sc_hd__a211o_1
X_11379_ _05473_ _05474_ vssd1 vssd1 vccd1 vccd1 _05475_ sky130_fd_sc_hd__or2_1
X_13118_ clknet_leaf_3_clk_i _00504_ vssd1 vssd1 vccd1 vccd1 det_t\[11\] sky130_fd_sc_hd__dfxtp_1
XFILLER_0_0_279 vssd1 vssd1 vccd1 vccd1 sky130_fd_sc_hd__fill_1
XTAP_503 vssd1 vccd1 sky130_fd_sc_hd__tapvpwrvgnd_1
XTAP_514 vssd1 vccd1 sky130_fd_sc_hd__tapvpwrvgnd_1
XTAP_525 vssd1 vccd1 sky130_fd_sc_hd__tapvpwrvgnd_1
XTAP_536 vssd1 vccd1 sky130_fd_sc_hd__tapvpwrvgnd_1
XTAP_547 vssd1 vccd1 sky130_fd_sc_hd__tapvpwrvgnd_1
XTAP_558 vssd1 vccd1 sky130_fd_sc_hd__tapvpwrvgnd_1
XTAP_569 vssd1 vccd1 sky130_fd_sc_hd__tapvpwrvgnd_1
X_13049_ clknet_leaf_45_clk_i _00435_ net1153 vssd1 vssd1 vccd1 vccd1 y2my0\[6\] sky130_fd_sc_hd__dfrtp_1
X_08590_ net1099 net756 vssd1 vssd1 vccd1 vccd1 _02705_ sky130_fd_sc_hd__nand2_1
X_07610_ _01732_ _01733_ _01713_ vssd1 vssd1 vccd1 vccd1 _01734_ sky130_fd_sc_hd__a21oi_1
XFILLER_0_72_21 vssd1 vssd1 vccd1 vccd1 sky130_fd_sc_hd__decap_6
X_07541_ _01461_ _01462_ _01664_ vssd1 vssd1 vccd1 vccd1 _01666_ sky130_fd_sc_hd__o21ai_1
XFILLER_0_88_363 vssd1 vssd1 vccd1 vccd1 sky130_fd_sc_hd__fill_1
XFILLER_0_72_76 vssd1 vssd1 vccd1 vccd1 sky130_fd_sc_hd__decap_8
X_07472_ net896 net891 net1128 net1138 vssd1 vssd1 vccd1 vccd1 _01597_ sky130_fd_sc_hd__and4_1
X_09211_ net1031 net802 net793 net1035 vssd1 vssd1 vccd1 vccd1 _03322_ sky130_fd_sc_hd__a22o_1
XFILLER_0_57_761 vssd1 vssd1 vccd1 vccd1 sky130_fd_sc_hd__fill_2
X_06423_ _00724_ _00725_ vssd1 vssd1 vccd1 vccd1 _00727_ sky130_fd_sc_hd__xnor2_4
X_09142_ _03150_ _03151_ _03250_ _03251_ vssd1 vssd1 vccd1 vccd1 _03254_ sky130_fd_sc_hd__o22ai_1
X_06354_ _00663_ _00665_ vssd1 vssd1 vccd1 vccd1 _00666_ sky130_fd_sc_hd__nand2_2
XFILLER_0_44_466 vssd1 vssd1 vccd1 vccd1 sky130_fd_sc_hd__fill_2
XFILLER_0_114_321 vssd1 vssd1 vccd1 vccd1 sky130_ef_sc_hd__decap_12
X_09073_ _03046_ _03050_ _03182_ _03184_ vssd1 vssd1 vccd1 vccd1 _03185_ sky130_fd_sc_hd__o211ai_4
X_06285_ _00597_ _00600_ vssd1 vssd1 vccd1 vccd1 _00601_ sky130_fd_sc_hd__nor2_4
XFILLER_0_114_365 vssd1 vssd1 vccd1 vccd1 sky130_ef_sc_hd__decap_12
X_08024_ _02125_ _02142_ _02143_ vssd1 vssd1 vccd1 vccd1 _02144_ sky130_fd_sc_hd__and3_1
XFILLER_0_12_330 vssd1 vssd1 vccd1 vccd1 sky130_fd_sc_hd__fill_2
Xmax_cap462 net463 vssd1 vssd1 vccd1 vccd1 net462 sky130_fd_sc_hd__clkbuf_1
XFILLER_0_97_51 vssd1 vssd1 vccd1 vccd1 sky130_fd_sc_hd__decap_4
Xmax_cap451 _00782_ vssd1 vssd1 vccd1 vccd1 net451 sky130_fd_sc_hd__buf_4
Xmax_cap495 _01933_ vssd1 vssd1 vccd1 vccd1 net495 sky130_fd_sc_hd__clkbuf_1
X_09975_ net1117 net699 net695 net1109 vssd1 vssd1 vccd1 vccd1 _04081_ sky130_fd_sc_hd__and4b_2
X_08926_ net835 net1009 _03036_ _03037_ vssd1 vssd1 vccd1 vccd1 _03039_ sky130_fd_sc_hd__o2bb2a_1
X_08857_ net1115 net727 net723 net1124 vssd1 vssd1 vccd1 vccd1 _02970_ sky130_fd_sc_hd__a22oi_1
X_07808_ _01831_ _01835_ _01927_ _01928_ vssd1 vssd1 vccd1 vccd1 _01930_ sky130_fd_sc_hd__a211oi_4
XFILLER_0_79_330 vssd1 vssd1 vccd1 vccd1 sky130_fd_sc_hd__decap_6
X_08788_ _02764_ _02766_ _02901_ vssd1 vssd1 vccd1 vccd1 _02902_ sky130_fd_sc_hd__a21o_2
X_07739_ net1132 net781 vssd1 vssd1 vccd1 vccd1 _01861_ sky130_fd_sc_hd__nand2_1
X_10750_ _04850_ vssd1 vssd1 vccd1 vccd1 _04851_ sky130_fd_sc_hd__inv_2
XFILLER_0_109_137 vssd1 vssd1 vccd1 vccd1 sky130_ef_sc_hd__decap_12
XFILLER_0_94_377 vssd1 vssd1 vccd1 vccd1 sky130_fd_sc_hd__fill_1
XFILLER_0_82_506 vssd1 vssd1 vccd1 vccd1 sky130_fd_sc_hd__fill_2
X_10681_ _04577_ _04580_ _04781_ vssd1 vssd1 vccd1 vccd1 _04783_ sky130_fd_sc_hd__and3_1
X_09409_ _03517_ _03518_ _03510_ vssd1 vssd1 vccd1 vccd1 _03519_ sky130_fd_sc_hd__a21o_1
XFILLER_0_54_219 vssd1 vssd1 vccd1 vccd1 sky130_fd_sc_hd__decap_8
XFILLER_0_106_800 vssd1 vssd1 vccd1 vccd1 sky130_fd_sc_hd__fill_2
X_12420_ net1712 _06202_ net570 vssd1 vssd1 vccd1 vccd1 _00465_ sky130_fd_sc_hd__mux2_1
XFILLER_0_118_693 vssd1 vssd1 vccd1 vccd1 sky130_fd_sc_hd__decap_6
XFILLER_0_117_181 vssd1 vssd1 vccd1 vccd1 sky130_ef_sc_hd__decap_12
X_12351_ net1515 _00840_ net657 vssd1 vssd1 vccd1 vccd1 _00403_ sky130_fd_sc_hd__mux2_1
XFILLER_0_23_617 vssd1 vssd1 vccd1 vccd1 sky130_fd_sc_hd__fill_2
X_12282_ net1677 _00813_ net675 vssd1 vssd1 vccd1 vccd1 _00334_ sky130_fd_sc_hd__mux2_1
X_11302_ _05395_ _05398_ vssd1 vssd1 vccd1 vccd1 _05399_ sky130_fd_sc_hd__and2b_1
X_11233_ net824 net816 net929 vssd1 vssd1 vccd1 vccd1 _05330_ sky130_fd_sc_hd__o21a_1
XFILLER_0_120_357 vssd1 vssd1 vccd1 vccd1 sky130_fd_sc_hd__decap_6
X_11164_ _05224_ _05260_ _05261_ vssd1 vssd1 vccd1 vccd1 _05262_ sky130_fd_sc_hd__or3_2
X_10115_ _04062_ _04064_ _04061_ vssd1 vssd1 vccd1 vccd1 _04221_ sky130_fd_sc_hd__o21ai_2
X_11095_ _05191_ _05192_ _05067_ _05069_ vssd1 vssd1 vccd1 vccd1 _05194_ sky130_fd_sc_hd__a211o_1
XFILLER_0_117_27 vssd1 vssd1 vccd1 vccd1 sky130_ef_sc_hd__decap_12
XFILLER_0_89_105 vssd1 vssd1 vccd1 vccd1 sky130_fd_sc_hd__decap_6
X_10046_ _04150_ _04151_ _04116_ vssd1 vssd1 vccd1 vccd1 _04152_ sky130_fd_sc_hd__a21oi_1
Xhold70 add1.b_i\[19\] vssd1 vssd1 vccd1 vccd1 net1285 sky130_fd_sc_hd__dlygate4sd3_1
Xhold92 add1.a_i\[14\] vssd1 vssd1 vccd1 vccd1 net1307 sky130_fd_sc_hd__dlygate4sd3_1
Xhold81 sub1.a_i\[21\] vssd1 vssd1 vccd1 vccd1 net1296 sky130_fd_sc_hd__dlygate4sd3_1
XFILLER_0_97_160 vssd1 vssd1 vccd1 vccd1 sky130_fd_sc_hd__decap_8
X_11997_ net1271 _06002_ net482 vssd1 vssd1 vccd1 vccd1 _00242_ sky130_fd_sc_hd__mux2_1
XFILLER_0_97_193 vssd1 vssd1 vccd1 vccd1 sky130_ef_sc_hd__decap_12
XFILLER_0_85_322 vssd1 vssd1 vccd1 vccd1 sky130_fd_sc_hd__decap_8
X_10948_ _05045_ _05046_ _04856_ _04858_ vssd1 vssd1 vccd1 vccd1 _05048_ sky130_fd_sc_hd__o211ai_1
XFILLER_0_58_569 vssd1 vssd1 vccd1 vccd1 sky130_ef_sc_hd__decap_12
XFILLER_0_42_46 vssd1 vssd1 vccd1 vccd1 sky130_fd_sc_hd__fill_2
XFILLER_0_66_580 vssd1 vssd1 vccd1 vccd1 sky130_fd_sc_hd__decap_8
X_10879_ _04959_ _04977_ vssd1 vssd1 vccd1 vccd1 _04979_ sky130_fd_sc_hd__xor2_1
XFILLER_0_26_411 vssd1 vssd1 vccd1 vccd1 sky130_fd_sc_hd__fill_1
XFILLER_0_38_282 vssd1 vssd1 vccd1 vccd1 sky130_fd_sc_hd__fill_1
XFILLER_0_109_671 vssd1 vssd1 vccd1 vccd1 sky130_fd_sc_hd__fill_1
X_12618_ clknet_leaf_49_clk_i _00004_ net1159 vssd1 vssd1 vccd1 vccd1 net361 sky130_fd_sc_hd__dfrtp_2
X_12549_ net1481 net2 net558 vssd1 vssd1 vccd1 vccd1 _00525_ sky130_fd_sc_hd__mux2_1
XFILLER_0_54_797 vssd1 vssd1 vccd1 vccd1 sky130_fd_sc_hd__fill_2
XFILLER_0_26_477 vssd1 vssd1 vccd1 vccd1 sky130_fd_sc_hd__fill_2
XFILLER_0_26_488 vssd1 vssd1 vccd1 vccd1 sky130_fd_sc_hd__fill_1
XFILLER_0_101_3 vssd1 vssd1 vccd1 vccd1 sky130_ef_sc_hd__decap_12
XANTENNA_1 _00601_ vssd1 vssd1 vccd1 vccd1 sky130_fd_sc_hd__diode_2
XFILLER_0_13_149 vssd1 vssd1 vccd1 vccd1 sky130_fd_sc_hd__decap_8
XFILLER_0_41_447 vssd1 vssd1 vccd1 vccd1 sky130_fd_sc_hd__fill_1
XFILLER_0_111_335 vssd1 vssd1 vccd1 vccd1 sky130_fd_sc_hd__fill_1
Xfanout508 net293 vssd1 vssd1 vccd1 vccd1 net508 sky130_fd_sc_hd__clkbuf_2
XFILLER_0_67_54 vssd1 vssd1 vccd1 vccd1 sky130_fd_sc_hd__fill_2
XTAP_333 vssd1 vccd1 sky130_fd_sc_hd__tapvpwrvgnd_1
XTAP_322 vssd1 vccd1 sky130_fd_sc_hd__tapvpwrvgnd_1
XTAP_311 vssd1 vccd1 sky130_fd_sc_hd__tapvpwrvgnd_1
XTAP_300 vssd1 vccd1 sky130_fd_sc_hd__tapvpwrvgnd_1
XFILLER_0_1_599 vssd1 vssd1 vccd1 vccd1 sky130_fd_sc_hd__fill_1
Xfanout519 net520 vssd1 vssd1 vccd1 vccd1 net519 sky130_fd_sc_hd__clkbuf_4
X_09760_ net883 net940 _03865_ _03866_ vssd1 vssd1 vccd1 vccd1 _03868_ sky130_fd_sc_hd__a22o_1
XTAP_366 vssd1 vccd1 sky130_fd_sc_hd__tapvpwrvgnd_1
XTAP_355 vssd1 vccd1 sky130_fd_sc_hd__tapvpwrvgnd_1
XTAP_344 vssd1 vccd1 sky130_fd_sc_hd__tapvpwrvgnd_1
X_06972_ _01090_ _01091_ _01096_ vssd1 vssd1 vccd1 vccd1 _01097_ sky130_fd_sc_hd__nand3_1
X_09691_ net1053 net752 net744 net1062 vssd1 vssd1 vccd1 vccd1 _03799_ sky130_fd_sc_hd__a22oi_2
X_08711_ _02704_ _02712_ _02711_ vssd1 vssd1 vccd1 vccd1 _02825_ sky130_fd_sc_hd__o21a_1
XTAP_399 vssd1 vccd1 sky130_fd_sc_hd__tapvpwrvgnd_1
XTAP_377 vssd1 vccd1 sky130_fd_sc_hd__tapvpwrvgnd_1
XTAP_388 vssd1 vccd1 sky130_fd_sc_hd__tapvpwrvgnd_1
X_08642_ _02620_ _02622_ vssd1 vssd1 vccd1 vccd1 _02757_ sky130_fd_sc_hd__or2_1
Xfanout1090 mul1.a\[7\] vssd1 vssd1 vccd1 vccd1 net1090 sky130_fd_sc_hd__clkbuf_4
XFILLER_0_107_93 vssd1 vssd1 vccd1 vccd1 sky130_ef_sc_hd__decap_12
X_08573_ _02686_ _02687_ vssd1 vssd1 vccd1 vccd1 _02688_ sky130_fd_sc_hd__or2_1
XPHY_17 vssd1 vssd1 vccd1 vccd1 sky130_fd_sc_hd__decap_3
XPHY_28 vssd1 vssd1 vccd1 vccd1 sky130_fd_sc_hd__decap_3
XFILLER_0_49_536 vssd1 vssd1 vccd1 vccd1 sky130_fd_sc_hd__decap_3
X_07524_ _01637_ _01648_ _01642_ vssd1 vssd1 vccd1 vccd1 _01649_ sky130_fd_sc_hd__o21ai_1
XPHY_39 vssd1 vssd1 vccd1 vccd1 sky130_fd_sc_hd__decap_3
XFILLER_0_9_644 vssd1 vssd1 vccd1 vccd1 sky130_fd_sc_hd__fill_2
X_07455_ _01577_ _01578_ _01571_ vssd1 vssd1 vccd1 vccd1 _01580_ sky130_fd_sc_hd__o21bai_1
X_06406_ _00700_ _00705_ _00710_ vssd1 vssd1 vccd1 vccd1 _00712_ sky130_fd_sc_hd__o21ba_1
XFILLER_0_9_666 vssd1 vssd1 vccd1 vccd1 sky130_fd_sc_hd__decap_6
XFILLER_0_8_132 vssd1 vssd1 vccd1 vccd1 sky130_fd_sc_hd__decap_3
XFILLER_0_123_81 vssd1 vssd1 vccd1 vccd1 sky130_ef_sc_hd__decap_12
X_07386_ _01508_ _01510_ vssd1 vssd1 vccd1 vccd1 _01511_ sky130_fd_sc_hd__nor2_1
XFILLER_0_115_641 vssd1 vssd1 vccd1 vccd1 sky130_ef_sc_hd__decap_12
X_09125_ _03235_ _03236_ _03218_ vssd1 vssd1 vccd1 vccd1 _03237_ sky130_fd_sc_hd__a21oi_2
XFILLER_0_60_701 vssd1 vssd1 vccd1 vccd1 sky130_fd_sc_hd__fill_2
X_06337_ add1.a_i\[0\] add1.b_i\[0\] vssd1 vssd1 vccd1 vccd1 _00649_ sky130_fd_sc_hd__nand2_4
XFILLER_0_115_685 vssd1 vssd1 vccd1 vccd1 sky130_fd_sc_hd__decap_8
X_09056_ _03166_ _03167_ vssd1 vssd1 vccd1 vccd1 _03168_ sky130_fd_sc_hd__and2_1
XFILLER_0_32_447 vssd1 vssd1 vccd1 vccd1 sky130_fd_sc_hd__fill_1
XFILLER_0_114_195 vssd1 vssd1 vccd1 vccd1 sky130_fd_sc_hd__fill_1
X_08007_ net889 net1007 net1000 net898 vssd1 vssd1 vccd1 vccd1 _02127_ sky130_fd_sc_hd__a22oi_1
X_09958_ _04062_ _04064_ vssd1 vssd1 vccd1 vccd1 _04065_ sky130_fd_sc_hd__xor2_4
X_08909_ _03019_ _03020_ vssd1 vssd1 vccd1 vccd1 _03022_ sky130_fd_sc_hd__xnor2_1
X_09889_ net809 net991 vssd1 vssd1 vccd1 vccd1 _03996_ sky130_fd_sc_hd__nand2_1
X_11920_ net148 net659 net502 net244 _05944_ vssd1 vssd1 vccd1 vccd1 _05945_ sky130_fd_sc_hd__a221o_1
X_11851_ net1498 _05888_ net484 vssd1 vssd1 vccd1 vccd1 _00210_ sky130_fd_sc_hd__mux2_1
X_10802_ _04900_ _04901_ vssd1 vssd1 vccd1 vccd1 _04903_ sky130_fd_sc_hd__xor2_1
XFILLER_0_67_311 vssd1 vssd1 vccd1 vccd1 sky130_fd_sc_hd__decap_4
X_11782_ net158 net470 _05829_ vssd1 vssd1 vccd1 vccd1 _05830_ sky130_fd_sc_hd__o21a_1
XFILLER_0_94_141 vssd1 vssd1 vccd1 vccd1 sky130_fd_sc_hd__decap_8
X_10733_ net808 net953 vssd1 vssd1 vccd1 vccd1 _04834_ sky130_fd_sc_hd__nand2_1
XFILLER_0_95_697 vssd1 vssd1 vccd1 vccd1 sky130_ef_sc_hd__decap_12
XFILLER_0_12_27 vssd1 vssd1 vccd1 vccd1 sky130_fd_sc_hd__fill_1
XFILLER_0_125_405 vssd1 vssd1 vccd1 vccd1 sky130_ef_sc_hd__decap_12
X_10664_ _04615_ _04621_ _04765_ vssd1 vssd1 vccd1 vccd1 _04766_ sky130_fd_sc_hd__o21a_1
XFILLER_0_35_241 vssd1 vssd1 vccd1 vccd1 sky130_fd_sc_hd__decap_3
XFILLER_0_125_449 vssd1 vssd1 vccd1 vccd1 sky130_ef_sc_hd__decap_12
X_10595_ _04694_ _04695_ vssd1 vssd1 vccd1 vccd1 _04697_ sky130_fd_sc_hd__xor2_2
X_12403_ net1438 _00946_ net685 vssd1 vssd1 vccd1 vccd1 _00455_ sky130_fd_sc_hd__mux2_1
XFILLER_0_90_391 vssd1 vssd1 vccd1 vccd1 sky130_ef_sc_hd__decap_12
X_12334_ net1664 _00918_ net670 vssd1 vssd1 vccd1 vccd1 _00386_ sky130_fd_sc_hd__mux2_1
XFILLER_0_120_121 vssd1 vssd1 vccd1 vccd1 sky130_ef_sc_hd__decap_12
XFILLER_0_50_244 vssd1 vssd1 vccd1 vccd1 sky130_fd_sc_hd__decap_8
X_12265_ net1216 net42 net689 vssd1 vssd1 vccd1 vccd1 _00319_ sky130_fd_sc_hd__mux2_1
XFILLER_0_50_288 vssd1 vssd1 vccd1 vccd1 sky130_fd_sc_hd__decap_4
XFILLER_0_120_165 vssd1 vssd1 vccd1 vccd1 sky130_ef_sc_hd__decap_12
X_11216_ _05311_ _05312_ _05189_ _05191_ vssd1 vssd1 vccd1 vccd1 _05314_ sky130_fd_sc_hd__o211a_1
X_12196_ _00862_ net509 net466 y1my2\[10\] _06150_ vssd1 vssd1 vccd1 vccd1 _06151_
+ sky130_fd_sc_hd__a221o_1
XFILLER_0_128_15 vssd1 vssd1 vccd1 vccd1 sky130_ef_sc_hd__decap_12
X_11147_ net789 net946 net941 net799 vssd1 vssd1 vccd1 vccd1 _05245_ sky130_fd_sc_hd__a22oi_1
XFILLER_0_37_57 vssd1 vssd1 vccd1 vccd1 sky130_fd_sc_hd__decap_8
X_11078_ _05052_ _05054_ _05175_ _05176_ vssd1 vssd1 vccd1 vccd1 _05177_ sky130_fd_sc_hd__o211a_2
Xinput160 v1y[15] vssd1 vssd1 vccd1 vccd1 net160 sky130_fd_sc_hd__clkbuf_1
Xinput171 v1y[25] vssd1 vssd1 vccd1 vccd1 net171 sky130_fd_sc_hd__clkbuf_1
X_10029_ net804 net794 net998 net991 vssd1 vssd1 vccd1 vccd1 _04135_ sky130_fd_sc_hd__nand4_2
Xinput193 v2x[16] vssd1 vssd1 vccd1 vccd1 net193 sky130_fd_sc_hd__clkbuf_1
Xinput182 v1y[6] vssd1 vssd1 vccd1 vccd1 net182 sky130_fd_sc_hd__buf_1
XFILLER_0_86_642 vssd1 vssd1 vccd1 vccd1 sky130_fd_sc_hd__fill_2
XFILLER_0_129_744 vssd1 vssd1 vccd1 vccd1 sky130_fd_sc_hd__fill_1
XFILLER_0_86_653 vssd1 vssd1 vccd1 vccd1 sky130_fd_sc_hd__fill_1
X_07240_ _01359_ _01364_ vssd1 vssd1 vccd1 vccd1 _01365_ sky130_fd_sc_hd__or2_1
XFILLER_0_128_298 vssd1 vssd1 vccd1 vccd1 sky130_fd_sc_hd__fill_1
XFILLER_0_5_113 vssd1 vssd1 vccd1 vccd1 sky130_fd_sc_hd__fill_1
X_07171_ net871 net862 net1111 net1118 vssd1 vssd1 vccd1 vccd1 _01296_ sky130_fd_sc_hd__and4_1
XFILLER_0_42_701 vssd1 vssd1 vccd1 vccd1 sky130_fd_sc_hd__fill_2
XFILLER_0_5_157 vssd1 vssd1 vccd1 vccd1 sky130_fd_sc_hd__fill_2
XFILLER_0_41_233 vssd1 vssd1 vccd1 vccd1 sky130_fd_sc_hd__decap_3
XFILLER_0_78_53 vssd1 vssd1 vccd1 vccd1 sky130_fd_sc_hd__decap_8
XFILLER_0_112_699 vssd1 vssd1 vccd1 vccd1 sky130_fd_sc_hd__fill_1
X_09812_ net1116 net700 net693 net1125 vssd1 vssd1 vccd1 vccd1 _03919_ sky130_fd_sc_hd__o2bb2a_1
XFILLER_0_10_697 vssd1 vssd1 vccd1 vccd1 sky130_fd_sc_hd__decap_3
XFILLER_0_94_41 vssd1 vssd1 vccd1 vccd1 sky130_ef_sc_hd__decap_12
X_09743_ _03847_ _03848_ _03835_ vssd1 vssd1 vccd1 vccd1 _03851_ sky130_fd_sc_hd__a21oi_1
X_06955_ _01077_ _01078_ _01073_ vssd1 vssd1 vccd1 vccd1 _01080_ sky130_fd_sc_hd__a21o_1
X_06886_ net1195 net47 net690 vssd1 vssd1 vccd1 vccd1 _01012_ sky130_fd_sc_hd__and3_1
X_09674_ _03776_ _03780_ _03781_ vssd1 vssd1 vccd1 vccd1 _03782_ sky130_fd_sc_hd__nand3_2
XTAP_2019 vssd1 vccd1 sky130_fd_sc_hd__tapvpwrvgnd_1
XTAP_2008 vssd1 vccd1 sky130_fd_sc_hd__tapvpwrvgnd_1
X_08625_ net823 _02739_ _02738_ vssd1 vssd1 vccd1 vccd1 _02740_ sky130_fd_sc_hd__a21bo_1
XTAP_1329 vssd1 vccd1 sky130_fd_sc_hd__tapvpwrvgnd_1
XTAP_1318 vssd1 vccd1 sky130_fd_sc_hd__tapvpwrvgnd_1
XTAP_1307 vssd1 vccd1 sky130_fd_sc_hd__tapvpwrvgnd_1
X_08556_ _02544_ _02671_ vssd1 vssd1 vccd1 vccd1 _02672_ sky130_fd_sc_hd__xnor2_2
XFILLER_0_92_601 vssd1 vssd1 vccd1 vccd1 sky130_fd_sc_hd__decap_3
XFILLER_0_77_653 vssd1 vssd1 vccd1 vccd1 sky130_fd_sc_hd__decap_8
X_07507_ _01619_ _01631_ vssd1 vssd1 vccd1 vccd1 _01632_ sky130_fd_sc_hd__nand2_1
XFILLER_0_92_634 vssd1 vssd1 vccd1 vccd1 sky130_fd_sc_hd__decap_8
XFILLER_0_91_100 vssd1 vssd1 vccd1 vccd1 sky130_ef_sc_hd__decap_12
X_08487_ net1016 net849 net840 net1024 vssd1 vssd1 vccd1 vccd1 _02603_ sky130_fd_sc_hd__a22o_1
XFILLER_0_92_645 vssd1 vssd1 vccd1 vccd1 sky130_fd_sc_hd__fill_2
XFILLER_0_64_336 vssd1 vssd1 vccd1 vccd1 sky130_fd_sc_hd__decap_8
X_07438_ net896 net888 net1119 net1128 vssd1 vssd1 vccd1 vccd1 _01563_ sky130_fd_sc_hd__and4_1
XFILLER_0_91_166 vssd1 vssd1 vccd1 vccd1 sky130_fd_sc_hd__fill_2
X_07369_ _01423_ _01466_ _01481_ vssd1 vssd1 vccd1 vccd1 _01494_ sky130_fd_sc_hd__a21oi_1
XFILLER_0_122_419 vssd1 vssd1 vccd1 vccd1 sky130_fd_sc_hd__fill_1
X_09108_ net892 net955 net949 net903 vssd1 vssd1 vccd1 vccd1 _03220_ sky130_fd_sc_hd__a22o_1
XFILLER_0_60_531 vssd1 vssd1 vccd1 vccd1 sky130_fd_sc_hd__fill_1
X_10380_ _04290_ _04292_ vssd1 vssd1 vccd1 vccd1 _04484_ sky130_fd_sc_hd__nand2_1
XFILLER_0_60_553 vssd1 vssd1 vccd1 vccd1 sky130_fd_sc_hd__decap_4
X_09039_ _03148_ _03149_ _03115_ vssd1 vssd1 vccd1 vccd1 _03151_ sky130_fd_sc_hd__o21a_1
XFILLER_0_60_597 vssd1 vssd1 vccd1 vccd1 sky130_fd_sc_hd__fill_2
XFILLER_0_130_496 vssd1 vssd1 vccd1 vccd1 sky130_fd_sc_hd__decap_8
Xhold370 posy\[4\] vssd1 vssd1 vccd1 vccd1 net1585 sky130_fd_sc_hd__dlygate4sd3_1
XFILLER_0_102_154 vssd1 vssd1 vccd1 vccd1 sky130_fd_sc_hd__decap_8
Xhold381 sub1.a_i\[17\] vssd1 vssd1 vccd1 vccd1 net1596 sky130_fd_sc_hd__dlygate4sd3_1
X_12050_ _00823_ _05752_ _06032_ _06043_ vssd1 vssd1 vccd1 vccd1 _06044_ sky130_fd_sc_hd__a31o_1
Xhold392 add1.b_i\[25\] vssd1 vssd1 vccd1 vccd1 net1607 sky130_fd_sc_hd__dlygate4sd3_1
X_11001_ _05099_ _05098_ vssd1 vssd1 vccd1 vccd1 _05100_ sky130_fd_sc_hd__and2b_2
Xfanout850 net851 vssd1 vssd1 vccd1 vccd1 net850 sky130_fd_sc_hd__clkbuf_4
Xfanout861 mul1.b\[8\] vssd1 vssd1 vccd1 vccd1 net861 sky130_fd_sc_hd__buf_2
Xfanout894 mul1.b\[4\] vssd1 vssd1 vccd1 vccd1 net894 sky130_fd_sc_hd__buf_2
Xfanout883 net884 vssd1 vssd1 vccd1 vccd1 net883 sky130_fd_sc_hd__clkbuf_4
Xfanout872 net876 vssd1 vssd1 vccd1 vccd1 net872 sky130_fd_sc_hd__clkbuf_2
X_12952_ clknet_leaf_52_clk_i _00338_ net1154 vssd1 vssd1 vccd1 vccd1 y1my2\[5\] sky130_fd_sc_hd__dfrtp_1
X_11903_ net2 net549 net624 net186 _05931_ vssd1 vssd1 vccd1 vccd1 _05932_ sky130_fd_sc_hd__a221o_1
X_12883_ clknet_leaf_37_clk_i _00269_ vssd1 vssd1 vccd1 vccd1 mul1.a\[18\] sky130_fd_sc_hd__dfxtp_2
XTAP_1852 vssd1 vccd1 sky130_fd_sc_hd__tapvpwrvgnd_1
XTAP_1841 vssd1 vccd1 sky130_fd_sc_hd__tapvpwrvgnd_1
XTAP_1830 vssd1 vccd1 sky130_fd_sc_hd__tapvpwrvgnd_1
X_11834_ net103 net669 _05871_ _05873_ vssd1 vssd1 vccd1 vccd1 _05874_ sky130_fd_sc_hd__a211o_1
XFILLER_0_23_15 vssd1 vssd1 vccd1 vccd1 sky130_ef_sc_hd__decap_12
XFILLER_0_28_506 vssd1 vssd1 vccd1 vccd1 sky130_ef_sc_hd__decap_12
XTAP_1885 vssd1 vccd1 sky130_fd_sc_hd__tapvpwrvgnd_1
XTAP_1863 vssd1 vccd1 sky130_fd_sc_hd__tapvpwrvgnd_1
XTAP_1874 vssd1 vccd1 sky130_fd_sc_hd__tapvpwrvgnd_1
XFILLER_0_68_686 vssd1 vssd1 vccd1 vccd1 sky130_fd_sc_hd__fill_1
X_11765_ net1275 _05815_ net479 vssd1 vssd1 vccd1 vccd1 _00197_ sky130_fd_sc_hd__mux2_1
XFILLER_0_126_725 vssd1 vssd1 vccd1 vccd1 sky130_ef_sc_hd__decap_12
XTAP_1896 vssd1 vccd1 sky130_fd_sc_hd__tapvpwrvgnd_1
X_10716_ _04664_ _04665_ _04808_ vssd1 vssd1 vccd1 vccd1 _04817_ sky130_fd_sc_hd__or3_1
X_11696_ net28 _00602_ _00615_ net37 net1170 vssd1 vssd1 vccd1 vccd1 _05757_ sky130_fd_sc_hd__o221a_1
XFILLER_0_130_27 vssd1 vssd1 vccd1 vccd1 sky130_fd_sc_hd__fill_1
XFILLER_0_126_769 vssd1 vssd1 vccd1 vccd1 sky130_ef_sc_hd__decap_12
X_10647_ _04746_ _04747_ _04565_ _04604_ vssd1 vssd1 vccd1 vccd1 _04749_ sky130_fd_sc_hd__a211oi_2
XFILLER_0_106_471 vssd1 vssd1 vccd1 vccd1 sky130_fd_sc_hd__fill_1
X_10578_ _04678_ _04679_ vssd1 vssd1 vccd1 vccd1 _04680_ sky130_fd_sc_hd__xor2_2
XFILLER_0_51_553 vssd1 vssd1 vccd1 vccd1 sky130_fd_sc_hd__decap_6
XFILLER_0_121_441 vssd1 vssd1 vccd1 vccd1 sky130_fd_sc_hd__decap_6
X_12317_ net1645 _00828_ net665 vssd1 vssd1 vccd1 vccd1 _00369_ sky130_fd_sc_hd__mux2_1
XFILLER_0_121_485 vssd1 vssd1 vccd1 vccd1 sky130_ef_sc_hd__decap_12
X_12248_ net712 _06185_ net518 vssd1 vssd1 vccd1 vccd1 _00310_ sky130_fd_sc_hd__mux2_1
X_12179_ mul1.b\[4\] _06139_ net513 vssd1 vssd1 vccd1 vccd1 _00287_ sky130_fd_sc_hd__mux2_1
XFILLER_0_64_44 vssd1 vssd1 vccd1 vccd1 sky130_ef_sc_hd__decap_12
X_06740_ sub1.a_i\[28\] sub1.b_i\[28\] vssd1 vssd1 vccd1 vccd1 _00957_ sky130_fd_sc_hd__nand2b_1
X_06671_ sub1.b_i\[18\] sub1.a_i\[18\] vssd1 vssd1 vccd1 vccd1 _00898_ sky130_fd_sc_hd__and2b_1
XFILLER_0_78_439 vssd1 vssd1 vccd1 vccd1 sky130_fd_sc_hd__fill_1
X_08410_ _02386_ _02389_ _02525_ _02526_ vssd1 vssd1 vccd1 vccd1 _02527_ sky130_fd_sc_hd__o211ai_2
X_09390_ _03357_ _03360_ _03498_ _03499_ vssd1 vssd1 vccd1 vccd1 _03500_ sky130_fd_sc_hd__o211a_1
XFILLER_0_58_141 vssd1 vssd1 vccd1 vccd1 sky130_ef_sc_hd__decap_12
X_08341_ _02442_ _02455_ _02456_ vssd1 vssd1 vccd1 vccd1 _02458_ sky130_fd_sc_hd__and3_2
XFILLER_0_80_65 vssd1 vssd1 vccd1 vccd1 sky130_fd_sc_hd__fill_1
XFILLER_0_129_585 vssd1 vssd1 vccd1 vccd1 sky130_ef_sc_hd__decap_12
X_08272_ _02328_ _02329_ _02387_ _02388_ vssd1 vssd1 vccd1 vccd1 _02390_ sky130_fd_sc_hd__a22oi_4
XFILLER_0_74_645 vssd1 vssd1 vccd1 vccd1 sky130_fd_sc_hd__decap_6
XFILLER_0_104_83 vssd1 vssd1 vccd1 vccd1 sky130_fd_sc_hd__fill_1
X_07223_ _01346_ _01347_ net830 net1104 vssd1 vssd1 vccd1 vccd1 _01348_ sky130_fd_sc_hd__and4bb_1
XFILLER_0_13_81 vssd1 vssd1 vccd1 vccd1 sky130_fd_sc_hd__decap_8
XFILLER_0_15_701 vssd1 vssd1 vccd1 vccd1 sky130_fd_sc_hd__fill_2
XFILLER_0_27_561 vssd1 vssd1 vccd1 vccd1 sky130_fd_sc_hd__decap_6
X_07154_ _01276_ _01277_ _01275_ vssd1 vssd1 vccd1 vccd1 _01279_ sky130_fd_sc_hd__a21bo_1
XFILLER_0_42_542 vssd1 vssd1 vccd1 vccd1 sky130_fd_sc_hd__fill_1
Xoutput420 net420 vssd1 vssd1 vccd1 vccd1 mstream_o[73] sky130_fd_sc_hd__clkbuf_4
XFILLER_0_73_3 vssd1 vssd1 vccd1 vccd1 sky130_ef_sc_hd__decap_12
X_07085_ _01203_ _01207_ _01208_ vssd1 vssd1 vccd1 vccd1 _01210_ sky130_fd_sc_hd__nand3_1
Xoutput442 net442 vssd1 vssd1 vccd1 vccd1 mstream_o[93] sky130_fd_sc_hd__clkbuf_4
Xoutput431 net431 vssd1 vssd1 vccd1 vccd1 mstream_o[83] sky130_fd_sc_hd__clkbuf_4
X_07987_ _02104_ _02105_ vssd1 vssd1 vccd1 vccd1 _02107_ sky130_fd_sc_hd__xor2_1
X_09726_ _03832_ _03833_ vssd1 vssd1 vccd1 vccd1 _03834_ sky130_fd_sc_hd__nor2_2
X_06938_ _01055_ _01060_ vssd1 vssd1 vccd1 vccd1 _01063_ sky130_fd_sc_hd__xor2_1
XFILLER_0_69_417 vssd1 vssd1 vccd1 vccd1 sky130_fd_sc_hd__fill_1
X_09657_ _03763_ _03764_ vssd1 vssd1 vccd1 vccd1 _03765_ sky130_fd_sc_hd__nor2_1
XFILLER_0_96_225 vssd1 vssd1 vccd1 vccd1 sky130_ef_sc_hd__decap_12
XTAP_1104 vssd1 vccd1 sky130_fd_sc_hd__tapvpwrvgnd_1
X_06869_ _00613_ _00800_ vssd1 vssd1 vccd1 vccd1 _00998_ sky130_fd_sc_hd__nor2_4
XFILLER_0_96_258 vssd1 vssd1 vccd1 vccd1 sky130_fd_sc_hd__fill_1
X_08608_ _02720_ _02721_ _02716_ vssd1 vssd1 vccd1 vccd1 _02723_ sky130_fd_sc_hd__a21o_1
XFILLER_0_84_409 vssd1 vssd1 vccd1 vccd1 sky130_fd_sc_hd__fill_1
X_09588_ net878 net867 net956 net950 vssd1 vssd1 vccd1 vccd1 _03697_ sky130_fd_sc_hd__nand4_2
XTAP_1137 vssd1 vccd1 sky130_fd_sc_hd__tapvpwrvgnd_1
XTAP_1126 vssd1 vccd1 sky130_fd_sc_hd__tapvpwrvgnd_1
XTAP_1115 vssd1 vccd1 sky130_fd_sc_hd__tapvpwrvgnd_1
X_08539_ _02651_ _02653_ _02518_ _02521_ vssd1 vssd1 vccd1 vccd1 _02655_ sky130_fd_sc_hd__a211oi_1
XTAP_1159 vssd1 vccd1 sky130_fd_sc_hd__tapvpwrvgnd_1
XTAP_1148 vssd1 vccd1 sky130_fd_sc_hd__tapvpwrvgnd_1
X_11550_ _05630_ _05642_ _05643_ vssd1 vssd1 vccd1 vccd1 _05645_ sky130_fd_sc_hd__nand3_1
XFILLER_0_37_358 vssd1 vssd1 vccd1 vccd1 sky130_fd_sc_hd__decap_4
X_10501_ _04565_ _04566_ _04602_ _04603_ vssd1 vssd1 vccd1 vccd1 _04604_ sky130_fd_sc_hd__and4bb_1
XFILLER_0_18_561 vssd1 vssd1 vccd1 vccd1 sky130_fd_sc_hd__fill_1
X_11481_ net771 net946 net941 net776 vssd1 vssd1 vccd1 vccd1 _05576_ sky130_fd_sc_hd__a22oi_1
XFILLER_0_33_531 vssd1 vssd1 vccd1 vccd1 sky130_fd_sc_hd__fill_1
X_10432_ _04432_ _04533_ _04534_ vssd1 vssd1 vccd1 vccd1 _04535_ sky130_fd_sc_hd__and3_1
XFILLER_0_33_553 vssd1 vssd1 vccd1 vccd1 sky130_fd_sc_hd__fill_1
X_13151_ clknet_leaf_14_clk_i _00537_ net1186 vssd1 vssd1 vccd1 vccd1 l0\[12\] sky130_fd_sc_hd__dfrtp_1
X_10363_ _04444_ _04445_ _04463_ _04464_ vssd1 vssd1 vccd1 vccd1 _04467_ sky130_fd_sc_hd__o22ai_1
X_13082_ clknet_leaf_57_clk_i _00468_ vssd1 vssd1 vccd1 vccd1 temp1\[7\] sky130_fd_sc_hd__dfxtp_1
X_12102_ _00892_ _06082_ net499 vssd1 vssd1 vccd1 vccd1 _06083_ sky130_fd_sc_hd__mux2_1
XFILLER_0_103_496 vssd1 vssd1 vccd1 vccd1 sky130_fd_sc_hd__decap_8
X_10294_ _04396_ _04397_ vssd1 vssd1 vccd1 vccd1 _04398_ sky130_fd_sc_hd__xnor2_2
X_12033_ x0mx2\[0\] net628 net590 y1my2\[0\] vssd1 vssd1 vccd1 vccd1 _06030_ sky130_fd_sc_hd__a22o_1
XFILLER_0_20_269 vssd1 vssd1 vccd1 vccd1 sky130_fd_sc_hd__fill_2
XFILLER_0_109_39 vssd1 vssd1 vccd1 vccd1 sky130_ef_sc_hd__decap_12
XFILLER_0_18_15 vssd1 vssd1 vccd1 vccd1 sky130_ef_sc_hd__decap_12
Xfanout680 net681 vssd1 vssd1 vccd1 vccd1 net680 sky130_fd_sc_hd__clkbuf_4
Xfanout691 net450 vssd1 vssd1 vccd1 vccd1 net691 sky130_fd_sc_hd__clkbuf_16
XFILLER_0_125_27 vssd1 vssd1 vccd1 vccd1 sky130_ef_sc_hd__decap_12
X_12935_ clknet_leaf_8_clk_i _00321_ net1193 vssd1 vssd1 vccd1 vccd1 posx\[6\] sky130_fd_sc_hd__dfrtp_1
XFILLER_0_88_737 vssd1 vssd1 vccd1 vccd1 sky130_fd_sc_hd__decap_3
XFILLER_0_87_225 vssd1 vssd1 vccd1 vccd1 sky130_fd_sc_hd__decap_4
X_12866_ clknet_leaf_47_clk_i _00252_ vssd1 vssd1 vccd1 vccd1 mul1.a\[1\] sky130_fd_sc_hd__dfxtp_1
XFILLER_0_34_69 vssd1 vssd1 vccd1 vccd1 sky130_fd_sc_hd__fill_1
XTAP_1660 vssd1 vccd1 sky130_fd_sc_hd__tapvpwrvgnd_1
X_11817_ temp1\[19\] net615 net610 net196 vssd1 vssd1 vccd1 vccd1 _05859_ sky130_fd_sc_hd__a22o_1
XFILLER_0_126_511 vssd1 vssd1 vccd1 vccd1 sky130_ef_sc_hd__decap_12
XTAP_1693 vssd1 vccd1 sky130_fd_sc_hd__tapvpwrvgnd_1
XTAP_1671 vssd1 vccd1 sky130_fd_sc_hd__tapvpwrvgnd_1
XTAP_1682 vssd1 vccd1 sky130_fd_sc_hd__tapvpwrvgnd_1
XFILLER_0_55_111 vssd1 vssd1 vccd1 vccd1 sky130_fd_sc_hd__fill_1
X_12797_ clknet_leaf_18_clk_i _00183_ vssd1 vssd1 vccd1 vccd1 add1.b_i\[28\] sky130_fd_sc_hd__dfxtp_1
XFILLER_0_50_24 vssd1 vssd1 vccd1 vccd1 sky130_fd_sc_hd__decap_4
XFILLER_0_126_533 vssd1 vssd1 vccd1 vccd1 sky130_ef_sc_hd__decap_12
XFILLER_0_83_486 vssd1 vssd1 vccd1 vccd1 sky130_fd_sc_hd__fill_2
X_11748_ net88 net677 net607 net216 vssd1 vssd1 vccd1 vccd1 _05801_ sky130_fd_sc_hd__a22o_1
XFILLER_0_50_79 vssd1 vssd1 vccd1 vccd1 sky130_fd_sc_hd__decap_4
X_11679_ net1685 _03749_ net538 vssd1 vssd1 vccd1 vccd1 _00171_ sky130_fd_sc_hd__mux2_1
XFILLER_0_24_531 vssd1 vssd1 vccd1 vccd1 sky130_fd_sc_hd__fill_1
XFILLER_0_113_205 vssd1 vssd1 vccd1 vccd1 sky130_ef_sc_hd__decap_12
XFILLER_0_51_350 vssd1 vssd1 vccd1 vccd1 sky130_fd_sc_hd__fill_1
XFILLER_0_113_249 vssd1 vssd1 vccd1 vccd1 sky130_ef_sc_hd__decap_12
XFILLER_0_3_447 vssd1 vssd1 vccd1 vccd1 sky130_fd_sc_hd__fill_1
XFILLER_0_59_77 vssd1 vssd1 vccd1 vccd1 sky130_fd_sc_hd__fill_1
XFILLER_0_11_225 vssd1 vssd1 vccd1 vccd1 sky130_fd_sc_hd__fill_1
XFILLER_0_121_293 vssd1 vssd1 vccd1 vccd1 sky130_ef_sc_hd__decap_12
X_08890_ _03001_ _03002_ vssd1 vssd1 vccd1 vccd1 _03003_ sky130_fd_sc_hd__or2_1
X_07910_ _02028_ _02029_ _02021_ vssd1 vssd1 vccd1 vccd1 _02031_ sky130_fd_sc_hd__a21o_1
X_07841_ _01960_ _01961_ vssd1 vssd1 vccd1 vccd1 _01962_ sky130_fd_sc_hd__xnor2_1
X_07772_ _01879_ _01892_ _01893_ vssd1 vssd1 vccd1 vccd1 _01894_ sky130_fd_sc_hd__nand3_1
X_09511_ _03617_ _03618_ _03613_ vssd1 vssd1 vccd1 vccd1 _03620_ sky130_fd_sc_hd__a21o_1
X_06723_ sub1.b_i\[26\] sub1.a_i\[26\] vssd1 vssd1 vccd1 vccd1 _00942_ sky130_fd_sc_hd__nand2b_1
X_09442_ _03548_ _03549_ _03550_ vssd1 vssd1 vccd1 vccd1 _03552_ sky130_fd_sc_hd__a21o_1
X_06654_ sub1.b_i\[15\] sub1.a_i\[15\] vssd1 vssd1 vccd1 vccd1 _00884_ sky130_fd_sc_hd__and2b_1
XPHY_209 vssd1 vssd1 vccd1 vccd1 sky130_fd_sc_hd__decap_3
X_09373_ _03473_ _03482_ vssd1 vssd1 vccd1 vccd1 _03483_ sky130_fd_sc_hd__xnor2_2
XFILLER_0_87_781 vssd1 vssd1 vccd1 vccd1 sky130_fd_sc_hd__decap_3
X_06585_ sub1.b_i\[4\] sub1.a_i\[4\] vssd1 vssd1 vccd1 vccd1 _00826_ sky130_fd_sc_hd__and2b_1
XFILLER_0_115_93 vssd1 vssd1 vccd1 vccd1 sky130_ef_sc_hd__decap_12
X_08324_ _02432_ _02440_ vssd1 vssd1 vccd1 vccd1 _02441_ sky130_fd_sc_hd__nand2b_1
XFILLER_0_24_80 vssd1 vssd1 vccd1 vccd1 sky130_fd_sc_hd__decap_4
XFILLER_0_74_475 vssd1 vssd1 vccd1 vccd1 sky130_fd_sc_hd__fill_1
XFILLER_0_62_615 vssd1 vssd1 vccd1 vccd1 sky130_fd_sc_hd__fill_2
XFILLER_0_34_317 vssd1 vssd1 vccd1 vccd1 sky130_fd_sc_hd__decap_3
X_08255_ _02371_ _02372_ _02364_ vssd1 vssd1 vccd1 vccd1 _02373_ sky130_fd_sc_hd__a21o_1
XFILLER_0_6_241 vssd1 vssd1 vccd1 vccd1 sky130_fd_sc_hd__fill_2
X_08186_ _02302_ _02303_ vssd1 vssd1 vccd1 vccd1 _02304_ sky130_fd_sc_hd__or2_1
X_07206_ _01329_ _01330_ vssd1 vssd1 vccd1 vccd1 _01331_ sky130_fd_sc_hd__nor2_1
XFILLER_0_104_238 vssd1 vssd1 vccd1 vccd1 sky130_fd_sc_hd__decap_6
XFILLER_0_30_523 vssd1 vssd1 vccd1 vccd1 sky130_fd_sc_hd__fill_1
X_07137_ _01260_ _01261_ vssd1 vssd1 vccd1 vccd1 _01262_ sky130_fd_sc_hd__or2_1
XFILLER_0_113_761 vssd1 vssd1 vccd1 vccd1 sky130_fd_sc_hd__decap_3
XFILLER_0_30_545 vssd1 vssd1 vccd1 vccd1 sky130_ef_sc_hd__decap_12
Xoutput250 net250 vssd1 vssd1 vccd1 vccd1 busy_o sky130_fd_sc_hd__clkbuf_4
Xoutput261 net261 vssd1 vssd1 vccd1 vccd1 div_mstream_o[18] sky130_fd_sc_hd__clkbuf_4
XFILLER_0_113_794 vssd1 vssd1 vccd1 vccd1 sky130_fd_sc_hd__decap_3
XFILLER_0_30_589 vssd1 vssd1 vccd1 vccd1 sky130_fd_sc_hd__fill_2
X_07068_ _01047_ _01051_ _01191_ _01192_ vssd1 vssd1 vccd1 vccd1 _01193_ sky130_fd_sc_hd__o211ai_2
Xoutput283 net283 vssd1 vssd1 vccd1 vccd1 div_mstream_o[38] sky130_fd_sc_hd__clkbuf_4
Xoutput272 net272 vssd1 vssd1 vccd1 vccd1 div_mstream_o[28] sky130_fd_sc_hd__clkbuf_4
Xoutput294 net294 vssd1 vssd1 vccd1 vccd1 div_mstream_o[4] sky130_fd_sc_hd__clkbuf_4
XFILLER_0_100_477 vssd1 vssd1 vccd1 vccd1 sky130_fd_sc_hd__decap_3
XFILLER_0_11_781 vssd1 vssd1 vccd1 vccd1 sky130_fd_sc_hd__decap_3
X_09709_ net803 net792 net1014 net1006 vssd1 vssd1 vccd1 vccd1 _03817_ sky130_fd_sc_hd__nand4_1
X_10981_ _05079_ _05080_ vssd1 vssd1 vccd1 vccd1 _05081_ sky130_fd_sc_hd__xnor2_2
Xclkbuf_leaf_30_clk_i clknet_3_4__leaf_clk_i vssd1 vssd1 vccd1 vccd1 clknet_leaf_30_clk_i
+ sky130_fd_sc_hd__clkbuf_16
X_12720_ clknet_leaf_8_clk_i _00106_ net1193 vssd1 vssd1 vccd1 vccd1 net339 sky130_fd_sc_hd__dfrtp_1
XFILLER_0_128_809 vssd1 vssd1 vccd1 vccd1 sky130_fd_sc_hd__decap_3
XFILLER_0_85_729 vssd1 vssd1 vccd1 vccd1 sky130_ef_sc_hd__decap_12
X_12651_ clknet_leaf_22_clk_i net1263 net1174 vssd1 vssd1 vccd1 vccd1 net377 sky130_fd_sc_hd__dfrtp_1
X_11602_ _05676_ _05695_ vssd1 vssd1 vccd1 vccd1 _05696_ sky130_fd_sc_hd__xnor2_1
XFILLER_0_38_645 vssd1 vssd1 vccd1 vccd1 sky130_ef_sc_hd__decap_12
Xclkbuf_leaf_45_clk_i clknet_3_1__leaf_clk_i vssd1 vssd1 vccd1 vccd1 clknet_leaf_45_clk_i
+ sky130_fd_sc_hd__clkbuf_16
X_12582_ net1600 net2 net554 vssd1 vssd1 vccd1 vccd1 _00557_ sky130_fd_sc_hd__mux2_1
XFILLER_0_123_503 vssd1 vssd1 vccd1 vccd1 sky130_fd_sc_hd__fill_1
X_11533_ _05627_ vssd1 vssd1 vccd1 vccd1 _05628_ sky130_fd_sc_hd__inv_2
X_11464_ _05556_ _05557_ _05438_ _05442_ vssd1 vssd1 vccd1 vccd1 _05560_ sky130_fd_sc_hd__o211a_1
XFILLER_0_20_27 vssd1 vssd1 vccd1 vccd1 sky130_fd_sc_hd__fill_1
XFILLER_0_34_840 vssd1 vssd1 vccd1 vccd1 sky130_fd_sc_hd__fill_2
XFILLER_0_40_309 vssd1 vssd1 vccd1 vccd1 sky130_fd_sc_hd__fill_2
XFILLER_0_111_709 vssd1 vssd1 vccd1 vccd1 sky130_ef_sc_hd__decap_12
X_10415_ _04516_ _04517_ vssd1 vssd1 vccd1 vccd1 _04519_ sky130_fd_sc_hd__xor2_2
XFILLER_0_104_761 vssd1 vssd1 vccd1 vccd1 sky130_fd_sc_hd__fill_1
X_11395_ _05361_ _05369_ _05368_ vssd1 vssd1 vccd1 vccd1 _05491_ sky130_fd_sc_hd__a21bo_1
X_13134_ clknet_leaf_4_clk_i _00520_ vssd1 vssd1 vccd1 vccd1 det_t\[27\] sky130_fd_sc_hd__dfxtp_1
X_10346_ net809 net970 vssd1 vssd1 vccd1 vccd1 _04450_ sky130_fd_sc_hd__nand2_1
XTAP_707 vssd1 vccd1 sky130_fd_sc_hd__tapvpwrvgnd_1
X_13065_ clknet_leaf_33_clk_i _00451_ net1165 vssd1 vssd1 vccd1 vccd1 y2my0\[22\]
+ sky130_fd_sc_hd__dfrtp_1
XTAP_718 vssd1 vccd1 sky130_fd_sc_hd__tapvpwrvgnd_1
X_10277_ temp1\[20\] _04381_ net542 vssd1 vssd1 vccd1 vccd1 _04382_ sky130_fd_sc_hd__mux2_1
XTAP_729 vssd1 vccd1 sky130_fd_sc_hd__tapvpwrvgnd_1
X_12016_ net142 net662 net505 net238 _06016_ vssd1 vssd1 vccd1 vccd1 _06017_ sky130_fd_sc_hd__a221o_1
Xmax_cap2 _03252_ vssd1 vssd1 vccd1 vccd1 net1743 sky130_fd_sc_hd__clkbuf_1
XFILLER_0_45_68 vssd1 vssd1 vccd1 vccd1 sky130_fd_sc_hd__decap_3
XFILLER_0_88_567 vssd1 vssd1 vccd1 vccd1 sky130_fd_sc_hd__decap_6
XFILLER_0_0_15 vssd1 vssd1 vccd1 vccd1 sky130_ef_sc_hd__decap_12
X_12918_ clknet_leaf_33_clk_i _00304_ vssd1 vssd1 vccd1 vccd1 mul1.b\[21\] sky130_fd_sc_hd__dfxtp_2
XTAP_2180 vssd1 vccd1 sky130_fd_sc_hd__tapvpwrvgnd_1
XFILLER_0_75_217 vssd1 vssd1 vccd1 vccd1 sky130_fd_sc_hd__fill_2
XFILLER_0_69_781 vssd1 vssd1 vccd1 vccd1 sky130_fd_sc_hd__decap_3
XTAP_2191 vssd1 vccd1 sky130_fd_sc_hd__tapvpwrvgnd_1
XFILLER_0_68_280 vssd1 vssd1 vccd1 vccd1 sky130_fd_sc_hd__fill_2
X_12849_ clknet_leaf_49_clk_i _00235_ vssd1 vssd1 vccd1 vccd1 sub1.b_i\[16\] sky130_fd_sc_hd__dfxtp_1
XTAP_1490 vssd1 vccd1 sky130_fd_sc_hd__tapvpwrvgnd_1
X_06370_ _00618_ _00676_ _00680_ vssd1 vssd1 vccd1 vccd1 _00681_ sky130_fd_sc_hd__a21o_1
XFILLER_0_29_689 vssd1 vssd1 vccd1 vccd1 sky130_fd_sc_hd__fill_2
XFILLER_0_83_272 vssd1 vssd1 vccd1 vccd1 sky130_fd_sc_hd__decap_8
XFILLER_0_56_486 vssd1 vssd1 vccd1 vccd1 sky130_fd_sc_hd__decap_8
XFILLER_0_44_648 vssd1 vssd1 vccd1 vccd1 sky130_fd_sc_hd__fill_1
XFILLER_0_43_125 vssd1 vssd1 vccd1 vccd1 sky130_fd_sc_hd__decap_6
XFILLER_0_4_701 vssd1 vssd1 vccd1 vccd1 sky130_fd_sc_hd__fill_1
XFILLER_0_28_177 vssd1 vssd1 vccd1 vccd1 sky130_fd_sc_hd__decap_3
XFILLER_0_114_525 vssd1 vssd1 vccd1 vccd1 sky130_fd_sc_hd__decap_6
X_08040_ _02047_ _02049_ vssd1 vssd1 vccd1 vccd1 _02160_ sky130_fd_sc_hd__nand2b_2
XFILLER_0_43_147 vssd1 vssd1 vccd1 vccd1 sky130_fd_sc_hd__fill_1
XFILLER_0_9_57 vssd1 vssd1 vccd1 vccd1 sky130_ef_sc_hd__decap_12
XFILLER_0_114_569 vssd1 vssd1 vccd1 vccd1 sky130_ef_sc_hd__decap_12
XFILLER_0_101_51 vssd1 vssd1 vccd1 vccd1 sky130_fd_sc_hd__decap_4
XFILLER_0_24_350 vssd1 vssd1 vccd1 vccd1 sky130_fd_sc_hd__decap_4
XFILLER_0_101_208 vssd1 vssd1 vccd1 vccd1 sky130_fd_sc_hd__fill_1
XFILLER_0_52_692 vssd1 vssd1 vccd1 vccd1 sky130_fd_sc_hd__decap_8
X_09991_ _04096_ _04095_ _04094_ vssd1 vssd1 vccd1 vccd1 _04097_ sky130_fd_sc_hd__nand3b_2
Xmax_cap655 _03435_ vssd1 vssd1 vccd1 vccd1 net655 sky130_fd_sc_hd__clkbuf_1
XFILLER_0_86_53 vssd1 vssd1 vccd1 vccd1 sky130_fd_sc_hd__decap_8
X_08942_ _03053_ _03054_ net861 net988 vssd1 vssd1 vccd1 vccd1 _03055_ sky130_fd_sc_hd__and4bb_1
X_08873_ _02982_ _02983_ _02837_ _02839_ vssd1 vssd1 vccd1 vccd1 _02986_ sky130_fd_sc_hd__o211a_1
XFILLER_0_36_3 vssd1 vssd1 vccd1 vccd1 sky130_ef_sc_hd__decap_12
XFILLER_0_98_309 vssd1 vssd1 vccd1 vccd1 sky130_fd_sc_hd__fill_2
X_07824_ _01943_ _01944_ vssd1 vssd1 vccd1 vccd1 _01946_ sky130_fd_sc_hd__xnor2_2
X_07755_ _01874_ _01876_ _01776_ _01779_ vssd1 vssd1 vccd1 vccd1 _01877_ sky130_fd_sc_hd__o211ai_2
X_07686_ net1066 net856 _01807_ _01808_ vssd1 vssd1 vccd1 vccd1 _01809_ sky130_fd_sc_hd__a22o_1
X_06706_ _00924_ _00927_ vssd1 vssd1 vccd1 vccd1 _00928_ sky130_fd_sc_hd__xnor2_4
XFILLER_0_67_729 vssd1 vssd1 vccd1 vccd1 sky130_ef_sc_hd__decap_12
X_09425_ net892 net944 vssd1 vssd1 vccd1 vccd1 _03535_ sky130_fd_sc_hd__nand2_1
X_06637_ _00868_ _00869_ vssd1 vssd1 vccd1 vccd1 _00870_ sky130_fd_sc_hd__nor2_2
X_09356_ _03463_ net462 _03337_ _03341_ vssd1 vssd1 vccd1 vccd1 _03466_ sky130_fd_sc_hd__o211ai_2
X_06568_ sub1.a_i\[1\] sub1.b_i\[1\] vssd1 vssd1 vccd1 vccd1 _00812_ sky130_fd_sc_hd__xnor2_2
X_06499_ det_t\[9\] net528 vssd1 vssd1 vccd1 vccd1 net332 sky130_fd_sc_hd__and2_1
XFILLER_0_90_732 vssd1 vssd1 vccd1 vccd1 sky130_ef_sc_hd__decap_12
X_09287_ _03240_ _03243_ _03396_ _03397_ vssd1 vssd1 vccd1 vccd1 _03398_ sky130_fd_sc_hd__o211a_2
X_08307_ _02286_ _02422_ vssd1 vssd1 vccd1 vccd1 _02424_ sky130_fd_sc_hd__xnor2_1
XFILLER_0_117_385 vssd1 vssd1 vccd1 vccd1 sky130_fd_sc_hd__decap_6
XFILLER_0_105_503 vssd1 vssd1 vccd1 vccd1 sky130_fd_sc_hd__fill_1
X_08238_ _02240_ _02243_ _02354_ _02355_ vssd1 vssd1 vccd1 vccd1 _02356_ sky130_fd_sc_hd__o211a_1
XFILLER_0_7_561 vssd1 vssd1 vccd1 vccd1 sky130_fd_sc_hd__decap_4
XFILLER_0_90_798 vssd1 vssd1 vccd1 vccd1 sky130_fd_sc_hd__decap_4
X_10200_ _04169_ _04172_ _04302_ _04304_ vssd1 vssd1 vccd1 vccd1 _04305_ sky130_fd_sc_hd__o211ai_4
X_08169_ _02178_ _02187_ vssd1 vssd1 vccd1 vccd1 _02287_ sky130_fd_sc_hd__nor2_1
X_11180_ _05276_ _05277_ vssd1 vssd1 vccd1 vccd1 _05278_ sky130_fd_sc_hd__nor2_1
X_10131_ net1109 net699 net695 net1101 vssd1 vssd1 vccd1 vccd1 _04236_ sky130_fd_sc_hd__and4b_1
XFILLER_0_100_274 vssd1 vssd1 vccd1 vccd1 sky130_fd_sc_hd__decap_3
X_10062_ _04160_ _04165_ _04166_ vssd1 vssd1 vccd1 vccd1 _04168_ sky130_fd_sc_hd__nand3_4
XFILLER_0_106_29 vssd1 vssd1 vccd1 vccd1 sky130_ef_sc_hd__decap_12
XFILLER_0_15_27 vssd1 vssd1 vccd1 vccd1 sky130_ef_sc_hd__decap_12
X_12703_ clknet_leaf_12_clk_i _00089_ net1188 vssd1 vssd1 vccd1 vccd1 net434 sky130_fd_sc_hd__dfrtp_1
XFILLER_0_85_526 vssd1 vssd1 vccd1 vccd1 sky130_fd_sc_hd__fill_2
X_10964_ _05061_ _05062_ _04930_ _04933_ vssd1 vssd1 vccd1 vccd1 _05064_ sky130_fd_sc_hd__a211oi_1
XFILLER_0_127_105 vssd1 vssd1 vccd1 vccd1 sky130_fd_sc_hd__decap_6
X_10895_ _04993_ _04994_ vssd1 vssd1 vccd1 vccd1 _04995_ sky130_fd_sc_hd__nand2b_1
XFILLER_0_38_431 vssd1 vssd1 vccd1 vccd1 sky130_fd_sc_hd__fill_1
X_12634_ clknet_leaf_38_clk_i _00020_ net1163 vssd1 vssd1 vccd1 vccd1 net358 sky130_fd_sc_hd__dfrtp_2
XFILLER_0_31_15 vssd1 vssd1 vccd1 vccd1 sky130_ef_sc_hd__decap_12
XFILLER_0_127_149 vssd1 vssd1 vccd1 vccd1 sky130_fd_sc_hd__decap_3
X_12565_ net1471 net9 net560 vssd1 vssd1 vccd1 vccd1 _00541_ sky130_fd_sc_hd__mux2_1
XFILLER_0_123_300 vssd1 vssd1 vccd1 vccd1 sky130_ef_sc_hd__decap_12
XFILLER_0_80_220 vssd1 vssd1 vccd1 vccd1 sky130_fd_sc_hd__decap_3
X_11516_ _05539_ _05541_ vssd1 vssd1 vccd1 vccd1 _05611_ sky130_fd_sc_hd__nand2b_1
XFILLER_0_41_607 vssd1 vssd1 vccd1 vccd1 sky130_fd_sc_hd__decap_8
X_12496_ _00792_ net562 vssd1 vssd1 vccd1 vccd1 _06245_ sky130_fd_sc_hd__nor2_1
XFILLER_0_111_517 vssd1 vssd1 vccd1 vccd1 sky130_ef_sc_hd__decap_12
X_11447_ _05376_ _05379_ _05541_ _05542_ vssd1 vssd1 vccd1 vccd1 _05543_ sky130_fd_sc_hd__o211ai_2
XFILLER_0_1_726 vssd1 vssd1 vccd1 vccd1 sky130_fd_sc_hd__fill_2
XFILLER_0_0_225 vssd1 vssd1 vccd1 vccd1 sky130_fd_sc_hd__fill_1
X_11378_ net757 net957 _05470_ _05472_ vssd1 vssd1 vccd1 vccd1 _05474_ sky130_fd_sc_hd__a22oi_1
X_13117_ clknet_leaf_3_clk_i _00503_ vssd1 vssd1 vccd1 vccd1 det_t\[10\] sky130_fd_sc_hd__dfxtp_1
X_10329_ net867 net933 net927 net878 vssd1 vssd1 vccd1 vccd1 _04433_ sky130_fd_sc_hd__a22o_1
XTAP_504 vssd1 vccd1 sky130_fd_sc_hd__tapvpwrvgnd_1
XTAP_515 vssd1 vccd1 sky130_fd_sc_hd__tapvpwrvgnd_1
XTAP_526 vssd1 vccd1 sky130_fd_sc_hd__tapvpwrvgnd_1
XTAP_537 vssd1 vccd1 sky130_fd_sc_hd__tapvpwrvgnd_1
XTAP_548 vssd1 vccd1 sky130_fd_sc_hd__tapvpwrvgnd_1
X_13048_ clknet_leaf_52_clk_i _00434_ net1153 vssd1 vssd1 vccd1 vccd1 y2my0\[5\] sky130_fd_sc_hd__dfrtp_1
XTAP_559 vssd1 vccd1 sky130_fd_sc_hd__tapvpwrvgnd_1
XFILLER_0_88_353 vssd1 vssd1 vccd1 vccd1 sky130_fd_sc_hd__fill_1
X_07540_ _01461_ _01462_ _01664_ vssd1 vssd1 vccd1 vccd1 _01665_ sky130_fd_sc_hd__or3_1
XFILLER_0_119_617 vssd1 vssd1 vccd1 vccd1 sky130_ef_sc_hd__decap_12
X_07471_ net896 net1128 net1138 net888 vssd1 vssd1 vccd1 vccd1 _01596_ sky130_fd_sc_hd__a22oi_1
X_09210_ net1025 net810 _03190_ _03191_ net1009 vssd1 vssd1 vccd1 vccd1 _03321_ sky130_fd_sc_hd__a32o_1
X_06422_ _00715_ _00718_ _00724_ vssd1 vssd1 vccd1 vccd1 _00726_ sky130_fd_sc_hd__o21ba_1
X_09141_ _03150_ _03151_ _03250_ _03251_ vssd1 vssd1 vccd1 vccd1 _03253_ sky130_fd_sc_hd__or4_1
X_06353_ _00658_ _00660_ _00664_ _00638_ vssd1 vssd1 vccd1 vccd1 _00665_ sky130_fd_sc_hd__a211o_1
XFILLER_0_17_615 vssd1 vssd1 vccd1 vccd1 sky130_fd_sc_hd__fill_1
XFILLER_0_17_626 vssd1 vssd1 vccd1 vccd1 sky130_fd_sc_hd__decap_4
X_09072_ _03168_ _03181_ vssd1 vssd1 vccd1 vccd1 _03184_ sky130_fd_sc_hd__nand2_1
XFILLER_0_114_333 vssd1 vssd1 vccd1 vccd1 sky130_ef_sc_hd__decap_12
XFILLER_0_112_83 vssd1 vssd1 vccd1 vccd1 sky130_fd_sc_hd__fill_1
XFILLER_0_71_286 vssd1 vssd1 vccd1 vccd1 sky130_fd_sc_hd__fill_1
XFILLER_0_71_275 vssd1 vssd1 vccd1 vccd1 sky130_fd_sc_hd__decap_4
X_08023_ _02139_ _02140_ _02141_ vssd1 vssd1 vccd1 vccd1 _02143_ sky130_fd_sc_hd__a21o_1
XFILLER_0_44_489 vssd1 vssd1 vccd1 vccd1 sky130_fd_sc_hd__decap_8
XFILLER_0_4_531 vssd1 vssd1 vccd1 vccd1 sky130_fd_sc_hd__fill_1
X_06284_ net1150 net1151 vssd1 vssd1 vccd1 vccd1 _00600_ sky130_fd_sc_hd__nand2b_2
XFILLER_0_25_670 vssd1 vssd1 vccd1 vccd1 sky130_fd_sc_hd__fill_2
XFILLER_0_114_377 vssd1 vssd1 vccd1 vccd1 sky130_ef_sc_hd__decap_12
XFILLER_0_130_837 vssd1 vssd1 vccd1 vccd1 sky130_fd_sc_hd__decap_3
XFILLER_0_102_528 vssd1 vssd1 vccd1 vccd1 sky130_fd_sc_hd__decap_4
Xmax_cap463 _03464_ vssd1 vssd1 vccd1 vccd1 net463 sky130_fd_sc_hd__clkbuf_1
Xmax_cap452 _04801_ vssd1 vssd1 vccd1 vccd1 net452 sky130_fd_sc_hd__clkbuf_2
XFILLER_0_40_662 vssd1 vssd1 vccd1 vccd1 sky130_ef_sc_hd__decap_12
Xmax_cap496 net1755 vssd1 vssd1 vccd1 vccd1 net496 sky130_fd_sc_hd__buf_1
X_09974_ net1109 net699 net693 net1117 vssd1 vssd1 vccd1 vccd1 _04080_ sky130_fd_sc_hd__o2bb2a_1
X_08925_ _03036_ _03037_ net835 net1009 vssd1 vssd1 vccd1 vccd1 _03038_ sky130_fd_sc_hd__and4bb_1
X_08856_ _02852_ _02854_ vssd1 vssd1 vccd1 vccd1 _02969_ sky130_fd_sc_hd__or2_1
X_07807_ _01908_ _01925_ _01926_ vssd1 vssd1 vccd1 vccd1 _01929_ sky130_fd_sc_hd__nand3_2
X_08787_ _02891_ _02899_ vssd1 vssd1 vccd1 vccd1 _02901_ sky130_fd_sc_hd__xnor2_1
XFILLER_0_79_375 vssd1 vssd1 vccd1 vccd1 sky130_fd_sc_hd__decap_8
X_07738_ mul1.a\[4\] net806 _01786_ _01787_ vssd1 vssd1 vccd1 vccd1 _01860_ sky130_fd_sc_hd__a31o_1
XFILLER_0_67_559 vssd1 vssd1 vccd1 vccd1 sky130_fd_sc_hd__fill_1
X_07669_ net1074 net848 net839 net1082 vssd1 vssd1 vccd1 vccd1 _01792_ sky130_fd_sc_hd__a22o_1
XFILLER_0_109_105 vssd1 vssd1 vccd1 vccd1 sky130_fd_sc_hd__decap_6
X_09408_ _03514_ _03515_ _03516_ vssd1 vssd1 vccd1 vccd1 _03518_ sky130_fd_sc_hd__a21o_1
X_10680_ _04577_ _04580_ _04781_ vssd1 vssd1 vccd1 vccd1 _04782_ sky130_fd_sc_hd__a21oi_4
XFILLER_0_125_609 vssd1 vssd1 vccd1 vccd1 sky130_fd_sc_hd__decap_6
XFILLER_0_109_149 vssd1 vssd1 vccd1 vccd1 sky130_ef_sc_hd__decap_12
X_09339_ net1100 net724 vssd1 vssd1 vccd1 vccd1 _03449_ sky130_fd_sc_hd__nand2_1
XFILLER_0_47_261 vssd1 vssd1 vccd1 vccd1 sky130_fd_sc_hd__decap_6
XFILLER_0_117_193 vssd1 vssd1 vccd1 vccd1 sky130_ef_sc_hd__decap_12
XFILLER_0_62_253 vssd1 vssd1 vccd1 vccd1 sky130_ef_sc_hd__decap_12
XFILLER_0_7_391 vssd1 vssd1 vccd1 vccd1 sky130_fd_sc_hd__fill_1
X_12350_ net1577 net526 net657 vssd1 vssd1 vccd1 vccd1 _00402_ sky130_fd_sc_hd__mux2_1
XFILLER_0_35_467 vssd1 vssd1 vccd1 vccd1 sky130_fd_sc_hd__decap_4
XFILLER_0_62_297 vssd1 vssd1 vccd1 vccd1 sky130_fd_sc_hd__decap_8
X_12281_ net1650 _00810_ net674 vssd1 vssd1 vccd1 vccd1 _00333_ sky130_fd_sc_hd__mux2_1
XFILLER_0_15_180 vssd1 vssd1 vccd1 vccd1 sky130_fd_sc_hd__fill_2
X_11301_ _05396_ _05397_ vssd1 vssd1 vccd1 vccd1 _05398_ sky130_fd_sc_hd__nor2_1
XFILLER_0_31_640 vssd1 vssd1 vccd1 vccd1 sky130_ef_sc_hd__decap_12
XFILLER_0_31_673 vssd1 vssd1 vccd1 vccd1 sky130_fd_sc_hd__decap_4
X_11232_ net824 net816 net929 vssd1 vssd1 vccd1 vccd1 _05329_ sky130_fd_sc_hd__and3_1
X_11163_ _05129_ _05131_ _05258_ _05259_ vssd1 vssd1 vccd1 vccd1 _05261_ sky130_fd_sc_hd__a211oi_2
X_10114_ _04067_ _04217_ vssd1 vssd1 vccd1 vccd1 _04220_ sky130_fd_sc_hd__xnor2_4
XFILLER_0_30_194 vssd1 vssd1 vccd1 vccd1 sky130_fd_sc_hd__fill_2
X_11094_ _05067_ _05069_ _05191_ _05192_ vssd1 vssd1 vccd1 vccd1 _05193_ sky130_fd_sc_hd__o211ai_4
X_10045_ _04147_ _04149_ _04007_ _04010_ vssd1 vssd1 vccd1 vccd1 _04151_ sky130_fd_sc_hd__a211o_1
XFILLER_0_26_15 vssd1 vssd1 vccd1 vccd1 sky130_ef_sc_hd__decap_12
XFILLER_0_117_39 vssd1 vssd1 vccd1 vccd1 sky130_ef_sc_hd__decap_12
Xhold82 add1.a_i\[21\] vssd1 vssd1 vccd1 vccd1 net1297 sky130_fd_sc_hd__dlygate4sd3_1
Xhold71 sub1.a_i\[15\] vssd1 vssd1 vccd1 vccd1 net1286 sky130_fd_sc_hd__dlygate4sd3_1
Xhold60 sub1.a_i\[10\] vssd1 vssd1 vccd1 vccd1 net1275 sky130_fd_sc_hd__dlygate4sd3_1
Xhold93 net363 vssd1 vssd1 vccd1 vccd1 net1308 sky130_fd_sc_hd__dlygate4sd3_1
X_11996_ net137 net661 net504 net233 _06001_ vssd1 vssd1 vccd1 vccd1 _06002_ sky130_fd_sc_hd__a221o_1
XFILLER_0_85_345 vssd1 vssd1 vccd1 vccd1 sky130_fd_sc_hd__decap_8
X_10947_ _04856_ _04858_ _05045_ _05046_ vssd1 vssd1 vccd1 vccd1 _05047_ sky130_fd_sc_hd__a211o_1
XFILLER_0_66_592 vssd1 vssd1 vccd1 vccd1 sky130_fd_sc_hd__decap_3
X_10878_ _04977_ _04959_ vssd1 vssd1 vccd1 vccd1 _04978_ sky130_fd_sc_hd__and2b_1
X_12617_ clknet_leaf_35_clk_i _00003_ net1167 vssd1 vssd1 vccd1 vccd1 net335 sky130_fd_sc_hd__dfrtp_1
XFILLER_0_26_401 vssd1 vssd1 vccd1 vccd1 sky130_fd_sc_hd__fill_1
XFILLER_0_81_551 vssd1 vssd1 vccd1 vccd1 sky130_fd_sc_hd__decap_8
XFILLER_0_54_765 vssd1 vssd1 vccd1 vccd1 sky130_fd_sc_hd__fill_2
X_12548_ net28 _00601_ vssd1 vssd1 vccd1 vccd1 _06271_ sky130_fd_sc_hd__and2_1
XFILLER_0_41_404 vssd1 vssd1 vccd1 vccd1 sky130_fd_sc_hd__decap_4
XANTENNA_2 _00699_ vssd1 vssd1 vccd1 vccd1 sky130_fd_sc_hd__diode_2
X_12479_ temp1\[30\] _06235_ net573 vssd1 vssd1 vccd1 vccd1 _00491_ sky130_fd_sc_hd__mux2_1
XFILLER_0_10_813 vssd1 vssd1 vccd1 vccd1 sky130_ef_sc_hd__decap_12
XFILLER_0_67_33 vssd1 vssd1 vccd1 vccd1 sky130_fd_sc_hd__fill_1
XTAP_323 vssd1 vccd1 sky130_fd_sc_hd__tapvpwrvgnd_1
XTAP_312 vssd1 vccd1 sky130_fd_sc_hd__tapvpwrvgnd_1
XTAP_301 vssd1 vccd1 sky130_fd_sc_hd__tapvpwrvgnd_1
Xfanout509 net510 vssd1 vssd1 vccd1 vccd1 net509 sky130_fd_sc_hd__clkbuf_4
XFILLER_0_21_183 vssd1 vssd1 vccd1 vccd1 sky130_fd_sc_hd__fill_2
XTAP_367 vssd1 vccd1 sky130_fd_sc_hd__tapvpwrvgnd_1
XTAP_356 vssd1 vccd1 sky130_fd_sc_hd__tapvpwrvgnd_1
XTAP_345 vssd1 vccd1 sky130_fd_sc_hd__tapvpwrvgnd_1
XTAP_334 vssd1 vccd1 sky130_fd_sc_hd__tapvpwrvgnd_1
X_06971_ _01092_ _01095_ vssd1 vssd1 vccd1 vccd1 _01096_ sky130_fd_sc_hd__xnor2_2
X_08710_ _02678_ _02682_ _02683_ _02686_ vssd1 vssd1 vccd1 vccd1 _02824_ sky130_fd_sc_hd__a31o_1
X_09690_ _03660_ _03661_ _03662_ _03666_ vssd1 vssd1 vccd1 vccd1 _03798_ sky130_fd_sc_hd__a31o_1
XTAP_378 vssd1 vccd1 sky130_fd_sc_hd__tapvpwrvgnd_1
XTAP_389 vssd1 vccd1 sky130_fd_sc_hd__tapvpwrvgnd_1
Xfanout1080 mul1.a\[9\] vssd1 vssd1 vccd1 vccd1 net1080 sky130_fd_sc_hd__clkbuf_4
X_08641_ _02736_ _02752_ _02753_ vssd1 vssd1 vccd1 vccd1 _02756_ sky130_fd_sc_hd__nand3_2
Xfanout1091 net1092 vssd1 vssd1 vccd1 vccd1 net1091 sky130_fd_sc_hd__clkbuf_4
X_08572_ _02684_ _02685_ _02549_ vssd1 vssd1 vccd1 vccd1 _02687_ sky130_fd_sc_hd__a21oi_1
XFILLER_0_89_673 vssd1 vssd1 vccd1 vccd1 sky130_fd_sc_hd__decap_8
XPHY_18 vssd1 vssd1 vccd1 vccd1 sky130_fd_sc_hd__decap_3
XPHY_29 vssd1 vssd1 vccd1 vccd1 sky130_fd_sc_hd__decap_3
XFILLER_0_76_323 vssd1 vssd1 vccd1 vccd1 sky130_ef_sc_hd__decap_12
X_07523_ _01591_ _01646_ _01647_ _01644_ _01645_ vssd1 vssd1 vccd1 vccd1 _01648_ sky130_fd_sc_hd__a2111o_1
X_07454_ _01571_ _01578_ vssd1 vssd1 vccd1 vccd1 _01579_ sky130_fd_sc_hd__or2_1
XFILLER_0_119_447 vssd1 vssd1 vccd1 vccd1 sky130_fd_sc_hd__fill_1
XFILLER_0_76_389 vssd1 vssd1 vccd1 vccd1 sky130_fd_sc_hd__fill_1
XFILLER_0_64_529 vssd1 vssd1 vccd1 vccd1 sky130_fd_sc_hd__decap_3
X_06405_ _00700_ _00705_ vssd1 vssd1 vccd1 vccd1 _00711_ sky130_fd_sc_hd__nor2_2
XFILLER_0_123_93 vssd1 vssd1 vccd1 vccd1 sky130_ef_sc_hd__decap_12
XFILLER_0_44_231 vssd1 vssd1 vccd1 vccd1 sky130_fd_sc_hd__decap_8
X_07385_ _01500_ _01507_ vssd1 vssd1 vccd1 vccd1 _01510_ sky130_fd_sc_hd__and2_1
X_09124_ _03232_ _03233_ _03234_ vssd1 vssd1 vccd1 vccd1 _03236_ sky130_fd_sc_hd__a21o_1
XFILLER_0_44_253 vssd1 vssd1 vccd1 vccd1 sky130_fd_sc_hd__decap_4
X_06336_ add1.a_i\[1\] add1.b_i\[1\] vssd1 vssd1 vccd1 vccd1 _00648_ sky130_fd_sc_hd__nand2_1
XFILLER_0_115_653 vssd1 vssd1 vccd1 vccd1 sky130_ef_sc_hd__decap_12
XFILLER_0_114_141 vssd1 vssd1 vccd1 vccd1 sky130_ef_sc_hd__decap_12
X_09055_ _03157_ _03165_ vssd1 vssd1 vccd1 vccd1 _03167_ sky130_fd_sc_hd__or2_1
XFILLER_0_60_757 vssd1 vssd1 vccd1 vccd1 sky130_fd_sc_hd__decap_4
XFILLER_0_102_303 vssd1 vssd1 vccd1 vccd1 sky130_fd_sc_hd__decap_4
X_08006_ net898 net889 net1007 net1000 vssd1 vssd1 vccd1 vccd1 _02126_ sky130_fd_sc_hd__and4_1
X_09957_ _03588_ _03748_ _03903_ _04063_ vssd1 vssd1 vccd1 vccd1 _04064_ sky130_fd_sc_hd__o31a_2
X_08908_ _03019_ _03020_ vssd1 vssd1 vccd1 vccd1 _03021_ sky130_fd_sc_hd__and2b_1
XFILLER_0_99_426 vssd1 vssd1 vccd1 vccd1 sky130_fd_sc_hd__fill_1
XFILLER_0_99_404 vssd1 vssd1 vccd1 vccd1 sky130_fd_sc_hd__fill_1
X_09888_ net977 _03994_ _03993_ vssd1 vssd1 vccd1 vccd1 _03995_ sky130_fd_sc_hd__a21bo_1
XTAP_890 vssd1 vccd1 sky130_fd_sc_hd__tapvpwrvgnd_1
X_08839_ _02799_ _02801_ net455 _02952_ vssd1 vssd1 vccd1 vccd1 _02953_ sky130_fd_sc_hd__a211oi_2
X_11850_ net169 net471 _05887_ vssd1 vssd1 vccd1 vccd1 _05888_ sky130_fd_sc_hd__o21a_1
X_10801_ _04900_ _04901_ vssd1 vssd1 vccd1 vccd1 _04902_ sky130_fd_sc_hd__and2b_1
X_11781_ net652 _00877_ net474 _05828_ vssd1 vssd1 vccd1 vccd1 _05829_ sky130_fd_sc_hd__a211o_1
X_10732_ _04831_ _04832_ vssd1 vssd1 vccd1 vccd1 _04833_ sky130_fd_sc_hd__and2b_1
XFILLER_0_94_175 vssd1 vssd1 vccd1 vccd1 sky130_fd_sc_hd__decap_3
XFILLER_0_94_164 vssd1 vssd1 vccd1 vccd1 sky130_fd_sc_hd__fill_1
XFILLER_0_125_417 vssd1 vssd1 vccd1 vccd1 sky130_ef_sc_hd__decap_12
X_10663_ _04760_ _04763_ vssd1 vssd1 vccd1 vccd1 _04765_ sky130_fd_sc_hd__xnor2_1
XFILLER_0_106_642 vssd1 vssd1 vccd1 vccd1 sky130_fd_sc_hd__fill_2
X_10594_ _04694_ _04695_ vssd1 vssd1 vccd1 vccd1 _04696_ sky130_fd_sc_hd__nand2b_1
X_12402_ net1431 _00940_ net685 vssd1 vssd1 vccd1 vccd1 _00454_ sky130_fd_sc_hd__mux2_1
XFILLER_0_50_223 vssd1 vssd1 vccd1 vccd1 sky130_fd_sc_hd__decap_4
X_12333_ net1653 _00913_ net669 vssd1 vssd1 vccd1 vccd1 _00385_ sky130_fd_sc_hd__mux2_1
XFILLER_0_120_133 vssd1 vssd1 vccd1 vccd1 sky130_fd_sc_hd__decap_6
X_12264_ net1474 net41 net690 vssd1 vssd1 vccd1 vccd1 _00318_ sky130_fd_sc_hd__mux2_1
XFILLER_0_120_177 vssd1 vssd1 vccd1 vccd1 sky130_ef_sc_hd__decap_12
X_11215_ _05189_ _05191_ _05311_ _05312_ vssd1 vssd1 vccd1 vccd1 _05313_ sky130_fd_sc_hd__a211oi_2
X_12195_ x2mx1\[10\] net603 net583 temp1\[10\] vssd1 vssd1 vccd1 vccd1 _06150_ sky130_fd_sc_hd__a22o_1
XFILLER_0_128_27 vssd1 vssd1 vccd1 vccd1 sky130_fd_sc_hd__fill_1
X_11146_ net799 net789 net946 net941 vssd1 vssd1 vccd1 vccd1 _05244_ sky130_fd_sc_hd__and4_1
X_11077_ _05172_ _05174_ _05047_ _05050_ vssd1 vssd1 vccd1 vccd1 _05176_ sky130_fd_sc_hd__o211ai_2
XFILLER_0_37_36 vssd1 vssd1 vccd1 vccd1 sky130_fd_sc_hd__decap_3
X_10028_ net794 net998 net991 net803 vssd1 vssd1 vccd1 vccd1 _04134_ sky130_fd_sc_hd__a22o_1
Xinput150 v1x[6] vssd1 vssd1 vccd1 vccd1 net150 sky130_fd_sc_hd__buf_1
Xinput161 v1y[16] vssd1 vssd1 vccd1 vccd1 net161 sky130_fd_sc_hd__clkbuf_1
Xinput172 v1y[26] vssd1 vssd1 vccd1 vccd1 net172 sky130_fd_sc_hd__clkbuf_1
Xinput183 v1y[7] vssd1 vssd1 vccd1 vccd1 net183 sky130_fd_sc_hd__clkbuf_1
Xinput194 v2x[17] vssd1 vssd1 vccd1 vccd1 net194 sky130_fd_sc_hd__clkbuf_1
XFILLER_0_86_676 vssd1 vssd1 vccd1 vccd1 sky130_fd_sc_hd__decap_3
XFILLER_0_74_805 vssd1 vssd1 vccd1 vccd1 sky130_fd_sc_hd__fill_1
X_11979_ net12 net551 net627 net196 _05988_ vssd1 vssd1 vccd1 vccd1 _05989_ sky130_fd_sc_hd__a221o_1
XFILLER_0_73_304 vssd1 vssd1 vccd1 vccd1 sky130_fd_sc_hd__fill_1
XFILLER_0_129_789 vssd1 vssd1 vccd1 vccd1 sky130_ef_sc_hd__decap_12
X_07170_ _01293_ _01294_ vssd1 vssd1 vccd1 vccd1 _01295_ sky130_fd_sc_hd__nor2_1
XFILLER_0_26_253 vssd1 vssd1 vccd1 vccd1 sky130_fd_sc_hd__fill_1
XFILLER_0_112_601 vssd1 vssd1 vccd1 vccd1 sky130_ef_sc_hd__decap_12
XFILLER_0_81_381 vssd1 vssd1 vccd1 vccd1 sky130_fd_sc_hd__fill_1
XFILLER_0_5_169 vssd1 vssd1 vccd1 vccd1 sky130_fd_sc_hd__fill_2
XFILLER_0_41_212 vssd1 vssd1 vccd1 vccd1 sky130_fd_sc_hd__fill_1
XFILLER_0_111_111 vssd1 vssd1 vccd1 vccd1 sky130_fd_sc_hd__fill_1
XFILLER_0_2_810 vssd1 vssd1 vccd1 vccd1 sky130_fd_sc_hd__fill_2
XFILLER_0_112_645 vssd1 vssd1 vccd1 vccd1 sky130_ef_sc_hd__decap_12
X_09811_ _03915_ _03916_ vssd1 vssd1 vccd1 vccd1 _03918_ sky130_fd_sc_hd__xnor2_1
XFILLER_0_94_53 vssd1 vssd1 vccd1 vccd1 sky130_ef_sc_hd__decap_12
X_09742_ _03835_ _03847_ _03848_ vssd1 vssd1 vccd1 vccd1 _03850_ sky130_fd_sc_hd__nand3_1
X_06954_ _01073_ _01077_ _01078_ vssd1 vssd1 vccd1 vccd1 _01079_ sky130_fd_sc_hd__and3_1
X_09673_ _03777_ _03778_ _03779_ vssd1 vssd1 vccd1 vccd1 _03781_ sky130_fd_sc_hd__a21bo_1
XFILLER_0_27_80 vssd1 vssd1 vccd1 vccd1 sky130_fd_sc_hd__decap_4
X_06885_ _00589_ _00981_ _01008_ _01011_ vssd1 vssd1 vccd1 vccd1 _00121_ sky130_fd_sc_hd__a2bb2o_1
XTAP_2009 vssd1 vccd1 sky130_fd_sc_hd__tapvpwrvgnd_1
X_08624_ net1034 net1043 net815 vssd1 vssd1 vccd1 vccd1 _02739_ sky130_fd_sc_hd__and3_1
XTAP_1319 vssd1 vccd1 sky130_fd_sc_hd__tapvpwrvgnd_1
XTAP_1308 vssd1 vccd1 sky130_fd_sc_hd__tapvpwrvgnd_1
X_08555_ _02537_ _02670_ vssd1 vssd1 vccd1 vccd1 _02671_ sky130_fd_sc_hd__xor2_2
X_07506_ _01628_ _01629_ _01626_ vssd1 vssd1 vccd1 vccd1 _01631_ sky130_fd_sc_hd__a21o_1
X_08486_ _02598_ _02601_ vssd1 vssd1 vccd1 vccd1 _02602_ sky130_fd_sc_hd__xor2_1
XFILLER_0_76_153 vssd1 vssd1 vccd1 vccd1 sky130_ef_sc_hd__decap_12
XFILLER_0_18_710 vssd1 vssd1 vccd1 vccd1 sky130_fd_sc_hd__fill_2
XFILLER_0_91_145 vssd1 vssd1 vccd1 vccd1 sky130_fd_sc_hd__fill_2
XFILLER_0_76_197 vssd1 vssd1 vccd1 vccd1 sky130_fd_sc_hd__decap_3
X_07437_ _01557_ _01560_ _01519_ _01556_ vssd1 vssd1 vccd1 vccd1 _01562_ sky130_fd_sc_hd__o211a_1
X_07368_ _01486_ _01491_ vssd1 vssd1 vccd1 vccd1 _01493_ sky130_fd_sc_hd__xnor2_1
X_09107_ net885 net961 vssd1 vssd1 vccd1 vccd1 _03219_ sky130_fd_sc_hd__nand2_1
X_06319_ add1.a_i\[9\] add1.b_i\[9\] vssd1 vssd1 vccd1 vccd1 _00631_ sky130_fd_sc_hd__or2_1
XFILLER_0_45_584 vssd1 vssd1 vccd1 vccd1 sky130_ef_sc_hd__decap_12
XFILLER_0_33_724 vssd1 vssd1 vccd1 vccd1 sky130_fd_sc_hd__decap_4
XFILLER_0_115_461 vssd1 vssd1 vccd1 vccd1 sky130_ef_sc_hd__decap_12
X_07299_ _01421_ _01422_ _01416_ vssd1 vssd1 vccd1 vccd1 _01424_ sky130_fd_sc_hd__a21bo_1
X_09038_ _03115_ _03148_ _03149_ vssd1 vssd1 vccd1 vccd1 _03150_ sky130_fd_sc_hd__nor3_1
XFILLER_0_130_486 vssd1 vssd1 vccd1 vccd1 sky130_fd_sc_hd__decap_4
Xhold360 net351 vssd1 vssd1 vccd1 vccd1 net1575 sky130_fd_sc_hd__dlygate4sd3_1
Xhold371 net442 vssd1 vssd1 vccd1 vccd1 net1586 sky130_fd_sc_hd__dlygate4sd3_1
Xhold393 add1.b_i\[23\] vssd1 vssd1 vccd1 vccd1 net1608 sky130_fd_sc_hd__dlygate4sd3_1
X_11000_ _04958_ _04979_ _04955_ vssd1 vssd1 vccd1 vccd1 _05099_ sky130_fd_sc_hd__o21a_1
Xhold382 net373 vssd1 vssd1 vccd1 vccd1 net1597 sky130_fd_sc_hd__dlygate4sd3_1
Xfanout840 net845 vssd1 vssd1 vccd1 vccd1 net840 sky130_fd_sc_hd__clkbuf_2
Xfanout851 net853 vssd1 vssd1 vccd1 vccd1 net851 sky130_fd_sc_hd__buf_4
Xfanout884 net885 vssd1 vssd1 vccd1 vccd1 net884 sky130_fd_sc_hd__clkbuf_2
Xfanout873 net875 vssd1 vssd1 vccd1 vccd1 net873 sky130_fd_sc_hd__clkbuf_4
Xfanout862 net863 vssd1 vssd1 vccd1 vccd1 net862 sky130_fd_sc_hd__buf_2
X_12951_ clknet_leaf_51_clk_i _00337_ net1152 vssd1 vssd1 vccd1 vccd1 y1my2\[4\] sky130_fd_sc_hd__dfrtp_1
Xfanout895 net897 vssd1 vssd1 vccd1 vccd1 net895 sky130_fd_sc_hd__buf_2
X_11902_ net90 net620 net594 net58 vssd1 vssd1 vccd1 vccd1 _05931_ sky130_fd_sc_hd__a22o_1
X_12882_ clknet_leaf_38_clk_i _00268_ vssd1 vssd1 vccd1 vccd1 mul1.a\[17\] sky130_fd_sc_hd__dfxtp_2
X_11833_ net231 net601 net581 net135 _05872_ vssd1 vssd1 vccd1 vccd1 _05873_ sky130_fd_sc_hd__a221o_1
XFILLER_0_114_29 vssd1 vssd1 vccd1 vccd1 sky130_ef_sc_hd__decap_12
XTAP_1842 vssd1 vccd1 sky130_fd_sc_hd__tapvpwrvgnd_1
XTAP_1831 vssd1 vccd1 sky130_fd_sc_hd__tapvpwrvgnd_1
XTAP_1820 vssd1 vccd1 sky130_fd_sc_hd__tapvpwrvgnd_1
XFILLER_0_68_665 vssd1 vssd1 vccd1 vccd1 sky130_fd_sc_hd__fill_1
XFILLER_0_23_27 vssd1 vssd1 vccd1 vccd1 sky130_ef_sc_hd__decap_12
XTAP_1864 vssd1 vccd1 sky130_fd_sc_hd__tapvpwrvgnd_1
XTAP_1875 vssd1 vccd1 sky130_fd_sc_hd__tapvpwrvgnd_1
XTAP_1853 vssd1 vccd1 sky130_fd_sc_hd__tapvpwrvgnd_1
XFILLER_0_83_635 vssd1 vssd1 vccd1 vccd1 sky130_fd_sc_hd__fill_2
X_11764_ net155 net470 _05814_ vssd1 vssd1 vccd1 vccd1 _05815_ sky130_fd_sc_hd__o21a_1
XFILLER_0_28_518 vssd1 vssd1 vccd1 vccd1 sky130_fd_sc_hd__decap_4
XFILLER_0_28_529 vssd1 vssd1 vccd1 vccd1 sky130_fd_sc_hd__decap_3
XTAP_1897 vssd1 vccd1 sky130_fd_sc_hd__tapvpwrvgnd_1
XTAP_1886 vssd1 vccd1 sky130_fd_sc_hd__tapvpwrvgnd_1
X_10715_ _04666_ _04808_ _04809_ _04667_ vssd1 vssd1 vccd1 vccd1 _04816_ sky130_fd_sc_hd__or4b_1
XFILLER_0_55_337 vssd1 vssd1 vccd1 vccd1 sky130_fd_sc_hd__decap_8
X_11695_ _00987_ net616 net609 net600 vssd1 vssd1 vccd1 vccd1 _05756_ sky130_fd_sc_hd__or4_2
XFILLER_0_126_737 vssd1 vssd1 vccd1 vccd1 sky130_ef_sc_hd__decap_12
XFILLER_0_82_156 vssd1 vssd1 vccd1 vccd1 sky130_ef_sc_hd__decap_12
X_10646_ _04565_ _04604_ _04746_ _04747_ vssd1 vssd1 vccd1 vccd1 _04748_ sky130_fd_sc_hd__o211a_2
X_10577_ _04531_ _04533_ vssd1 vssd1 vccd1 vccd1 _04679_ sky130_fd_sc_hd__nand2_1
X_12316_ net1657 _00823_ net667 vssd1 vssd1 vccd1 vccd1 _00368_ sky130_fd_sc_hd__mux2_1
X_12247_ _00951_ net511 net468 y1my2\[27\] _06184_ vssd1 vssd1 vccd1 vccd1 _06185_
+ sky130_fd_sc_hd__a221o_1
XFILLER_0_121_497 vssd1 vssd1 vccd1 vccd1 sky130_fd_sc_hd__decap_6
X_12178_ _00828_ net509 net466 y1my2\[4\] _06138_ vssd1 vssd1 vccd1 vccd1 _06139_
+ sky130_fd_sc_hd__a221o_1
XFILLER_0_3_15 vssd1 vssd1 vccd1 vccd1 sky130_ef_sc_hd__decap_12
X_11129_ net750 net975 net743 net982 vssd1 vssd1 vccd1 vccd1 _05227_ sky130_fd_sc_hd__a22o_1
XFILLER_0_64_56 vssd1 vssd1 vccd1 vccd1 sky130_fd_sc_hd__decap_3
X_06670_ net1709 _00897_ net634 vssd1 vssd1 vccd1 vccd1 _00020_ sky130_fd_sc_hd__mux2_1
X_08340_ _02455_ _02456_ _02442_ vssd1 vssd1 vccd1 vccd1 _02457_ sky130_fd_sc_hd__a21oi_2
XFILLER_0_74_602 vssd1 vssd1 vccd1 vccd1 sky130_fd_sc_hd__fill_1
X_08271_ _02328_ _02329_ _02387_ _02388_ vssd1 vssd1 vccd1 vccd1 _02389_ sky130_fd_sc_hd__and4_2
XFILLER_0_74_668 vssd1 vssd1 vccd1 vccd1 sky130_fd_sc_hd__decap_3
XFILLER_0_46_359 vssd1 vssd1 vccd1 vccd1 sky130_fd_sc_hd__fill_1
XFILLER_0_129_597 vssd1 vssd1 vccd1 vccd1 sky130_ef_sc_hd__decap_12
XFILLER_0_117_737 vssd1 vssd1 vccd1 vccd1 sky130_ef_sc_hd__decap_12
XFILLER_0_73_167 vssd1 vssd1 vccd1 vccd1 sky130_fd_sc_hd__fill_1
X_07222_ net1089 net1096 net847 net838 vssd1 vssd1 vccd1 vccd1 _01347_ sky130_fd_sc_hd__and4_1
XFILLER_0_104_409 vssd1 vssd1 vccd1 vccd1 sky130_fd_sc_hd__decap_8
X_07153_ _01275_ _01276_ _01277_ vssd1 vssd1 vccd1 vccd1 _01278_ sky130_fd_sc_hd__nand3_1
XFILLER_0_124_291 vssd1 vssd1 vccd1 vccd1 sky130_fd_sc_hd__fill_2
XFILLER_0_124_280 vssd1 vssd1 vccd1 vccd1 sky130_fd_sc_hd__fill_2
XFILLER_0_120_83 vssd1 vssd1 vccd1 vccd1 sky130_fd_sc_hd__fill_1
Xoutput410 net410 vssd1 vssd1 vccd1 vccd1 mstream_o[64] sky130_fd_sc_hd__clkbuf_4
X_07084_ _01207_ _01208_ _01203_ vssd1 vssd1 vccd1 vccd1 _01209_ sky130_fd_sc_hd__a21o_1
XFILLER_0_42_576 vssd1 vssd1 vccd1 vccd1 sky130_fd_sc_hd__fill_1
XFILLER_0_42_587 vssd1 vssd1 vccd1 vccd1 sky130_fd_sc_hd__fill_1
XFILLER_0_112_475 vssd1 vssd1 vccd1 vccd1 sky130_fd_sc_hd__fill_1
Xoutput443 net443 vssd1 vssd1 vccd1 vccd1 mstream_o[94] sky130_fd_sc_hd__clkbuf_4
Xoutput432 net432 vssd1 vssd1 vccd1 vccd1 mstream_o[84] sky130_fd_sc_hd__clkbuf_4
Xoutput421 net421 vssd1 vssd1 vccd1 vccd1 mstream_o[74] sky130_fd_sc_hd__clkbuf_4
X_07986_ _02104_ _02105_ vssd1 vssd1 vccd1 vccd1 _02106_ sky130_fd_sc_hd__and2_1
X_09725_ _03798_ _03830_ _03831_ vssd1 vssd1 vccd1 vccd1 _03833_ sky130_fd_sc_hd__and3_1
X_06937_ net820 net1143 vssd1 vssd1 vccd1 vccd1 _01062_ sky130_fd_sc_hd__nand2_1
X_09656_ net1134 net700 net695 net1125 vssd1 vssd1 vccd1 vccd1 _03764_ sky130_fd_sc_hd__and4b_2
XFILLER_0_97_705 vssd1 vssd1 vccd1 vccd1 sky130_ef_sc_hd__decap_12
XFILLER_0_97_749 vssd1 vssd1 vccd1 vccd1 sky130_fd_sc_hd__fill_1
XFILLER_0_96_237 vssd1 vssd1 vccd1 vccd1 sky130_fd_sc_hd__decap_8
X_08607_ _02716_ _02720_ _02721_ vssd1 vssd1 vccd1 vccd1 _02722_ sky130_fd_sc_hd__nand3_1
XTAP_1105 vssd1 vccd1 sky130_fd_sc_hd__tapvpwrvgnd_1
X_06868_ _00603_ _00800_ vssd1 vssd1 vccd1 vccd1 _00997_ sky130_fd_sc_hd__nor2_1
X_06799_ net1560 net1559 net642 vssd1 vssd1 vccd1 vccd1 _00073_ sky130_fd_sc_hd__mux2_1
XFILLER_0_77_440 vssd1 vssd1 vccd1 vccd1 sky130_fd_sc_hd__decap_3
X_09587_ net867 net956 net950 net878 vssd1 vssd1 vccd1 vccd1 _03696_ sky130_fd_sc_hd__a22o_1
XTAP_1138 vssd1 vccd1 sky130_fd_sc_hd__tapvpwrvgnd_1
XTAP_1127 vssd1 vccd1 sky130_fd_sc_hd__tapvpwrvgnd_1
XTAP_1116 vssd1 vccd1 sky130_fd_sc_hd__tapvpwrvgnd_1
X_08538_ _02518_ _02521_ _02651_ _02653_ vssd1 vssd1 vccd1 vccd1 _02654_ sky130_fd_sc_hd__o211a_2
XTAP_1149 vssd1 vccd1 sky130_fd_sc_hd__tapvpwrvgnd_1
XFILLER_0_49_153 vssd1 vssd1 vccd1 vccd1 sky130_ef_sc_hd__decap_12
X_08469_ _02575_ _02582_ _02583_ vssd1 vssd1 vccd1 vccd1 _02585_ sky130_fd_sc_hd__nand3_1
XFILLER_0_37_337 vssd1 vssd1 vccd1 vccd1 sky130_fd_sc_hd__fill_2
XFILLER_0_37_348 vssd1 vssd1 vccd1 vccd1 sky130_fd_sc_hd__fill_1
X_10500_ _04497_ _04500_ _04600_ _04601_ vssd1 vssd1 vccd1 vccd1 _04603_ sky130_fd_sc_hd__o211ai_2
XFILLER_0_64_178 vssd1 vssd1 vccd1 vccd1 sky130_ef_sc_hd__decap_12
Xwire526 _00833_ vssd1 vssd1 vccd1 vccd1 net526 sky130_fd_sc_hd__buf_4
X_11480_ _05573_ _05574_ vssd1 vssd1 vccd1 vccd1 _05575_ sky130_fd_sc_hd__xnor2_1
XFILLER_0_123_729 vssd1 vssd1 vccd1 vccd1 sky130_ef_sc_hd__decap_12
XFILLER_0_61_841 vssd1 vssd1 vccd1 vccd1 sky130_fd_sc_hd__fill_1
X_10431_ net859 net933 _04531_ _04532_ vssd1 vssd1 vccd1 vccd1 _04534_ sky130_fd_sc_hd__a22o_1
X_13150_ clknet_leaf_14_clk_i _00536_ net1186 vssd1 vssd1 vccd1 vccd1 l0\[11\] sky130_fd_sc_hd__dfrtp_1
X_10362_ _04444_ _04445_ _04463_ _04464_ vssd1 vssd1 vccd1 vccd1 _04466_ sky130_fd_sc_hd__or4_1
X_10293_ _04233_ _04238_ _04232_ vssd1 vssd1 vccd1 vccd1 _04397_ sky130_fd_sc_hd__a21o_1
X_13081_ clknet_leaf_0_clk_i _00467_ vssd1 vssd1 vccd1 vccd1 temp1\[6\] sky130_fd_sc_hd__dfxtp_2
X_12101_ y2my0\[16\] net586 net533 x2mx1\[16\] _06081_ vssd1 vssd1 vccd1 vccd1 _06082_
+ sky130_fd_sc_hd__a221o_1
X_12032_ state\[2\] _00976_ vssd1 vssd1 vccd1 vccd1 _06029_ sky130_fd_sc_hd__nor2_1
Xhold190 _00079_ vssd1 vssd1 vccd1 vccd1 net1405 sky130_fd_sc_hd__dlygate4sd3_1
XFILLER_0_18_27 vssd1 vssd1 vccd1 vccd1 sky130_fd_sc_hd__fill_1
Xfanout681 _00985_ vssd1 vssd1 vccd1 vccd1 net681 sky130_fd_sc_hd__buf_2
Xfanout670 _00998_ vssd1 vssd1 vccd1 vccd1 net670 sky130_fd_sc_hd__buf_2
X_12934_ clknet_leaf_7_clk_i _00320_ net1195 vssd1 vssd1 vccd1 vccd1 posx\[5\] sky130_fd_sc_hd__dfrtp_1
XFILLER_0_125_39 vssd1 vssd1 vccd1 vccd1 sky130_ef_sc_hd__decap_12
XFILLER_0_34_15 vssd1 vssd1 vccd1 vccd1 sky130_fd_sc_hd__decap_6
XFILLER_0_68_440 vssd1 vssd1 vccd1 vccd1 sky130_fd_sc_hd__decap_3
X_12865_ clknet_leaf_52_clk_i _00251_ vssd1 vssd1 vccd1 vccd1 mul1.a\[0\] sky130_fd_sc_hd__dfxtp_1
XTAP_1650 vssd1 vccd1 sky130_fd_sc_hd__tapvpwrvgnd_1
X_12796_ clknet_leaf_18_clk_i _00182_ vssd1 vssd1 vccd1 vccd1 add1.b_i\[27\] sky130_fd_sc_hd__dfxtp_1
X_11816_ net1272 _05858_ net481 vssd1 vssd1 vccd1 vccd1 _00205_ sky130_fd_sc_hd__mux2_1
XFILLER_0_95_281 vssd1 vssd1 vccd1 vccd1 sky130_fd_sc_hd__decap_6
XTAP_1694 vssd1 vccd1 sky130_fd_sc_hd__tapvpwrvgnd_1
XTAP_1683 vssd1 vccd1 sky130_fd_sc_hd__tapvpwrvgnd_1
XTAP_1661 vssd1 vccd1 sky130_fd_sc_hd__tapvpwrvgnd_1
XTAP_1672 vssd1 vccd1 sky130_fd_sc_hd__tapvpwrvgnd_1
X_11747_ net1460 _05800_ net478 vssd1 vssd1 vccd1 vccd1 _00194_ sky130_fd_sc_hd__mux2_1
XFILLER_0_126_545 vssd1 vssd1 vccd1 vccd1 sky130_ef_sc_hd__decap_12
XFILLER_0_126_523 vssd1 vssd1 vccd1 vccd1 sky130_fd_sc_hd__decap_8
XFILLER_0_55_167 vssd1 vssd1 vccd1 vccd1 sky130_fd_sc_hd__fill_1
XFILLER_0_114_718 vssd1 vssd1 vccd1 vccd1 sky130_ef_sc_hd__decap_12
XFILLER_0_83_498 vssd1 vssd1 vccd1 vccd1 sky130_fd_sc_hd__decap_6
XFILLER_0_71_627 vssd1 vssd1 vccd1 vccd1 sky130_fd_sc_hd__decap_6
X_11678_ net1282 _03581_ net538 vssd1 vssd1 vccd1 vccd1 _00170_ sky130_fd_sc_hd__mux2_1
XFILLER_0_126_589 vssd1 vssd1 vccd1 vccd1 sky130_ef_sc_hd__decap_12
XFILLER_0_113_217 vssd1 vssd1 vccd1 vccd1 sky130_fd_sc_hd__decap_6
X_10629_ net782 net976 _04728_ _04729_ vssd1 vssd1 vccd1 vccd1 _04731_ sky130_fd_sc_hd__o2bb2a_1
XFILLER_0_59_34 vssd1 vssd1 vccd1 vccd1 sky130_fd_sc_hd__decap_3
XFILLER_0_51_362 vssd1 vssd1 vccd1 vccd1 sky130_fd_sc_hd__fill_2
XFILLER_0_121_261 vssd1 vssd1 vccd1 vccd1 sky130_ef_sc_hd__decap_12
XFILLER_0_12_749 vssd1 vssd1 vccd1 vccd1 sky130_fd_sc_hd__fill_1
X_07840_ net1147 net755 vssd1 vssd1 vccd1 vccd1 _01961_ sky130_fd_sc_hd__nand2_1
X_07771_ _01884_ _01890_ _01891_ vssd1 vssd1 vccd1 vccd1 _01893_ sky130_fd_sc_hd__nand3_2
X_09510_ _03613_ _03617_ _03618_ vssd1 vssd1 vccd1 vccd1 _03619_ sky130_fd_sc_hd__nand3_2
X_06722_ sub1.a_i\[26\] sub1.b_i\[26\] vssd1 vssd1 vccd1 vccd1 _00941_ sky130_fd_sc_hd__nand2b_1
XFILLER_0_78_248 vssd1 vssd1 vccd1 vccd1 sky130_fd_sc_hd__decap_4
X_09441_ _03548_ _03549_ _03550_ vssd1 vssd1 vccd1 vccd1 _03551_ sky130_fd_sc_hd__nand3_2
X_06653_ _00879_ _00881_ _00878_ vssd1 vssd1 vccd1 vccd1 _00883_ sky130_fd_sc_hd__o21bai_4
X_09372_ _03480_ _03481_ vssd1 vssd1 vccd1 vccd1 _03482_ sky130_fd_sc_hd__nand2b_1
X_06584_ sub1.a_i\[4\] sub1.b_i\[4\] vssd1 vssd1 vccd1 vccd1 _00825_ sky130_fd_sc_hd__and2b_1
X_08323_ _02437_ _02438_ vssd1 vssd1 vccd1 vccd1 _02440_ sky130_fd_sc_hd__xnor2_1
XFILLER_0_24_92 vssd1 vssd1 vccd1 vccd1 sky130_ef_sc_hd__decap_12
XFILLER_0_46_145 vssd1 vssd1 vccd1 vccd1 sky130_fd_sc_hd__fill_1
X_08254_ _02368_ _02369_ _02370_ vssd1 vssd1 vccd1 vccd1 _02372_ sky130_fd_sc_hd__a21o_1
X_08185_ net1122 net755 _02300_ _02301_ vssd1 vssd1 vccd1 vccd1 _02303_ sky130_fd_sc_hd__o2bb2a_1
XFILLER_0_43_841 vssd1 vssd1 vccd1 vccd1 sky130_fd_sc_hd__fill_1
X_07205_ _01326_ _01328_ _01243_ _01245_ vssd1 vssd1 vccd1 vccd1 _01330_ sky130_fd_sc_hd__a211oi_1
XFILLER_0_70_671 vssd1 vssd1 vccd1 vccd1 sky130_fd_sc_hd__decap_6
X_07136_ net1144 net798 _01259_ vssd1 vssd1 vccd1 vccd1 _01261_ sky130_fd_sc_hd__a21oi_1
XFILLER_0_30_557 vssd1 vssd1 vccd1 vccd1 sky130_fd_sc_hd__decap_6
X_07067_ _01129_ _01131_ _01190_ vssd1 vssd1 vccd1 vccd1 _01192_ sky130_fd_sc_hd__nand3_1
Xoutput251 net251 vssd1 vssd1 vccd1 vccd1 discard_o sky130_fd_sc_hd__clkbuf_4
Xoutput262 net262 vssd1 vssd1 vccd1 vccd1 div_mstream_o[19] sky130_fd_sc_hd__clkbuf_4
Xoutput284 net284 vssd1 vssd1 vccd1 vccd1 div_mstream_o[39] sky130_fd_sc_hd__clkbuf_4
Xoutput273 net273 vssd1 vssd1 vccd1 vccd1 div_mstream_o[29] sky130_fd_sc_hd__clkbuf_4
Xoutput295 net295 vssd1 vssd1 vccd1 vccd1 div_mstream_o[5] sky130_fd_sc_hd__clkbuf_4
X_09708_ net792 net1014 net1006 net803 vssd1 vssd1 vccd1 vccd1 _03816_ sky130_fd_sc_hd__a22o_1
X_07969_ _02075_ _02088_ vssd1 vssd1 vccd1 vccd1 _02089_ sky130_fd_sc_hd__nor2_1
X_10980_ _04820_ _04951_ _04949_ vssd1 vssd1 vccd1 vccd1 _05080_ sky130_fd_sc_hd__a21boi_1
X_09639_ _03745_ _03746_ vssd1 vssd1 vccd1 vccd1 _03748_ sky130_fd_sc_hd__xor2_4
XFILLER_0_97_579 vssd1 vssd1 vccd1 vccd1 sky130_fd_sc_hd__decap_6
XFILLER_0_38_613 vssd1 vssd1 vccd1 vccd1 sky130_fd_sc_hd__fill_1
X_12650_ clknet_leaf_22_clk_i _00036_ net1174 vssd1 vssd1 vccd1 vccd1 net376 sky130_fd_sc_hd__dfrtp_1
XFILLER_0_93_741 vssd1 vssd1 vccd1 vccd1 sky130_fd_sc_hd__decap_6
XFILLER_0_77_281 vssd1 vssd1 vccd1 vccd1 sky130_fd_sc_hd__fill_2
X_11601_ _05691_ _05694_ vssd1 vssd1 vccd1 vccd1 _05695_ sky130_fd_sc_hd__xnor2_1
XFILLER_0_37_123 vssd1 vssd1 vccd1 vccd1 sky130_fd_sc_hd__decap_8
XFILLER_0_38_657 vssd1 vssd1 vccd1 vccd1 sky130_fd_sc_hd__decap_6
XFILLER_0_92_251 vssd1 vssd1 vccd1 vccd1 sky130_fd_sc_hd__fill_1
XFILLER_0_53_605 vssd1 vssd1 vccd1 vccd1 sky130_fd_sc_hd__decap_8
X_12581_ net28 net654 vssd1 vssd1 vccd1 vccd1 _06272_ sky130_fd_sc_hd__and2_1
XFILLER_0_37_167 vssd1 vssd1 vccd1 vccd1 sky130_fd_sc_hd__fill_1
XFILLER_0_53_638 vssd1 vssd1 vccd1 vccd1 sky130_fd_sc_hd__decap_8
X_11532_ _05624_ _05625_ vssd1 vssd1 vccd1 vccd1 _05627_ sky130_fd_sc_hd__xnor2_1
XFILLER_0_108_589 vssd1 vssd1 vccd1 vccd1 sky130_ef_sc_hd__decap_12
XFILLER_0_80_446 vssd1 vssd1 vccd1 vccd1 sky130_ef_sc_hd__decap_12
X_11463_ _05558_ vssd1 vssd1 vccd1 vccd1 _05559_ sky130_fd_sc_hd__inv_2
XFILLER_0_123_559 vssd1 vssd1 vccd1 vccd1 sky130_fd_sc_hd__fill_1
X_10414_ _04516_ _04517_ vssd1 vssd1 vccd1 vccd1 _04518_ sky130_fd_sc_hd__nor2_1
X_13202_ clknet_leaf_15_clk_i _00588_ net1183 vssd1 vssd1 vccd1 vccd1 l1\[31\] sky130_fd_sc_hd__dfrtp_1
XFILLER_0_61_671 vssd1 vssd1 vccd1 vccd1 sky130_fd_sc_hd__fill_1
X_13133_ clknet_leaf_3_clk_i _00519_ vssd1 vssd1 vccd1 vccd1 det_t\[26\] sky130_fd_sc_hd__dfxtp_1
XFILLER_0_110_209 vssd1 vssd1 vccd1 vccd1 sky130_ef_sc_hd__decap_12
XFILLER_0_61_693 vssd1 vssd1 vccd1 vccd1 sky130_fd_sc_hd__fill_1
X_11394_ _05481_ _05489_ vssd1 vssd1 vccd1 vccd1 _05490_ sky130_fd_sc_hd__xnor2_1
X_10345_ net958 _04448_ _04447_ vssd1 vssd1 vccd1 vccd1 _04449_ sky130_fd_sc_hd__a21bo_1
XFILLER_0_29_15 vssd1 vssd1 vccd1 vccd1 sky130_fd_sc_hd__decap_8
X_10276_ _04375_ _04380_ vssd1 vssd1 vccd1 vccd1 _04381_ sky130_fd_sc_hd__xor2_4
X_13064_ clknet_leaf_35_clk_i _00450_ net1167 vssd1 vssd1 vccd1 vccd1 y2my0\[21\]
+ sky130_fd_sc_hd__dfrtp_1
XTAP_708 vssd1 vccd1 sky130_fd_sc_hd__tapvpwrvgnd_1
XTAP_719 vssd1 vccd1 sky130_fd_sc_hd__tapvpwrvgnd_1
X_12015_ net22 net552 net626 net206 _06015_ vssd1 vssd1 vccd1 vccd1 _06016_ sky130_fd_sc_hd__a221o_1
Xmax_cap3 _02951_ vssd1 vssd1 vccd1 vccd1 net1744 sky130_fd_sc_hd__clkbuf_1
X_12917_ clknet_leaf_37_clk_i _00303_ vssd1 vssd1 vccd1 vccd1 mul1.b\[20\] sky130_fd_sc_hd__dfxtp_1
XTAP_2170 vssd1 vccd1 sky130_fd_sc_hd__tapvpwrvgnd_1
X_12848_ clknet_leaf_49_clk_i _00234_ vssd1 vssd1 vccd1 vccd1 sub1.b_i\[15\] sky130_fd_sc_hd__dfxtp_1
XFILLER_0_0_27 vssd1 vssd1 vccd1 vccd1 sky130_fd_sc_hd__fill_1
XTAP_2192 vssd1 vccd1 sky130_fd_sc_hd__tapvpwrvgnd_1
XTAP_2181 vssd1 vccd1 sky130_fd_sc_hd__tapvpwrvgnd_1
XFILLER_0_118_309 vssd1 vssd1 vccd1 vccd1 sky130_ef_sc_hd__decap_12
XFILLER_0_56_421 vssd1 vssd1 vccd1 vccd1 sky130_fd_sc_hd__decap_4
XFILLER_0_127_821 vssd1 vssd1 vccd1 vccd1 sky130_ef_sc_hd__decap_12
XTAP_1491 vssd1 vccd1 sky130_fd_sc_hd__tapvpwrvgnd_1
XTAP_1480 vssd1 vccd1 sky130_fd_sc_hd__tapvpwrvgnd_1
XFILLER_0_56_443 vssd1 vssd1 vccd1 vccd1 sky130_fd_sc_hd__fill_1
X_12779_ clknet_leaf_1_clk_i _00165_ vssd1 vssd1 vccd1 vccd1 add1.b_i\[10\] sky130_fd_sc_hd__dfxtp_1
XFILLER_0_126_342 vssd1 vssd1 vccd1 vccd1 sky130_fd_sc_hd__decap_3
XFILLER_0_9_69 vssd1 vssd1 vccd1 vccd1 sky130_ef_sc_hd__decap_12
XFILLER_0_25_841 vssd1 vssd1 vccd1 vccd1 sky130_fd_sc_hd__fill_1
XFILLER_0_122_581 vssd1 vssd1 vccd1 vccd1 sky130_fd_sc_hd__decap_6
X_09990_ net1079 net719 vssd1 vssd1 vccd1 vccd1 _04096_ sky130_fd_sc_hd__nand2_1
XFILLER_0_10_83 vssd1 vssd1 vccd1 vccd1 sky130_fd_sc_hd__fill_1
X_08941_ net877 net869 net980 net974 vssd1 vssd1 vccd1 vccd1 _03054_ sky130_fd_sc_hd__and4_1
X_08872_ _02837_ _02839_ _02982_ _02983_ vssd1 vssd1 vccd1 vccd1 _02985_ sky130_fd_sc_hd__a211oi_2
X_07823_ _01943_ _01944_ vssd1 vssd1 vccd1 vccd1 _01945_ sky130_fd_sc_hd__or2_1
XFILLER_0_19_81 vssd1 vssd1 vccd1 vccd1 sky130_fd_sc_hd__decap_8
XFILLER_0_79_513 vssd1 vssd1 vccd1 vccd1 sky130_fd_sc_hd__decap_3
X_07754_ _01801_ _01805_ _01873_ vssd1 vssd1 vccd1 vccd1 _01876_ sky130_fd_sc_hd__and3_1
XFILLER_0_29_3 vssd1 vssd1 vccd1 vccd1 sky130_ef_sc_hd__decap_12
X_07685_ net1050 net1058 net873 net864 vssd1 vssd1 vccd1 vccd1 _01808_ sky130_fd_sc_hd__nand4_1
X_06705_ _00925_ _00926_ vssd1 vssd1 vccd1 vccd1 _00927_ sky130_fd_sc_hd__and2b_1
X_09424_ _03526_ _03533_ vssd1 vssd1 vccd1 vccd1 _03534_ sky130_fd_sc_hd__xnor2_1
X_06636_ sub1.a_i\[12\] sub1.b_i\[12\] vssd1 vssd1 vccd1 vccd1 _00869_ sky130_fd_sc_hd__and2b_1
XFILLER_0_59_281 vssd1 vssd1 vccd1 vccd1 sky130_fd_sc_hd__decap_4
X_09355_ _03337_ _03341_ _03463_ net463 vssd1 vssd1 vccd1 vccd1 _03465_ sky130_fd_sc_hd__a211o_1
X_06567_ sub1.b_i\[1\] sub1.a_i\[1\] vssd1 vssd1 vccd1 vccd1 _00811_ sky130_fd_sc_hd__and2b_1
XFILLER_0_19_134 vssd1 vssd1 vccd1 vccd1 sky130_fd_sc_hd__fill_2
X_06498_ det_t\[8\] net527 vssd1 vssd1 vccd1 vccd1 net324 sky130_fd_sc_hd__and2_1
X_08306_ _02286_ _02422_ vssd1 vssd1 vccd1 vccd1 _02423_ sky130_fd_sc_hd__nand2_1
X_09286_ _03359_ _03360_ _03394_ _03395_ vssd1 vssd1 vccd1 vccd1 _03397_ sky130_fd_sc_hd__or4bb_4
XFILLER_0_47_487 vssd1 vssd1 vccd1 vccd1 sky130_fd_sc_hd__decap_4
XFILLER_0_19_167 vssd1 vssd1 vccd1 vccd1 sky130_fd_sc_hd__fill_1
XFILLER_0_90_777 vssd1 vssd1 vccd1 vccd1 sky130_fd_sc_hd__fill_1
XFILLER_0_90_744 vssd1 vssd1 vccd1 vccd1 sky130_fd_sc_hd__decap_4
X_08237_ net1024 net857 _02352_ _02353_ vssd1 vssd1 vccd1 vccd1 _02355_ sky130_fd_sc_hd__nand4_2
XFILLER_0_34_126 vssd1 vssd1 vccd1 vccd1 sky130_fd_sc_hd__decap_4
XFILLER_0_43_671 vssd1 vssd1 vccd1 vccd1 sky130_fd_sc_hd__fill_1
XFILLER_0_15_362 vssd1 vssd1 vccd1 vccd1 sky130_fd_sc_hd__decap_4
X_08168_ _02178_ _02187_ vssd1 vssd1 vccd1 vccd1 _02286_ sky130_fd_sc_hd__and2_2
XFILLER_0_101_710 vssd1 vssd1 vccd1 vccd1 sky130_fd_sc_hd__fill_2
X_08099_ _02214_ _02217_ vssd1 vssd1 vccd1 vccd1 _02218_ sky130_fd_sc_hd__xor2_1
X_07119_ _01243_ vssd1 vssd1 vccd1 vccd1 _01244_ sky130_fd_sc_hd__inv_2
XFILLER_0_100_220 vssd1 vssd1 vccd1 vccd1 sky130_ef_sc_hd__decap_12
X_10130_ net1101 net699 net693 net1109 vssd1 vssd1 vccd1 vccd1 _04235_ sky130_fd_sc_hd__o2bb2a_1
X_10061_ _04165_ _04166_ _04160_ vssd1 vssd1 vccd1 vccd1 _04167_ sky130_fd_sc_hd__a21o_1
X_10963_ _04930_ _04933_ _05061_ _05062_ vssd1 vssd1 vccd1 vccd1 _05063_ sky130_fd_sc_hd__o211a_2
XFILLER_0_15_39 vssd1 vssd1 vccd1 vccd1 sky130_ef_sc_hd__decap_12
X_12702_ clknet_leaf_12_clk_i _00088_ net1187 vssd1 vssd1 vccd1 vccd1 net433 sky130_fd_sc_hd__dfrtp_1
X_10894_ net992 net758 _04862_ _04861_ vssd1 vssd1 vccd1 vccd1 _04994_ sky130_fd_sc_hd__a31o_1
XFILLER_0_122_29 vssd1 vssd1 vccd1 vccd1 sky130_ef_sc_hd__decap_12
XFILLER_0_65_251 vssd1 vssd1 vccd1 vccd1 sky130_fd_sc_hd__decap_4
X_12633_ clknet_leaf_38_clk_i _00019_ net1162 vssd1 vssd1 vccd1 vccd1 net357 sky130_fd_sc_hd__dfrtp_2
XFILLER_0_38_465 vssd1 vssd1 vccd1 vccd1 sky130_fd_sc_hd__decap_3
X_12564_ net1572 net8 net559 vssd1 vssd1 vccd1 vccd1 _00540_ sky130_fd_sc_hd__mux2_1
XFILLER_0_31_27 vssd1 vssd1 vccd1 vccd1 sky130_fd_sc_hd__decap_8
XFILLER_0_31_49 vssd1 vssd1 vccd1 vccd1 sky130_fd_sc_hd__fill_2
XFILLER_0_124_813 vssd1 vssd1 vccd1 vccd1 sky130_ef_sc_hd__decap_12
XFILLER_0_81_755 vssd1 vssd1 vccd1 vccd1 sky130_fd_sc_hd__decap_3
XFILLER_0_25_126 vssd1 vssd1 vccd1 vccd1 sky130_fd_sc_hd__decap_3
XFILLER_0_25_148 vssd1 vssd1 vccd1 vccd1 sky130_ef_sc_hd__decap_12
X_11515_ _05608_ _05609_ vssd1 vssd1 vccd1 vccd1 _05610_ sky130_fd_sc_hd__nor2_1
XFILLER_0_123_312 vssd1 vssd1 vccd1 vccd1 sky130_ef_sc_hd__decap_12
X_12495_ _00790_ net568 _06244_ vssd1 vssd1 vccd1 vccd1 _00498_ sky130_fd_sc_hd__a21oi_1
XFILLER_0_53_468 vssd1 vssd1 vccd1 vccd1 sky130_fd_sc_hd__fill_1
XFILLER_0_22_811 vssd1 vssd1 vccd1 vccd1 sky130_fd_sc_hd__fill_1
Xbary_pipe_m_1210 vssd1 vssd1 vccd1 vccd1 bary_pipe_m_1210/HI div_mstream_o[60] sky130_fd_sc_hd__conb_1
XFILLER_0_34_682 vssd1 vssd1 vccd1 vccd1 sky130_fd_sc_hd__decap_6
X_11446_ _05539_ _05540_ _05523_ vssd1 vssd1 vccd1 vccd1 _05542_ sky130_fd_sc_hd__o21ai_1
XFILLER_0_111_529 vssd1 vssd1 vccd1 vccd1 sky130_ef_sc_hd__decap_12
X_11377_ net757 net957 _05470_ _05472_ vssd1 vssd1 vccd1 vccd1 _05473_ sky130_fd_sc_hd__and4_1
X_13116_ clknet_leaf_3_clk_i _00502_ vssd1 vssd1 vccd1 vccd1 det_t\[9\] sky130_fd_sc_hd__dfxtp_1
X_10328_ net884 _04175_ _04173_ vssd1 vssd1 vccd1 vccd1 _04432_ sky130_fd_sc_hd__a21o_2
XTAP_505 vssd1 vccd1 sky130_fd_sc_hd__tapvpwrvgnd_1
XTAP_516 vssd1 vccd1 sky130_fd_sc_hd__tapvpwrvgnd_1
X_13047_ clknet_leaf_50_clk_i _00433_ net1152 vssd1 vssd1 vccd1 vccd1 y2my0\[4\] sky130_fd_sc_hd__dfrtp_1
XTAP_527 vssd1 vccd1 sky130_fd_sc_hd__tapvpwrvgnd_1
XTAP_538 vssd1 vccd1 sky130_fd_sc_hd__tapvpwrvgnd_1
XTAP_549 vssd1 vccd1 sky130_fd_sc_hd__tapvpwrvgnd_1
X_10259_ _04115_ _04208_ _04207_ vssd1 vssd1 vccd1 vccd1 _04364_ sky130_fd_sc_hd__a21oi_2
XFILLER_0_56_79 vssd1 vssd1 vccd1 vccd1 sky130_fd_sc_hd__decap_4
XFILLER_0_56_68 vssd1 vssd1 vccd1 vccd1 sky130_fd_sc_hd__decap_4
XFILLER_0_88_365 vssd1 vssd1 vccd1 vccd1 sky130_fd_sc_hd__decap_3
XFILLER_0_72_45 vssd1 vssd1 vccd1 vccd1 sky130_fd_sc_hd__decap_6
XFILLER_0_48_229 vssd1 vssd1 vccd1 vccd1 sky130_fd_sc_hd__fill_2
X_07470_ _01561_ _01589_ _01594_ vssd1 vssd1 vccd1 vccd1 _01595_ sky130_fd_sc_hd__and3_1
XFILLER_0_119_629 vssd1 vssd1 vccd1 vccd1 sky130_ef_sc_hd__decap_12
X_06421_ _00715_ _00718_ vssd1 vssd1 vccd1 vccd1 _00725_ sky130_fd_sc_hd__nor2_2
XFILLER_0_118_139 vssd1 vssd1 vccd1 vccd1 sky130_fd_sc_hd__fill_1
X_09140_ _03150_ _03151_ _03250_ _03251_ vssd1 vssd1 vccd1 vccd1 _03252_ sky130_fd_sc_hd__nor4_1
X_06352_ _00636_ _00637_ vssd1 vssd1 vccd1 vccd1 _00664_ sky130_fd_sc_hd__nand2b_2
XFILLER_0_44_413 vssd1 vssd1 vccd1 vccd1 sky130_fd_sc_hd__fill_1
XFILLER_0_29_487 vssd1 vssd1 vccd1 vccd1 sky130_fd_sc_hd__decap_4
XFILLER_0_127_673 vssd1 vssd1 vccd1 vccd1 sky130_ef_sc_hd__decap_12
XFILLER_0_114_301 vssd1 vssd1 vccd1 vccd1 sky130_fd_sc_hd__decap_6
X_09071_ _03168_ _03181_ vssd1 vssd1 vccd1 vccd1 _03183_ sky130_fd_sc_hd__and2_1
XFILLER_0_72_755 vssd1 vssd1 vccd1 vccd1 sky130_fd_sc_hd__fill_1
X_06283_ _00597_ _00598_ vssd1 vssd1 vccd1 vccd1 _00599_ sky130_fd_sc_hd__nor2_4
XFILLER_0_71_265 vssd1 vssd1 vccd1 vccd1 sky130_fd_sc_hd__fill_1
X_08022_ _02139_ _02140_ _02141_ vssd1 vssd1 vccd1 vccd1 _02142_ sky130_fd_sc_hd__nand3_4
XFILLER_0_114_345 vssd1 vssd1 vccd1 vccd1 sky130_ef_sc_hd__decap_12
XFILLER_0_114_389 vssd1 vssd1 vccd1 vccd1 sky130_ef_sc_hd__decap_12
Xmax_cap453 _05065_ vssd1 vssd1 vccd1 vccd1 net453 sky130_fd_sc_hd__clkbuf_2
Xmax_cap464 net465 vssd1 vssd1 vccd1 vccd1 net464 sky130_fd_sc_hd__clkbuf_1
X_09973_ _04076_ _04077_ vssd1 vssd1 vccd1 vccd1 _04079_ sky130_fd_sc_hd__xnor2_1
Xmax_cap486 _04647_ vssd1 vssd1 vccd1 vccd1 net486 sky130_fd_sc_hd__buf_1
X_08924_ net852 net843 net1002 net995 vssd1 vssd1 vccd1 vccd1 _03037_ sky130_fd_sc_hd__and4_1
Xmax_cap497 _01741_ vssd1 vssd1 vccd1 vccd1 net497 sky130_fd_sc_hd__clkbuf_1
Xclkbuf_leaf_44_clk_i clknet_3_0__leaf_clk_i vssd1 vssd1 vccd1 vccd1 clknet_leaf_44_clk_i
+ sky130_fd_sc_hd__clkbuf_16
X_08855_ net1141 net720 _02830_ _02829_ vssd1 vssd1 vccd1 vccd1 _02968_ sky130_fd_sc_hd__a31o_1
X_08786_ _02891_ _02899_ vssd1 vssd1 vccd1 vccd1 _02900_ sky130_fd_sc_hd__and2_1
X_07806_ _01908_ _01925_ _01926_ vssd1 vssd1 vccd1 vccd1 _01928_ sky130_fd_sc_hd__and3_1
X_07737_ net798 _01769_ _01770_ _01767_ vssd1 vssd1 vccd1 vccd1 _01859_ sky130_fd_sc_hd__o2bb2ai_1
XFILLER_0_67_549 vssd1 vssd1 vccd1 vccd1 sky130_fd_sc_hd__fill_1
X_07668_ net1089 net831 vssd1 vssd1 vccd1 vccd1 _01791_ sky130_fd_sc_hd__nand2_1
X_09407_ _03514_ _03515_ _03516_ vssd1 vssd1 vccd1 vccd1 _03517_ sky130_fd_sc_hd__nand3_1
X_07599_ net920 net1018 net912 net1010 vssd1 vssd1 vccd1 vccd1 _01723_ sky130_fd_sc_hd__nand4_1
X_06619_ _00853_ _00854_ vssd1 vssd1 vccd1 vccd1 _00855_ sky130_fd_sc_hd__xnor2_4
X_09338_ net1087 net1094 net738 net732 vssd1 vssd1 vccd1 vccd1 _03448_ sky130_fd_sc_hd__nand4_2
XFILLER_0_124_109 vssd1 vssd1 vccd1 vccd1 sky130_ef_sc_hd__decap_12
XFILLER_0_117_161 vssd1 vssd1 vccd1 vccd1 sky130_fd_sc_hd__decap_6
XFILLER_0_90_585 vssd1 vssd1 vccd1 vccd1 sky130_fd_sc_hd__decap_3
XFILLER_0_62_243 vssd1 vssd1 vccd1 vccd1 sky130_fd_sc_hd__fill_1
X_09269_ net923 net915 net937 net932 vssd1 vssd1 vccd1 vccd1 _03380_ sky130_fd_sc_hd__nand4_2
X_11300_ net1045 net697 net696 net1036 vssd1 vssd1 vccd1 vccd1 _05397_ sky130_fd_sc_hd__and4b_1
XFILLER_0_50_427 vssd1 vssd1 vccd1 vccd1 sky130_fd_sc_hd__fill_2
X_12280_ net1706 _00605_ _06195_ vssd1 vssd1 vccd1 vccd1 _00332_ sky130_fd_sc_hd__a21o_1
XFILLER_0_31_652 vssd1 vssd1 vccd1 vccd1 sky130_fd_sc_hd__fill_1
X_11231_ _05209_ _05214_ _05207_ vssd1 vssd1 vccd1 vccd1 _05328_ sky130_fd_sc_hd__o21ai_1
X_11162_ _05258_ _05259_ _05129_ _05131_ vssd1 vssd1 vccd1 vccd1 _05260_ sky130_fd_sc_hd__o211a_1
X_10113_ _04218_ vssd1 vssd1 vccd1 vccd1 _04219_ sky130_fd_sc_hd__inv_2
X_11093_ _05189_ _05190_ _05060_ _05063_ vssd1 vssd1 vccd1 vccd1 _05192_ sky130_fd_sc_hd__a211o_1
Xhold50 det_t\[14\] vssd1 vssd1 vccd1 vccd1 net1265 sky130_fd_sc_hd__dlygate4sd3_1
X_10044_ _04007_ _04010_ _04147_ _04149_ vssd1 vssd1 vccd1 vccd1 _04150_ sky130_fd_sc_hd__o211ai_1
Xhold83 sub1.a_i\[26\] vssd1 vssd1 vccd1 vccd1 net1298 sky130_fd_sc_hd__dlygate4sd3_1
Xhold72 sub1.a_i\[14\] vssd1 vssd1 vccd1 vccd1 net1287 sky130_fd_sc_hd__dlygate4sd3_1
Xhold61 sub1.b_i\[11\] vssd1 vssd1 vccd1 vccd1 net1276 sky130_fd_sc_hd__dlygate4sd3_1
XFILLER_0_26_27 vssd1 vssd1 vccd1 vccd1 sky130_fd_sc_hd__fill_1
Xhold94 sub1.a_i\[5\] vssd1 vssd1 vccd1 vccd1 net1309 sky130_fd_sc_hd__dlygate4sd3_1
XFILLER_0_58_516 vssd1 vssd1 vccd1 vccd1 sky130_ef_sc_hd__decap_12
X_11995_ net17 net551 net626 net201 _06000_ vssd1 vssd1 vccd1 vccd1 _06001_ sky130_fd_sc_hd__a221o_1
XFILLER_0_85_335 vssd1 vssd1 vccd1 vccd1 sky130_fd_sc_hd__fill_1
X_10946_ net1030 net718 _05043_ _05044_ vssd1 vssd1 vccd1 vccd1 _05046_ sky130_fd_sc_hd__o2bb2a_1
X_10877_ _04961_ _04975_ vssd1 vssd1 vccd1 vccd1 _04977_ sky130_fd_sc_hd__xnor2_1
X_12616_ clknet_leaf_23_clk_i _00002_ net1170 vssd1 vssd1 vccd1 vccd1 net251 sky130_fd_sc_hd__dfrtp_4
XFILLER_0_109_673 vssd1 vssd1 vccd1 vccd1 sky130_ef_sc_hd__decap_12
XFILLER_0_54_755 vssd1 vssd1 vccd1 vccd1 sky130_fd_sc_hd__fill_1
XFILLER_0_53_210 vssd1 vssd1 vccd1 vccd1 sky130_fd_sc_hd__fill_1
X_12547_ net451 net569 _06270_ vssd1 vssd1 vccd1 vccd1 _00524_ sky130_fd_sc_hd__a21oi_1
XFILLER_0_124_643 vssd1 vssd1 vccd1 vccd1 sky130_fd_sc_hd__fill_1
XFILLER_0_53_254 vssd1 vssd1 vccd1 vccd1 sky130_fd_sc_hd__fill_2
XFILLER_0_13_107 vssd1 vssd1 vccd1 vccd1 sky130_fd_sc_hd__decap_4
XANTENNA_3 _00699_ vssd1 vssd1 vccd1 vccd1 sky130_fd_sc_hd__diode_2
X_12478_ _00970_ net618 _05671_ net577 vssd1 vssd1 vccd1 vccd1 _06235_ sky130_fd_sc_hd__a22o_1
XFILLER_0_6_15 vssd1 vssd1 vccd1 vccd1 sky130_ef_sc_hd__decap_12
X_11429_ _05345_ _05347_ vssd1 vssd1 vccd1 vccd1 _05525_ sky130_fd_sc_hd__or2_1
XFILLER_0_111_337 vssd1 vssd1 vccd1 vccd1 sky130_ef_sc_hd__decap_12
XFILLER_0_10_825 vssd1 vssd1 vccd1 vccd1 sky130_ef_sc_hd__decap_12
XTAP_324 vssd1 vccd1 sky130_fd_sc_hd__tapvpwrvgnd_1
XTAP_313 vssd1 vccd1 sky130_fd_sc_hd__tapvpwrvgnd_1
XTAP_302 vssd1 vccd1 sky130_fd_sc_hd__tapvpwrvgnd_1
XFILLER_0_21_195 vssd1 vssd1 vccd1 vccd1 sky130_fd_sc_hd__fill_1
XTAP_357 vssd1 vccd1 sky130_fd_sc_hd__tapvpwrvgnd_1
XTAP_346 vssd1 vccd1 sky130_fd_sc_hd__tapvpwrvgnd_1
XTAP_335 vssd1 vccd1 sky130_fd_sc_hd__tapvpwrvgnd_1
X_06970_ _01093_ _01094_ vssd1 vssd1 vccd1 vccd1 _01095_ sky130_fd_sc_hd__nor2_1
XTAP_379 vssd1 vccd1 sky130_fd_sc_hd__tapvpwrvgnd_1
XTAP_368 vssd1 vccd1 sky130_fd_sc_hd__tapvpwrvgnd_1
Xfanout1092 mul1.a\[7\] vssd1 vssd1 vccd1 vccd1 net1092 sky130_fd_sc_hd__clkbuf_4
X_08640_ _02736_ _02752_ _02753_ vssd1 vssd1 vccd1 vccd1 _02755_ sky130_fd_sc_hd__and3_1
Xfanout1070 net1071 vssd1 vssd1 vccd1 vccd1 net1070 sky130_fd_sc_hd__clkbuf_4
Xfanout1081 net1082 vssd1 vssd1 vccd1 vccd1 net1081 sky130_fd_sc_hd__clkbuf_4
XFILLER_0_107_51 vssd1 vssd1 vccd1 vccd1 sky130_fd_sc_hd__decap_4
XFILLER_0_83_55 vssd1 vssd1 vccd1 vccd1 sky130_fd_sc_hd__fill_1
X_08571_ _02549_ _02684_ _02685_ vssd1 vssd1 vccd1 vccd1 _02686_ sky130_fd_sc_hd__and3_1
XFILLER_0_89_685 vssd1 vssd1 vccd1 vccd1 sky130_fd_sc_hd__decap_8
XFILLER_0_49_505 vssd1 vssd1 vccd1 vccd1 sky130_fd_sc_hd__fill_1
XPHY_19 vssd1 vssd1 vccd1 vccd1 sky130_fd_sc_hd__decap_3
X_07522_ net918 net910 net1138 net1145 vssd1 vssd1 vccd1 vccd1 _01647_ sky130_fd_sc_hd__nand4_1
XFILLER_0_76_346 vssd1 vssd1 vccd1 vccd1 sky130_fd_sc_hd__decap_4
X_07453_ _01528_ _01555_ _01570_ vssd1 vssd1 vccd1 vccd1 _01578_ sky130_fd_sc_hd__a21oi_1
X_06404_ _00708_ _00709_ vssd1 vssd1 vccd1 vccd1 _00710_ sky130_fd_sc_hd__or2_2
XFILLER_0_17_402 vssd1 vssd1 vccd1 vccd1 sky130_fd_sc_hd__fill_2
XFILLER_0_106_109 vssd1 vssd1 vccd1 vccd1 sky130_ef_sc_hd__decap_12
X_09123_ _03232_ _03233_ _03234_ vssd1 vssd1 vccd1 vccd1 _03235_ sky130_fd_sc_hd__nand3_2
XFILLER_0_57_593 vssd1 vssd1 vccd1 vccd1 sky130_fd_sc_hd__fill_1
X_07384_ _01506_ _01508_ _01455_ _01463_ vssd1 vssd1 vccd1 vccd1 _01509_ sky130_fd_sc_hd__o211a_1
XFILLER_0_32_92 vssd1 vssd1 vccd1 vccd1 sky130_fd_sc_hd__decap_8
XFILLER_0_96_3 vssd1 vssd1 vccd1 vccd1 sky130_ef_sc_hd__decap_12
X_06335_ add1.a_i\[2\] add1.b_i\[2\] vssd1 vssd1 vccd1 vccd1 _00647_ sky130_fd_sc_hd__or2_1
XFILLER_0_5_841 vssd1 vssd1 vccd1 vccd1 sky130_fd_sc_hd__fill_1
XFILLER_0_115_665 vssd1 vssd1 vccd1 vccd1 sky130_fd_sc_hd__decap_6
XFILLER_0_114_153 vssd1 vssd1 vccd1 vccd1 sky130_ef_sc_hd__decap_12
X_09054_ _03157_ _03165_ vssd1 vssd1 vccd1 vccd1 _03166_ sky130_fd_sc_hd__nand2_1
XFILLER_0_130_613 vssd1 vssd1 vccd1 vccd1 sky130_fd_sc_hd__decap_3
X_08005_ _02115_ _02123_ vssd1 vssd1 vccd1 vccd1 _02125_ sky130_fd_sc_hd__xor2_2
Xhold520 mul1.b\[1\] vssd1 vssd1 vccd1 vccd1 net1735 sky130_fd_sc_hd__dlygate4sd3_1
XFILLER_0_130_657 vssd1 vssd1 vccd1 vccd1 sky130_fd_sc_hd__decap_3
XFILLER_0_114_197 vssd1 vssd1 vccd1 vccd1 sky130_ef_sc_hd__decap_12
XFILLER_0_102_337 vssd1 vssd1 vccd1 vccd1 sky130_fd_sc_hd__fill_1
X_09956_ _03747_ _03900_ _03901_ vssd1 vssd1 vccd1 vccd1 _04063_ sky130_fd_sc_hd__a21o_1
X_08907_ _02867_ _02875_ _02874_ vssd1 vssd1 vccd1 vccd1 _03020_ sky130_fd_sc_hd__a21o_1
X_09887_ net827 net819 net985 vssd1 vssd1 vccd1 vccd1 _03994_ sky130_fd_sc_hd__and3_1
XTAP_880 vssd1 vccd1 sky130_fd_sc_hd__tapvpwrvgnd_1
X_08838_ _02849_ _02850_ _02949_ _02950_ vssd1 vssd1 vccd1 vccd1 _02952_ sky130_fd_sc_hd__o22a_1
XTAP_891 vssd1 vccd1 sky130_fd_sc_hd__tapvpwrvgnd_1
X_08769_ _02880_ _02881_ _02752_ _02756_ vssd1 vssd1 vccd1 vccd1 _02883_ sky130_fd_sc_hd__o211ai_4
X_10800_ _04754_ _04755_ vssd1 vssd1 vccd1 vccd1 _04901_ sky130_fd_sc_hd__or2_1
XFILLER_0_67_335 vssd1 vssd1 vccd1 vccd1 sky130_fd_sc_hd__fill_1
XFILLER_0_67_302 vssd1 vssd1 vccd1 vccd1 sky130_fd_sc_hd__fill_1
X_11780_ net222 net599 net579 net126 _05827_ vssd1 vssd1 vccd1 vccd1 _05828_ sky130_fd_sc_hd__a221o_1
X_10731_ net816 net948 net943 net824 vssd1 vssd1 vccd1 vccd1 _04832_ sky130_fd_sc_hd__a22o_1
XFILLER_0_83_839 vssd1 vssd1 vccd1 vccd1 sky130_fd_sc_hd__fill_1
XFILLER_0_82_305 vssd1 vssd1 vccd1 vccd1 sky130_fd_sc_hd__decap_3
XFILLER_0_67_379 vssd1 vssd1 vccd1 vccd1 sky130_fd_sc_hd__fill_1
XFILLER_0_125_429 vssd1 vssd1 vccd1 vccd1 sky130_ef_sc_hd__decap_12
X_10662_ _04760_ _04763_ vssd1 vssd1 vccd1 vccd1 _04764_ sky130_fd_sc_hd__and2b_1
XFILLER_0_12_29 vssd1 vssd1 vccd1 vccd1 sky130_ef_sc_hd__decap_12
X_12401_ net1593 _00935_ net686 vssd1 vssd1 vccd1 vccd1 _00453_ sky130_fd_sc_hd__mux2_1
XFILLER_0_35_232 vssd1 vssd1 vccd1 vccd1 sky130_fd_sc_hd__decap_3
XFILLER_0_106_610 vssd1 vssd1 vccd1 vccd1 sky130_ef_sc_hd__decap_12
X_10593_ _04552_ _04553_ vssd1 vssd1 vccd1 vccd1 _04695_ sky130_fd_sc_hd__nand2_1
XFILLER_0_63_585 vssd1 vssd1 vccd1 vccd1 sky130_fd_sc_hd__decap_3
X_12332_ net1654 _00908_ net669 vssd1 vssd1 vccd1 vccd1 _00384_ sky130_fd_sc_hd__mux2_1
X_12263_ net1623 net40 net689 vssd1 vssd1 vccd1 vccd1 _00317_ sky130_fd_sc_hd__mux2_1
XFILLER_0_106_698 vssd1 vssd1 vccd1 vccd1 sky130_fd_sc_hd__fill_2
XFILLER_0_106_687 vssd1 vssd1 vccd1 vccd1 sky130_fd_sc_hd__fill_2
XFILLER_0_23_449 vssd1 vssd1 vccd1 vccd1 sky130_fd_sc_hd__decap_4
X_11214_ _05309_ _05310_ _05182_ _05184_ vssd1 vssd1 vccd1 vccd1 _05312_ sky130_fd_sc_hd__o211a_1
X_12194_ net853 _06149_ net514 vssd1 vssd1 vccd1 vccd1 _00292_ sky130_fd_sc_hd__mux2_1
XFILLER_0_120_189 vssd1 vssd1 vccd1 vccd1 sky130_fd_sc_hd__decap_6
XFILLER_0_101_381 vssd1 vssd1 vccd1 vccd1 sky130_fd_sc_hd__decap_8
X_11145_ _05084_ _05086_ _05083_ vssd1 vssd1 vccd1 vccd1 _05243_ sky130_fd_sc_hd__o21ba_1
XFILLER_0_37_15 vssd1 vssd1 vccd1 vccd1 sky130_fd_sc_hd__decap_6
X_11076_ _05047_ _05050_ _05172_ _05174_ vssd1 vssd1 vccd1 vccd1 _05175_ sky130_fd_sc_hd__a211o_1
X_10027_ net811 net991 _03993_ _03994_ net977 vssd1 vssd1 vccd1 vccd1 _04133_ sky130_fd_sc_hd__a32o_1
Xinput151 v1x[7] vssd1 vssd1 vccd1 vccd1 net151 sky130_fd_sc_hd__buf_1
Xinput140 v1x[26] vssd1 vssd1 vccd1 vccd1 net140 sky130_fd_sc_hd__buf_1
Xinput162 v1y[17] vssd1 vssd1 vccd1 vccd1 net162 sky130_fd_sc_hd__clkbuf_1
Xinput184 v1y[8] vssd1 vssd1 vccd1 vccd1 net184 sky130_fd_sc_hd__clkbuf_1
Xinput173 v1y[27] vssd1 vssd1 vccd1 vccd1 net173 sky130_fd_sc_hd__clkbuf_1
Xinput195 v2x[18] vssd1 vssd1 vccd1 vccd1 net195 sky130_fd_sc_hd__buf_1
XFILLER_0_129_702 vssd1 vssd1 vccd1 vccd1 sky130_fd_sc_hd__fill_2
XFILLER_0_85_110 vssd1 vssd1 vccd1 vccd1 sky130_fd_sc_hd__fill_2
X_11978_ net100 net622 net596 net68 vssd1 vssd1 vccd1 vccd1 _05988_ sky130_fd_sc_hd__a22o_1
X_10929_ net1064 net703 _04897_ _04896_ vssd1 vssd1 vccd1 vccd1 _05029_ sky130_fd_sc_hd__a31o_1
XFILLER_0_27_722 vssd1 vssd1 vccd1 vccd1 sky130_fd_sc_hd__fill_1
XPHY_190 vssd1 vssd1 vccd1 vccd1 sky130_fd_sc_hd__decap_3
XFILLER_0_81_393 vssd1 vssd1 vccd1 vccd1 sky130_ef_sc_hd__decap_12
XFILLER_0_81_360 vssd1 vssd1 vccd1 vccd1 sky130_fd_sc_hd__decap_8
XFILLER_0_112_613 vssd1 vssd1 vccd1 vccd1 sky130_ef_sc_hd__decap_12
XFILLER_0_112_657 vssd1 vssd1 vccd1 vccd1 sky130_ef_sc_hd__decap_12
XFILLER_0_111_167 vssd1 vssd1 vccd1 vccd1 sky130_fd_sc_hd__fill_1
XFILLER_0_100_819 vssd1 vssd1 vccd1 vccd1 sky130_fd_sc_hd__fill_1
X_09810_ _03915_ _03916_ vssd1 vssd1 vccd1 vccd1 _03917_ sky130_fd_sc_hd__and2b_1
X_09741_ _03835_ _03847_ _03848_ vssd1 vssd1 vccd1 vccd1 _03849_ sky130_fd_sc_hd__and3_1
X_06953_ _01074_ _01075_ _01076_ vssd1 vssd1 vccd1 vccd1 _01078_ sky130_fd_sc_hd__o21ai_1
XFILLER_0_94_65 vssd1 vssd1 vccd1 vccd1 sky130_ef_sc_hd__decap_12
XFILLER_0_118_83 vssd1 vssd1 vccd1 vccd1 sky130_fd_sc_hd__fill_1
X_09672_ _03779_ _03778_ _03777_ vssd1 vssd1 vccd1 vccd1 _03780_ sky130_fd_sc_hd__nand3b_2
X_06884_ last _00802_ net686 _00782_ _00975_ vssd1 vssd1 vccd1 vccd1 _01011_ sky130_fd_sc_hd__a221o_1
XFILLER_0_96_419 vssd1 vssd1 vccd1 vccd1 sky130_fd_sc_hd__fill_1
X_08623_ net1034 net823 net815 net1043 vssd1 vssd1 vccd1 vccd1 _02738_ sky130_fd_sc_hd__a22o_1
XFILLER_0_89_493 vssd1 vssd1 vccd1 vccd1 sky130_fd_sc_hd__fill_2
XTAP_1309 vssd1 vccd1 sky130_fd_sc_hd__tapvpwrvgnd_1
X_08554_ _02545_ _02668_ vssd1 vssd1 vccd1 vccd1 _02670_ sky130_fd_sc_hd__xnor2_2
XFILLER_0_11_3 vssd1 vssd1 vccd1 vccd1 sky130_ef_sc_hd__decap_12
X_07505_ _01626_ _01629_ vssd1 vssd1 vccd1 vccd1 _01630_ sky130_fd_sc_hd__and2b_1
XFILLER_0_119_223 vssd1 vssd1 vccd1 vccd1 sky130_fd_sc_hd__fill_1
X_08485_ net823 _02600_ _02599_ vssd1 vssd1 vccd1 vccd1 _02601_ sky130_fd_sc_hd__a21bo_1
XFILLER_0_76_165 vssd1 vssd1 vccd1 vccd1 sky130_fd_sc_hd__fill_1
XFILLER_0_64_305 vssd1 vssd1 vccd1 vccd1 sky130_fd_sc_hd__decap_3
XFILLER_0_9_421 vssd1 vssd1 vccd1 vccd1 sky130_fd_sc_hd__fill_2
XFILLER_0_91_113 vssd1 vssd1 vccd1 vccd1 sky130_fd_sc_hd__fill_2
XFILLER_0_17_221 vssd1 vssd1 vccd1 vccd1 sky130_fd_sc_hd__decap_3
X_07436_ net904 net1119 _01558_ _01559_ vssd1 vssd1 vccd1 vccd1 _01561_ sky130_fd_sc_hd__nand4_1
XFILLER_0_91_157 vssd1 vssd1 vccd1 vccd1 sky130_fd_sc_hd__decap_3
XFILLER_0_45_541 vssd1 vssd1 vccd1 vccd1 sky130_fd_sc_hd__decap_8
X_07367_ _01486_ _01491_ vssd1 vssd1 vccd1 vccd1 _01492_ sky130_fd_sc_hd__and2_1
X_09106_ _03209_ _03217_ vssd1 vssd1 vccd1 vccd1 _03218_ sky130_fd_sc_hd__xor2_2
X_06318_ add1.a_i\[9\] add1.b_i\[9\] vssd1 vssd1 vccd1 vccd1 _00630_ sky130_fd_sc_hd__nand2_1
XFILLER_0_45_596 vssd1 vssd1 vccd1 vccd1 sky130_ef_sc_hd__decap_12
XFILLER_0_115_473 vssd1 vssd1 vccd1 vccd1 sky130_ef_sc_hd__decap_12
X_09037_ _03145_ _03146_ _03025_ _03029_ vssd1 vssd1 vccd1 vccd1 _03149_ sky130_fd_sc_hd__o211a_1
XFILLER_0_60_544 vssd1 vssd1 vccd1 vccd1 sky130_fd_sc_hd__fill_1
X_07298_ _01416_ _01421_ _01422_ vssd1 vssd1 vccd1 vccd1 _01423_ sky130_fd_sc_hd__nand3_1
XFILLER_0_103_668 vssd1 vssd1 vccd1 vccd1 sky130_fd_sc_hd__decap_4
Xhold361 posx\[6\] vssd1 vssd1 vccd1 vccd1 net1576 sky130_fd_sc_hd__dlygate4sd3_1
Xhold350 y2my0\[6\] vssd1 vssd1 vccd1 vccd1 net1565 sky130_fd_sc_hd__dlygate4sd3_1
Xhold383 net420 vssd1 vssd1 vccd1 vccd1 net1598 sky130_fd_sc_hd__dlygate4sd3_1
Xhold372 sub1.a_i\[8\] vssd1 vssd1 vccd1 vccd1 net1587 sky130_fd_sc_hd__dlygate4sd3_1
Xhold394 add1.a_i\[2\] vssd1 vssd1 vccd1 vccd1 net1609 sky130_fd_sc_hd__dlygate4sd3_1
Xfanout852 net853 vssd1 vssd1 vccd1 vccd1 net852 sky130_fd_sc_hd__clkbuf_4
Xfanout841 net844 vssd1 vssd1 vccd1 vccd1 net841 sky130_fd_sc_hd__buf_4
Xfanout830 mul1.b\[11\] vssd1 vssd1 vccd1 vccd1 net830 sky130_fd_sc_hd__dlymetal6s2s_1
X_09939_ _04043_ _04044_ vssd1 vssd1 vccd1 vccd1 _04046_ sky130_fd_sc_hd__xor2_4
Xfanout885 net886 vssd1 vssd1 vccd1 vccd1 net885 sky130_fd_sc_hd__buf_2
Xfanout874 net875 vssd1 vssd1 vccd1 vccd1 net874 sky130_fd_sc_hd__clkbuf_2
Xfanout863 net866 vssd1 vssd1 vccd1 vccd1 net863 sky130_fd_sc_hd__clkbuf_2
X_12950_ clknet_leaf_50_clk_i _00336_ net1152 vssd1 vssd1 vccd1 vccd1 y1my2\[3\] sky130_fd_sc_hd__dfrtp_1
Xfanout896 net897 vssd1 vssd1 vccd1 vccd1 net896 sky130_fd_sc_hd__clkbuf_4
XFILLER_0_99_279 vssd1 vssd1 vccd1 vccd1 sky130_fd_sc_hd__fill_1
X_11901_ _00987_ _00988_ net661 vssd1 vssd1 vccd1 vccd1 _05930_ sky130_fd_sc_hd__nor3_4
X_12881_ clknet_leaf_46_clk_i _00267_ vssd1 vssd1 vccd1 vccd1 mul1.a\[16\] sky130_fd_sc_hd__dfxtp_1
X_11832_ net43 net687 net678 net71 vssd1 vssd1 vccd1 vccd1 _05872_ sky130_fd_sc_hd__a22o_1
XTAP_1843 vssd1 vccd1 sky130_fd_sc_hd__tapvpwrvgnd_1
XTAP_1832 vssd1 vccd1 sky130_fd_sc_hd__tapvpwrvgnd_1
XTAP_1821 vssd1 vccd1 sky130_fd_sc_hd__tapvpwrvgnd_1
XTAP_1810 vssd1 vccd1 sky130_fd_sc_hd__tapvpwrvgnd_1
XTAP_1865 vssd1 vccd1 sky130_fd_sc_hd__tapvpwrvgnd_1
XTAP_1876 vssd1 vccd1 sky130_fd_sc_hd__tapvpwrvgnd_1
XTAP_1854 vssd1 vccd1 sky130_fd_sc_hd__tapvpwrvgnd_1
X_11763_ net652 _00862_ net474 _05813_ vssd1 vssd1 vccd1 vccd1 _05814_ sky130_fd_sc_hd__a211o_1
XFILLER_0_23_39 vssd1 vssd1 vccd1 vccd1 sky130_ef_sc_hd__decap_12
XTAP_1898 vssd1 vccd1 sky130_fd_sc_hd__tapvpwrvgnd_1
XTAP_1887 vssd1 vccd1 sky130_fd_sc_hd__tapvpwrvgnd_1
X_10714_ _04666_ _04808_ _04809_ _04668_ vssd1 vssd1 vccd1 vccd1 _04815_ sky130_fd_sc_hd__or4b_4
X_11694_ net1320 _05750_ _05755_ vssd1 vssd1 vccd1 vccd1 _00186_ sky130_fd_sc_hd__mux2_1
XFILLER_0_126_749 vssd1 vssd1 vccd1 vccd1 sky130_fd_sc_hd__decap_6
XFILLER_0_82_168 vssd1 vssd1 vccd1 vccd1 sky130_fd_sc_hd__decap_8
X_10645_ _04707_ _04708_ _04744_ _04745_ vssd1 vssd1 vccd1 vccd1 _04747_ sky130_fd_sc_hd__a22o_1
XFILLER_0_130_29 vssd1 vssd1 vccd1 vccd1 sky130_fd_sc_hd__decap_8
XFILLER_0_125_259 vssd1 vssd1 vccd1 vccd1 sky130_fd_sc_hd__fill_2
X_10576_ _04676_ _04677_ vssd1 vssd1 vccd1 vccd1 _04678_ sky130_fd_sc_hd__nand2_1
X_12315_ net1655 _00818_ net667 vssd1 vssd1 vccd1 vccd1 _00367_ sky130_fd_sc_hd__mux2_1
X_12246_ x2mx1\[27\] net605 net588 temp1\[27\] vssd1 vssd1 vccd1 vccd1 _06184_ sky130_fd_sc_hd__a22o_1
X_12177_ x2mx1\[4\] net602 net582 temp1\[4\] vssd1 vssd1 vccd1 vccd1 _06138_ sky130_fd_sc_hd__a22o_1
X_11128_ _05225_ vssd1 vssd1 vccd1 vccd1 _05226_ sky130_fd_sc_hd__inv_2
XFILLER_0_3_27 vssd1 vssd1 vccd1 vccd1 sky130_ef_sc_hd__decap_12
X_11059_ _05030_ _05035_ _05156_ vssd1 vssd1 vccd1 vccd1 _05158_ sky130_fd_sc_hd__or3_1
XFILLER_0_64_79 vssd1 vssd1 vccd1 vccd1 sky130_fd_sc_hd__decap_4
XFILLER_0_86_452 vssd1 vssd1 vccd1 vccd1 sky130_fd_sc_hd__decap_8
XFILLER_0_104_41 vssd1 vssd1 vccd1 vccd1 sky130_ef_sc_hd__decap_12
X_08270_ _02383_ _02385_ _02261_ net493 vssd1 vssd1 vccd1 vccd1 _02388_ sky130_fd_sc_hd__a211o_1
XFILLER_0_73_113 vssd1 vssd1 vccd1 vccd1 sky130_fd_sc_hd__fill_2
XFILLER_0_39_390 vssd1 vssd1 vccd1 vccd1 sky130_fd_sc_hd__fill_2
XFILLER_0_117_749 vssd1 vssd1 vccd1 vccd1 sky130_fd_sc_hd__fill_1
XFILLER_0_104_85 vssd1 vssd1 vccd1 vccd1 sky130_ef_sc_hd__decap_12
X_07221_ net1089 net847 net838 net1096 vssd1 vssd1 vccd1 vccd1 _01346_ sky130_fd_sc_hd__a22oi_1
X_07152_ net919 net1074 net1082 net910 vssd1 vssd1 vccd1 vccd1 _01277_ sky130_fd_sc_hd__a22o_1
XFILLER_0_81_190 vssd1 vssd1 vccd1 vccd1 sky130_fd_sc_hd__fill_1
XFILLER_0_112_421 vssd1 vssd1 vccd1 vccd1 sky130_ef_sc_hd__decap_12
Xoutput411 net411 vssd1 vssd1 vccd1 vccd1 mstream_o[65] sky130_fd_sc_hd__clkbuf_4
Xoutput400 net400 vssd1 vssd1 vccd1 vccd1 mstream_o[55] sky130_fd_sc_hd__clkbuf_4
X_07083_ _01205_ _01206_ _01204_ vssd1 vssd1 vccd1 vccd1 _01208_ sky130_fd_sc_hd__a21o_1
Xoutput444 net444 vssd1 vssd1 vccd1 vccd1 mstream_o[95] sky130_fd_sc_hd__clkbuf_4
Xoutput433 net433 vssd1 vssd1 vccd1 vccd1 mstream_o[85] sky130_fd_sc_hd__clkbuf_4
Xoutput422 net422 vssd1 vssd1 vccd1 vccd1 mstream_o[75] sky130_fd_sc_hd__clkbuf_4
XFILLER_0_59_3 vssd1 vssd1 vccd1 vccd1 sky130_fd_sc_hd__fill_2
X_07985_ _01992_ _01994_ vssd1 vssd1 vccd1 vccd1 _02105_ sky130_fd_sc_hd__or2_1
X_09724_ _03830_ _03831_ _03798_ vssd1 vssd1 vccd1 vccd1 _03832_ sky130_fd_sc_hd__a21oi_1
X_06936_ _01055_ _01060_ vssd1 vssd1 vccd1 vccd1 _01061_ sky130_fd_sc_hd__nand2_1
X_09655_ net1125 net700 net693 net1134 vssd1 vssd1 vccd1 vccd1 _03763_ sky130_fd_sc_hd__o2bb2a_1
XFILLER_0_97_717 vssd1 vssd1 vccd1 vccd1 sky130_fd_sc_hd__decap_8
X_06867_ _00616_ _00976_ vssd1 vssd1 vccd1 vccd1 _00996_ sky130_fd_sc_hd__nor2_4
XFILLER_0_96_216 vssd1 vssd1 vccd1 vccd1 sky130_fd_sc_hd__decap_3
XFILLER_0_96_205 vssd1 vssd1 vccd1 vccd1 sky130_fd_sc_hd__fill_2
X_08606_ _02717_ _02718_ _02719_ vssd1 vssd1 vccd1 vccd1 _02721_ sky130_fd_sc_hd__a21bo_1
X_06798_ net1502 net1388 net642 vssd1 vssd1 vccd1 vccd1 _00072_ sky130_fd_sc_hd__mux2_1
X_09586_ net892 net944 _03536_ _03537_ net939 vssd1 vssd1 vccd1 vccd1 _03695_ sky130_fd_sc_hd__a32o_1
XTAP_1128 vssd1 vccd1 sky130_fd_sc_hd__tapvpwrvgnd_1
XTAP_1117 vssd1 vccd1 sky130_fd_sc_hd__tapvpwrvgnd_1
XTAP_1106 vssd1 vccd1 sky130_fd_sc_hd__tapvpwrvgnd_1
X_08537_ _02616_ _02649_ _02650_ vssd1 vssd1 vccd1 vccd1 _02653_ sky130_fd_sc_hd__or3_1
XTAP_1139 vssd1 vccd1 sky130_fd_sc_hd__tapvpwrvgnd_1
XFILLER_0_49_165 vssd1 vssd1 vccd1 vccd1 sky130_fd_sc_hd__decap_3
X_08468_ _02582_ _02583_ _02575_ vssd1 vssd1 vccd1 vccd1 _02584_ sky130_fd_sc_hd__a21o_1
XFILLER_0_77_485 vssd1 vssd1 vccd1 vccd1 sky130_fd_sc_hd__decap_3
X_07419_ _01541_ _01542_ vssd1 vssd1 vccd1 vccd1 _01544_ sky130_fd_sc_hd__xnor2_1
XFILLER_0_18_530 vssd1 vssd1 vccd1 vccd1 sky130_fd_sc_hd__fill_2
X_08399_ _02496_ _02513_ _02514_ vssd1 vssd1 vccd1 vccd1 _02516_ sky130_fd_sc_hd__and3_1
X_10430_ net859 net933 _04531_ _04532_ vssd1 vssd1 vccd1 vccd1 _04533_ sky130_fd_sc_hd__nand4_2
XFILLER_0_18_585 vssd1 vssd1 vccd1 vccd1 sky130_fd_sc_hd__decap_3
XFILLER_0_45_393 vssd1 vssd1 vccd1 vccd1 sky130_fd_sc_hd__decap_4
XFILLER_0_115_281 vssd1 vssd1 vccd1 vccd1 sky130_ef_sc_hd__decap_12
X_10361_ _04444_ _04445_ _04463_ _04464_ vssd1 vssd1 vccd1 vccd1 _04465_ sky130_fd_sc_hd__nor4_1
XFILLER_0_60_363 vssd1 vssd1 vccd1 vccd1 sky130_fd_sc_hd__fill_1
X_10292_ _04391_ _04395_ vssd1 vssd1 vccd1 vccd1 _04396_ sky130_fd_sc_hd__xnor2_2
X_12100_ x0mx2\[16\] net630 net591 y1my2\[16\] vssd1 vssd1 vccd1 vccd1 _06081_ sky130_fd_sc_hd__a22o_1
X_13080_ clknet_leaf_0_clk_i _00466_ vssd1 vssd1 vccd1 vccd1 temp1\[5\] sky130_fd_sc_hd__dfxtp_2
X_12031_ _00994_ _05753_ net534 net1168 vssd1 vssd1 vccd1 vccd1 _06028_ sky130_fd_sc_hd__o31a_1
Xhold180 y2my0\[27\] vssd1 vssd1 vccd1 vccd1 net1395 sky130_fd_sc_hd__dlygate4sd3_1
Xhold191 net402 vssd1 vssd1 vccd1 vccd1 net1406 sky130_fd_sc_hd__dlygate4sd3_1
XFILLER_0_0_3 vssd1 vssd1 vccd1 vccd1 sky130_ef_sc_hd__decap_12
Xfanout660 net664 vssd1 vssd1 vccd1 vccd1 net660 sky130_fd_sc_hd__clkbuf_4
Xfanout693 net694 vssd1 vssd1 vccd1 vccd1 net693 sky130_fd_sc_hd__clkbuf_4
Xfanout682 net684 vssd1 vssd1 vccd1 vccd1 net682 sky130_fd_sc_hd__buf_4
Xfanout671 net673 vssd1 vssd1 vccd1 vccd1 net671 sky130_fd_sc_hd__buf_4
X_12933_ clknet_3_6__leaf_clk_i _00319_ net1192 vssd1 vssd1 vccd1 vccd1 posx\[4\]
+ sky130_fd_sc_hd__dfrtp_1
X_12864_ clknet_leaf_28_clk_i _00250_ vssd1 vssd1 vccd1 vccd1 sub1.b_i\[31\] sky130_fd_sc_hd__dfxtp_1
XTAP_1651 vssd1 vccd1 sky130_fd_sc_hd__tapvpwrvgnd_1
XTAP_1640 vssd1 vccd1 sky130_fd_sc_hd__tapvpwrvgnd_1
X_12795_ clknet_leaf_19_clk_i _00181_ vssd1 vssd1 vccd1 vccd1 add1.b_i\[26\] sky130_fd_sc_hd__dfxtp_1
X_11815_ net163 net471 _05857_ vssd1 vssd1 vccd1 vccd1 _05858_ sky130_fd_sc_hd__o21a_1
XTAP_1684 vssd1 vccd1 sky130_fd_sc_hd__tapvpwrvgnd_1
XTAP_1662 vssd1 vccd1 sky130_fd_sc_hd__tapvpwrvgnd_1
XTAP_1673 vssd1 vccd1 sky130_fd_sc_hd__tapvpwrvgnd_1
XFILLER_0_55_113 vssd1 vssd1 vccd1 vccd1 sky130_fd_sc_hd__decap_8
XFILLER_0_50_15 vssd1 vssd1 vccd1 vccd1 sky130_fd_sc_hd__fill_2
X_11746_ net183 net470 _05799_ vssd1 vssd1 vccd1 vccd1 _05800_ sky130_fd_sc_hd__o21a_1
XTAP_1695 vssd1 vccd1 sky130_fd_sc_hd__tapvpwrvgnd_1
XFILLER_0_83_477 vssd1 vssd1 vccd1 vccd1 sky130_fd_sc_hd__fill_1
XFILLER_0_71_617 vssd1 vssd1 vccd1 vccd1 sky130_fd_sc_hd__decap_6
XFILLER_0_126_557 vssd1 vssd1 vccd1 vccd1 sky130_ef_sc_hd__decap_12
XFILLER_0_50_59 vssd1 vssd1 vccd1 vccd1 sky130_fd_sc_hd__fill_1
X_11677_ net1316 _03420_ net537 vssd1 vssd1 vccd1 vccd1 _00169_ sky130_fd_sc_hd__mux2_1
X_10628_ _04728_ _04729_ net782 net976 vssd1 vssd1 vccd1 vccd1 _04730_ sky130_fd_sc_hd__and4bb_1
XFILLER_0_24_533 vssd1 vssd1 vccd1 vccd1 sky130_fd_sc_hd__decap_4
XFILLER_0_24_555 vssd1 vssd1 vccd1 vccd1 sky130_fd_sc_hd__fill_1
X_10559_ _04528_ _04661_ vssd1 vssd1 vccd1 vccd1 _04662_ sky130_fd_sc_hd__and2_1
XFILLER_0_3_449 vssd1 vssd1 vccd1 vccd1 sky130_fd_sc_hd__decap_3
XFILLER_0_59_57 vssd1 vssd1 vccd1 vccd1 sky130_fd_sc_hd__fill_1
XFILLER_0_121_273 vssd1 vssd1 vccd1 vccd1 sky130_fd_sc_hd__decap_6
X_12229_ _00918_ net511 net468 y1my2\[21\] _06172_ vssd1 vssd1 vccd1 vccd1 _06173_
+ sky130_fd_sc_hd__a221o_1
XFILLER_0_75_45 vssd1 vssd1 vccd1 vccd1 sky130_fd_sc_hd__decap_8
X_07770_ _01890_ _01891_ _01884_ vssd1 vssd1 vccd1 vccd1 _01892_ sky130_fd_sc_hd__a21o_1
X_06721_ net1339 _00940_ net635 vssd1 vssd1 vccd1 vccd1 _00028_ sky130_fd_sc_hd__mux2_1
XFILLER_0_78_205 vssd1 vssd1 vccd1 vccd1 sky130_fd_sc_hd__decap_3
X_09440_ _03377_ _03385_ _03384_ vssd1 vssd1 vccd1 vccd1 _03550_ sky130_fd_sc_hd__a21bo_1
XFILLER_0_91_55 vssd1 vssd1 vccd1 vccd1 sky130_fd_sc_hd__fill_1
X_06652_ net1737 _00882_ net633 vssd1 vssd1 vccd1 vccd1 _00017_ sky130_fd_sc_hd__mux2_1
XFILLER_0_115_51 vssd1 vssd1 vccd1 vccd1 sky130_fd_sc_hd__decap_4
X_09371_ _03478_ _03479_ _03311_ _03313_ vssd1 vssd1 vccd1 vccd1 _03481_ sky130_fd_sc_hd__a211o_1
XFILLER_0_59_474 vssd1 vssd1 vccd1 vccd1 sky130_fd_sc_hd__fill_2
X_06583_ _00819_ _00820_ _00821_ vssd1 vssd1 vccd1 vccd1 _00824_ sky130_fd_sc_hd__a21bo_2
X_08322_ _02438_ _02437_ vssd1 vssd1 vccd1 vccd1 _02439_ sky130_fd_sc_hd__nand2b_1
XFILLER_0_87_794 vssd1 vssd1 vccd1 vccd1 sky130_fd_sc_hd__fill_1
XFILLER_0_47_625 vssd1 vssd1 vccd1 vccd1 sky130_fd_sc_hd__fill_1
X_08253_ _02368_ _02369_ _02370_ vssd1 vssd1 vccd1 vccd1 _02371_ sky130_fd_sc_hd__nand3_2
XFILLER_0_47_669 vssd1 vssd1 vccd1 vccd1 sky130_fd_sc_hd__decap_3
X_07204_ _01243_ _01245_ _01326_ _01328_ vssd1 vssd1 vccd1 vccd1 _01329_ sky130_fd_sc_hd__o211a_1
X_08184_ _02301_ net755 net1122 _02299_ vssd1 vssd1 vccd1 vccd1 _02302_ sky130_fd_sc_hd__and4b_1
XFILLER_0_113_741 vssd1 vssd1 vccd1 vccd1 sky130_ef_sc_hd__decap_12
X_07135_ net1144 net798 _01259_ vssd1 vssd1 vccd1 vccd1 _01260_ sky130_fd_sc_hd__and3_1
XFILLER_0_112_251 vssd1 vssd1 vccd1 vccd1 sky130_fd_sc_hd__fill_1
X_07066_ _01129_ _01131_ _01190_ vssd1 vssd1 vccd1 vccd1 _01191_ sky130_fd_sc_hd__a21o_1
Xoutput252 net252 vssd1 vssd1 vccd1 vccd1 div_mstream_o[0] sky130_fd_sc_hd__clkbuf_4
XFILLER_0_11_750 vssd1 vssd1 vccd1 vccd1 sky130_fd_sc_hd__decap_6
XFILLER_0_11_761 vssd1 vssd1 vccd1 vccd1 sky130_ef_sc_hd__decap_12
Xoutput263 net263 vssd1 vssd1 vccd1 vccd1 div_mstream_o[1] sky130_fd_sc_hd__clkbuf_4
Xoutput285 net285 vssd1 vssd1 vccd1 vccd1 div_mstream_o[3] sky130_fd_sc_hd__clkbuf_4
Xoutput274 net274 vssd1 vssd1 vccd1 vccd1 div_mstream_o[2] sky130_fd_sc_hd__clkbuf_4
Xoutput296 net296 vssd1 vssd1 vccd1 vccd1 div_mstream_o[64] sky130_fd_sc_hd__clkbuf_4
X_07968_ _02085_ _02086_ vssd1 vssd1 vccd1 vccd1 _02088_ sky130_fd_sc_hd__xnor2_1
X_09707_ net809 net1006 _03674_ _03675_ net998 vssd1 vssd1 vccd1 vccd1 _03815_ sky130_fd_sc_hd__a32o_1
X_06919_ net846 net1120 net1126 net837 vssd1 vssd1 vccd1 vccd1 _01044_ sky130_fd_sc_hd__a22o_1
X_07899_ _02018_ _02019_ vssd1 vssd1 vccd1 vccd1 _02020_ sky130_fd_sc_hd__nor2_1
XFILLER_0_97_547 vssd1 vssd1 vccd1 vccd1 sky130_fd_sc_hd__fill_2
X_09638_ _03743_ _03744_ _03746_ vssd1 vssd1 vccd1 vccd1 _03747_ sky130_fd_sc_hd__or3_1
X_09569_ _03676_ _03677_ vssd1 vssd1 vccd1 vccd1 _03678_ sky130_fd_sc_hd__xor2_1
X_12580_ net1470 net26 net561 vssd1 vssd1 vccd1 vccd1 _00556_ sky130_fd_sc_hd__mux2_1
Xclkbuf_3_0__f_clk_i clknet_0_clk_i vssd1 vssd1 vccd1 vccd1 clknet_3_0__leaf_clk_i
+ sky130_fd_sc_hd__clkbuf_16
X_11600_ _05692_ _05693_ vssd1 vssd1 vccd1 vccd1 _05694_ sky130_fd_sc_hd__xnor2_1
XFILLER_0_65_466 vssd1 vssd1 vccd1 vccd1 sky130_fd_sc_hd__decap_3
XFILLER_0_65_455 vssd1 vssd1 vccd1 vccd1 sky130_fd_sc_hd__fill_1
X_11531_ _05624_ _05625_ vssd1 vssd1 vccd1 vccd1 _05626_ sky130_fd_sc_hd__and2_1
XFILLER_0_108_546 vssd1 vssd1 vccd1 vccd1 sky130_fd_sc_hd__fill_2
XFILLER_0_92_263 vssd1 vssd1 vccd1 vccd1 sky130_fd_sc_hd__decap_8
XFILLER_0_65_488 vssd1 vssd1 vccd1 vccd1 sky130_fd_sc_hd__fill_1
XFILLER_0_52_105 vssd1 vssd1 vccd1 vccd1 sky130_fd_sc_hd__decap_4
XFILLER_0_123_505 vssd1 vssd1 vccd1 vccd1 sky130_ef_sc_hd__decap_12
XFILLER_0_92_296 vssd1 vssd1 vccd1 vccd1 sky130_fd_sc_hd__fill_1
XFILLER_0_80_458 vssd1 vssd1 vccd1 vccd1 sky130_fd_sc_hd__fill_1
X_11462_ _05438_ _05442_ _05556_ _05557_ vssd1 vssd1 vccd1 vccd1 _05558_ sky130_fd_sc_hd__a211oi_2
XFILLER_0_45_190 vssd1 vssd1 vccd1 vccd1 sky130_fd_sc_hd__fill_1
XFILLER_0_20_29 vssd1 vssd1 vccd1 vccd1 sky130_ef_sc_hd__decap_12
X_10413_ _04225_ _04366_ _04365_ vssd1 vssd1 vccd1 vccd1 _04517_ sky130_fd_sc_hd__a21boi_2
X_13201_ clknet_leaf_16_clk_i _00587_ net1182 vssd1 vssd1 vccd1 vccd1 l1\[30\] sky130_fd_sc_hd__dfstp_1
X_11393_ _05482_ _05487_ vssd1 vssd1 vccd1 vccd1 _05489_ sky130_fd_sc_hd__xnor2_1
X_13132_ clknet_leaf_3_clk_i _00518_ vssd1 vssd1 vccd1 vccd1 det_t\[25\] sky130_fd_sc_hd__dfxtp_1
X_10344_ net826 net817 net964 vssd1 vssd1 vccd1 vccd1 _04448_ sky130_fd_sc_hd__and3_1
XFILLER_0_21_558 vssd1 vssd1 vccd1 vccd1 sky130_fd_sc_hd__fill_2
X_10275_ _03588_ _04379_ _04378_ vssd1 vssd1 vccd1 vccd1 _04380_ sky130_fd_sc_hd__o21a_2
X_13063_ clknet_leaf_37_clk_i _00449_ net1167 vssd1 vssd1 vccd1 vccd1 y2my0\[20\]
+ sky130_fd_sc_hd__dfrtp_1
XTAP_709 vssd1 vccd1 sky130_fd_sc_hd__tapvpwrvgnd_1
X_12014_ net110 net623 net597 net78 vssd1 vssd1 vccd1 vccd1 _06015_ sky130_fd_sc_hd__a22o_1
Xmax_cap4 _05065_ vssd1 vssd1 vccd1 vccd1 net1745 sky130_fd_sc_hd__dlymetal6s2s_1
X_12916_ clknet_leaf_37_clk_i _00302_ vssd1 vssd1 vccd1 vccd1 mul1.b\[19\] sky130_fd_sc_hd__dfxtp_1
XTAP_2160 vssd1 vccd1 sky130_fd_sc_hd__tapvpwrvgnd_1
XTAP_2171 vssd1 vccd1 sky130_fd_sc_hd__tapvpwrvgnd_1
X_12847_ clknet_leaf_49_clk_i _00233_ vssd1 vssd1 vccd1 vccd1 sub1.b_i\[14\] sky130_fd_sc_hd__dfxtp_1
XTAP_2193 vssd1 vccd1 sky130_fd_sc_hd__tapvpwrvgnd_1
XTAP_2182 vssd1 vccd1 sky130_fd_sc_hd__tapvpwrvgnd_1
XFILLER_0_28_124 vssd1 vssd1 vccd1 vccd1 sky130_ef_sc_hd__decap_12
XFILLER_0_127_833 vssd1 vssd1 vccd1 vccd1 sky130_fd_sc_hd__decap_6
XTAP_1492 vssd1 vccd1 sky130_fd_sc_hd__tapvpwrvgnd_1
XTAP_1470 vssd1 vccd1 sky130_fd_sc_hd__tapvpwrvgnd_1
XTAP_1481 vssd1 vccd1 sky130_fd_sc_hd__tapvpwrvgnd_1
X_12778_ clknet_leaf_58_clk_i _00164_ vssd1 vssd1 vccd1 vccd1 add1.b_i\[9\] sky130_fd_sc_hd__dfxtp_1
XFILLER_0_28_157 vssd1 vssd1 vccd1 vccd1 sky130_ef_sc_hd__decap_12
XFILLER_0_56_477 vssd1 vssd1 vccd1 vccd1 sky130_fd_sc_hd__fill_2
XFILLER_0_9_15 vssd1 vssd1 vccd1 vccd1 sky130_ef_sc_hd__decap_12
X_11729_ net244 net598 net578 net148 _05785_ vssd1 vssd1 vccd1 vccd1 _05786_ sky130_fd_sc_hd__a221o_1
XFILLER_0_126_387 vssd1 vssd1 vccd1 vccd1 sky130_fd_sc_hd__decap_6
XFILLER_0_117_3 vssd1 vssd1 vccd1 vccd1 sky130_ef_sc_hd__decap_12
XFILLER_0_37_691 vssd1 vssd1 vccd1 vccd1 sky130_fd_sc_hd__decap_8
XFILLER_0_24_363 vssd1 vssd1 vccd1 vccd1 sky130_fd_sc_hd__fill_1
X_08940_ net869 net980 net974 net877 vssd1 vssd1 vccd1 vccd1 _03053_ sky130_fd_sc_hd__a22oi_1
X_08871_ _02833_ _02835_ _02979_ _02981_ vssd1 vssd1 vccd1 vccd1 _02984_ sky130_fd_sc_hd__a211o_1
X_07822_ _01844_ _01846_ vssd1 vssd1 vccd1 vccd1 _01944_ sky130_fd_sc_hd__and2b_1
X_07753_ _01801_ _01805_ _01873_ vssd1 vssd1 vccd1 vccd1 _01875_ sky130_fd_sc_hd__a21o_1
XFILLER_0_126_83 vssd1 vssd1 vccd1 vccd1 sky130_fd_sc_hd__fill_1
XFILLER_0_79_558 vssd1 vssd1 vccd1 vccd1 sky130_fd_sc_hd__fill_2
X_07684_ net1050 net873 net864 net1058 vssd1 vssd1 vccd1 vccd1 _01807_ sky130_fd_sc_hd__a22o_1
X_06704_ sub1.b_i\[23\] sub1.a_i\[23\] vssd1 vssd1 vccd1 vccd1 _00926_ sky130_fd_sc_hd__nand2b_2
XFILLER_0_79_569 vssd1 vssd1 vccd1 vccd1 sky130_fd_sc_hd__decap_3
X_09423_ _03531_ _03532_ vssd1 vssd1 vccd1 vccd1 _03533_ sky130_fd_sc_hd__nand2b_1
X_06635_ sub1.b_i\[12\] sub1.a_i\[12\] vssd1 vssd1 vccd1 vccd1 _00868_ sky130_fd_sc_hd__and2b_1
X_09354_ _03442_ _03443_ _03461_ _03462_ vssd1 vssd1 vccd1 vccd1 _03464_ sky130_fd_sc_hd__nor4_1
XFILLER_0_59_260 vssd1 vssd1 vccd1 vccd1 sky130_fd_sc_hd__decap_6
XFILLER_0_19_113 vssd1 vssd1 vccd1 vccd1 sky130_fd_sc_hd__fill_1
XFILLER_0_118_811 vssd1 vssd1 vccd1 vccd1 sky130_fd_sc_hd__fill_1
X_08305_ _02420_ _02421_ vssd1 vssd1 vccd1 vccd1 _02422_ sky130_fd_sc_hd__nor2_2
XFILLER_0_47_444 vssd1 vssd1 vccd1 vccd1 sky130_fd_sc_hd__decap_4
X_06566_ net1722 _00810_ net650 vssd1 vssd1 vccd1 vccd1 _00003_ sky130_fd_sc_hd__mux2_1
X_06497_ det_t\[7\] net527 vssd1 vssd1 vccd1 vccd1 net313 sky130_fd_sc_hd__and2_1
X_09285_ _03359_ _03360_ _03394_ _03395_ vssd1 vssd1 vccd1 vccd1 _03396_ sky130_fd_sc_hd__a2bb2o_1
XFILLER_0_51_80 vssd1 vssd1 vccd1 vccd1 sky130_ef_sc_hd__decap_12
XFILLER_0_19_179 vssd1 vssd1 vccd1 vccd1 sky130_fd_sc_hd__decap_4
XFILLER_0_105_527 vssd1 vssd1 vccd1 vccd1 sky130_ef_sc_hd__decap_12
XFILLER_0_105_505 vssd1 vssd1 vccd1 vccd1 sky130_fd_sc_hd__decap_4
X_08236_ net1024 net857 _02352_ _02353_ vssd1 vssd1 vccd1 vccd1 _02354_ sky130_fd_sc_hd__a22o_1
XFILLER_0_62_458 vssd1 vssd1 vccd1 vccd1 sky130_fd_sc_hd__decap_4
X_08167_ net1736 _02285_ net522 vssd1 vssd1 vccd1 vccd1 _00129_ sky130_fd_sc_hd__mux2_1
X_07118_ net820 net813 net1120 net1129 vssd1 vssd1 vccd1 vccd1 _01243_ sky130_fd_sc_hd__and4_1
X_08098_ net849 _02216_ _02215_ vssd1 vssd1 vccd1 vccd1 _02217_ sky130_fd_sc_hd__a21bo_1
XFILLER_0_100_232 vssd1 vssd1 vccd1 vccd1 sky130_fd_sc_hd__decap_6
X_07049_ _01171_ _01173_ _01121_ _01134_ vssd1 vssd1 vccd1 vccd1 _01174_ sky130_fd_sc_hd__o211a_1
X_10060_ _04163_ _04164_ _04000_ _04001_ vssd1 vssd1 vccd1 vccd1 _04166_ sky130_fd_sc_hd__a211o_1
XFILLER_0_97_333 vssd1 vssd1 vccd1 vccd1 sky130_fd_sc_hd__decap_3
X_10962_ _05058_ _05059_ _04887_ _04890_ vssd1 vssd1 vccd1 vccd1 _05062_ sky130_fd_sc_hd__a211o_1
X_12701_ clknet_leaf_12_clk_i net1402 net1188 vssd1 vssd1 vccd1 vccd1 net432 sky130_fd_sc_hd__dfrtp_1
XFILLER_0_57_208 vssd1 vssd1 vccd1 vccd1 sky130_fd_sc_hd__fill_1
X_10893_ _04991_ _04992_ vssd1 vssd1 vccd1 vccd1 _04993_ sky130_fd_sc_hd__xnor2_1
X_12632_ clknet_leaf_47_clk_i _00018_ net1160 vssd1 vssd1 vccd1 vccd1 net356 sky130_fd_sc_hd__dfrtp_2
XFILLER_0_93_561 vssd1 vssd1 vccd1 vccd1 sky130_fd_sc_hd__fill_1
X_12563_ net1269 net7 net559 vssd1 vssd1 vccd1 vccd1 _00539_ sky130_fd_sc_hd__mux2_1
X_12494_ net1247 net568 vssd1 vssd1 vccd1 vccd1 _06244_ sky130_fd_sc_hd__nor2_1
XFILLER_0_108_365 vssd1 vssd1 vccd1 vccd1 sky130_fd_sc_hd__decap_3
XFILLER_0_80_233 vssd1 vssd1 vccd1 vccd1 sky130_fd_sc_hd__decap_4
XFILLER_0_53_447 vssd1 vssd1 vccd1 vccd1 sky130_fd_sc_hd__fill_1
X_11514_ _05605_ _05606_ _05607_ vssd1 vssd1 vccd1 vccd1 _05609_ sky130_fd_sc_hd__a21oi_1
XFILLER_0_123_324 vssd1 vssd1 vccd1 vccd1 sky130_ef_sc_hd__decap_12
X_11445_ _05523_ _05539_ _05540_ vssd1 vssd1 vccd1 vccd1 _05541_ sky130_fd_sc_hd__or3_2
Xbary_pipe_m_1200 vssd1 vssd1 vccd1 vccd1 bary_pipe_m_1200/HI div_mstream_o[50] sky130_fd_sc_hd__conb_1
Xbary_pipe_m_1211 vssd1 vssd1 vccd1 vccd1 bary_pipe_m_1211/HI div_mstream_o[61] sky130_fd_sc_hd__conb_1
X_11376_ _05471_ vssd1 vssd1 vccd1 vccd1 _05472_ sky130_fd_sc_hd__inv_2
X_13115_ clknet_leaf_2_clk_i _00501_ vssd1 vssd1 vccd1 vccd1 det_t\[8\] sky130_fd_sc_hd__dfxtp_1
X_10327_ _04320_ _04322_ vssd1 vssd1 vccd1 vccd1 _04431_ sky130_fd_sc_hd__nand2_1
XTAP_506 vssd1 vccd1 sky130_fd_sc_hd__tapvpwrvgnd_1
X_10258_ _04271_ _04362_ vssd1 vssd1 vccd1 vccd1 _04363_ sky130_fd_sc_hd__xor2_4
X_13046_ clknet_leaf_50_clk_i _00432_ net1152 vssd1 vssd1 vccd1 vccd1 y2my0\[3\] sky130_fd_sc_hd__dfrtp_1
XTAP_517 vssd1 vccd1 sky130_fd_sc_hd__tapvpwrvgnd_1
XTAP_528 vssd1 vccd1 sky130_fd_sc_hd__tapvpwrvgnd_1
XTAP_539 vssd1 vccd1 sky130_fd_sc_hd__tapvpwrvgnd_1
XFILLER_0_56_25 vssd1 vssd1 vccd1 vccd1 sky130_fd_sc_hd__decap_3
X_10189_ _04288_ _04292_ _04293_ vssd1 vssd1 vccd1 vccd1 _04294_ sky130_fd_sc_hd__nand3_1
X_06420_ _00721_ _00723_ vssd1 vssd1 vccd1 vccd1 _00724_ sky130_fd_sc_hd__nand2_2
XFILLER_0_48_219 vssd1 vssd1 vccd1 vccd1 sky130_fd_sc_hd__decap_3
XFILLER_0_84_550 vssd1 vssd1 vccd1 vccd1 sky130_fd_sc_hd__decap_8
XFILLER_0_72_701 vssd1 vssd1 vccd1 vccd1 sky130_fd_sc_hd__fill_1
X_06351_ add1.a_i\[6\] add1.b_i\[6\] _00637_ _00636_ vssd1 vssd1 vccd1 vccd1 _00663_
+ sky130_fd_sc_hd__a31oi_2
XFILLER_0_112_41 vssd1 vssd1 vccd1 vccd1 sky130_ef_sc_hd__decap_12
X_09070_ _03168_ _03181_ vssd1 vssd1 vccd1 vccd1 _03182_ sky130_fd_sc_hd__or2_1
XFILLER_0_71_222 vssd1 vssd1 vccd1 vccd1 sky130_fd_sc_hd__fill_2
X_06282_ net1151 net1150 vssd1 vssd1 vccd1 vccd1 _00598_ sky130_fd_sc_hd__nand2b_2
XFILLER_0_112_85 vssd1 vssd1 vccd1 vccd1 sky130_ef_sc_hd__decap_12
X_08021_ _02021_ _02029_ _02028_ vssd1 vssd1 vccd1 vccd1 _02141_ sky130_fd_sc_hd__a21bo_1
XFILLER_0_130_817 vssd1 vssd1 vccd1 vccd1 sky130_ef_sc_hd__decap_12
XFILLER_0_114_357 vssd1 vssd1 vccd1 vccd1 sky130_fd_sc_hd__decap_6
XFILLER_0_24_171 vssd1 vssd1 vccd1 vccd1 sky130_fd_sc_hd__fill_1
Xmax_cap454 net1746 vssd1 vssd1 vccd1 vccd1 net454 sky130_fd_sc_hd__buf_1
Xmax_cap487 _03630_ vssd1 vssd1 vccd1 vccd1 net487 sky130_fd_sc_hd__buf_1
Xmax_cap465 _02988_ vssd1 vssd1 vccd1 vccd1 net465 sky130_fd_sc_hd__clkbuf_1
X_09972_ _04076_ _04077_ vssd1 vssd1 vccd1 vccd1 _04078_ sky130_fd_sc_hd__and2b_1
XFILLER_0_40_686 vssd1 vssd1 vccd1 vccd1 sky130_fd_sc_hd__fill_1
X_08923_ net843 net1002 net995 net852 vssd1 vssd1 vccd1 vccd1 _03036_ sky130_fd_sc_hd__a22oi_1
XFILLER_0_0_783 vssd1 vssd1 vccd1 vccd1 sky130_fd_sc_hd__fill_1
Xmax_cap498 _01140_ vssd1 vssd1 vccd1 vccd1 net498 sky130_fd_sc_hd__clkbuf_1
XFILLER_0_41_3 vssd1 vssd1 vccd1 vccd1 sky130_ef_sc_hd__decap_12
X_08854_ _02966_ vssd1 vssd1 vccd1 vccd1 _02967_ sky130_fd_sc_hd__inv_2
X_08785_ _02896_ _02897_ vssd1 vssd1 vccd1 vccd1 _02899_ sky130_fd_sc_hd__xor2_1
X_07805_ _01925_ _01926_ _01908_ vssd1 vssd1 vccd1 vccd1 _01927_ sky130_fd_sc_hd__a21oi_2
X_07736_ _01856_ _01857_ vssd1 vssd1 vccd1 vccd1 _01858_ sky130_fd_sc_hd__nand2_1
XFILLER_0_46_80 vssd1 vssd1 vccd1 vccd1 sky130_fd_sc_hd__decap_4
X_07667_ _01785_ _01789_ vssd1 vssd1 vccd1 vccd1 _01790_ sky130_fd_sc_hd__xor2_1
X_09406_ _03348_ _03350_ _03349_ vssd1 vssd1 vccd1 vccd1 _03516_ sky130_fd_sc_hd__a21bo_1
X_07598_ net1018 net912 net1010 net920 vssd1 vssd1 vccd1 vccd1 _01722_ sky130_fd_sc_hd__a22o_1
X_06618_ _00849_ _00851_ _00848_ vssd1 vssd1 vccd1 vccd1 _00854_ sky130_fd_sc_hd__a21oi_2
X_06549_ net545 _00798_ vssd1 vssd1 vccd1 vccd1 net308 sky130_fd_sc_hd__nor2_1
X_09337_ net1087 net738 net732 net1094 vssd1 vssd1 vccd1 vccd1 _03447_ sky130_fd_sc_hd__a22o_1
XFILLER_0_75_561 vssd1 vssd1 vccd1 vccd1 sky130_ef_sc_hd__decap_12
XFILLER_0_63_701 vssd1 vssd1 vccd1 vccd1 sky130_fd_sc_hd__decap_4
XFILLER_0_90_531 vssd1 vssd1 vccd1 vccd1 sky130_fd_sc_hd__fill_1
XFILLER_0_63_756 vssd1 vssd1 vccd1 vccd1 sky130_fd_sc_hd__decap_4
X_09268_ net915 net937 net932 net923 vssd1 vssd1 vccd1 vccd1 _03379_ sky130_fd_sc_hd__a22o_1
XFILLER_0_105_335 vssd1 vssd1 vccd1 vccd1 sky130_fd_sc_hd__fill_1
X_08219_ net1033 net849 net840 net1043 vssd1 vssd1 vccd1 vccd1 _02337_ sky130_fd_sc_hd__a22o_1
XFILLER_0_105_357 vssd1 vssd1 vccd1 vccd1 sky130_fd_sc_hd__decap_3
X_09199_ net1054 net780 net770 net1063 vssd1 vssd1 vccd1 vccd1 _03310_ sky130_fd_sc_hd__a22o_1
XFILLER_0_43_480 vssd1 vssd1 vccd1 vccd1 sky130_ef_sc_hd__decap_12
XFILLER_0_16_672 vssd1 vssd1 vccd1 vccd1 sky130_fd_sc_hd__fill_1
X_11230_ _05203_ _05323_ _05326_ vssd1 vssd1 vccd1 vccd1 _05327_ sky130_fd_sc_hd__o21a_1
X_11161_ _05255_ _05257_ _05093_ _05096_ vssd1 vssd1 vccd1 vccd1 _05259_ sky130_fd_sc_hd__o211a_1
XFILLER_0_30_141 vssd1 vssd1 vccd1 vccd1 sky130_fd_sc_hd__decap_6
X_10112_ _04067_ _04217_ vssd1 vssd1 vccd1 vccd1 _04218_ sky130_fd_sc_hd__nor2_1
X_11092_ _05060_ _05063_ _05189_ _05190_ vssd1 vssd1 vccd1 vccd1 _05191_ sky130_fd_sc_hd__o211ai_4
Xhold40 det_t\[3\] vssd1 vssd1 vccd1 vccd1 net1255 sky130_fd_sc_hd__dlygate4sd3_1
X_10043_ _04131_ _04144_ _04146_ vssd1 vssd1 vccd1 vccd1 _04149_ sky130_fd_sc_hd__nand3_1
Xhold51 det_t\[9\] vssd1 vssd1 vccd1 vccd1 net1266 sky130_fd_sc_hd__dlygate4sd3_1
Xhold73 add1.b_i\[7\] vssd1 vssd1 vccd1 vccd1 net1288 sky130_fd_sc_hd__dlygate4sd3_1
Xhold62 sub1.b_i\[30\] vssd1 vssd1 vccd1 vccd1 net1277 sky130_fd_sc_hd__dlygate4sd3_1
Xhold84 sub1.b_i\[29\] vssd1 vssd1 vccd1 vccd1 net1299 sky130_fd_sc_hd__dlygate4sd3_1
Xhold95 add1.a_i\[31\] vssd1 vssd1 vccd1 vccd1 net1310 sky130_fd_sc_hd__dlygate4sd3_1
X_11994_ net105 net622 net596 net73 vssd1 vssd1 vccd1 vccd1 _06000_ sky130_fd_sc_hd__a22o_1
XFILLER_0_58_528 vssd1 vssd1 vccd1 vccd1 sky130_fd_sc_hd__decap_4
X_10945_ _05043_ _05044_ net1027 net718 vssd1 vssd1 vccd1 vccd1 _05045_ sky130_fd_sc_hd__and4bb_1
X_10876_ _04961_ _04975_ vssd1 vssd1 vccd1 vccd1 _04976_ sky130_fd_sc_hd__and2_1
XFILLER_0_109_641 vssd1 vssd1 vccd1 vccd1 sky130_ef_sc_hd__decap_12
X_12615_ clknet_leaf_26_clk_i _00001_ net1170 vssd1 vssd1 vccd1 vccd1 net334 sky130_fd_sc_hd__dfrtp_4
XFILLER_0_81_520 vssd1 vssd1 vccd1 vccd1 sky130_fd_sc_hd__fill_1
X_12546_ net1267 net569 vssd1 vssd1 vccd1 vccd1 _06270_ sky130_fd_sc_hd__nor2_1
XFILLER_0_109_685 vssd1 vssd1 vccd1 vccd1 sky130_ef_sc_hd__decap_12
XFILLER_0_108_195 vssd1 vssd1 vccd1 vccd1 sky130_fd_sc_hd__fill_1
X_12477_ temp1\[29\] _06234_ net572 vssd1 vssd1 vccd1 vccd1 _00490_ sky130_fd_sc_hd__mux2_1
XANTENNA_4 _00699_ vssd1 vssd1 vccd1 vccd1 sky130_fd_sc_hd__diode_2
XFILLER_0_124_699 vssd1 vssd1 vccd1 vccd1 sky130_fd_sc_hd__fill_1
XFILLER_0_111_305 vssd1 vssd1 vccd1 vccd1 sky130_ef_sc_hd__decap_12
XFILLER_0_1_503 vssd1 vssd1 vccd1 vccd1 sky130_fd_sc_hd__fill_1
X_11428_ net1003 net717 _05411_ _05410_ vssd1 vssd1 vccd1 vccd1 _05524_ sky130_fd_sc_hd__a31o_1
XFILLER_0_111_349 vssd1 vssd1 vccd1 vccd1 sky130_ef_sc_hd__decap_12
XFILLER_0_104_390 vssd1 vssd1 vccd1 vccd1 sky130_fd_sc_hd__fill_1
XFILLER_0_6_27 vssd1 vssd1 vccd1 vccd1 sky130_fd_sc_hd__fill_1
XFILLER_0_10_837 vssd1 vssd1 vccd1 vccd1 sky130_fd_sc_hd__fill_1
X_11359_ _05209_ _05454_ vssd1 vssd1 vccd1 vccd1 _05455_ sky130_fd_sc_hd__xor2_2
XTAP_314 vssd1 vccd1 sky130_fd_sc_hd__tapvpwrvgnd_1
XTAP_303 vssd1 vccd1 sky130_fd_sc_hd__tapvpwrvgnd_1
XTAP_358 vssd1 vccd1 sky130_fd_sc_hd__tapvpwrvgnd_1
XTAP_347 vssd1 vccd1 sky130_fd_sc_hd__tapvpwrvgnd_1
XTAP_336 vssd1 vccd1 sky130_fd_sc_hd__tapvpwrvgnd_1
XTAP_325 vssd1 vccd1 sky130_fd_sc_hd__tapvpwrvgnd_1
XTAP_369 vssd1 vccd1 sky130_fd_sc_hd__tapvpwrvgnd_1
X_13029_ clknet_leaf_49_clk_i _00415_ net1161 vssd1 vssd1 vccd1 vccd1 x0mx2\[18\]
+ sky130_fd_sc_hd__dfrtp_1
Xfanout1071 net1072 vssd1 vssd1 vccd1 vccd1 net1071 sky130_fd_sc_hd__buf_4
Xfanout1060 net1061 vssd1 vssd1 vccd1 vccd1 net1060 sky130_fd_sc_hd__clkbuf_2
Xfanout1082 net1083 vssd1 vssd1 vccd1 vccd1 net1082 sky130_fd_sc_hd__clkbuf_4
Xfanout1093 net1094 vssd1 vssd1 vccd1 vccd1 net1093 sky130_fd_sc_hd__clkbuf_4
X_08570_ _02682_ _02683_ _02678_ vssd1 vssd1 vccd1 vccd1 _02685_ sky130_fd_sc_hd__a21o_1
X_07521_ net905 net1130 vssd1 vssd1 vccd1 vccd1 _01646_ sky130_fd_sc_hd__or2_1
XFILLER_0_49_528 vssd1 vssd1 vccd1 vccd1 sky130_fd_sc_hd__decap_8
XFILLER_0_16_83 vssd1 vssd1 vccd1 vccd1 sky130_fd_sc_hd__fill_1
XFILLER_0_119_405 vssd1 vssd1 vccd1 vccd1 sky130_ef_sc_hd__decap_12
XFILLER_0_76_358 vssd1 vssd1 vccd1 vccd1 sky130_fd_sc_hd__fill_2
X_07452_ _01575_ _01576_ vssd1 vssd1 vccd1 vccd1 _01577_ sky130_fd_sc_hd__or2_1
XFILLER_0_123_51 vssd1 vssd1 vccd1 vccd1 sky130_fd_sc_hd__decap_4
XFILLER_0_119_449 vssd1 vssd1 vccd1 vccd1 sky130_ef_sc_hd__decap_12
XFILLER_0_57_561 vssd1 vssd1 vccd1 vccd1 sky130_fd_sc_hd__decap_3
X_06403_ add1.a_i\[19\] add1.b_i\[19\] vssd1 vssd1 vccd1 vccd1 _00709_ sky130_fd_sc_hd__nor2_1
X_07383_ _01500_ _01507_ vssd1 vssd1 vccd1 vccd1 _01508_ sky130_fd_sc_hd__nor2_1
XFILLER_0_29_263 vssd1 vssd1 vccd1 vccd1 sky130_fd_sc_hd__fill_1
X_09122_ _03066_ _03074_ _03073_ vssd1 vssd1 vccd1 vccd1 _03234_ sky130_fd_sc_hd__a21bo_1
XFILLER_0_45_745 vssd1 vssd1 vccd1 vccd1 sky130_fd_sc_hd__fill_2
X_06334_ add1.a_i\[2\] add1.b_i\[2\] vssd1 vssd1 vccd1 vccd1 _00646_ sky130_fd_sc_hd__nor2_1
XFILLER_0_17_447 vssd1 vssd1 vccd1 vccd1 sky130_fd_sc_hd__fill_1
XFILLER_0_32_60 vssd1 vssd1 vccd1 vccd1 sky130_fd_sc_hd__decap_4
XFILLER_0_72_564 vssd1 vssd1 vccd1 vccd1 sky130_ef_sc_hd__decap_12
XFILLER_0_114_121 vssd1 vssd1 vccd1 vccd1 sky130_ef_sc_hd__decap_12
X_09053_ _03162_ _03163_ vssd1 vssd1 vccd1 vccd1 _03165_ sky130_fd_sc_hd__xnor2_1
XFILLER_0_89_3 vssd1 vssd1 vccd1 vccd1 sky130_ef_sc_hd__decap_12
XFILLER_0_130_603 vssd1 vssd1 vccd1 vccd1 sky130_fd_sc_hd__fill_2
XFILLER_0_114_165 vssd1 vssd1 vccd1 vccd1 sky130_ef_sc_hd__decap_12
X_08004_ _02115_ _02123_ vssd1 vssd1 vccd1 vccd1 _02124_ sky130_fd_sc_hd__nand2_1
Xhold510 net346 vssd1 vssd1 vccd1 vccd1 net1725 sky130_fd_sc_hd__dlygate4sd3_1
Xhold521 add1.a_i\[6\] vssd1 vssd1 vccd1 vccd1 net1736 sky130_fd_sc_hd__dlygate4sd3_1
XFILLER_0_12_141 vssd1 vssd1 vccd1 vccd1 sky130_ef_sc_hd__decap_12
XFILLER_0_40_472 vssd1 vssd1 vccd1 vccd1 sky130_fd_sc_hd__decap_4
XFILLER_0_110_360 vssd1 vssd1 vccd1 vccd1 sky130_fd_sc_hd__decap_4
X_09955_ _04059_ _04060_ vssd1 vssd1 vccd1 vccd1 _04062_ sky130_fd_sc_hd__xnor2_4
X_08906_ _03010_ _03018_ vssd1 vssd1 vccd1 vccd1 _03019_ sky130_fd_sc_hd__xnor2_1
X_09886_ net817 net985 net977 net826 vssd1 vssd1 vccd1 vccd1 _03993_ sky130_fd_sc_hd__a22o_1
XTAP_870 vssd1 vccd1 sky130_fd_sc_hd__tapvpwrvgnd_1
X_08837_ _02849_ _02850_ _02949_ _02950_ vssd1 vssd1 vccd1 vccd1 _02951_ sky130_fd_sc_hd__nor4_1
XTAP_881 vssd1 vccd1 sky130_fd_sc_hd__tapvpwrvgnd_1
XTAP_892 vssd1 vccd1 sky130_fd_sc_hd__tapvpwrvgnd_1
X_08768_ _02752_ _02756_ _02880_ _02881_ vssd1 vssd1 vccd1 vccd1 _02882_ sky130_fd_sc_hd__a211o_2
XFILLER_0_79_174 vssd1 vssd1 vccd1 vccd1 sky130_fd_sc_hd__decap_4
X_08699_ _02813_ _02670_ vssd1 vssd1 vccd1 vccd1 _02814_ sky130_fd_sc_hd__nand2b_1
X_07719_ _01783_ _01784_ _01840_ _01841_ vssd1 vssd1 vccd1 vccd1 _01842_ sky130_fd_sc_hd__nand4_2
X_10730_ net824 net816 net948 net942 vssd1 vssd1 vccd1 vccd1 _04831_ sky130_fd_sc_hd__and4_1
X_10661_ _04761_ _04762_ vssd1 vssd1 vccd1 vccd1 _04763_ sky130_fd_sc_hd__nor2_1
XFILLER_0_106_600 vssd1 vssd1 vccd1 vccd1 sky130_fd_sc_hd__decap_3
XFILLER_0_94_188 vssd1 vssd1 vccd1 vccd1 sky130_fd_sc_hd__fill_1
XFILLER_0_82_339 vssd1 vssd1 vccd1 vccd1 sky130_fd_sc_hd__fill_2
XFILLER_0_75_391 vssd1 vssd1 vccd1 vccd1 sky130_fd_sc_hd__fill_1
XFILLER_0_75_380 vssd1 vssd1 vccd1 vccd1 sky130_fd_sc_hd__fill_1
X_12400_ net1372 _00928_ net686 vssd1 vssd1 vccd1 vccd1 _00452_ sky130_fd_sc_hd__mux2_1
XFILLER_0_106_622 vssd1 vssd1 vccd1 vccd1 sky130_ef_sc_hd__decap_12
X_10592_ _04692_ _04693_ vssd1 vssd1 vccd1 vccd1 _04694_ sky130_fd_sc_hd__xnor2_2
XFILLER_0_90_383 vssd1 vssd1 vccd1 vccd1 sky130_fd_sc_hd__decap_3
XFILLER_0_51_726 vssd1 vssd1 vccd1 vccd1 sky130_fd_sc_hd__fill_2
X_12331_ net1639 _00903_ net669 vssd1 vssd1 vccd1 vccd1 _00383_ sky130_fd_sc_hd__mux2_1
X_12262_ net1462 net39 net689 vssd1 vssd1 vccd1 vccd1 _00316_ sky130_fd_sc_hd__mux2_1
X_11213_ _05182_ _05184_ _05309_ _05310_ vssd1 vssd1 vccd1 vccd1 _05311_ sky130_fd_sc_hd__a211oi_4
X_12193_ _00855_ net509 net466 y1my2\[9\] _06148_ vssd1 vssd1 vccd1 vccd1 _06149_
+ sky130_fd_sc_hd__a221o_1
X_11144_ _05120_ _05122_ vssd1 vssd1 vccd1 vccd1 _05242_ sky130_fd_sc_hd__or2_1
XFILLER_0_128_29 vssd1 vssd1 vccd1 vccd1 sky130_ef_sc_hd__decap_12
X_11075_ _04995_ _04997_ _05171_ vssd1 vssd1 vccd1 vccd1 _05174_ sky130_fd_sc_hd__and3_1
X_10026_ _03973_ _03975_ vssd1 vssd1 vccd1 vccd1 _04132_ sky130_fd_sc_hd__nand2_1
Xinput152 v1x[8] vssd1 vssd1 vccd1 vccd1 net152 sky130_fd_sc_hd__buf_1
Xinput130 v1x[17] vssd1 vssd1 vccd1 vccd1 net130 sky130_fd_sc_hd__buf_1
Xinput163 v1y[18] vssd1 vssd1 vccd1 vccd1 net163 sky130_fd_sc_hd__clkbuf_1
Xinput141 v1x[27] vssd1 vssd1 vccd1 vccd1 net141 sky130_fd_sc_hd__buf_1
Xinput185 v1y[9] vssd1 vssd1 vccd1 vccd1 net185 sky130_fd_sc_hd__clkbuf_1
Xinput196 v2x[19] vssd1 vssd1 vccd1 vccd1 net196 sky130_fd_sc_hd__buf_1
Xinput174 v1y[28] vssd1 vssd1 vccd1 vccd1 net174 sky130_fd_sc_hd__clkbuf_1
XFILLER_0_86_612 vssd1 vssd1 vccd1 vccd1 sky130_fd_sc_hd__fill_2
X_11977_ net1330 _05987_ net481 vssd1 vssd1 vccd1 vccd1 _00237_ sky130_fd_sc_hd__mux2_1
XFILLER_0_86_645 vssd1 vssd1 vccd1 vccd1 sky130_fd_sc_hd__fill_1
X_10928_ _05026_ _05027_ vssd1 vssd1 vccd1 vccd1 _05028_ sky130_fd_sc_hd__xnor2_1
XFILLER_0_39_550 vssd1 vssd1 vccd1 vccd1 sky130_fd_sc_hd__decap_3
XFILLER_0_39_561 vssd1 vssd1 vccd1 vccd1 sky130_ef_sc_hd__decap_12
XFILLER_0_116_419 vssd1 vssd1 vccd1 vccd1 sky130_fd_sc_hd__fill_1
X_10859_ _04843_ _04845_ vssd1 vssd1 vccd1 vccd1 _04959_ sky130_fd_sc_hd__nand2_1
XFILLER_0_26_222 vssd1 vssd1 vccd1 vccd1 sky130_fd_sc_hd__fill_2
XPHY_191 vssd1 vssd1 vccd1 vccd1 sky130_fd_sc_hd__decap_3
XPHY_180 vssd1 vssd1 vccd1 vccd1 sky130_fd_sc_hd__decap_3
Xclkbuf_leaf_43_clk_i clknet_3_3__leaf_clk_i vssd1 vssd1 vccd1 vccd1 clknet_leaf_43_clk_i
+ sky130_fd_sc_hd__clkbuf_16
X_12529_ _00733_ net566 _06261_ vssd1 vssd1 vccd1 vccd1 _00515_ sky130_fd_sc_hd__o21ai_1
XFILLER_0_112_625 vssd1 vssd1 vccd1 vccd1 sky130_ef_sc_hd__decap_12
XFILLER_0_111_113 vssd1 vssd1 vccd1 vccd1 sky130_ef_sc_hd__decap_12
XFILLER_0_112_669 vssd1 vssd1 vccd1 vccd1 sky130_ef_sc_hd__decap_12
Xclkbuf_leaf_58_clk_i clknet_3_3__leaf_clk_i vssd1 vssd1 vccd1 vccd1 clknet_leaf_58_clk_i
+ sky130_fd_sc_hd__clkbuf_16
X_09740_ _03839_ _03845_ _03846_ vssd1 vssd1 vccd1 vccd1 _03848_ sky130_fd_sc_hd__nand3_2
X_06952_ _01074_ _01075_ _01076_ vssd1 vssd1 vccd1 vccd1 _01077_ sky130_fd_sc_hd__or3_1
.ends
