* NGSPICE file created from wb_mul_accel_m.ext - technology: sky130A

* Black-box entry subcircuit for sky130_fd_sc_hd__decap_6 abstract view
.subckt sky130_fd_sc_hd__decap_6 VGND VNB VPB VPWR
.ends

* Black-box entry subcircuit for sky130_fd_sc_hd__a31o_1 abstract view
.subckt sky130_fd_sc_hd__a31o_1 A1 A2 A3 B1 VGND VNB VPB VPWR X
.ends

* Black-box entry subcircuit for sky130_fd_sc_hd__a21o_1 abstract view
.subckt sky130_fd_sc_hd__a21o_1 A1 A2 B1 VGND VNB VPB VPWR X
.ends

* Black-box entry subcircuit for sky130_fd_sc_hd__a22o_1 abstract view
.subckt sky130_fd_sc_hd__a22o_1 A1 A2 B1 B2 VGND VNB VPB VPWR X
.ends

* Black-box entry subcircuit for sky130_fd_sc_hd__xnor2_1 abstract view
.subckt sky130_fd_sc_hd__xnor2_1 A B VGND VNB VPB VPWR Y
.ends

* Black-box entry subcircuit for sky130_fd_sc_hd__fill_2 abstract view
.subckt sky130_fd_sc_hd__fill_2 VGND VNB VPB VPWR
.ends

* Black-box entry subcircuit for sky130_fd_sc_hd__a21oi_2 abstract view
.subckt sky130_fd_sc_hd__a21oi_2 A1 A2 B1 VGND VNB VPB VPWR Y
.ends

* Black-box entry subcircuit for sky130_ef_sc_hd__decap_12 abstract view
.subckt sky130_ef_sc_hd__decap_12 VGND VNB VPB VPWR
.ends

* Black-box entry subcircuit for sky130_fd_sc_hd__nand2_1 abstract view
.subckt sky130_fd_sc_hd__nand2_1 A B VGND VNB VPB VPWR Y
.ends

* Black-box entry subcircuit for sky130_fd_sc_hd__decap_8 abstract view
.subckt sky130_fd_sc_hd__decap_8 VGND VNB VPB VPWR
.ends

* Black-box entry subcircuit for sky130_fd_sc_hd__xor2_2 abstract view
.subckt sky130_fd_sc_hd__xor2_2 A B VGND VNB VPB VPWR X
.ends

* Black-box entry subcircuit for sky130_fd_sc_hd__fill_1 abstract view
.subckt sky130_fd_sc_hd__fill_1 VGND VNB VPB VPWR
.ends

* Black-box entry subcircuit for sky130_fd_sc_hd__nand4_4 abstract view
.subckt sky130_fd_sc_hd__nand4_4 A B C D VGND VNB VPB VPWR Y
.ends

* Black-box entry subcircuit for sky130_fd_sc_hd__a41o_1 abstract view
.subckt sky130_fd_sc_hd__a41o_1 A1 A2 A3 A4 B1 VGND VNB VPB VPWR X
.ends

* Black-box entry subcircuit for sky130_fd_sc_hd__nor2_1 abstract view
.subckt sky130_fd_sc_hd__nor2_1 A B VGND VNB VPB VPWR Y
.ends

* Black-box entry subcircuit for sky130_fd_sc_hd__a21oi_1 abstract view
.subckt sky130_fd_sc_hd__a21oi_1 A1 A2 B1 VGND VNB VPB VPWR Y
.ends

* Black-box entry subcircuit for sky130_fd_sc_hd__o211ai_1 abstract view
.subckt sky130_fd_sc_hd__o211ai_1 A1 A2 B1 C1 VGND VNB VPB VPWR Y
.ends

* Black-box entry subcircuit for sky130_fd_sc_hd__clkbuf_1 abstract view
.subckt sky130_fd_sc_hd__clkbuf_1 A VGND VNB VPB VPWR X
.ends

* Black-box entry subcircuit for sky130_fd_sc_hd__decap_3 abstract view
.subckt sky130_fd_sc_hd__decap_3 VGND VNB VPB VPWR
.ends

* Black-box entry subcircuit for sky130_fd_sc_hd__decap_4 abstract view
.subckt sky130_fd_sc_hd__decap_4 VGND VNB VPB VPWR
.ends

* Black-box entry subcircuit for sky130_fd_sc_hd__inv_2 abstract view
.subckt sky130_fd_sc_hd__inv_2 A VGND VNB VPB VPWR Y
.ends

* Black-box entry subcircuit for sky130_fd_sc_hd__a22oi_1 abstract view
.subckt sky130_fd_sc_hd__a22oi_1 A1 A2 B1 B2 VGND VNB VPB VPWR Y
.ends

* Black-box entry subcircuit for sky130_fd_sc_hd__xnor2_2 abstract view
.subckt sky130_fd_sc_hd__xnor2_2 A B VGND VNB VPB VPWR Y
.ends

* Black-box entry subcircuit for sky130_fd_sc_hd__or3_1 abstract view
.subckt sky130_fd_sc_hd__or3_1 A B C VGND VNB VPB VPWR X
.ends

* Black-box entry subcircuit for sky130_fd_sc_hd__clkbuf_4 abstract view
.subckt sky130_fd_sc_hd__clkbuf_4 A VGND VNB VPB VPWR X
.ends

* Black-box entry subcircuit for sky130_fd_sc_hd__buf_2 abstract view
.subckt sky130_fd_sc_hd__buf_2 A VGND VNB VPB VPWR X
.ends

* Black-box entry subcircuit for sky130_fd_sc_hd__nand3_1 abstract view
.subckt sky130_fd_sc_hd__nand3_1 A B C VGND VNB VPB VPWR Y
.ends

* Black-box entry subcircuit for sky130_fd_sc_hd__a211oi_1 abstract view
.subckt sky130_fd_sc_hd__a211oi_1 A1 A2 B1 C1 VGND VNB VPB VPWR Y
.ends

* Black-box entry subcircuit for sky130_fd_sc_hd__nand4_1 abstract view
.subckt sky130_fd_sc_hd__nand4_1 A B C D VGND VNB VPB VPWR Y
.ends

* Black-box entry subcircuit for sky130_fd_sc_hd__and3_1 abstract view
.subckt sky130_fd_sc_hd__and3_1 A B C VGND VNB VPB VPWR X
.ends

* Black-box entry subcircuit for sky130_fd_sc_hd__and2b_1 abstract view
.subckt sky130_fd_sc_hd__and2b_1 A_N B VGND VNB VPB VPWR X
.ends

* Black-box entry subcircuit for sky130_fd_sc_hd__tapvpwrvgnd_1 abstract view
.subckt sky130_fd_sc_hd__tapvpwrvgnd_1 VGND VPWR
.ends

* Black-box entry subcircuit for sky130_fd_sc_hd__or2_1 abstract view
.subckt sky130_fd_sc_hd__or2_1 A B VGND VNB VPB VPWR X
.ends

* Black-box entry subcircuit for sky130_fd_sc_hd__nand4_2 abstract view
.subckt sky130_fd_sc_hd__nand4_2 A B C D VGND VNB VPB VPWR Y
.ends

* Black-box entry subcircuit for sky130_fd_sc_hd__nand3_2 abstract view
.subckt sky130_fd_sc_hd__nand3_2 A B C VGND VNB VPB VPWR Y
.ends

* Black-box entry subcircuit for sky130_fd_sc_hd__o211a_1 abstract view
.subckt sky130_fd_sc_hd__o211a_1 A1 A2 B1 C1 VGND VNB VPB VPWR X
.ends

* Black-box entry subcircuit for sky130_fd_sc_hd__a211o_1 abstract view
.subckt sky130_fd_sc_hd__a211o_1 A1 A2 B1 C1 VGND VNB VPB VPWR X
.ends

* Black-box entry subcircuit for sky130_fd_sc_hd__o21ai_1 abstract view
.subckt sky130_fd_sc_hd__o21ai_1 A1 A2 B1 VGND VNB VPB VPWR Y
.ends

* Black-box entry subcircuit for sky130_fd_sc_hd__and4_1 abstract view
.subckt sky130_fd_sc_hd__and4_1 A B C D VGND VNB VPB VPWR X
.ends

* Black-box entry subcircuit for sky130_fd_sc_hd__nor3_1 abstract view
.subckt sky130_fd_sc_hd__nor3_1 A B C VGND VNB VPB VPWR Y
.ends

* Black-box entry subcircuit for sky130_fd_sc_hd__and2_1 abstract view
.subckt sky130_fd_sc_hd__and2_1 A B VGND VNB VPB VPWR X
.ends

* Black-box entry subcircuit for sky130_fd_sc_hd__a211oi_2 abstract view
.subckt sky130_fd_sc_hd__a211oi_2 A1 A2 B1 C1 VGND VNB VPB VPWR Y
.ends

* Black-box entry subcircuit for sky130_fd_sc_hd__xor2_1 abstract view
.subckt sky130_fd_sc_hd__xor2_1 A B VGND VNB VPB VPWR X
.ends

* Black-box entry subcircuit for sky130_fd_sc_hd__o2bb2a_1 abstract view
.subckt sky130_fd_sc_hd__o2bb2a_1 A1_N A2_N B1 B2 VGND VNB VPB VPWR X
.ends

* Black-box entry subcircuit for sky130_fd_sc_hd__o22a_1 abstract view
.subckt sky130_fd_sc_hd__o22a_1 A1 A2 B1 B2 VGND VNB VPB VPWR X
.ends

* Black-box entry subcircuit for sky130_fd_sc_hd__a2bb2oi_2 abstract view
.subckt sky130_fd_sc_hd__a2bb2oi_2 A1_N A2_N B1 B2 VGND VNB VPB VPWR Y
.ends

* Black-box entry subcircuit for sky130_fd_sc_hd__and4_2 abstract view
.subckt sky130_fd_sc_hd__and4_2 A B C D VGND VNB VPB VPWR X
.ends

* Black-box entry subcircuit for sky130_fd_sc_hd__o21ai_2 abstract view
.subckt sky130_fd_sc_hd__o21ai_2 A1 A2 B1 VGND VNB VPB VPWR Y
.ends

* Black-box entry subcircuit for sky130_fd_sc_hd__and4b_1 abstract view
.subckt sky130_fd_sc_hd__and4b_1 A_N B C D VGND VNB VPB VPWR X
.ends

* Black-box entry subcircuit for sky130_fd_sc_hd__a21bo_1 abstract view
.subckt sky130_fd_sc_hd__a21bo_1 A1 A2 B1_N VGND VNB VPB VPWR X
.ends

* Black-box entry subcircuit for sky130_fd_sc_hd__nor2_2 abstract view
.subckt sky130_fd_sc_hd__nor2_2 A B VGND VNB VPB VPWR Y
.ends

* Black-box entry subcircuit for sky130_fd_sc_hd__nor4_1 abstract view
.subckt sky130_fd_sc_hd__nor4_1 A B C D VGND VNB VPB VPWR Y
.ends

* Black-box entry subcircuit for sky130_fd_sc_hd__dfrtp_2 abstract view
.subckt sky130_fd_sc_hd__dfrtp_2 CLK D RESET_B VGND VNB VPB VPWR Q
.ends

* Black-box entry subcircuit for sky130_fd_sc_hd__diode_2 abstract view
.subckt sky130_fd_sc_hd__diode_2 DIODE VGND VNB VPB VPWR
.ends

* Black-box entry subcircuit for sky130_fd_sc_hd__nand2b_1 abstract view
.subckt sky130_fd_sc_hd__nand2b_1 A_N B VGND VNB VPB VPWR Y
.ends

* Black-box entry subcircuit for sky130_fd_sc_hd__buf_1 abstract view
.subckt sky130_fd_sc_hd__buf_1 A VGND VNB VPB VPWR X
.ends

* Black-box entry subcircuit for sky130_fd_sc_hd__o21a_1 abstract view
.subckt sky130_fd_sc_hd__o21a_1 A1 A2 B1 VGND VNB VPB VPWR X
.ends

* Black-box entry subcircuit for sky130_fd_sc_hd__a21oi_4 abstract view
.subckt sky130_fd_sc_hd__a21oi_4 A1 A2 B1 VGND VNB VPB VPWR Y
.ends

* Black-box entry subcircuit for sky130_fd_sc_hd__mux2_1 abstract view
.subckt sky130_fd_sc_hd__mux2_1 A0 A1 S VGND VNB VPB VPWR X
.ends

* Black-box entry subcircuit for sky130_fd_sc_hd__or3_2 abstract view
.subckt sky130_fd_sc_hd__or3_2 A B C VGND VNB VPB VPWR X
.ends

* Black-box entry subcircuit for sky130_fd_sc_hd__a32o_1 abstract view
.subckt sky130_fd_sc_hd__a32o_1 A1 A2 A3 B1 B2 VGND VNB VPB VPWR X
.ends

* Black-box entry subcircuit for sky130_fd_sc_hd__o21ba_1 abstract view
.subckt sky130_fd_sc_hd__o21ba_1 A1 A2 B1_N VGND VNB VPB VPWR X
.ends

* Black-box entry subcircuit for sky130_fd_sc_hd__buf_6 abstract view
.subckt sky130_fd_sc_hd__buf_6 A VGND VNB VPB VPWR X
.ends

* Black-box entry subcircuit for sky130_fd_sc_hd__and3_2 abstract view
.subckt sky130_fd_sc_hd__and3_2 A B C VGND VNB VPB VPWR X
.ends

* Black-box entry subcircuit for sky130_fd_sc_hd__o21bai_1 abstract view
.subckt sky130_fd_sc_hd__o21bai_1 A1 A2 B1_N VGND VNB VPB VPWR Y
.ends

* Black-box entry subcircuit for sky130_fd_sc_hd__o21a_4 abstract view
.subckt sky130_fd_sc_hd__o21a_4 A1 A2 B1 VGND VNB VPB VPWR X
.ends

* Black-box entry subcircuit for sky130_fd_sc_hd__clkbuf_8 abstract view
.subckt sky130_fd_sc_hd__clkbuf_8 A VGND VNB VPB VPWR X
.ends

* Black-box entry subcircuit for sky130_fd_sc_hd__xnor2_4 abstract view
.subckt sky130_fd_sc_hd__xnor2_4 A B VGND VNB VPB VPWR Y
.ends

* Black-box entry subcircuit for sky130_fd_sc_hd__buf_4 abstract view
.subckt sky130_fd_sc_hd__buf_4 A VGND VNB VPB VPWR X
.ends

* Black-box entry subcircuit for sky130_fd_sc_hd__o211ai_4 abstract view
.subckt sky130_fd_sc_hd__o211ai_4 A1 A2 B1 C1 VGND VNB VPB VPWR Y
.ends

* Black-box entry subcircuit for sky130_fd_sc_hd__or4_2 abstract view
.subckt sky130_fd_sc_hd__or4_2 A B C D VGND VNB VPB VPWR X
.ends

* Black-box entry subcircuit for sky130_fd_sc_hd__and4bb_1 abstract view
.subckt sky130_fd_sc_hd__and4bb_1 A_N B_N C D VGND VNB VPB VPWR X
.ends

* Black-box entry subcircuit for sky130_fd_sc_hd__a31oi_2 abstract view
.subckt sky130_fd_sc_hd__a31oi_2 A1 A2 A3 B1 VGND VNB VPB VPWR Y
.ends

* Black-box entry subcircuit for sky130_fd_sc_hd__a211oi_4 abstract view
.subckt sky130_fd_sc_hd__a211oi_4 A1 A2 B1 C1 VGND VNB VPB VPWR Y
.ends

* Black-box entry subcircuit for sky130_fd_sc_hd__dfrtp_4 abstract view
.subckt sky130_fd_sc_hd__dfrtp_4 CLK D RESET_B VGND VNB VPB VPWR Q
.ends

* Black-box entry subcircuit for sky130_fd_sc_hd__o31ai_2 abstract view
.subckt sky130_fd_sc_hd__o31ai_2 A1 A2 A3 B1 VGND VNB VPB VPWR Y
.ends

* Black-box entry subcircuit for sky130_fd_sc_hd__clkbuf_2 abstract view
.subckt sky130_fd_sc_hd__clkbuf_2 A VGND VNB VPB VPWR X
.ends

* Black-box entry subcircuit for sky130_fd_sc_hd__o211ai_2 abstract view
.subckt sky130_fd_sc_hd__o211ai_2 A1 A2 B1 C1 VGND VNB VPB VPWR Y
.ends

* Black-box entry subcircuit for sky130_fd_sc_hd__nor3b_2 abstract view
.subckt sky130_fd_sc_hd__nor3b_2 A B C_N VGND VNB VPB VPWR Y
.ends

* Black-box entry subcircuit for sky130_fd_sc_hd__a2111oi_2 abstract view
.subckt sky130_fd_sc_hd__a2111oi_2 A1 A2 B1 C1 D1 VGND VNB VPB VPWR Y
.ends

* Black-box entry subcircuit for sky130_fd_sc_hd__nand2_2 abstract view
.subckt sky130_fd_sc_hd__nand2_2 A B VGND VNB VPB VPWR Y
.ends

* Black-box entry subcircuit for sky130_fd_sc_hd__a22oi_2 abstract view
.subckt sky130_fd_sc_hd__a22oi_2 A1 A2 B1 B2 VGND VNB VPB VPWR Y
.ends

* Black-box entry subcircuit for sky130_fd_sc_hd__a211o_4 abstract view
.subckt sky130_fd_sc_hd__a211o_4 A1 A2 B1 C1 VGND VNB VPB VPWR X
.ends

* Black-box entry subcircuit for sky130_fd_sc_hd__dlymetal6s2s_1 abstract view
.subckt sky130_fd_sc_hd__dlymetal6s2s_1 A VGND VNB VPB VPWR X
.ends

* Black-box entry subcircuit for sky130_fd_sc_hd__o22ai_4 abstract view
.subckt sky130_fd_sc_hd__o22ai_4 A1 A2 B1 B2 VGND VNB VPB VPWR Y
.ends

* Black-box entry subcircuit for sky130_fd_sc_hd__and3b_1 abstract view
.subckt sky130_fd_sc_hd__and3b_1 A_N B C VGND VNB VPB VPWR X
.ends

* Black-box entry subcircuit for sky130_fd_sc_hd__o21bai_2 abstract view
.subckt sky130_fd_sc_hd__o21bai_2 A1 A2 B1_N VGND VNB VPB VPWR Y
.ends

* Black-box entry subcircuit for sky130_fd_sc_hd__dlygate4sd3_1 abstract view
.subckt sky130_fd_sc_hd__dlygate4sd3_1 A VGND VNB VPB VPWR X
.ends

* Black-box entry subcircuit for sky130_fd_sc_hd__and3_4 abstract view
.subckt sky130_fd_sc_hd__and3_4 A B C VGND VNB VPB VPWR X
.ends

* Black-box entry subcircuit for sky130_fd_sc_hd__and4bb_2 abstract view
.subckt sky130_fd_sc_hd__and4bb_2 A_N B_N C D VGND VNB VPB VPWR X
.ends

* Black-box entry subcircuit for sky130_fd_sc_hd__a221o_1 abstract view
.subckt sky130_fd_sc_hd__a221o_1 A1 A2 B1 B2 C1 VGND VNB VPB VPWR X
.ends

* Black-box entry subcircuit for sky130_fd_sc_hd__a211o_2 abstract view
.subckt sky130_fd_sc_hd__a211o_2 A1 A2 B1 C1 VGND VNB VPB VPWR X
.ends

* Black-box entry subcircuit for sky130_fd_sc_hd__or4_4 abstract view
.subckt sky130_fd_sc_hd__or4_4 A B C D VGND VNB VPB VPWR X
.ends

* Black-box entry subcircuit for sky130_fd_sc_hd__a2bb2o_2 abstract view
.subckt sky130_fd_sc_hd__a2bb2o_2 A1_N A2_N B1 B2 VGND VNB VPB VPWR X
.ends

* Black-box entry subcircuit for sky130_fd_sc_hd__o211a_4 abstract view
.subckt sky130_fd_sc_hd__o211a_4 A1 A2 B1 C1 VGND VNB VPB VPWR X
.ends

* Black-box entry subcircuit for sky130_fd_sc_hd__o22ai_2 abstract view
.subckt sky130_fd_sc_hd__o22ai_2 A1 A2 B1 B2 VGND VNB VPB VPWR Y
.ends

* Black-box entry subcircuit for sky130_fd_sc_hd__nor3_4 abstract view
.subckt sky130_fd_sc_hd__nor3_4 A B C VGND VNB VPB VPWR Y
.ends

* Black-box entry subcircuit for sky130_fd_sc_hd__o211a_2 abstract view
.subckt sky130_fd_sc_hd__o211a_2 A1 A2 B1 C1 VGND VNB VPB VPWR X
.ends

* Black-box entry subcircuit for sky130_fd_sc_hd__o2111a_1 abstract view
.subckt sky130_fd_sc_hd__o2111a_1 A1 A2 B1 C1 D1 VGND VNB VPB VPWR X
.ends

* Black-box entry subcircuit for sky130_fd_sc_hd__and2_2 abstract view
.subckt sky130_fd_sc_hd__and2_2 A B VGND VNB VPB VPWR X
.ends

* Black-box entry subcircuit for sky130_fd_sc_hd__or4b_1 abstract view
.subckt sky130_fd_sc_hd__or4b_1 A B C D_N VGND VNB VPB VPWR X
.ends

* Black-box entry subcircuit for sky130_fd_sc_hd__nor3b_1 abstract view
.subckt sky130_fd_sc_hd__nor3b_1 A B C_N VGND VNB VPB VPWR Y
.ends

* Black-box entry subcircuit for sky130_fd_sc_hd__nor3_2 abstract view
.subckt sky130_fd_sc_hd__nor3_2 A B C VGND VNB VPB VPWR Y
.ends

* Black-box entry subcircuit for sky130_fd_sc_hd__xor2_4 abstract view
.subckt sky130_fd_sc_hd__xor2_4 A B VGND VNB VPB VPWR X
.ends

* Black-box entry subcircuit for sky130_fd_sc_hd__o21ba_2 abstract view
.subckt sky130_fd_sc_hd__o21ba_2 A1 A2 B1_N VGND VNB VPB VPWR X
.ends

* Black-box entry subcircuit for sky130_fd_sc_hd__a21boi_1 abstract view
.subckt sky130_fd_sc_hd__a21boi_1 A1 A2 B1_N VGND VNB VPB VPWR Y
.ends

* Black-box entry subcircuit for sky130_fd_sc_hd__nand3_4 abstract view
.subckt sky130_fd_sc_hd__nand3_4 A B C VGND VNB VPB VPWR Y
.ends

* Black-box entry subcircuit for sky130_fd_sc_hd__o311ai_2 abstract view
.subckt sky130_fd_sc_hd__o311ai_2 A1 A2 A3 B1 C1 VGND VNB VPB VPWR Y
.ends

* Black-box entry subcircuit for sky130_fd_sc_hd__or3_4 abstract view
.subckt sky130_fd_sc_hd__or3_4 A B C VGND VNB VPB VPWR X
.ends

* Black-box entry subcircuit for sky130_fd_sc_hd__o21a_2 abstract view
.subckt sky130_fd_sc_hd__o21a_2 A1 A2 B1 VGND VNB VPB VPWR X
.ends

* Black-box entry subcircuit for sky130_fd_sc_hd__o31a_1 abstract view
.subckt sky130_fd_sc_hd__o31a_1 A1 A2 A3 B1 VGND VNB VPB VPWR X
.ends

* Black-box entry subcircuit for sky130_fd_sc_hd__nor4_2 abstract view
.subckt sky130_fd_sc_hd__nor4_2 A B C D VGND VNB VPB VPWR Y
.ends

* Black-box entry subcircuit for sky130_fd_sc_hd__or3b_1 abstract view
.subckt sky130_fd_sc_hd__or3b_1 A B C_N VGND VNB VPB VPWR X
.ends

* Black-box entry subcircuit for sky130_fd_sc_hd__nand2_4 abstract view
.subckt sky130_fd_sc_hd__nand2_4 A B VGND VNB VPB VPWR Y
.ends

* Black-box entry subcircuit for sky130_fd_sc_hd__o221a_1 abstract view
.subckt sky130_fd_sc_hd__o221a_1 A1 A2 B1 B2 C1 VGND VNB VPB VPWR X
.ends

* Black-box entry subcircuit for sky130_fd_sc_hd__or3b_4 abstract view
.subckt sky130_fd_sc_hd__or3b_4 A B C_N VGND VNB VPB VPWR X
.ends

* Black-box entry subcircuit for sky130_fd_sc_hd__nand2_8 abstract view
.subckt sky130_fd_sc_hd__nand2_8 A B VGND VNB VPB VPWR Y
.ends

* Black-box entry subcircuit for sky130_fd_sc_hd__o22ai_1 abstract view
.subckt sky130_fd_sc_hd__o22ai_1 A1 A2 B1 B2 VGND VNB VPB VPWR Y
.ends

* Black-box entry subcircuit for sky130_fd_sc_hd__and2_4 abstract view
.subckt sky130_fd_sc_hd__and2_4 A B VGND VNB VPB VPWR X
.ends

* Black-box entry subcircuit for sky130_fd_sc_hd__or2_2 abstract view
.subckt sky130_fd_sc_hd__or2_2 A B VGND VNB VPB VPWR X
.ends

* Black-box entry subcircuit for sky130_fd_sc_hd__a22oi_4 abstract view
.subckt sky130_fd_sc_hd__a22oi_4 A1 A2 B1 B2 VGND VNB VPB VPWR Y
.ends

* Black-box entry subcircuit for sky130_fd_sc_hd__a2bb2o_1 abstract view
.subckt sky130_fd_sc_hd__a2bb2o_1 A1_N A2_N B1 B2 VGND VNB VPB VPWR X
.ends

* Black-box entry subcircuit for sky130_fd_sc_hd__nand2b_2 abstract view
.subckt sky130_fd_sc_hd__nand2b_2 A_N B VGND VNB VPB VPWR Y
.ends

* Black-box entry subcircuit for sky130_fd_sc_hd__a21boi_2 abstract view
.subckt sky130_fd_sc_hd__a21boi_2 A1 A2 B1_N VGND VNB VPB VPWR Y
.ends

* Black-box entry subcircuit for sky130_fd_sc_hd__or4_1 abstract view
.subckt sky130_fd_sc_hd__or4_1 A B C D VGND VNB VPB VPWR X
.ends

* Black-box entry subcircuit for sky130_fd_sc_hd__or4bb_4 abstract view
.subckt sky130_fd_sc_hd__or4bb_4 A B C_N D_N VGND VNB VPB VPWR X
.ends

* Black-box entry subcircuit for sky130_fd_sc_hd__a2bb2oi_1 abstract view
.subckt sky130_fd_sc_hd__a2bb2oi_1 A1_N A2_N B1 B2 VGND VNB VPB VPWR Y
.ends

* Black-box entry subcircuit for sky130_fd_sc_hd__dfrtp_1 abstract view
.subckt sky130_fd_sc_hd__dfrtp_1 CLK D RESET_B VGND VNB VPB VPWR Q
.ends

* Black-box entry subcircuit for sky130_fd_sc_hd__o32ai_2 abstract view
.subckt sky130_fd_sc_hd__o32ai_2 A1 A2 A3 B1 B2 VGND VNB VPB VPWR Y
.ends

* Black-box entry subcircuit for sky130_fd_sc_hd__o32ai_4 abstract view
.subckt sky130_fd_sc_hd__o32ai_4 A1 A2 A3 B1 B2 VGND VNB VPB VPWR Y
.ends

* Black-box entry subcircuit for sky130_fd_sc_hd__a2111o_1 abstract view
.subckt sky130_fd_sc_hd__a2111o_1 A1 A2 B1 C1 D1 VGND VNB VPB VPWR X
.ends

* Black-box entry subcircuit for sky130_fd_sc_hd__and2b_4 abstract view
.subckt sky130_fd_sc_hd__and2b_4 A_N B VGND VNB VPB VPWR X
.ends

* Black-box entry subcircuit for sky130_fd_sc_hd__or4bb_1 abstract view
.subckt sky130_fd_sc_hd__or4bb_1 A B C_N D_N VGND VNB VPB VPWR X
.ends

* Black-box entry subcircuit for sky130_fd_sc_hd__a311o_1 abstract view
.subckt sky130_fd_sc_hd__a311o_1 A1 A2 A3 B1 C1 VGND VNB VPB VPWR X
.ends

* Black-box entry subcircuit for sky130_fd_sc_hd__a2111oi_1 abstract view
.subckt sky130_fd_sc_hd__a2111oi_1 A1 A2 B1 C1 D1 VGND VNB VPB VPWR Y
.ends

* Black-box entry subcircuit for sky130_fd_sc_hd__o32a_1 abstract view
.subckt sky130_fd_sc_hd__o32a_1 A1 A2 A3 B1 B2 VGND VNB VPB VPWR X
.ends

* Black-box entry subcircuit for sky130_fd_sc_hd__nand3b_1 abstract view
.subckt sky130_fd_sc_hd__nand3b_1 A_N B C VGND VNB VPB VPWR Y
.ends

* Black-box entry subcircuit for sky130_fd_sc_hd__dfxtp_1 abstract view
.subckt sky130_fd_sc_hd__dfxtp_1 CLK D VGND VNB VPB VPWR Q
.ends

* Black-box entry subcircuit for sky130_fd_sc_hd__nand2b_4 abstract view
.subckt sky130_fd_sc_hd__nand2b_4 A_N B VGND VNB VPB VPWR Y
.ends

* Black-box entry subcircuit for sky130_fd_sc_hd__a21o_2 abstract view
.subckt sky130_fd_sc_hd__a21o_2 A1 A2 B1 VGND VNB VPB VPWR X
.ends

* Black-box entry subcircuit for sky130_fd_sc_hd__and2b_2 abstract view
.subckt sky130_fd_sc_hd__and2b_2 A_N B VGND VNB VPB VPWR X
.ends

* Black-box entry subcircuit for sky130_fd_sc_hd__or4bb_2 abstract view
.subckt sky130_fd_sc_hd__or4bb_2 A B C_N D_N VGND VNB VPB VPWR X
.ends

* Black-box entry subcircuit for sky130_fd_sc_hd__dlygate4sd1_1 abstract view
.subckt sky130_fd_sc_hd__dlygate4sd1_1 A VGND VNB VPB VPWR X
.ends

* Black-box entry subcircuit for sky130_fd_sc_hd__nor4_4 abstract view
.subckt sky130_fd_sc_hd__nor4_4 A B C D VGND VNB VPB VPWR Y
.ends

* Black-box entry subcircuit for sky130_fd_sc_hd__clkbuf_16 abstract view
.subckt sky130_fd_sc_hd__clkbuf_16 A VGND VNB VPB VPWR X
.ends

* Black-box entry subcircuit for sky130_fd_sc_hd__or2_4 abstract view
.subckt sky130_fd_sc_hd__or2_4 A B VGND VNB VPB VPWR X
.ends

* Black-box entry subcircuit for sky130_fd_sc_hd__or4b_4 abstract view
.subckt sky130_fd_sc_hd__or4b_4 A B C D_N VGND VNB VPB VPWR X
.ends

* Black-box entry subcircuit for sky130_fd_sc_hd__o31ai_1 abstract view
.subckt sky130_fd_sc_hd__o31ai_1 A1 A2 A3 B1 VGND VNB VPB VPWR Y
.ends

* Black-box entry subcircuit for sky130_fd_sc_hd__dlygate4sd2_1 abstract view
.subckt sky130_fd_sc_hd__dlygate4sd2_1 A VGND VNB VPB VPWR X
.ends

* Black-box entry subcircuit for sky130_fd_sc_hd__o31ai_4 abstract view
.subckt sky130_fd_sc_hd__o31ai_4 A1 A2 A3 B1 VGND VNB VPB VPWR Y
.ends

.subckt wb_mul_accel_m vccd1 vssd1 wb_clk_i wb_rst_i wbs_ack_o wbs_adr_i[0] wbs_adr_i[10]
+ wbs_adr_i[11] wbs_adr_i[12] wbs_adr_i[13] wbs_adr_i[14] wbs_adr_i[15] wbs_adr_i[16]
+ wbs_adr_i[17] wbs_adr_i[18] wbs_adr_i[19] wbs_adr_i[1] wbs_adr_i[20] wbs_adr_i[21]
+ wbs_adr_i[22] wbs_adr_i[23] wbs_adr_i[24] wbs_adr_i[25] wbs_adr_i[26] wbs_adr_i[27]
+ wbs_adr_i[28] wbs_adr_i[29] wbs_adr_i[2] wbs_adr_i[30] wbs_adr_i[31] wbs_adr_i[3]
+ wbs_adr_i[4] wbs_adr_i[5] wbs_adr_i[6] wbs_adr_i[7] wbs_adr_i[8] wbs_adr_i[9] wbs_cyc_i
+ wbs_dat_i[0] wbs_dat_i[10] wbs_dat_i[11] wbs_dat_i[12] wbs_dat_i[13] wbs_dat_i[14]
+ wbs_dat_i[15] wbs_dat_i[16] wbs_dat_i[17] wbs_dat_i[18] wbs_dat_i[19] wbs_dat_i[1]
+ wbs_dat_i[20] wbs_dat_i[21] wbs_dat_i[22] wbs_dat_i[23] wbs_dat_i[24] wbs_dat_i[25]
+ wbs_dat_i[26] wbs_dat_i[27] wbs_dat_i[28] wbs_dat_i[29] wbs_dat_i[2] wbs_dat_i[30]
+ wbs_dat_i[31] wbs_dat_i[3] wbs_dat_i[4] wbs_dat_i[5] wbs_dat_i[6] wbs_dat_i[7] wbs_dat_i[8]
+ wbs_dat_i[9] wbs_dat_o[0] wbs_dat_o[10] wbs_dat_o[11] wbs_dat_o[12] wbs_dat_o[13]
+ wbs_dat_o[14] wbs_dat_o[15] wbs_dat_o[16] wbs_dat_o[17] wbs_dat_o[18] wbs_dat_o[19]
+ wbs_dat_o[1] wbs_dat_o[20] wbs_dat_o[21] wbs_dat_o[22] wbs_dat_o[23] wbs_dat_o[24]
+ wbs_dat_o[25] wbs_dat_o[26] wbs_dat_o[27] wbs_dat_o[28] wbs_dat_o[29] wbs_dat_o[2]
+ wbs_dat_o[30] wbs_dat_o[31] wbs_dat_o[3] wbs_dat_o[4] wbs_dat_o[5] wbs_dat_o[6]
+ wbs_dat_o[7] wbs_dat_o[8] wbs_dat_o[9] wbs_sel_i[0] wbs_sel_i[1] wbs_sel_i[2] wbs_sel_i[3]
+ wbs_stb_i wbs_we_i
XFILLER_0_94_77 vssd1 vssd1 vccd1 vccd1 sky130_fd_sc_hd__decap_6
X_05903_ net139 _00281_ _00282_ _00283_ vssd1 vssd1 vccd1 vccd1 net51 sky130_fd_sc_hd__a31o_1
X_06883_ _01120_ _01124_ _01254_ vssd1 vssd1 vccd1 vccd1 _01255_ sky130_fd_sc_hd__a21o_1
X_09671_ net162 net477 net486 net156 vssd1 vssd1 vccd1 vccd1 _04178_ sky130_fd_sc_hd__a22o_1
X_08622_ _03027_ _03029_ _03030_ vssd1 vssd1 vccd1 vccd1 _03032_ sky130_fd_sc_hd__a21o_1
X_05834_ _00210_ _00213_ vssd1 vssd1 vccd1 vccd1 _00215_ sky130_fd_sc_hd__xnor2_1
XFILLER_0_77_623 vssd1 vssd1 vccd1 vccd1 sky130_fd_sc_hd__fill_2
X_08553_ _02952_ _02953_ _02954_ vssd1 vssd1 vccd1 vccd1 _02956_ sky130_fd_sc_hd__a21oi_2
X_05765_ _00143_ _00144_ _00145_ vssd1 vssd1 vccd1 vccd1 _00147_ sky130_fd_sc_hd__a21o_1
XFILLER_0_49_303 vssd1 vssd1 vccd1 vccd1 sky130_ef_sc_hd__decap_12
X_08484_ _02730_ _02735_ vssd1 vssd1 vccd1 vccd1 _02881_ sky130_fd_sc_hd__nand2_1
XFILLER_0_89_494 vssd1 vssd1 vccd1 vccd1 sky130_fd_sc_hd__decap_8
X_07504_ _01874_ _01875_ vssd1 vssd1 vccd1 vccd1 _01876_ sky130_fd_sc_hd__xor2_2
XFILLER_0_76_177 vssd1 vssd1 vccd1 vccd1 sky130_fd_sc_hd__fill_1
XFILLER_0_64_306 vssd1 vssd1 vccd1 vccd1 sky130_fd_sc_hd__fill_2
X_05696_ _04963_ _04964_ _04878_ vssd1 vssd1 vccd1 vccd1 _04966_ sky130_fd_sc_hd__a21o_1
X_07435_ net154 net159 net628 net636 vssd1 vssd1 vccd1 vccd1 _01803_ sky130_fd_sc_hd__nand4_4
XFILLER_0_57_391 vssd1 vssd1 vccd1 vccd1 sky130_fd_sc_hd__fill_1
XFILLER_0_91_169 vssd1 vssd1 vccd1 vccd1 sky130_ef_sc_hd__decap_12
X_07366_ net285 net295 net483 net492 _01594_ vssd1 vssd1 vccd1 vccd1 _01735_ sky130_fd_sc_hd__a41o_1
X_09105_ _03552_ _03559_ vssd1 vssd1 vccd1 vccd1 _03560_ sky130_fd_sc_hd__nor2_1
X_06317_ _00690_ _00691_ _00658_ vssd1 vssd1 vccd1 vccd1 _00694_ sky130_fd_sc_hd__a21oi_1
X_07297_ _01664_ _01665_ vssd1 vssd1 vccd1 vccd1 _01666_ sky130_fd_sc_hd__nor2_1
XFILLER_0_45_575 vssd1 vssd1 vccd1 vccd1 sky130_fd_sc_hd__fill_1
X_09036_ _03481_ _03482_ _03284_ _03286_ vssd1 vssd1 vccd1 vccd1 _03484_ sky130_fd_sc_hd__o211ai_1
XFILLER_0_60_545 vssd1 vssd1 vccd1 vccd1 sky130_fd_sc_hd__fill_2
XFILLER_0_4_160 vssd1 vssd1 vccd1 vccd1 sky130_fd_sc_hd__fill_1
X_06248_ net252 net590 _00622_ _00623_ vssd1 vssd1 vccd1 vccd1 _00625_ sky130_fd_sc_hd__a22o_1
XFILLER_0_60_589 vssd1 vssd1 vccd1 vccd1 sky130_fd_sc_hd__fill_1
X_06179_ net311 net530 net540 net301 vssd1 vssd1 vccd1 vccd1 _00557_ sky130_fd_sc_hd__a22o_1
X_09938_ _04467_ _04468_ vssd1 vssd1 vccd1 vccd1 _04469_ sky130_fd_sc_hd__nand2_1
X_09869_ _04359_ _04393_ vssd1 vssd1 vccd1 vccd1 _04395_ sky130_fd_sc_hd__nand2_1
XFILLER_0_23_18 vssd1 vssd1 vccd1 vccd1 sky130_fd_sc_hd__decap_6
XFILLER_0_48_380 vssd1 vssd1 vccd1 vccd1 sky130_fd_sc_hd__decap_8
XFILLER_0_51_523 vssd1 vssd1 vccd1 vccd1 sky130_fd_sc_hd__fill_1
XFILLER_0_36_575 vssd1 vssd1 vccd1 vccd1 sky130_fd_sc_hd__fill_1
Xrebuffer7 _02093_ vssd1 vssd1 vccd1 vccd1 net652 sky130_fd_sc_hd__clkbuf_1
XFILLER_0_23_236 vssd1 vssd1 vccd1 vccd1 sky130_fd_sc_hd__decap_3
XFILLER_0_64_36 vssd1 vssd1 vccd1 vccd1 sky130_fd_sc_hd__decap_4
X_10009_ net638 vssd1 vssd1 vccd1 vccd1 _00005_ sky130_fd_sc_hd__inv_2
XFILLER_0_59_623 vssd1 vssd1 vccd1 vccd1 sky130_fd_sc_hd__fill_2
XFILLER_0_58_100 vssd1 vssd1 vccd1 vccd1 sky130_fd_sc_hd__fill_1
X_05550_ _04818_ _04819_ vssd1 vssd1 vccd1 vccd1 _04820_ sky130_fd_sc_hd__nor2_1
XFILLER_0_86_475 vssd1 vssd1 vccd1 vccd1 sky130_fd_sc_hd__fill_1
X_05481_ net347 net560 net567 net337 vssd1 vssd1 vccd1 vccd1 _04751_ sky130_fd_sc_hd__a22oi_1
XFILLER_0_13_40 vssd1 vssd1 vccd1 vccd1 sky130_fd_sc_hd__fill_1
XFILLER_0_73_147 vssd1 vssd1 vccd1 vccd1 sky130_fd_sc_hd__fill_1
X_07220_ net285 net498 _01450_ _01449_ vssd1 vssd1 vccd1 vccd1 _01590_ sky130_fd_sc_hd__a31o_1
XFILLER_0_6_447 vssd1 vssd1 vccd1 vccd1 sky130_ef_sc_hd__decap_12
XFILLER_0_14_203 vssd1 vssd1 vccd1 vccd1 sky130_fd_sc_hd__decap_3
X_07151_ _01373_ _01519_ vssd1 vssd1 vccd1 vccd1 _01521_ sky130_fd_sc_hd__xnor2_1
XFILLER_0_81_180 vssd1 vssd1 vccd1 vccd1 sky130_fd_sc_hd__decap_3
X_06102_ _00383_ _00479_ vssd1 vssd1 vccd1 vccd1 _00481_ sky130_fd_sc_hd__xnor2_2
XFILLER_0_42_556 vssd1 vssd1 vccd1 vccd1 sky130_fd_sc_hd__fill_1
X_07082_ _01451_ _01452_ vssd1 vssd1 vccd1 vccd1 _01453_ sky130_fd_sc_hd__xnor2_1
X_06033_ _00307_ _00312_ _00410_ vssd1 vssd1 vccd1 vccd1 _00412_ sky130_fd_sc_hd__or3_1
XFILLER_0_22_280 vssd1 vssd1 vccd1 vccd1 sky130_fd_sc_hd__decap_8
Xfanout138 _03053_ vssd1 vssd1 vccd1 vccd1 net138 sky130_fd_sc_hd__clkbuf_4
Xfanout127 _02232_ vssd1 vssd1 vccd1 vccd1 net127 sky130_fd_sc_hd__buf_2
X_07984_ _02342_ _02354_ _02355_ vssd1 vssd1 vccd1 vccd1 _02357_ sky130_fd_sc_hd__nand3_1
Xfanout149 net150 vssd1 vssd1 vccd1 vccd1 net149 sky130_fd_sc_hd__buf_2
X_09723_ _04231_ _04233_ _04076_ _04080_ vssd1 vssd1 vccd1 vccd1 _04235_ sky130_fd_sc_hd__a211oi_1
X_06935_ net323 net470 _01304_ _01305_ vssd1 vssd1 vccd1 vccd1 _01307_ sky130_fd_sc_hd__nand4_1
X_09654_ _04004_ _04158_ _04159_ vssd1 vssd1 vccd1 vccd1 _04160_ sky130_fd_sc_hd__and3_1
X_06866_ _01234_ _01237_ vssd1 vssd1 vccd1 vccd1 _01238_ sky130_fd_sc_hd__and2b_1
X_08605_ _02841_ _02844_ vssd1 vssd1 vccd1 vccd1 _03013_ sky130_fd_sc_hd__nand2_1
X_05817_ _00196_ _00197_ vssd1 vssd1 vccd1 vccd1 _00198_ sky130_fd_sc_hd__nand2_1
XTAP_1129 vssd1 vccd1 sky130_fd_sc_hd__tapvpwrvgnd_1
XTAP_1118 vssd1 vccd1 sky130_fd_sc_hd__tapvpwrvgnd_1
XTAP_1107 vssd1 vccd1 sky130_fd_sc_hd__tapvpwrvgnd_1
X_09585_ _04082_ _04083_ vssd1 vssd1 vccd1 vccd1 _04084_ sky130_fd_sc_hd__or2_1
X_06797_ net313 net321 net477 net486 vssd1 vssd1 vccd1 vccd1 _01170_ sky130_fd_sc_hd__nand4_2
X_08536_ net173 net534 net544 net168 vssd1 vssd1 vccd1 vccd1 _02937_ sky130_fd_sc_hd__a22o_1
X_05748_ _05016_ _05017_ vssd1 vssd1 vccd1 vccd1 _05018_ sky130_fd_sc_hd__or2_1
X_08467_ _02859_ _02860_ _02861_ vssd1 vssd1 vccd1 vccd1 _02862_ sky130_fd_sc_hd__nand3_2
X_05679_ net390 net496 _04947_ vssd1 vssd1 vccd1 vccd1 _04949_ sky130_fd_sc_hd__and3_1
XFILLER_0_92_467 vssd1 vssd1 vccd1 vccd1 sky130_fd_sc_hd__decap_4
X_08398_ _02778_ _02779_ _02784_ vssd1 vssd1 vccd1 vccd1 _02786_ sky130_fd_sc_hd__a21o_1
XFILLER_0_52_309 vssd1 vssd1 vccd1 vccd1 sky130_fd_sc_hd__decap_8
XFILLER_0_9_274 vssd1 vssd1 vccd1 vccd1 sky130_fd_sc_hd__decap_6
X_07418_ _01784_ _01785_ _01517_ _01520_ vssd1 vssd1 vccd1 vccd1 _01787_ sky130_fd_sc_hd__o211a_1
XFILLER_0_64_169 vssd1 vssd1 vccd1 vccd1 sky130_fd_sc_hd__fill_1
X_07349_ _01715_ _01717_ vssd1 vssd1 vccd1 vccd1 _01718_ sky130_fd_sc_hd__nand2_1
XFILLER_0_20_206 vssd1 vssd1 vccd1 vccd1 sky130_ef_sc_hd__decap_12
XFILLER_0_33_567 vssd1 vssd1 vccd1 vccd1 sky130_fd_sc_hd__fill_2
X_09019_ _03164_ _03464_ vssd1 vssd1 vccd1 vccd1 _03466_ sky130_fd_sc_hd__xnor2_1
XFILLER_0_28_339 vssd1 vssd1 vccd1 vccd1 sky130_fd_sc_hd__fill_2
XFILLER_0_83_456 vssd1 vssd1 vccd1 vccd1 sky130_fd_sc_hd__decap_3
XFILLER_0_50_27 vssd1 vssd1 vccd1 vccd1 sky130_fd_sc_hd__fill_1
XFILLER_0_55_169 vssd1 vssd1 vccd1 vccd1 sky130_fd_sc_hd__decap_4
XFILLER_0_70_139 vssd1 vssd1 vccd1 vccd1 sky130_fd_sc_hd__fill_1
XFILLER_0_3_406 vssd1 vssd1 vccd1 vccd1 sky130_ef_sc_hd__decap_12
XFILLER_0_59_36 vssd1 vssd1 vccd1 vccd1 sky130_ef_sc_hd__decap_12
XFILLER_0_59_69 vssd1 vssd1 vccd1 vccd1 sky130_fd_sc_hd__decap_4
X_06720_ _01090_ _01091_ _00951_ _00953_ vssd1 vssd1 vccd1 vccd1 _01094_ sky130_fd_sc_hd__a211o_1
X_06651_ net357 net454 net462 net346 vssd1 vssd1 vccd1 vccd1 _01025_ sky130_fd_sc_hd__a22o_1
XFILLER_0_91_34 vssd1 vssd1 vccd1 vccd1 sky130_fd_sc_hd__decap_3
X_05602_ _04860_ _04870_ vssd1 vssd1 vccd1 vccd1 _04872_ sky130_fd_sc_hd__xnor2_1
X_09370_ _03846_ _03847_ vssd1 vssd1 vccd1 vccd1 _03850_ sky130_fd_sc_hd__xnor2_1
XFILLER_0_93_209 vssd1 vssd1 vccd1 vccd1 sky130_ef_sc_hd__decap_12
XFILLER_0_86_250 vssd1 vssd1 vccd1 vccd1 sky130_fd_sc_hd__fill_2
XFILLER_0_59_453 vssd1 vssd1 vccd1 vccd1 sky130_fd_sc_hd__decap_8
XFILLER_0_24_50 vssd1 vssd1 vccd1 vccd1 sky130_ef_sc_hd__decap_12
X_06582_ _00955_ _00842_ vssd1 vssd1 vccd1 vccd1 _00957_ sky130_fd_sc_hd__and2b_1
X_08321_ _02533_ _02535_ _02701_ _02702_ vssd1 vssd1 vccd1 vccd1 _02703_ sky130_fd_sc_hd__a211o_1
XFILLER_0_59_497 vssd1 vssd1 vccd1 vccd1 sky130_fd_sc_hd__decap_6
X_05533_ net103 _04801_ _04695_ _04716_ vssd1 vssd1 vccd1 vccd1 _04803_ sky130_fd_sc_hd__o211a_1
X_08252_ net228 net231 net483 net492 vssd1 vssd1 vccd1 vccd1 _02627_ sky130_fd_sc_hd__nand4_1
X_05464_ _04066_ _04099_ _04732_ vssd1 vssd1 vccd1 vccd1 _04734_ sky130_fd_sc_hd__o21ai_1
X_07203_ net358 net429 _01570_ _01571_ vssd1 vssd1 vccd1 vccd1 _01573_ sky130_fd_sc_hd__nand4_2
X_08183_ _02551_ _02552_ _02553_ vssd1 vssd1 vccd1 vccd1 _02555_ sky130_fd_sc_hd__a21oi_1
X_05395_ net615 mul.b\[0\] _04664_ net386 vssd1 vssd1 vccd1 vccd1 _04665_ sky130_fd_sc_hd__o211a_1
X_07134_ net181 net188 net602 net612 vssd1 vssd1 vccd1 vccd1 _01504_ sky130_fd_sc_hd__and4_1
XFILLER_0_71_3 vssd1 vssd1 vccd1 vccd1 sky130_fd_sc_hd__decap_6
XFILLER_0_30_548 vssd1 vssd1 vccd1 vccd1 sky130_fd_sc_hd__decap_8
X_07065_ _01293_ _01295_ _01434_ _01435_ vssd1 vssd1 vccd1 vccd1 _01436_ sky130_fd_sc_hd__a211oi_1
X_06016_ _00289_ _00293_ _00393_ vssd1 vssd1 vccd1 vccd1 _00395_ sky130_fd_sc_hd__nand3_1
XFILLER_0_10_283 vssd1 vssd1 vccd1 vccd1 sky130_ef_sc_hd__decap_12
X_07967_ _02336_ _02337_ _02338_ vssd1 vssd1 vccd1 vccd1 _02340_ sky130_fd_sc_hd__a21oi_1
X_06918_ net339 net456 net463 net331 vssd1 vssd1 vccd1 vccd1 _01290_ sky130_fd_sc_hd__a22o_1
X_09706_ _04214_ _04215_ vssd1 vssd1 vccd1 vccd1 _04216_ sky130_fd_sc_hd__nand2_1
X_07898_ _02269_ _02270_ _02113_ vssd1 vssd1 vccd1 vccd1 _02272_ sky130_fd_sc_hd__a21o_1
X_09637_ _03964_ _03991_ _04139_ vssd1 vssd1 vccd1 vccd1 _04141_ sky130_fd_sc_hd__nor3_1
X_06849_ _01220_ _01221_ net139 vssd1 vssd1 vccd1 vccd1 _01222_ sky130_fd_sc_hd__o21ai_1
X_09568_ _04040_ _04064_ vssd1 vssd1 vccd1 vccd1 _04065_ sky130_fd_sc_hd__xor2_2
X_08519_ _02916_ _02917_ _02753_ _02756_ vssd1 vssd1 vccd1 vccd1 _02920_ sky130_fd_sc_hd__a211o_1
X_09499_ _03965_ _03989_ vssd1 vssd1 vccd1 vccd1 _03991_ sky130_fd_sc_hd__and2_1
XFILLER_0_92_253 vssd1 vssd1 vccd1 vccd1 sky130_fd_sc_hd__fill_2
Xfanout491 net492 vssd1 vssd1 vccd1 vccd1 net491 sky130_fd_sc_hd__clkbuf_4
Xfanout480 net481 vssd1 vssd1 vccd1 vccd1 net480 sky130_fd_sc_hd__clkbuf_4
Xmax_cap5 _00701_ vssd1 vssd1 vccd1 vccd1 net715 sky130_fd_sc_hd__clkbuf_1
XFILLER_0_88_537 vssd1 vssd1 vccd1 vccd1 sky130_fd_sc_hd__fill_2
XFILLER_0_0_29 vssd1 vssd1 vccd1 vccd1 sky130_ef_sc_hd__decap_12
XFILLER_0_56_456 vssd1 vssd1 vccd1 vccd1 sky130_fd_sc_hd__decap_4
XFILLER_0_28_147 vssd1 vssd1 vccd1 vccd1 sky130_fd_sc_hd__fill_2
XFILLER_0_83_264 vssd1 vssd1 vccd1 vccd1 sky130_ef_sc_hd__decap_12
XFILLER_0_9_27 vssd1 vssd1 vccd1 vccd1 sky130_fd_sc_hd__decap_6
X_05180_ _03410_ _03509_ vssd1 vssd1 vccd1 vccd1 _03520_ sky130_fd_sc_hd__nor2_1
XFILLER_0_24_342 vssd1 vssd1 vccd1 vccd1 sky130_fd_sc_hd__decap_4
XFILLER_0_10_85 vssd1 vssd1 vccd1 vccd1 sky130_fd_sc_hd__fill_2
X_08870_ _03143_ _03145_ _03299_ _03300_ vssd1 vssd1 vccd1 vccd1 _03303_ sky130_fd_sc_hd__a211o_1
X_07821_ _02052_ _02054_ _02189_ _02191_ vssd1 vssd1 vccd1 vccd1 _02192_ sky130_fd_sc_hd__a211oi_2
X_07752_ net165 net600 net610 net159 vssd1 vssd1 vccd1 vccd1 _02123_ sky130_fd_sc_hd__a22o_1
X_07683_ _02051_ _02053_ _01883_ _01885_ vssd1 vssd1 vccd1 vccd1 _02055_ sky130_fd_sc_hd__o211ai_1
X_06703_ _01015_ _01074_ _01075_ vssd1 vssd1 vccd1 vccd1 _01077_ sky130_fd_sc_hd__nand3_2
XFILLER_0_66_209 vssd1 vssd1 vccd1 vccd1 sky130_fd_sc_hd__decap_3
X_09422_ _03754_ _03756_ vssd1 vssd1 vccd1 vccd1 _03906_ sky130_fd_sc_hd__or2_1
X_06634_ mul.a\[16\] net560 net567 net242 vssd1 vssd1 vccd1 vccd1 _01008_ sky130_fd_sc_hd__a22o_1
X_09353_ _03828_ _03829_ _03682_ _03685_ vssd1 vssd1 vccd1 vccd1 _03831_ sky130_fd_sc_hd__o211a_1
X_08304_ _02673_ _02683_ vssd1 vssd1 vccd1 vccd1 _02684_ sky130_fd_sc_hd__xor2_1
XFILLER_0_74_220 vssd1 vssd1 vccd1 vccd1 sky130_fd_sc_hd__fill_1
XFILLER_0_19_147 vssd1 vssd1 vccd1 vccd1 sky130_ef_sc_hd__decap_12
X_06565_ _00937_ _00938_ net671 _00814_ vssd1 vssd1 vccd1 vccd1 _00940_ sky130_fd_sc_hd__a211o_1
XFILLER_0_74_253 vssd1 vssd1 vccd1 vccd1 sky130_fd_sc_hd__decap_4
X_09284_ net208 net449 _03753_ _03754_ vssd1 vssd1 vccd1 vccd1 _03755_ sky130_fd_sc_hd__o2bb2a_1
XFILLER_0_51_70 vssd1 vssd1 vccd1 vccd1 sky130_fd_sc_hd__decap_3
X_05516_ net302 net311 net595 net605 vssd1 vssd1 vccd1 vccd1 _04786_ sky130_fd_sc_hd__nand4_2
XFILLER_0_19_169 vssd1 vssd1 vccd1 vccd1 sky130_fd_sc_hd__fill_2
X_06496_ _00740_ _00744_ _00869_ vssd1 vssd1 vccd1 vccd1 _00871_ sky130_fd_sc_hd__nand3_1
X_08235_ net194 net527 _02604_ _02606_ vssd1 vssd1 vccd1 vccd1 _02608_ sky130_fd_sc_hd__and4_1
X_05447_ _04694_ _04696_ _04713_ _04714_ vssd1 vssd1 vccd1 vccd1 _04717_ sky130_fd_sc_hd__o22a_1
X_08166_ _02516_ net723 _02535_ _02536_ vssd1 vssd1 vccd1 vccd1 _02538_ sky130_fd_sc_hd__a2bb2oi_2
X_05378_ _04639_ _04647_ vssd1 vssd1 vccd1 vccd1 _04648_ sky130_fd_sc_hd__xnor2_1
X_07117_ _01485_ _01486_ _01346_ _01348_ vssd1 vssd1 vccd1 vccd1 _01488_ sky130_fd_sc_hd__o211a_1
X_08097_ net160 net593 _02465_ _02466_ vssd1 vssd1 vccd1 vccd1 _02469_ sky130_fd_sc_hd__and4_1
XFILLER_0_30_356 vssd1 vssd1 vccd1 vccd1 sky130_fd_sc_hd__decap_8
X_07048_ _01402_ _01418_ vssd1 vssd1 vccd1 vccd1 _01419_ sky130_fd_sc_hd__xnor2_1
X_08999_ net222 net449 _03441_ _03442_ vssd1 vssd1 vccd1 vccd1 _03444_ sky130_fd_sc_hd__o2bb2a_1
XFILLER_0_97_345 vssd1 vssd1 vccd1 vccd1 sky130_fd_sc_hd__decap_3
XFILLER_0_25_128 vssd1 vssd1 vccd1 vccd1 sky130_fd_sc_hd__decap_6
XFILLER_0_21_367 vssd1 vssd1 vccd1 vccd1 sky130_fd_sc_hd__decap_8
XTAP_507 vssd1 vccd1 sky130_fd_sc_hd__tapvpwrvgnd_1
XTAP_518 vssd1 vccd1 sky130_fd_sc_hd__tapvpwrvgnd_1
XTAP_529 vssd1 vccd1 sky130_fd_sc_hd__tapvpwrvgnd_1
XFILLER_0_56_37 vssd1 vssd1 vccd1 vccd1 sky130_fd_sc_hd__fill_2
XFILLER_0_56_26 vssd1 vssd1 vccd1 vccd1 sky130_fd_sc_hd__fill_2
XFILLER_0_8_317 vssd1 vssd1 vccd1 vccd1 sky130_fd_sc_hd__fill_2
XFILLER_0_29_456 vssd1 vssd1 vccd1 vccd1 sky130_fd_sc_hd__decap_8
XTAP_1290 vssd1 vccd1 sky130_fd_sc_hd__tapvpwrvgnd_1
XFILLER_0_56_253 vssd1 vssd1 vccd1 vccd1 sky130_fd_sc_hd__decap_4
X_06350_ net204 net211 net627 net635 vssd1 vssd1 vccd1 vccd1 _00726_ sky130_fd_sc_hd__and4_2
XFILLER_0_16_128 vssd1 vssd1 vccd1 vccd1 sky130_ef_sc_hd__decap_12
X_06281_ _00656_ _00657_ vssd1 vssd1 vccd1 vccd1 _00658_ sky130_fd_sc_hd__nor2_1
X_05301_ _04567_ _04569_ _04570_ vssd1 vssd1 vccd1 vccd1 _04571_ sky130_fd_sc_hd__nand3_1
XFILLER_0_44_448 vssd1 vssd1 vccd1 vccd1 sky130_ef_sc_hd__decap_12
X_08020_ _02379_ _02380_ _02390_ vssd1 vssd1 vccd1 vccd1 _02393_ sky130_fd_sc_hd__o21ai_2
X_05232_ net387 net530 net540 net377 vssd1 vssd1 vccd1 vccd1 _04088_ sky130_fd_sc_hd__a22oi_1
XFILLER_0_21_62 vssd1 vssd1 vccd1 vccd1 sky130_fd_sc_hd__decap_6
XFILLER_0_52_470 vssd1 vssd1 vccd1 vccd1 sky130_fd_sc_hd__decap_6
XFILLER_0_97_33 vssd1 vssd1 vccd1 vccd1 sky130_fd_sc_hd__fill_1
X_05163_ _03181_ _03236_ vssd1 vssd1 vccd1 vccd1 _03334_ sky130_fd_sc_hd__and2_1
XFILLER_0_24_194 vssd1 vssd1 vccd1 vccd1 sky130_fd_sc_hd__fill_2
X_09971_ _04499_ _04505_ vssd1 vssd1 vccd1 vccd1 _04506_ sky130_fd_sc_hd__xnor2_1
X_05094_ net710 net142 net37 net4 vssd1 vssd1 vccd1 vccd1 _00001_ sky130_fd_sc_hd__and4b_1
X_08922_ net153 net138 _03359_ vssd1 vssd1 vccd1 vccd1 _03360_ sky130_fd_sc_hd__a21bo_1
X_08853_ net241 net251 net436 net442 vssd1 vssd1 vccd1 vccd1 _03284_ sky130_fd_sc_hd__nand4_2
XFILLER_0_34_3 vssd1 vssd1 vccd1 vccd1 sky130_ef_sc_hd__decap_12
X_08784_ _02885_ _03208_ vssd1 vssd1 vccd1 vccd1 _03209_ sky130_fd_sc_hd__xor2_1
X_07804_ _02019_ _02021_ vssd1 vssd1 vccd1 vccd1 _02175_ sky130_fd_sc_hd__nand2_1
X_05996_ _00274_ _00276_ vssd1 vssd1 vccd1 vccd1 _00376_ sky130_fd_sc_hd__nor2_2
XFILLER_0_79_312 vssd1 vssd1 vccd1 vccd1 sky130_fd_sc_hd__decap_3
X_07735_ _02105_ _02106_ _01942_ _01944_ vssd1 vssd1 vccd1 vccd1 _02107_ sky130_fd_sc_hd__o211a_1
XFILLER_0_79_356 vssd1 vssd1 vccd1 vccd1 sky130_fd_sc_hd__decap_8
XFILLER_0_79_389 vssd1 vssd1 vccd1 vccd1 sky130_fd_sc_hd__decap_3
X_07666_ net316 net446 net452 net307 vssd1 vssd1 vccd1 vccd1 _02038_ sky130_fd_sc_hd__a22o_1
X_09405_ _03872_ _03885_ vssd1 vssd1 vccd1 vccd1 _03887_ sky130_fd_sc_hd__xnor2_1
XFILLER_0_39_209 vssd1 vssd1 vccd1 vccd1 sky130_fd_sc_hd__decap_6
XFILLER_0_94_359 vssd1 vssd1 vccd1 vccd1 sky130_fd_sc_hd__decap_4
X_06617_ _00988_ _00989_ _00882_ vssd1 vssd1 vccd1 vccd1 _00991_ sky130_fd_sc_hd__a21o_1
X_07597_ _01962_ _01968_ vssd1 vssd1 vccd1 vccd1 _01969_ sky130_fd_sc_hd__and2_1
X_09336_ _03631_ _03637_ _03636_ vssd1 vssd1 vccd1 vccd1 _03812_ sky130_fd_sc_hd__a21oi_1
X_06548_ _00796_ _00798_ _00797_ vssd1 vssd1 vccd1 vccd1 _00923_ sky130_fd_sc_hd__a21bo_1
X_09267_ net185 net472 _03733_ _03734_ vssd1 vssd1 vccd1 vccd1 _03736_ sky130_fd_sc_hd__a22o_1
XFILLER_0_62_201 vssd1 vssd1 vccd1 vccd1 sky130_fd_sc_hd__fill_1
XFILLER_0_35_426 vssd1 vssd1 vccd1 vccd1 sky130_fd_sc_hd__fill_1
XFILLER_0_62_245 vssd1 vssd1 vccd1 vccd1 sky130_fd_sc_hd__decap_6
X_08218_ _02587_ _02588_ _02427_ _02429_ vssd1 vssd1 vccd1 vccd1 _02591_ sky130_fd_sc_hd__a211oi_2
X_06479_ _00850_ _00853_ vssd1 vssd1 vccd1 vccd1 _00854_ sky130_fd_sc_hd__and2b_1
X_09198_ _03626_ _03627_ _03659_ _03660_ vssd1 vssd1 vccd1 vccd1 _03661_ sky130_fd_sc_hd__nor4_1
X_08149_ net307 net432 _02519_ _02520_ vssd1 vssd1 vccd1 vccd1 _02521_ sky130_fd_sc_hd__a22o_1
XFILLER_0_43_492 vssd1 vssd1 vccd1 vccd1 sky130_ef_sc_hd__decap_12
X_10111_ clknet_3_0_0_wb_clk_i _00105_ _00041_ vssd1 vssd1 vccd1 vccd1 mul.a\[6\]
+ sky130_fd_sc_hd__dfrtp_2
XFILLER_0_30_197 vssd1 vssd1 vccd1 vccd1 sky130_fd_sc_hd__decap_4
X_10042_ net638 vssd1 vssd1 vccd1 vccd1 _00038_ sky130_fd_sc_hd__inv_2
XFILLER_0_26_29 vssd1 vssd1 vccd1 vccd1 sky130_fd_sc_hd__fill_1
XFILLER_0_98_621 vssd1 vssd1 vccd1 vccd1 sky130_fd_sc_hd__decap_4
XFILLER_0_42_39 vssd1 vssd1 vccd1 vccd1 sky130_fd_sc_hd__decap_4
XFILLER_0_66_562 vssd1 vssd1 vccd1 vccd1 sky130_fd_sc_hd__decap_6
XFILLER_0_53_223 vssd1 vssd1 vccd1 vccd1 sky130_fd_sc_hd__fill_1
XANTENNA_5 net318 vssd1 vssd1 vccd1 vccd1 sky130_fd_sc_hd__diode_2
XFILLER_0_1_537 vssd1 vssd1 vccd1 vccd1 sky130_fd_sc_hd__decap_4
XFILLER_0_21_153 vssd1 vssd1 vccd1 vccd1 sky130_fd_sc_hd__decap_4
XTAP_315 vssd1 vccd1 sky130_fd_sc_hd__tapvpwrvgnd_1
XTAP_304 vssd1 vccd1 sky130_fd_sc_hd__tapvpwrvgnd_1
XTAP_348 vssd1 vccd1 sky130_fd_sc_hd__tapvpwrvgnd_1
XTAP_337 vssd1 vccd1 sky130_fd_sc_hd__tapvpwrvgnd_1
XTAP_326 vssd1 vccd1 sky130_fd_sc_hd__tapvpwrvgnd_1
XTAP_359 vssd1 vccd1 sky130_fd_sc_hd__tapvpwrvgnd_1
X_05850_ _00226_ _00230_ vssd1 vssd1 vccd1 vccd1 _00231_ sky130_fd_sc_hd__nand2_1
Xrebuffer17 net661 vssd1 vssd1 vccd1 vccd1 net662 sky130_fd_sc_hd__clkbuf_1
X_07520_ net277 net482 net491 net269 vssd1 vssd1 vccd1 vccd1 _01893_ sky130_fd_sc_hd__a22o_1
X_05781_ _00160_ _00162_ vssd1 vssd1 vccd1 vccd1 _00163_ sky130_fd_sc_hd__nand2b_1
Xrebuffer39 _00358_ vssd1 vssd1 vccd1 vccd1 net684 sky130_fd_sc_hd__buf_1
XFILLER_0_16_40 vssd1 vssd1 vccd1 vccd1 sky130_ef_sc_hd__decap_12
Xrebuffer28 net672 vssd1 vssd1 vccd1 vccd1 net673 sky130_fd_sc_hd__clkbuf_1
XFILLER_0_88_153 vssd1 vssd1 vccd1 vccd1 sky130_fd_sc_hd__fill_2
X_07451_ _01816_ _01817_ _01694_ vssd1 vssd1 vccd1 vccd1 _01819_ sky130_fd_sc_hd__a21o_1
X_07382_ net223 net231 net537 net547 vssd1 vssd1 vccd1 vccd1 _01751_ sky130_fd_sc_hd__nand4_2
X_06402_ _00654_ _00777_ vssd1 vssd1 vccd1 vccd1 _00778_ sky130_fd_sc_hd__and2_1
XFILLER_0_91_329 vssd1 vssd1 vccd1 vccd1 sky130_fd_sc_hd__decap_6
X_09121_ _03575_ _03576_ vssd1 vssd1 vccd1 vccd1 _03577_ sky130_fd_sc_hd__xor2_1
X_06333_ _00516_ _00519_ _00708_ _00709_ vssd1 vssd1 vccd1 vccd1 _00710_ sky130_fd_sc_hd__a211o_1
XFILLER_0_29_275 vssd1 vssd1 vccd1 vccd1 sky130_fd_sc_hd__decap_4
XFILLER_0_72_565 vssd1 vssd1 vccd1 vccd1 sky130_fd_sc_hd__fill_1
XFILLER_0_44_256 vssd1 vssd1 vccd1 vccd1 sky130_fd_sc_hd__fill_1
X_09052_ _03308_ _03348_ _03501_ vssd1 vssd1 vccd1 vccd1 _03502_ sky130_fd_sc_hd__o21a_1
XFILLER_0_72_587 vssd1 vssd1 vccd1 vccd1 sky130_fd_sc_hd__fill_1
X_06264_ _00500_ _00522_ _00640_ vssd1 vssd1 vccd1 vccd1 _00641_ sky130_fd_sc_hd__a21oi_4
X_08003_ _02369_ _02370_ _02375_ vssd1 vssd1 vccd1 vccd1 _02376_ sky130_fd_sc_hd__nand3_1
X_05215_ _03542_ _03760_ _03891_ vssd1 vssd1 vccd1 vccd1 _03902_ sky130_fd_sc_hd__nand3_1
X_06195_ _00538_ _00571_ _00572_ vssd1 vssd1 vccd1 vccd1 _00573_ sky130_fd_sc_hd__and3_1
X_05146_ net377 net385 net559 net568 vssd1 vssd1 vccd1 vccd1 _03148_ sky130_fd_sc_hd__and4_1
XFILLER_0_12_197 vssd1 vssd1 vccd1 vccd1 sky130_fd_sc_hd__decap_4
XFILLER_0_12_186 vssd1 vssd1 vccd1 vccd1 sky130_fd_sc_hd__decap_4
XFILLER_0_40_484 vssd1 vssd1 vccd1 vccd1 sky130_fd_sc_hd__decap_4
XFILLER_0_40_495 vssd1 vssd1 vccd1 vccd1 sky130_ef_sc_hd__decap_12
X_05077_ net10 net510 net124 vssd1 vssd1 vccd1 vccd1 _00081_ sky130_fd_sc_hd__mux2_1
X_09954_ _04483_ _04486_ vssd1 vssd1 vccd1 vccd1 _04487_ sky130_fd_sc_hd__xnor2_1
X_08905_ _03326_ _03338_ _03340_ vssd1 vssd1 vccd1 vccd1 _03341_ sky130_fd_sc_hd__or3_2
X_09885_ _04411_ vssd1 vssd1 vccd1 vccd1 _04412_ sky130_fd_sc_hd__inv_2
XTAP_871 vssd1 vccd1 sky130_fd_sc_hd__tapvpwrvgnd_1
XTAP_860 vssd1 vccd1 sky130_fd_sc_hd__tapvpwrvgnd_1
X_08836_ net201 net207 net480 net493 _03119_ vssd1 vssd1 vccd1 vccd1 _03265_ sky130_fd_sc_hd__a41o_1
XTAP_893 vssd1 vccd1 sky130_fd_sc_hd__tapvpwrvgnd_1
XTAP_882 vssd1 vccd1 sky130_fd_sc_hd__tapvpwrvgnd_1
XFILLER_0_99_429 vssd1 vssd1 vccd1 vccd1 sky130_fd_sc_hd__decap_3
X_08767_ _03187_ _03188_ _03174_ vssd1 vssd1 vccd1 vccd1 _03190_ sky130_fd_sc_hd__a21o_1
X_05979_ _00255_ _00257_ _00356_ _00357_ vssd1 vssd1 vccd1 vccd1 _00359_ sky130_fd_sc_hd__a211o_1
X_08698_ net201 net499 _02946_ _02947_ net515 vssd1 vssd1 vccd1 vccd1 _03114_ sky130_fd_sc_hd__a32o_1
X_07718_ _02087_ _02088_ _02056_ vssd1 vssd1 vccd1 vccd1 _02090_ sky130_fd_sc_hd__o21ba_1
XFILLER_0_94_134 vssd1 vssd1 vccd1 vccd1 sky130_fd_sc_hd__decap_6
XFILLER_0_67_337 vssd1 vssd1 vccd1 vccd1 sky130_ef_sc_hd__decap_12
X_07649_ net350 net421 _02018_ _02019_ vssd1 vssd1 vccd1 vccd1 _02021_ sky130_fd_sc_hd__nand4_2
X_09319_ _03602_ _03604_ _03791_ _03792_ vssd1 vssd1 vccd1 vccd1 _03794_ sky130_fd_sc_hd__a211o_1
XFILLER_0_90_362 vssd1 vssd1 vccd1 vccd1 sky130_fd_sc_hd__fill_2
XFILLER_0_63_587 vssd1 vssd1 vccd1 vccd1 sky130_fd_sc_hd__fill_1
XFILLER_0_50_259 vssd1 vssd1 vccd1 vccd1 sky130_fd_sc_hd__fill_1
Xoutput42 net42 vssd1 vssd1 vccd1 vccd1 wbs_dat_o[11] sky130_fd_sc_hd__clkbuf_4
Xoutput64 net64 vssd1 vssd1 vccd1 vccd1 wbs_dat_o[31] sky130_fd_sc_hd__buf_6
XFILLER_0_101_361 vssd1 vssd1 vccd1 vccd1 sky130_fd_sc_hd__decap_3
Xoutput53 net53 vssd1 vssd1 vccd1 vccd1 wbs_dat_o[21] sky130_fd_sc_hd__clkbuf_4
X_10025_ net642 vssd1 vssd1 vccd1 vccd1 _00021_ sky130_fd_sc_hd__inv_2
XFILLER_0_53_38 vssd1 vssd1 vccd1 vccd1 sky130_fd_sc_hd__decap_8
XFILLER_0_58_359 vssd1 vssd1 vccd1 vccd1 sky130_fd_sc_hd__decap_4
XFILLER_0_58_326 vssd1 vssd1 vccd1 vccd1 sky130_fd_sc_hd__decap_8
XPHY_170 vssd1 vssd1 vccd1 vccd1 sky130_fd_sc_hd__decap_3
XFILLER_0_66_381 vssd1 vssd1 vccd1 vccd1 sky130_fd_sc_hd__decap_6
XFILLER_0_39_595 vssd1 vssd1 vccd1 vccd1 sky130_fd_sc_hd__fill_1
XPHY_192 vssd1 vssd1 vccd1 vccd1 sky130_fd_sc_hd__decap_3
XPHY_181 vssd1 vssd1 vccd1 vccd1 sky130_fd_sc_hd__decap_3
XFILLER_0_5_128 vssd1 vssd1 vccd1 vccd1 sky130_fd_sc_hd__fill_2
XFILLER_0_41_215 vssd1 vssd1 vccd1 vccd1 sky130_fd_sc_hd__decap_8
XFILLER_0_78_24 vssd1 vssd1 vccd1 vccd1 sky130_fd_sc_hd__decap_4
XFILLER_0_41_237 vssd1 vssd1 vccd1 vccd1 sky130_fd_sc_hd__decap_8
XFILLER_0_78_46 vssd1 vssd1 vccd1 vccd1 sky130_fd_sc_hd__decap_3
XFILLER_0_1_389 vssd1 vssd1 vccd1 vccd1 sky130_fd_sc_hd__decap_3
Xfanout309 mul.a\[10\] vssd1 vssd1 vccd1 vccd1 net309 sky130_fd_sc_hd__clkbuf_4
X_06951_ _01320_ _01321_ _01322_ vssd1 vssd1 vccd1 vccd1 _01323_ sky130_fd_sc_hd__nand3_1
X_05902_ net625 net142 net128 net383 vssd1 vssd1 vccd1 vccd1 _00283_ sky130_fd_sc_hd__a22o_1
X_09670_ _04026_ _04028_ vssd1 vssd1 vccd1 vccd1 _04177_ sky130_fd_sc_hd__nor2_1
X_08621_ _03027_ _03029_ _03030_ vssd1 vssd1 vccd1 vccd1 _03031_ sky130_fd_sc_hd__nand3_2
X_06882_ _01251_ _01252_ vssd1 vssd1 vccd1 vccd1 _01254_ sky130_fd_sc_hd__xor2_1
X_05833_ _00210_ _00213_ vssd1 vssd1 vccd1 vccd1 _00214_ sky130_fd_sc_hd__and2b_1
X_08552_ _02952_ _02953_ _02954_ vssd1 vssd1 vccd1 vccd1 _02955_ sky130_fd_sc_hd__and3_2
X_05764_ _00143_ _00144_ _00145_ vssd1 vssd1 vccd1 vccd1 _00146_ sky130_fd_sc_hd__nand3_1
XFILLER_0_49_315 vssd1 vssd1 vccd1 vccd1 sky130_ef_sc_hd__decap_12
X_08483_ _02673_ _02682_ _02681_ vssd1 vssd1 vccd1 vccd1 _02880_ sky130_fd_sc_hd__o21bai_1
XFILLER_0_76_123 vssd1 vssd1 vccd1 vccd1 sky130_fd_sc_hd__decap_6
X_07503_ net340 net432 vssd1 vssd1 vccd1 vccd1 _01875_ sky130_fd_sc_hd__nand2_1
XFILLER_0_49_337 vssd1 vssd1 vccd1 vccd1 sky130_ef_sc_hd__decap_12
X_05695_ _04878_ _04963_ _04964_ vssd1 vssd1 vccd1 vccd1 _04965_ sky130_fd_sc_hd__nand3_1
X_07434_ net159 net628 net636 net154 vssd1 vssd1 vccd1 vccd1 _01802_ sky130_fd_sc_hd__a22o_1
XFILLER_0_64_318 vssd1 vssd1 vccd1 vccd1 sky130_fd_sc_hd__decap_3
XFILLER_0_57_381 vssd1 vssd1 vccd1 vccd1 sky130_fd_sc_hd__decap_3
X_07365_ _01731_ _01732_ _01581_ _01583_ vssd1 vssd1 vccd1 vccd1 _01734_ sky130_fd_sc_hd__o211a_1
X_09104_ _02282_ _03555_ _03558_ vssd1 vssd1 vccd1 vccd1 _03559_ sky130_fd_sc_hd__o21a_4
X_06316_ _00658_ _00690_ _00691_ vssd1 vssd1 vccd1 vccd1 _00693_ sky130_fd_sc_hd__nand3_2
X_07296_ _01510_ _01515_ _01663_ vssd1 vssd1 vccd1 vccd1 _01665_ sky130_fd_sc_hd__nor3_1
X_09035_ _03284_ _03286_ _03481_ _03482_ vssd1 vssd1 vccd1 vccd1 _03483_ sky130_fd_sc_hd__a211o_1
X_06247_ net252 net590 _00622_ _00623_ vssd1 vssd1 vccd1 vccd1 _00624_ sky130_fd_sc_hd__nand4_2
XFILLER_0_60_579 vssd1 vssd1 vccd1 vccd1 sky130_fd_sc_hd__fill_2
XFILLER_0_13_473 vssd1 vssd1 vccd1 vccd1 sky130_fd_sc_hd__decap_8
X_06178_ net301 net310 net530 net540 vssd1 vssd1 vccd1 vccd1 _00556_ sky130_fd_sc_hd__nand4_2
X_05129_ _02875_ _02940_ _02951_ vssd1 vssd1 vccd1 vccd1 _02962_ sky130_fd_sc_hd__and3_1
X_09937_ net191 net428 _04320_ _04322_ vssd1 vssd1 vccd1 vccd1 _04468_ sky130_fd_sc_hd__a211o_1
X_09868_ _04360_ _04392_ vssd1 vssd1 vccd1 vccd1 _04393_ sky130_fd_sc_hd__xnor2_1
XTAP_690 vssd1 vccd1 sky130_fd_sc_hd__tapvpwrvgnd_1
X_08819_ net156 net161 net697 net544 vssd1 vssd1 vccd1 vccd1 _03247_ sky130_fd_sc_hd__and4_1
X_09799_ net151 net497 _04168_ _04166_ vssd1 vssd1 vccd1 vccd1 _04318_ sky130_fd_sc_hd__a31o_1
XFILLER_0_95_443 vssd1 vssd1 vccd1 vccd1 sky130_fd_sc_hd__fill_1
XFILLER_0_67_189 vssd1 vssd1 vccd1 vccd1 sky130_fd_sc_hd__decap_8
XFILLER_0_63_373 vssd1 vssd1 vccd1 vccd1 sky130_fd_sc_hd__fill_1
XFILLER_0_36_587 vssd1 vssd1 vccd1 vccd1 sky130_fd_sc_hd__fill_1
Xrebuffer8 _01335_ vssd1 vssd1 vccd1 vccd1 net653 sky130_fd_sc_hd__buf_1
XFILLER_0_31_270 vssd1 vssd1 vccd1 vccd1 sky130_fd_sc_hd__fill_1
XFILLER_0_31_281 vssd1 vssd1 vccd1 vccd1 sky130_fd_sc_hd__fill_1
XFILLER_0_48_27 vssd1 vssd1 vccd1 vccd1 sky130_fd_sc_hd__fill_1
X_10008_ net638 vssd1 vssd1 vccd1 vccd1 _00004_ sky130_fd_sc_hd__inv_2
XFILLER_0_86_421 vssd1 vssd1 vccd1 vccd1 sky130_fd_sc_hd__decap_4
XFILLER_0_46_307 vssd1 vssd1 vccd1 vccd1 sky130_fd_sc_hd__fill_1
XFILLER_0_86_498 vssd1 vssd1 vccd1 vccd1 sky130_fd_sc_hd__decap_4
XFILLER_0_80_58 vssd1 vssd1 vccd1 vccd1 sky130_fd_sc_hd__fill_2
X_05480_ net339 net351 net562 net570 vssd1 vssd1 vccd1 vccd1 _04750_ sky130_fd_sc_hd__and4_1
XFILLER_0_39_381 vssd1 vssd1 vccd1 vccd1 sky130_fd_sc_hd__decap_4
XFILLER_0_73_137 vssd1 vssd1 vccd1 vccd1 sky130_fd_sc_hd__fill_1
XFILLER_0_89_12 vssd1 vssd1 vccd1 vccd1 sky130_fd_sc_hd__decap_3
XFILLER_0_6_459 vssd1 vssd1 vccd1 vccd1 sky130_fd_sc_hd__fill_2
XFILLER_0_13_96 vssd1 vssd1 vccd1 vccd1 sky130_fd_sc_hd__fill_1
X_07150_ _01373_ _01519_ vssd1 vssd1 vccd1 vccd1 _01520_ sky130_fd_sc_hd__nand2_1
X_07081_ net285 net498 vssd1 vssd1 vccd1 vccd1 _01452_ sky130_fd_sc_hd__nand2_1
X_06101_ _00383_ _00479_ vssd1 vssd1 vccd1 vccd1 _00480_ sky130_fd_sc_hd__nor2_1
XFILLER_0_89_89 vssd1 vssd1 vccd1 vccd1 sky130_fd_sc_hd__decap_8
X_06032_ _00307_ _00312_ _00410_ vssd1 vssd1 vccd1 vccd1 _00411_ sky130_fd_sc_hd__o21a_1
XFILLER_0_10_421 vssd1 vssd1 vccd1 vccd1 sky130_fd_sc_hd__decap_6
Xfanout117 net118 vssd1 vssd1 vccd1 vccd1 net117 sky130_fd_sc_hd__clkbuf_8
Xfanout128 _00184_ vssd1 vssd1 vccd1 vccd1 net128 sky130_fd_sc_hd__clkbuf_4
X_07983_ _02342_ _02354_ _02355_ vssd1 vssd1 vccd1 vccd1 _02356_ sky130_fd_sc_hd__and3_1
X_09722_ _04076_ _04080_ _04231_ _04233_ vssd1 vssd1 vccd1 vccd1 _04234_ sky130_fd_sc_hd__o211a_1
Xfanout139 net141 vssd1 vssd1 vccd1 vccd1 net139 sky130_fd_sc_hd__clkbuf_4
X_06934_ net323 net470 _01304_ _01305_ vssd1 vssd1 vccd1 vccd1 _01306_ sky130_fd_sc_hd__a22o_1
X_09653_ _03842_ _03844_ _04002_ _03849_ vssd1 vssd1 vccd1 vccd1 _04159_ sky130_fd_sc_hd__a31o_1
X_06865_ _01235_ _01236_ vssd1 vssd1 vccd1 vccd1 _01237_ sky130_fd_sc_hd__nor2_1
X_08604_ _03010_ _03011_ vssd1 vssd1 vccd1 vccd1 _03012_ sky130_fd_sc_hd__and2_1
X_09584_ _04079_ _04081_ _03927_ _03930_ vssd1 vssd1 vccd1 vccd1 _04083_ sky130_fd_sc_hd__a211oi_1
X_05816_ _04981_ _04985_ _00195_ vssd1 vssd1 vccd1 vccd1 _00197_ sky130_fd_sc_hd__nand3_1
XTAP_1119 vssd1 vccd1 sky130_fd_sc_hd__tapvpwrvgnd_1
XTAP_1108 vssd1 vccd1 sky130_fd_sc_hd__tapvpwrvgnd_1
X_08535_ net619 _02120_ _02715_ _02900_ _02118_ vssd1 vssd1 vccd1 vccd1 _02936_ sky130_fd_sc_hd__a32o_1
X_06796_ net313 net496 _01049_ _01050_ net512 vssd1 vssd1 vccd1 vccd1 _01169_ sky130_fd_sc_hd__a32o_1
X_05747_ net312 net322 net563 net571 vssd1 vssd1 vccd1 vccd1 _05017_ sky130_fd_sc_hd__and4_1
X_08466_ _02685_ _02693_ _02692_ vssd1 vssd1 vccd1 vccd1 _02861_ sky130_fd_sc_hd__a21bo_1
XFILLER_0_9_220 vssd1 vssd1 vccd1 vccd1 sky130_fd_sc_hd__decap_4
X_05678_ net390 net496 vssd1 vssd1 vccd1 vccd1 _04948_ sky130_fd_sc_hd__nand2_1
XFILLER_0_49_189 vssd1 vssd1 vccd1 vccd1 sky130_fd_sc_hd__decap_6
X_08397_ _02778_ _02779_ _02784_ vssd1 vssd1 vccd1 vccd1 _02785_ sky130_fd_sc_hd__nand3_1
X_07417_ _01517_ _01520_ _01784_ _01785_ vssd1 vssd1 vccd1 vccd1 _01786_ sky130_fd_sc_hd__a211oi_2
X_07348_ _01716_ vssd1 vssd1 vccd1 vccd1 _01717_ sky130_fd_sc_hd__inv_2
XFILLER_0_33_513 vssd1 vssd1 vccd1 vccd1 sky130_fd_sc_hd__fill_2
XFILLER_0_60_332 vssd1 vssd1 vccd1 vccd1 sky130_fd_sc_hd__decap_4
XFILLER_0_45_384 vssd1 vssd1 vccd1 vccd1 sky130_fd_sc_hd__decap_8
X_07279_ _01500_ _01647_ _01648_ vssd1 vssd1 vccd1 vccd1 _01649_ sky130_fd_sc_hd__o21a_1
X_09018_ net315 net136 _03463_ _03310_ vssd1 vssd1 vccd1 vccd1 _03464_ sky130_fd_sc_hd__o22a_1
XFILLER_0_20_218 vssd1 vssd1 vccd1 vccd1 sky130_ef_sc_hd__decap_12
Xfanout640 net641 vssd1 vssd1 vccd1 vccd1 net640 sky130_fd_sc_hd__clkbuf_4
XFILLER_0_34_29 vssd1 vssd1 vccd1 vccd1 sky130_ef_sc_hd__decap_12
XFILLER_0_83_402 vssd1 vssd1 vccd1 vccd1 sky130_ef_sc_hd__decap_12
XFILLER_0_83_446 vssd1 vssd1 vccd1 vccd1 sky130_fd_sc_hd__fill_2
XFILLER_0_70_118 vssd1 vssd1 vccd1 vccd1 sky130_fd_sc_hd__decap_8
XFILLER_0_36_351 vssd1 vssd1 vccd1 vccd1 sky130_fd_sc_hd__fill_1
XFILLER_0_51_332 vssd1 vssd1 vccd1 vccd1 sky130_fd_sc_hd__decap_4
XFILLER_0_3_418 vssd1 vssd1 vccd1 vccd1 sky130_fd_sc_hd__decap_8
XFILLER_0_36_373 vssd1 vssd1 vccd1 vccd1 sky130_fd_sc_hd__decap_8
XFILLER_0_59_48 vssd1 vssd1 vccd1 vccd1 sky130_fd_sc_hd__decap_8
X_06650_ net347 net357 net456 net461 vssd1 vssd1 vccd1 vccd1 _01024_ sky130_fd_sc_hd__nand4_4
XFILLER_0_91_57 vssd1 vssd1 vccd1 vccd1 sky130_fd_sc_hd__decap_6
X_05601_ _04860_ _04870_ vssd1 vssd1 vccd1 vccd1 _04871_ sky130_fd_sc_hd__and2b_1
X_06581_ _00842_ _00955_ vssd1 vssd1 vccd1 vccd1 _00956_ sky130_fd_sc_hd__nand2b_1
X_08320_ _02698_ _02699_ _02684_ vssd1 vssd1 vccd1 vccd1 _02702_ sky130_fd_sc_hd__a21oi_1
X_05532_ _04695_ _04716_ net103 _04801_ vssd1 vssd1 vccd1 vccd1 _04802_ sky130_fd_sc_hd__a211oi_2
XFILLER_0_24_62 vssd1 vssd1 vccd1 vccd1 sky130_fd_sc_hd__decap_8
X_08251_ net237 net483 net492 net228 vssd1 vssd1 vccd1 vccd1 _02626_ sky130_fd_sc_hd__a22o_1
XFILLER_0_6_201 vssd1 vssd1 vccd1 vccd1 sky130_fd_sc_hd__fill_1
X_05463_ _04066_ _04099_ _04732_ vssd1 vssd1 vccd1 vccd1 _04733_ sky130_fd_sc_hd__or3_1
X_07202_ net358 net429 _01570_ _01571_ vssd1 vssd1 vccd1 vccd1 _01572_ sky130_fd_sc_hd__a22o_1
XFILLER_0_27_351 vssd1 vssd1 vccd1 vccd1 sky130_fd_sc_hd__decap_3
XFILLER_0_46_159 vssd1 vssd1 vccd1 vccd1 sky130_fd_sc_hd__fill_1
X_08182_ _02551_ _02552_ _02553_ vssd1 vssd1 vccd1 vccd1 _02554_ sky130_fd_sc_hd__and3_1
X_05394_ net374 net615 net632 _04662_ vssd1 vssd1 vccd1 vccd1 _04664_ sky130_fd_sc_hd__a31o_1
XFILLER_0_42_321 vssd1 vssd1 vccd1 vccd1 sky130_ef_sc_hd__decap_12
XFILLER_0_15_568 vssd1 vssd1 vccd1 vccd1 sky130_fd_sc_hd__decap_6
XFILLER_0_40_83 vssd1 vssd1 vccd1 vccd1 sky130_fd_sc_hd__fill_1
X_07133_ _01402_ _01418_ _01416_ vssd1 vssd1 vccd1 vccd1 _01503_ sky130_fd_sc_hd__a21oi_1
XFILLER_0_42_365 vssd1 vssd1 vccd1 vccd1 sky130_ef_sc_hd__decap_12
X_07064_ _01432_ _01433_ _01420_ vssd1 vssd1 vccd1 vccd1 _01435_ sky130_fd_sc_hd__a21oi_1
XFILLER_0_64_3 vssd1 vssd1 vccd1 vccd1 sky130_fd_sc_hd__decap_3
XFILLER_0_2_473 vssd1 vssd1 vccd1 vccd1 sky130_fd_sc_hd__decap_3
X_06015_ _00289_ _00293_ _00393_ vssd1 vssd1 vccd1 vccd1 _00394_ sky130_fd_sc_hd__a21o_1
XFILLER_0_10_240 vssd1 vssd1 vccd1 vccd1 sky130_ef_sc_hd__decap_12
XFILLER_0_2_495 vssd1 vssd1 vccd1 vccd1 sky130_fd_sc_hd__fill_1
XFILLER_0_10_295 vssd1 vssd1 vccd1 vccd1 sky130_ef_sc_hd__decap_12
X_07966_ _02336_ _02337_ _02338_ vssd1 vssd1 vccd1 vccd1 _02339_ sky130_fd_sc_hd__and3_1
XFILLER_0_4_83 vssd1 vssd1 vccd1 vccd1 sky130_fd_sc_hd__fill_1
X_09705_ _04212_ _04213_ _04057_ _04059_ vssd1 vssd1 vccd1 vccd1 _04215_ sky130_fd_sc_hd__o211ai_1
X_06917_ net330 net338 net456 net463 vssd1 vssd1 vccd1 vccd1 _01289_ sky130_fd_sc_hd__nand4_4
X_09636_ _03964_ _03991_ _04139_ vssd1 vssd1 vccd1 vccd1 _04140_ sky130_fd_sc_hd__o21a_1
XFILLER_0_97_505 vssd1 vssd1 vccd1 vccd1 sky130_fd_sc_hd__decap_4
XFILLER_0_65_91 vssd1 vssd1 vccd1 vccd1 sky130_ef_sc_hd__decap_12
X_07897_ _02113_ _02269_ _02270_ vssd1 vssd1 vccd1 vccd1 _02271_ sky130_fd_sc_hd__nand3_2
X_06848_ _00966_ _01095_ _01092_ vssd1 vssd1 vccd1 vccd1 _01221_ sky130_fd_sc_hd__a21o_1
XFILLER_0_77_240 vssd1 vssd1 vccd1 vccd1 sky130_fd_sc_hd__fill_1
X_09567_ _04041_ _04063_ vssd1 vssd1 vccd1 vccd1 _04064_ sky130_fd_sc_hd__xor2_2
X_06779_ _01150_ _01151_ vssd1 vssd1 vccd1 vccd1 _01152_ sky130_fd_sc_hd__and2b_1
X_09498_ _03966_ _03987_ vssd1 vssd1 vccd1 vccd1 _03989_ sky130_fd_sc_hd__xnor2_4
XFILLER_0_77_262 vssd1 vssd1 vccd1 vccd1 sky130_fd_sc_hd__decap_6
X_08518_ _02753_ _02756_ _02916_ _02917_ vssd1 vssd1 vccd1 vccd1 _02918_ sky130_fd_sc_hd__o211a_1
XFILLER_0_65_402 vssd1 vssd1 vccd1 vccd1 sky130_fd_sc_hd__fill_1
X_08449_ net341 net398 _02840_ _02841_ vssd1 vssd1 vccd1 vccd1 _02843_ sky130_fd_sc_hd__a22o_1
XFILLER_0_37_137 vssd1 vssd1 vccd1 vccd1 sky130_fd_sc_hd__fill_1
XFILLER_0_21_505 vssd1 vssd1 vccd1 vccd1 sky130_fd_sc_hd__decap_6
XFILLER_0_33_343 vssd1 vssd1 vccd1 vccd1 sky130_fd_sc_hd__fill_1
XFILLER_0_29_18 vssd1 vssd1 vccd1 vccd1 sky130_ef_sc_hd__decap_12
Xfanout492 net493 vssd1 vssd1 vccd1 vccd1 net492 sky130_fd_sc_hd__buf_4
Xfanout481 net484 vssd1 vssd1 vccd1 vccd1 net481 sky130_fd_sc_hd__clkbuf_4
Xfanout470 net475 vssd1 vssd1 vccd1 vccd1 net470 sky130_fd_sc_hd__buf_2
XFILLER_0_45_39 vssd1 vssd1 vccd1 vccd1 sky130_ef_sc_hd__decap_12
Xmax_cap6 _00267_ vssd1 vssd1 vccd1 vccd1 net716 sky130_fd_sc_hd__clkbuf_1
XFILLER_0_68_251 vssd1 vssd1 vccd1 vccd1 sky130_fd_sc_hd__fill_1
XFILLER_0_61_27 vssd1 vssd1 vccd1 vccd1 sky130_fd_sc_hd__decap_3
XFILLER_0_28_115 vssd1 vssd1 vccd1 vccd1 sky130_fd_sc_hd__decap_4
XFILLER_0_83_276 vssd1 vssd1 vccd1 vccd1 sky130_fd_sc_hd__decap_4
XFILLER_0_71_427 vssd1 vssd1 vccd1 vccd1 sky130_fd_sc_hd__decap_4
XFILLER_0_24_321 vssd1 vssd1 vccd1 vccd1 sky130_fd_sc_hd__decap_8
XFILLER_0_10_20 vssd1 vssd1 vccd1 vccd1 sky130_fd_sc_hd__fill_1
XFILLER_0_3_237 vssd1 vssd1 vccd1 vccd1 sky130_fd_sc_hd__fill_2
XFILLER_0_24_365 vssd1 vssd1 vccd1 vccd1 sky130_ef_sc_hd__decap_12
XFILLER_0_51_184 vssd1 vssd1 vccd1 vccd1 sky130_fd_sc_hd__decap_3
XFILLER_0_20_560 vssd1 vssd1 vccd1 vccd1 sky130_ef_sc_hd__decap_12
X_07820_ _02186_ _02188_ _02174_ vssd1 vssd1 vccd1 vccd1 _02191_ sky130_fd_sc_hd__o21a_1
X_07751_ net154 net618 vssd1 vssd1 vccd1 vccd1 _02122_ sky130_fd_sc_hd__nand2_1
XFILLER_0_79_505 vssd1 vssd1 vccd1 vccd1 sky130_fd_sc_hd__decap_4
X_06702_ _01015_ _01074_ _01075_ vssd1 vssd1 vccd1 vccd1 _01076_ sky130_fd_sc_hd__and3_1
X_07682_ _01883_ _01885_ _02051_ _02053_ vssd1 vssd1 vccd1 vccd1 _02054_ sky130_fd_sc_hd__a211o_1
X_06633_ _00899_ _00901_ vssd1 vssd1 vccd1 vccd1 _01007_ sky130_fd_sc_hd__or2_1
X_09421_ _03903_ _03904_ vssd1 vssd1 vccd1 vccd1 _03905_ sky130_fd_sc_hd__or2_1
X_09352_ _03682_ _03685_ _03828_ _03829_ vssd1 vssd1 vccd1 vccd1 _03830_ sky130_fd_sc_hd__a211oi_2
X_06564_ net671 _00814_ _00937_ _00938_ vssd1 vssd1 vccd1 vccd1 _00939_ sky130_fd_sc_hd__o211ai_4
X_08303_ _02681_ _02682_ vssd1 vssd1 vccd1 vccd1 _02683_ sky130_fd_sc_hd__or2_1
X_05515_ _04783_ _04784_ vssd1 vssd1 vccd1 vccd1 _04785_ sky130_fd_sc_hd__nor2_1
XFILLER_0_47_435 vssd1 vssd1 vccd1 vccd1 sky130_ef_sc_hd__decap_12
XFILLER_0_74_265 vssd1 vssd1 vccd1 vccd1 sky130_fd_sc_hd__decap_4
X_09283_ net192 net200 net458 net465 vssd1 vssd1 vccd1 vccd1 _03754_ sky130_fd_sc_hd__and4_1
XFILLER_0_19_159 vssd1 vssd1 vccd1 vccd1 sky130_fd_sc_hd__decap_8
X_06495_ _00740_ _00744_ _00869_ vssd1 vssd1 vccd1 vccd1 _00870_ sky130_fd_sc_hd__a21o_1
XFILLER_0_34_107 vssd1 vssd1 vccd1 vccd1 sky130_fd_sc_hd__decap_3
X_08234_ net193 net527 _02604_ _02606_ vssd1 vssd1 vccd1 vccd1 _02607_ sky130_fd_sc_hd__a22o_1
XFILLER_0_51_82 vssd1 vssd1 vccd1 vccd1 sky130_fd_sc_hd__fill_1
X_05446_ _04694_ _04696_ _04713_ _04714_ vssd1 vssd1 vccd1 vccd1 _04716_ sky130_fd_sc_hd__or4_2
X_08165_ _02516_ _02517_ _02535_ _02536_ vssd1 vssd1 vccd1 vccd1 _02537_ sky130_fd_sc_hd__and4bb_1
XFILLER_0_15_343 vssd1 vssd1 vccd1 vccd1 sky130_fd_sc_hd__fill_2
XFILLER_0_27_181 vssd1 vssd1 vccd1 vccd1 sky130_fd_sc_hd__decap_3
X_05377_ net615 _04601_ _04640_ _04646_ vssd1 vssd1 vccd1 vccd1 _04647_ sky130_fd_sc_hd__a31oi_2
X_07116_ _01346_ _01348_ _01485_ _01486_ vssd1 vssd1 vccd1 vccd1 _01487_ sky130_fd_sc_hd__a211oi_4
X_08096_ net160 net593 _02465_ _02466_ vssd1 vssd1 vccd1 vccd1 _02468_ sky130_fd_sc_hd__a22o_1
XFILLER_0_42_195 vssd1 vssd1 vccd1 vccd1 sky130_fd_sc_hd__fill_1
X_07047_ _01416_ _01417_ vssd1 vssd1 vccd1 vccd1 _01418_ sky130_fd_sc_hd__nor2_1
X_08998_ net208 net216 net458 net465 vssd1 vssd1 vccd1 vccd1 _03442_ sky130_fd_sc_hd__and4_1
X_07949_ _02302_ _02321_ vssd1 vssd1 vccd1 vccd1 _02322_ sky130_fd_sc_hd__xor2_1
XFILLER_0_97_335 vssd1 vssd1 vccd1 vccd1 sky130_fd_sc_hd__fill_1
X_09619_ net123 _04119_ vssd1 vssd1 vccd1 vccd1 _04122_ sky130_fd_sc_hd__xnor2_1
XFILLER_0_80_224 vssd1 vssd1 vccd1 vccd1 sky130_ef_sc_hd__decap_12
XFILLER_0_53_449 vssd1 vssd1 vccd1 vccd1 sky130_fd_sc_hd__decap_6
XFILLER_0_21_324 vssd1 vssd1 vccd1 vccd1 sky130_fd_sc_hd__decap_6
XFILLER_0_21_335 vssd1 vssd1 vccd1 vccd1 sky130_fd_sc_hd__fill_1
XTAP_508 vssd1 vccd1 sky130_fd_sc_hd__tapvpwrvgnd_1
XTAP_519 vssd1 vccd1 sky130_fd_sc_hd__tapvpwrvgnd_1
XFILLER_0_88_379 vssd1 vssd1 vccd1 vccd1 sky130_fd_sc_hd__fill_1
XTAP_1291 vssd1 vccd1 sky130_fd_sc_hd__tapvpwrvgnd_1
XTAP_1280 vssd1 vccd1 sky130_fd_sc_hd__tapvpwrvgnd_1
XFILLER_0_44_405 vssd1 vssd1 vccd1 vccd1 sky130_fd_sc_hd__decap_4
X_06280_ _00546_ _00548_ _00655_ vssd1 vssd1 vccd1 vccd1 _00657_ sky130_fd_sc_hd__and3_1
X_05300_ _03815_ _04561_ _04566_ vssd1 vssd1 vccd1 vccd1 _04570_ sky130_fd_sc_hd__a21o_1
XFILLER_0_71_235 vssd1 vssd1 vccd1 vccd1 sky130_fd_sc_hd__decap_8
X_05231_ net381 net387 net530 net540 vssd1 vssd1 vccd1 vccd1 _04077_ sky130_fd_sc_hd__and4_1
XFILLER_0_4_513 vssd1 vssd1 vccd1 vccd1 sky130_fd_sc_hd__fill_1
XFILLER_0_12_313 vssd1 vssd1 vccd1 vccd1 sky130_fd_sc_hd__decap_4
XFILLER_0_12_346 vssd1 vssd1 vccd1 vccd1 sky130_fd_sc_hd__decap_6
X_05162_ _03236_ _03312_ vssd1 vssd1 vccd1 vccd1 _03323_ sky130_fd_sc_hd__nand2_1
X_09970_ _04500_ _04504_ vssd1 vssd1 vccd1 vccd1 _04505_ sky130_fd_sc_hd__xnor2_1
X_05093_ net2 net37 _01849_ _02561_ vssd1 vssd1 vccd1 vccd1 _00000_ sky130_fd_sc_hd__and4b_1
X_08921_ net153 net558 net579 net147 vssd1 vssd1 vccd1 vccd1 _03359_ sky130_fd_sc_hd__a22o_1
X_08852_ net251 net436 net442 net241 vssd1 vssd1 vccd1 vccd1 _03283_ sky130_fd_sc_hd__a22o_1
X_07803_ _02165_ _02173_ vssd1 vssd1 vccd1 vccd1 _02174_ sky130_fd_sc_hd__xor2_2
X_08783_ net158 net138 _03207_ vssd1 vssd1 vccd1 vccd1 _03208_ sky130_fd_sc_hd__a21bo_1
X_05995_ _00284_ _00374_ vssd1 vssd1 vccd1 vccd1 _00375_ sky130_fd_sc_hd__xnor2_2
XFILLER_0_27_3 vssd1 vssd1 vccd1 vccd1 sky130_fd_sc_hd__fill_1
X_07734_ _02103_ _02104_ _01807_ _01810_ vssd1 vssd1 vccd1 vccd1 _02106_ sky130_fd_sc_hd__o211a_1
XFILLER_0_46_71 vssd1 vssd1 vccd1 vccd1 sky130_fd_sc_hd__decap_3
XFILLER_0_79_335 vssd1 vssd1 vccd1 vccd1 sky130_fd_sc_hd__fill_1
X_07665_ net324 net438 vssd1 vssd1 vccd1 vccd1 _02037_ sky130_fd_sc_hd__nand2_1
X_09404_ _03872_ _03885_ vssd1 vssd1 vccd1 vccd1 _03886_ sky130_fd_sc_hd__and2_1
XFILLER_0_1_51 vssd1 vssd1 vccd1 vccd1 sky130_fd_sc_hd__fill_1
X_06616_ _00882_ _00988_ _00989_ vssd1 vssd1 vccd1 vccd1 _00990_ sky130_fd_sc_hd__nand3_1
XFILLER_0_47_221 vssd1 vssd1 vccd1 vccd1 sky130_fd_sc_hd__decap_3
X_07596_ _01966_ _01967_ vssd1 vssd1 vccd1 vccd1 _01968_ sky130_fd_sc_hd__nor2_1
X_09335_ _03808_ _03809_ _03626_ _03661_ vssd1 vssd1 vccd1 vccd1 _03811_ sky130_fd_sc_hd__a211oi_1
XFILLER_0_75_574 vssd1 vssd1 vccd1 vccd1 sky130_fd_sc_hd__fill_1
X_06547_ _00919_ _00920_ _00918_ vssd1 vssd1 vccd1 vccd1 _00922_ sky130_fd_sc_hd__a21o_1
XFILLER_0_47_254 vssd1 vssd1 vccd1 vccd1 sky130_fd_sc_hd__fill_1
X_09266_ net185 net472 _03733_ _03734_ vssd1 vssd1 vccd1 vccd1 _03735_ sky130_fd_sc_hd__a22oi_1
XFILLER_0_7_351 vssd1 vssd1 vccd1 vccd1 sky130_fd_sc_hd__decap_8
X_06478_ _00851_ _00852_ vssd1 vssd1 vccd1 vccd1 _00853_ sky130_fd_sc_hd__nor2_1
X_08217_ _02589_ vssd1 vssd1 vccd1 vccd1 _02590_ sky130_fd_sc_hd__inv_2
X_05429_ _04697_ _04698_ vssd1 vssd1 vccd1 vccd1 _04699_ sky130_fd_sc_hd__nor2_1
X_09197_ _03657_ _03658_ _03490_ _03492_ vssd1 vssd1 vccd1 vccd1 _03660_ sky130_fd_sc_hd__o211a_1
XFILLER_0_31_600 vssd1 vssd1 vccd1 vccd1 sky130_fd_sc_hd__fill_1
X_08148_ net290 net300 net438 net445 vssd1 vssd1 vccd1 vccd1 _02520_ sky130_fd_sc_hd__nand4_4
XFILLER_0_101_510 vssd1 vssd1 vccd1 vccd1 sky130_ef_sc_hd__decap_12
X_08079_ _02445_ _02450_ vssd1 vssd1 vccd1 vccd1 _02451_ sky130_fd_sc_hd__and2b_1
XFILLER_0_101_543 vssd1 vssd1 vccd1 vccd1 sky130_fd_sc_hd__fill_2
X_10110_ clknet_3_3_0_wb_clk_i _00104_ _00040_ vssd1 vssd1 vccd1 vccd1 mul.a\[5\]
+ sky130_fd_sc_hd__dfrtp_4
X_10041_ net638 vssd1 vssd1 vccd1 vccd1 _00037_ sky130_fd_sc_hd__inv_2
XFILLER_0_97_198 vssd1 vssd1 vccd1 vccd1 sky130_fd_sc_hd__fill_1
XFILLER_0_42_29 vssd1 vssd1 vccd1 vccd1 sky130_fd_sc_hd__decap_4
XFILLER_0_66_541 vssd1 vssd1 vccd1 vccd1 sky130_fd_sc_hd__decap_8
XFILLER_0_93_371 vssd1 vssd1 vccd1 vccd1 sky130_fd_sc_hd__decap_8
XFILLER_0_81_544 vssd1 vssd1 vccd1 vccd1 sky130_ef_sc_hd__decap_12
XFILLER_0_41_408 vssd1 vssd1 vccd1 vccd1 sky130_fd_sc_hd__fill_1
XANTENNA_6 net318 vssd1 vssd1 vccd1 vccd1 sky130_fd_sc_hd__diode_2
XFILLER_0_6_29 vssd1 vssd1 vccd1 vccd1 sky130_fd_sc_hd__decap_6
XTAP_305 vssd1 vccd1 sky130_fd_sc_hd__tapvpwrvgnd_1
XTAP_349 vssd1 vccd1 sky130_fd_sc_hd__tapvpwrvgnd_1
XTAP_338 vssd1 vccd1 sky130_fd_sc_hd__tapvpwrvgnd_1
XTAP_327 vssd1 vccd1 sky130_fd_sc_hd__tapvpwrvgnd_1
XTAP_316 vssd1 vccd1 sky130_fd_sc_hd__tapvpwrvgnd_1
Xrebuffer18 net686 vssd1 vssd1 vccd1 vccd1 net663 sky130_fd_sc_hd__clkbuf_1
X_05780_ _04933_ _04934_ _04958_ _00161_ vssd1 vssd1 vccd1 vccd1 _00162_ sky130_fd_sc_hd__o31ai_2
Xrebuffer29 _00361_ vssd1 vssd1 vccd1 vccd1 net674 sky130_fd_sc_hd__clkbuf_2
XFILLER_0_16_52 vssd1 vssd1 vccd1 vccd1 sky130_fd_sc_hd__decap_4
XFILLER_0_76_305 vssd1 vssd1 vccd1 vccd1 sky130_fd_sc_hd__decap_3
XFILLER_0_76_349 vssd1 vssd1 vccd1 vccd1 sky130_fd_sc_hd__decap_4
XFILLER_0_69_390 vssd1 vssd1 vccd1 vccd1 sky130_fd_sc_hd__fill_2
X_07450_ _01694_ _01816_ _01817_ vssd1 vssd1 vccd1 vccd1 _01818_ sky130_fd_sc_hd__and3_1
X_07381_ net224 net231 net537 net547 vssd1 vssd1 vccd1 vccd1 _01750_ sky130_fd_sc_hd__and4_1
XFILLER_0_8_104 vssd1 vssd1 vccd1 vccd1 sky130_fd_sc_hd__fill_1
X_06401_ _00764_ _00775_ vssd1 vssd1 vccd1 vccd1 _00777_ sky130_fd_sc_hd__xnor2_2
X_09120_ net172 net499 vssd1 vssd1 vccd1 vccd1 _03576_ sky130_fd_sc_hd__nand2_1
XFILLER_0_57_585 vssd1 vssd1 vccd1 vccd1 sky130_fd_sc_hd__fill_1
X_06332_ _00705_ _00707_ _00585_ _00588_ vssd1 vssd1 vccd1 vccd1 _00709_ sky130_fd_sc_hd__o211a_1
XFILLER_0_44_202 vssd1 vssd1 vccd1 vccd1 sky130_fd_sc_hd__decap_6
X_09051_ _03499_ _03500_ vssd1 vssd1 vccd1 vccd1 _03501_ sky130_fd_sc_hd__nor2_1
XFILLER_0_72_533 vssd1 vssd1 vccd1 vccd1 sky130_fd_sc_hd__decap_4
X_08002_ _02373_ _02374_ vssd1 vssd1 vccd1 vccd1 _02375_ sky130_fd_sc_hd__xor2_1
X_06263_ _00530_ _00638_ vssd1 vssd1 vccd1 vccd1 _00640_ sky130_fd_sc_hd__xnor2_2
X_06194_ _00568_ _00570_ _00452_ _00454_ vssd1 vssd1 vccd1 vccd1 _00572_ sky130_fd_sc_hd__o211ai_2
X_05214_ _03858_ _03869_ _03837_ vssd1 vssd1 vccd1 vccd1 _03891_ sky130_fd_sc_hd__a21bo_1
X_05145_ net353 net585 _02995_ _03006_ vssd1 vssd1 vccd1 vccd1 _03137_ sky130_fd_sc_hd__a22o_1
X_05076_ net11 net502 net126 vssd1 vssd1 vccd1 vccd1 _00082_ sky130_fd_sc_hd__mux2_1
X_09953_ _04484_ _04485_ vssd1 vssd1 vccd1 vccd1 _04486_ sky130_fd_sc_hd__xor2_1
X_08904_ _03182_ _03184_ _03337_ vssd1 vssd1 vccd1 vccd1 _03340_ sky130_fd_sc_hd__and3_1
X_09884_ _03670_ _04272_ _04271_ vssd1 vssd1 vccd1 vccd1 _04411_ sky130_fd_sc_hd__a21oi_1
XTAP_861 vssd1 vccd1 sky130_fd_sc_hd__tapvpwrvgnd_1
XTAP_850 vssd1 vccd1 sky130_fd_sc_hd__tapvpwrvgnd_1
X_08835_ _03260_ _03261_ _03262_ vssd1 vssd1 vccd1 vccd1 _03264_ sky130_fd_sc_hd__a21oi_2
XTAP_894 vssd1 vccd1 sky130_fd_sc_hd__tapvpwrvgnd_1
XTAP_872 vssd1 vccd1 sky130_fd_sc_hd__tapvpwrvgnd_1
XTAP_883 vssd1 vccd1 sky130_fd_sc_hd__tapvpwrvgnd_1
X_08766_ _03174_ _03187_ _03188_ vssd1 vssd1 vccd1 vccd1 _03189_ sky130_fd_sc_hd__nand3_2
XFILLER_0_79_132 vssd1 vssd1 vccd1 vccd1 sky130_fd_sc_hd__decap_8
X_07717_ _02087_ _02088_ _02056_ vssd1 vssd1 vccd1 vccd1 _02089_ sky130_fd_sc_hd__nor3b_2
X_05978_ _00255_ _00257_ _00356_ _00357_ vssd1 vssd1 vccd1 vccd1 _00358_ sky130_fd_sc_hd__a211oi_2
XFILLER_0_95_614 vssd1 vssd1 vccd1 vccd1 sky130_fd_sc_hd__fill_2
X_08697_ net207 net217 net482 net491 _02963_ vssd1 vssd1 vccd1 vccd1 _03113_ sky130_fd_sc_hd__a41o_1
XFILLER_0_67_316 vssd1 vssd1 vccd1 vccd1 sky130_fd_sc_hd__decap_4
XFILLER_0_67_349 vssd1 vssd1 vccd1 vccd1 sky130_fd_sc_hd__decap_3
X_07648_ net350 net420 _02018_ _02019_ vssd1 vssd1 vccd1 vccd1 _02020_ sky130_fd_sc_hd__a22o_1
X_07579_ _01950_ _01951_ _01949_ vssd1 vssd1 vccd1 vccd1 _01952_ sky130_fd_sc_hd__a21o_1
X_09318_ _03789_ _03790_ net258 net412 vssd1 vssd1 vccd1 vccd1 _03792_ sky130_fd_sc_hd__and4bb_1
XFILLER_0_63_500 vssd1 vssd1 vccd1 vccd1 sky130_fd_sc_hd__decap_4
XFILLER_0_48_574 vssd1 vssd1 vccd1 vccd1 sky130_fd_sc_hd__decap_3
XFILLER_0_35_235 vssd1 vssd1 vccd1 vccd1 sky130_fd_sc_hd__fill_1
X_09249_ net151 net524 _03713_ _03714_ vssd1 vssd1 vccd1 vccd1 _03717_ sky130_fd_sc_hd__a211o_1
XFILLER_0_35_268 vssd1 vssd1 vccd1 vccd1 sky130_fd_sc_hd__fill_1
XFILLER_0_31_496 vssd1 vssd1 vccd1 vccd1 sky130_fd_sc_hd__fill_2
Xoutput43 net43 vssd1 vssd1 vccd1 vccd1 wbs_dat_o[12] sky130_fd_sc_hd__clkbuf_4
Xoutput54 net54 vssd1 vssd1 vccd1 vccd1 wbs_dat_o[22] sky130_fd_sc_hd__clkbuf_4
Xoutput65 net65 vssd1 vssd1 vccd1 vccd1 wbs_dat_o[3] sky130_fd_sc_hd__clkbuf_4
X_10024_ net642 vssd1 vssd1 vccd1 vccd1 _00020_ sky130_fd_sc_hd__inv_2
XFILLER_0_98_474 vssd1 vssd1 vccd1 vccd1 sky130_fd_sc_hd__fill_2
XFILLER_0_85_113 vssd1 vssd1 vccd1 vccd1 sky130_fd_sc_hd__decap_8
XFILLER_0_73_308 vssd1 vssd1 vccd1 vccd1 sky130_fd_sc_hd__decap_6
XFILLER_0_39_541 vssd1 vssd1 vccd1 vccd1 sky130_fd_sc_hd__decap_3
XFILLER_0_39_552 vssd1 vssd1 vccd1 vccd1 sky130_fd_sc_hd__decap_8
XPHY_160 vssd1 vssd1 vccd1 vccd1 sky130_fd_sc_hd__decap_3
XPHY_193 vssd1 vssd1 vccd1 vccd1 sky130_fd_sc_hd__decap_3
XPHY_182 vssd1 vssd1 vccd1 vccd1 sky130_fd_sc_hd__decap_3
XPHY_171 vssd1 vssd1 vccd1 vccd1 sky130_fd_sc_hd__decap_3
XFILLER_0_81_330 vssd1 vssd1 vccd1 vccd1 sky130_fd_sc_hd__decap_6
X_06950_ _01183_ _01185_ _01184_ vssd1 vssd1 vccd1 vccd1 _01322_ sky130_fd_sc_hd__a21bo_1
X_05901_ _00178_ _00183_ _00280_ vssd1 vssd1 vccd1 vccd1 _00282_ sky130_fd_sc_hd__a21o_1
X_06881_ _01251_ _01252_ vssd1 vssd1 vccd1 vccd1 _01253_ sky130_fd_sc_hd__nand2b_1
X_08620_ _02850_ _02858_ _02857_ vssd1 vssd1 vccd1 vccd1 _03030_ sky130_fd_sc_hd__a21bo_1
X_05832_ _00211_ _00212_ vssd1 vssd1 vccd1 vccd1 _00213_ sky130_fd_sc_hd__nor2_1
XFILLER_0_27_51 vssd1 vssd1 vccd1 vccd1 sky130_fd_sc_hd__decap_4
X_08551_ _02779_ _02784_ _02778_ vssd1 vssd1 vccd1 vccd1 _02954_ sky130_fd_sc_hd__a21bo_1
X_05763_ _04938_ _04939_ _04940_ vssd1 vssd1 vccd1 vccd1 _00145_ sky130_fd_sc_hd__a21bo_1
X_08482_ _02728_ _02732_ _02735_ _02737_ _02727_ vssd1 vssd1 vccd1 vccd1 _02879_ sky130_fd_sc_hd__a32o_1
X_07502_ net445 _01873_ _01872_ vssd1 vssd1 vccd1 vccd1 _01874_ sky130_fd_sc_hd__a21bo_1
X_05694_ _04961_ _04962_ _04841_ _04881_ vssd1 vssd1 vccd1 vccd1 _04964_ sky130_fd_sc_hd__o211ai_1
XFILLER_0_49_349 vssd1 vssd1 vccd1 vccd1 sky130_fd_sc_hd__fill_2
X_07433_ _01798_ _01799_ vssd1 vssd1 vccd1 vccd1 _01801_ sky130_fd_sc_hd__xnor2_1
X_09103_ _02928_ _03554_ _03556_ _03557_ _03393_ vssd1 vssd1 vccd1 vccd1 _03558_ sky130_fd_sc_hd__a2111oi_2
X_07364_ _01581_ _01583_ _01731_ _01732_ vssd1 vssd1 vccd1 vccd1 _01733_ sky130_fd_sc_hd__a211oi_2
XFILLER_0_9_479 vssd1 vssd1 vccd1 vccd1 sky130_ef_sc_hd__decap_12
XFILLER_0_17_235 vssd1 vssd1 vccd1 vccd1 sky130_fd_sc_hd__decap_6
XFILLER_0_94_3 vssd1 vssd1 vccd1 vccd1 sky130_fd_sc_hd__decap_8
XFILLER_0_72_363 vssd1 vssd1 vccd1 vccd1 sky130_fd_sc_hd__fill_1
X_06315_ _00658_ _00690_ _00691_ vssd1 vssd1 vccd1 vccd1 _00692_ sky130_fd_sc_hd__and3_1
X_07295_ _01510_ _01515_ _01663_ vssd1 vssd1 vccd1 vccd1 _01664_ sky130_fd_sc_hd__o21a_1
X_09034_ _03479_ _03480_ net278 net412 vssd1 vssd1 vccd1 vccd1 _03482_ sky130_fd_sc_hd__and4bb_1
X_06246_ net288 net554 net580 net262 vssd1 vssd1 vccd1 vccd1 _00623_ sky130_fd_sc_hd__a22o_1
XFILLER_0_32_216 vssd1 vssd1 vccd1 vccd1 sky130_fd_sc_hd__fill_2
XFILLER_0_13_452 vssd1 vssd1 vccd1 vccd1 sky130_fd_sc_hd__decap_8
XFILLER_0_4_195 vssd1 vssd1 vccd1 vccd1 sky130_fd_sc_hd__fill_1
X_06177_ net320 net522 vssd1 vssd1 vccd1 vccd1 _00555_ sky130_fd_sc_hd__and2_1
X_05128_ _02776_ _02787_ _02930_ vssd1 vssd1 vccd1 vccd1 _02951_ sky130_fd_sc_hd__a21o_1
X_05059_ val_b_reg.wb_helper.wbs_ack_o _02221_ vssd1 vssd1 vccd1 vccd1 _02232_ sky130_fd_sc_hd__nand2_2
X_09936_ _04320_ _04322_ net191 net428 vssd1 vssd1 vccd1 vccd1 _04467_ sky130_fd_sc_hd__o211ai_1
X_09867_ _04390_ _04391_ vssd1 vssd1 vccd1 vccd1 _04392_ sky130_fd_sc_hd__nor2_1
XTAP_680 vssd1 vccd1 sky130_fd_sc_hd__tapvpwrvgnd_1
XTAP_691 vssd1 vccd1 sky130_fd_sc_hd__tapvpwrvgnd_1
X_08818_ net161 net701 net544 net156 vssd1 vssd1 vccd1 vccd1 _03245_ sky130_fd_sc_hd__a22o_1
X_09798_ _04179_ _04182_ vssd1 vssd1 vccd1 vccd1 _04316_ sky130_fd_sc_hd__nand2_1
X_08749_ _03009_ _03011_ _03168_ _03169_ vssd1 vssd1 vccd1 vccd1 _03171_ sky130_fd_sc_hd__a211o_1
XFILLER_0_67_102 vssd1 vssd1 vccd1 vccd1 sky130_fd_sc_hd__fill_1
XFILLER_0_95_455 vssd1 vssd1 vccd1 vccd1 sky130_fd_sc_hd__decap_3
XFILLER_0_51_536 vssd1 vssd1 vccd1 vccd1 sky130_ef_sc_hd__decap_12
Xrebuffer9 _01773_ vssd1 vssd1 vccd1 vccd1 net654 sky130_fd_sc_hd__clkbuf_1
XFILLER_0_23_216 vssd1 vssd1 vccd1 vccd1 sky130_fd_sc_hd__decap_3
XFILLER_0_51_569 vssd1 vssd1 vccd1 vccd1 sky130_fd_sc_hd__fill_2
XFILLER_0_51_558 vssd1 vssd1 vccd1 vccd1 sky130_fd_sc_hd__fill_2
XFILLER_0_23_249 vssd1 vssd1 vccd1 vccd1 sky130_fd_sc_hd__fill_1
XFILLER_0_101_181 vssd1 vssd1 vccd1 vccd1 sky130_ef_sc_hd__decap_12
X_10007_ val_y_reg.wb_helper.wbs_ack_o net139 _04543_ _01849_ vssd1 vssd1 vccd1 vccd1
+ net39 sky130_fd_sc_hd__a22o_1
XFILLER_0_46_319 vssd1 vssd1 vccd1 vccd1 sky130_ef_sc_hd__decap_12
XFILLER_0_6_416 vssd1 vssd1 vccd1 vccd1 sky130_fd_sc_hd__decap_4
XFILLER_0_39_393 vssd1 vssd1 vccd1 vccd1 sky130_fd_sc_hd__decap_8
XFILLER_0_89_24 vssd1 vssd1 vccd1 vccd1 sky130_fd_sc_hd__fill_1
XFILLER_0_6_427 vssd1 vssd1 vccd1 vccd1 sky130_fd_sc_hd__fill_1
XFILLER_0_80_9 vssd1 vssd1 vccd1 vccd1 sky130_fd_sc_hd__fill_1
X_07080_ _01449_ _01450_ vssd1 vssd1 vccd1 vccd1 _01451_ sky130_fd_sc_hd__and2b_1
XFILLER_0_54_396 vssd1 vssd1 vccd1 vccd1 sky130_fd_sc_hd__fill_2
X_06100_ _00476_ _00478_ vssd1 vssd1 vccd1 vccd1 _00479_ sky130_fd_sc_hd__nor2_1
XFILLER_0_14_216 vssd1 vssd1 vccd1 vccd1 sky130_fd_sc_hd__decap_8
X_06031_ _00405_ _00408_ vssd1 vssd1 vccd1 vccd1 _00410_ sky130_fd_sc_hd__xnor2_1
XFILLER_0_1_154 vssd1 vssd1 vccd1 vccd1 sky130_fd_sc_hd__fill_1
Xfanout118 net119 vssd1 vssd1 vccd1 vccd1 net118 sky130_fd_sc_hd__buf_2
X_07982_ _02351_ _02352_ _02353_ vssd1 vssd1 vccd1 vccd1 _02355_ sky130_fd_sc_hd__a21o_1
XFILLER_0_10_477 vssd1 vssd1 vccd1 vccd1 sky130_fd_sc_hd__decap_4
Xfanout129 _00184_ vssd1 vssd1 vccd1 vccd1 net129 sky130_fd_sc_hd__clkbuf_2
X_09721_ _04232_ vssd1 vssd1 vccd1 vccd1 _04233_ sky130_fd_sc_hd__inv_2
XFILLER_0_10_499 vssd1 vssd1 vccd1 vccd1 sky130_fd_sc_hd__decap_8
X_06933_ net304 net314 net479 net490 vssd1 vssd1 vccd1 vccd1 _01305_ sky130_fd_sc_hd__nand4_2
X_09652_ _03851_ _04156_ vssd1 vssd1 vccd1 vccd1 _04158_ sky130_fd_sc_hd__nand2_1
X_06864_ net182 net629 net637 net175 vssd1 vssd1 vccd1 vccd1 _01236_ sky130_fd_sc_hd__a22oi_1
X_08603_ net334 net396 _03008_ _03009_ vssd1 vssd1 vccd1 vccd1 _03011_ sky130_fd_sc_hd__nand4_2
X_09583_ _03927_ _03930_ _04079_ _04081_ vssd1 vssd1 vccd1 vccd1 _04082_ sky130_fd_sc_hd__o211a_1
X_05815_ _04981_ _04985_ _00195_ vssd1 vssd1 vccd1 vccd1 _00196_ sky130_fd_sc_hd__a21o_1
X_06795_ _01040_ _01042_ vssd1 vssd1 vccd1 vccd1 _01168_ sky130_fd_sc_hd__nand2_1
XTAP_1109 vssd1 vccd1 sky130_fd_sc_hd__tapvpwrvgnd_1
X_08534_ _02924_ _02932_ vssd1 vssd1 vccd1 vccd1 _02935_ sky130_fd_sc_hd__or2_1
X_05746_ net322 net563 net571 net312 vssd1 vssd1 vccd1 vccd1 _05016_ sky130_fd_sc_hd__a22oi_2
X_08465_ _02857_ _02858_ _02850_ vssd1 vssd1 vccd1 vccd1 _02860_ sky130_fd_sc_hd__a21o_1
X_05677_ _04945_ _04946_ vssd1 vssd1 vccd1 vccd1 _04947_ sky130_fd_sc_hd__nor2_1
XFILLER_0_37_308 vssd1 vssd1 vccd1 vccd1 sky130_fd_sc_hd__fill_1
X_08396_ _02782_ _02783_ vssd1 vssd1 vccd1 vccd1 _02784_ sky130_fd_sc_hd__xor2_1
XFILLER_0_64_138 vssd1 vssd1 vccd1 vccd1 sky130_fd_sc_hd__fill_2
XFILLER_0_18_522 vssd1 vssd1 vccd1 vccd1 sky130_fd_sc_hd__fill_1
X_07416_ _01782_ _01783_ _01636_ _01638_ vssd1 vssd1 vccd1 vccd1 _01785_ sky130_fd_sc_hd__o211a_1
X_07347_ net332 net340 net439 mul.b\[22\] vssd1 vssd1 vccd1 vccd1 _01716_ sky130_fd_sc_hd__and4_1
XFILLER_0_9_298 vssd1 vssd1 vccd1 vccd1 sky130_fd_sc_hd__fill_2
XFILLER_0_33_525 vssd1 vssd1 vccd1 vccd1 sky130_fd_sc_hd__fill_2
X_09017_ net315 net392 vssd1 vssd1 vccd1 vccd1 _03463_ sky130_fd_sc_hd__and2b_1
XFILLER_0_72_193 vssd1 vssd1 vccd1 vccd1 sky130_fd_sc_hd__decap_3
XFILLER_0_60_355 vssd1 vssd1 vccd1 vccd1 sky130_fd_sc_hd__decap_8
XFILLER_0_5_471 vssd1 vssd1 vccd1 vccd1 sky130_fd_sc_hd__decap_6
X_07278_ _01500_ _01647_ _00182_ vssd1 vssd1 vccd1 vccd1 _01648_ sky130_fd_sc_hd__a21oi_1
XFILLER_0_60_399 vssd1 vssd1 vccd1 vccd1 sky130_ef_sc_hd__decap_12
X_06229_ _00604_ _00605_ vssd1 vssd1 vccd1 vccd1 _00606_ sky130_fd_sc_hd__nand2b_1
Xfanout630 net631 vssd1 vssd1 vccd1 vccd1 net630 sky130_fd_sc_hd__buf_2
Xfanout641 net1 vssd1 vssd1 vccd1 vccd1 net641 sky130_fd_sc_hd__buf_2
X_09919_ _04399_ _04400_ _04424_ vssd1 vssd1 vccd1 vccd1 _04449_ sky130_fd_sc_hd__o21a_1
XFILLER_0_68_444 vssd1 vssd1 vccd1 vccd1 sky130_fd_sc_hd__decap_8
XFILLER_0_95_274 vssd1 vssd1 vccd1 vccd1 sky130_fd_sc_hd__decap_6
XFILLER_0_95_263 vssd1 vssd1 vccd1 vccd1 sky130_fd_sc_hd__decap_8
XFILLER_0_83_425 vssd1 vssd1 vccd1 vccd1 sky130_fd_sc_hd__decap_3
XFILLER_0_83_414 vssd1 vssd1 vccd1 vccd1 sky130_fd_sc_hd__fill_1
XFILLER_0_55_105 vssd1 vssd1 vccd1 vccd1 sky130_fd_sc_hd__decap_4
XFILLER_0_50_29 vssd1 vssd1 vccd1 vccd1 sky130_ef_sc_hd__decap_12
XFILLER_0_24_503 vssd1 vssd1 vccd1 vccd1 sky130_ef_sc_hd__decap_12
XFILLER_0_36_363 vssd1 vssd1 vccd1 vccd1 sky130_fd_sc_hd__fill_1
XFILLER_0_36_385 vssd1 vssd1 vccd1 vccd1 sky130_fd_sc_hd__decap_4
XFILLER_0_63_193 vssd1 vssd1 vccd1 vccd1 sky130_fd_sc_hd__decap_4
XFILLER_0_78_208 vssd1 vssd1 vccd1 vccd1 sky130_fd_sc_hd__decap_8
X_05600_ _04861_ _04868_ vssd1 vssd1 vccd1 vccd1 _04870_ sky130_fd_sc_hd__xnor2_1
XFILLER_0_86_230 vssd1 vssd1 vccd1 vccd1 sky130_fd_sc_hd__decap_4
X_06580_ _00953_ _00954_ vssd1 vssd1 vccd1 vccd1 _00955_ sky130_fd_sc_hd__or2_1
XFILLER_0_86_263 vssd1 vssd1 vccd1 vccd1 sky130_ef_sc_hd__decap_12
XFILLER_0_74_403 vssd1 vssd1 vccd1 vccd1 sky130_fd_sc_hd__decap_3
X_05531_ _04781_ _04782_ _04798_ _04799_ vssd1 vssd1 vccd1 vccd1 _04801_ sky130_fd_sc_hd__o22a_1
XFILLER_0_24_85 vssd1 vssd1 vccd1 vccd1 sky130_fd_sc_hd__decap_4
X_08250_ net228 net501 _02493_ _02494_ net519 vssd1 vssd1 vccd1 vccd1 _02625_ sky130_fd_sc_hd__a32o_1
XFILLER_0_74_458 vssd1 vssd1 vccd1 vccd1 sky130_fd_sc_hd__decap_8
X_05462_ _04730_ _04731_ vssd1 vssd1 vccd1 vccd1 _04732_ sky130_fd_sc_hd__nand2_1
XFILLER_0_24_96 vssd1 vssd1 vccd1 vccd1 sky130_fd_sc_hd__decap_6
X_08181_ _02333_ _02335_ _02334_ vssd1 vssd1 vccd1 vccd1 _02553_ sky130_fd_sc_hd__a21bo_1
X_07201_ net342 net349 net435 net441 vssd1 vssd1 vccd1 vccd1 _01571_ sky130_fd_sc_hd__nand4_2
XFILLER_0_15_503 vssd1 vssd1 vccd1 vccd1 sky130_fd_sc_hd__fill_1
X_05393_ net374 net632 _04662_ vssd1 vssd1 vccd1 vccd1 _04663_ sky130_fd_sc_hd__and3_1
X_07132_ _01381_ _01396_ _01395_ vssd1 vssd1 vccd1 vccd1 _01502_ sky130_fd_sc_hd__o21ai_1
XFILLER_0_54_193 vssd1 vssd1 vccd1 vccd1 sky130_fd_sc_hd__decap_3
XFILLER_0_42_333 vssd1 vssd1 vccd1 vccd1 sky130_ef_sc_hd__decap_12
XFILLER_0_42_377 vssd1 vssd1 vccd1 vccd1 sky130_fd_sc_hd__fill_1
X_07063_ _01420_ _01432_ _01433_ vssd1 vssd1 vccd1 vccd1 _01434_ sky130_fd_sc_hd__and3_1
XFILLER_0_100_405 vssd1 vssd1 vccd1 vccd1 sky130_fd_sc_hd__fill_1
X_06014_ _00390_ _00391_ vssd1 vssd1 vccd1 vccd1 _00393_ sky130_fd_sc_hd__xor2_1
XFILLER_0_23_580 vssd1 vssd1 vccd1 vccd1 sky130_fd_sc_hd__fill_1
XFILLER_0_57_3 vssd1 vssd1 vccd1 vccd1 sky130_ef_sc_hd__decap_12
X_07965_ _02166_ _02168_ _02167_ vssd1 vssd1 vccd1 vccd1 _02338_ sky130_fd_sc_hd__a21bo_1
X_06916_ _01286_ _01287_ vssd1 vssd1 vccd1 vccd1 _01288_ sky130_fd_sc_hd__and2_1
X_09704_ _04057_ _04059_ _04212_ _04213_ vssd1 vssd1 vccd1 vccd1 _04214_ sky130_fd_sc_hd__a211o_1
X_09635_ _04117_ _04138_ vssd1 vssd1 vccd1 vccd1 _04139_ sky130_fd_sc_hd__xor2_1
XFILLER_0_97_517 vssd1 vssd1 vccd1 vccd1 sky130_fd_sc_hd__fill_2
X_07896_ _02267_ _02268_ _02099_ net725 vssd1 vssd1 vccd1 vccd1 _02270_ sky130_fd_sc_hd__a211o_4
X_06847_ _01218_ _01219_ vssd1 vssd1 vccd1 vccd1 _01220_ sky130_fd_sc_hd__and2b_1
X_09566_ _04042_ _04061_ vssd1 vssd1 vccd1 vccd1 _04063_ sky130_fd_sc_hd__xnor2_2
X_06778_ net373 net434 net440 net365 vssd1 vssd1 vccd1 vccd1 _01151_ sky130_fd_sc_hd__a22o_1
X_09497_ _03966_ _03987_ vssd1 vssd1 vccd1 vccd1 _03988_ sky130_fd_sc_hd__and2b_1
X_08517_ _02912_ _02913_ _02914_ vssd1 vssd1 vccd1 vccd1 _02917_ sky130_fd_sc_hd__o21ai_1
X_05729_ _04997_ _04998_ vssd1 vssd1 vccd1 vccd1 _04999_ sky130_fd_sc_hd__and2b_1
X_08448_ net325 net333 net404 net410 vssd1 vssd1 vccd1 vccd1 _02841_ sky130_fd_sc_hd__nand4_2
XFILLER_0_65_447 vssd1 vssd1 vccd1 vccd1 sky130_fd_sc_hd__fill_1
XFILLER_0_65_425 vssd1 vssd1 vccd1 vccd1 sky130_fd_sc_hd__fill_2
XFILLER_0_37_149 vssd1 vssd1 vccd1 vccd1 sky130_fd_sc_hd__fill_1
XFILLER_0_80_439 vssd1 vssd1 vccd1 vccd1 sky130_fd_sc_hd__fill_2
X_08379_ _02595_ _02601_ _02765_ vssd1 vssd1 vccd1 vccd1 _02767_ sky130_fd_sc_hd__nand3_1
XFILLER_0_60_141 vssd1 vssd1 vccd1 vccd1 sky130_fd_sc_hd__decap_4
XFILLER_0_33_333 vssd1 vssd1 vccd1 vccd1 sky130_fd_sc_hd__decap_3
XFILLER_0_33_377 vssd1 vssd1 vccd1 vccd1 sky130_fd_sc_hd__fill_2
XFILLER_0_33_399 vssd1 vssd1 vccd1 vccd1 sky130_fd_sc_hd__fill_1
Xfanout493 net494 vssd1 vssd1 vccd1 vccd1 net493 sky130_fd_sc_hd__clkbuf_2
Xfanout482 net483 vssd1 vssd1 vccd1 vccd1 net482 sky130_fd_sc_hd__buf_4
Xfanout460 mul.b\[20\] vssd1 vssd1 vccd1 vccd1 net460 sky130_fd_sc_hd__clkbuf_4
Xfanout471 net475 vssd1 vssd1 vccd1 vccd1 net471 sky130_fd_sc_hd__clkbuf_4
XFILLER_0_88_506 vssd1 vssd1 vccd1 vccd1 sky130_fd_sc_hd__decap_8
Xmax_cap7 _00462_ vssd1 vssd1 vccd1 vccd1 net717 sky130_fd_sc_hd__dlymetal6s2s_1
XFILLER_0_68_241 vssd1 vssd1 vccd1 vccd1 sky130_fd_sc_hd__decap_3
XFILLER_0_61_17 vssd1 vssd1 vccd1 vccd1 sky130_fd_sc_hd__fill_1
XFILLER_0_68_285 vssd1 vssd1 vccd1 vccd1 sky130_fd_sc_hd__fill_1
XFILLER_0_56_447 vssd1 vssd1 vccd1 vccd1 sky130_fd_sc_hd__fill_2
XFILLER_0_71_406 vssd1 vssd1 vccd1 vccd1 sky130_fd_sc_hd__decap_4
XFILLER_0_36_160 vssd1 vssd1 vccd1 vccd1 sky130_fd_sc_hd__decap_6
XFILLER_0_51_141 vssd1 vssd1 vccd1 vccd1 sky130_fd_sc_hd__decap_8
XFILLER_0_12_539 vssd1 vssd1 vccd1 vccd1 sky130_fd_sc_hd__fill_1
XFILLER_0_86_36 vssd1 vssd1 vccd1 vccd1 sky130_fd_sc_hd__fill_2
XFILLER_0_20_572 vssd1 vssd1 vccd1 vccd1 sky130_fd_sc_hd__fill_1
XFILLER_0_20_583 vssd1 vssd1 vccd1 vccd1 sky130_fd_sc_hd__decap_4
X_07750_ _02120_ vssd1 vssd1 vccd1 vccd1 _02121_ sky130_fd_sc_hd__inv_2
XFILLER_0_19_96 vssd1 vssd1 vccd1 vccd1 sky130_fd_sc_hd__decap_4
X_06701_ _01072_ _01073_ net102 _00936_ vssd1 vssd1 vccd1 vccd1 _01075_ sky130_fd_sc_hd__a211o_4
X_07681_ _02049_ _02050_ _02036_ vssd1 vssd1 vccd1 vccd1 _02053_ sky130_fd_sc_hd__a21oi_1
X_06632_ _01002_ _01004_ _00873_ _00875_ vssd1 vssd1 vccd1 vccd1 _01006_ sky130_fd_sc_hd__o211ai_2
X_09420_ net199 net448 _03899_ _03901_ vssd1 vssd1 vccd1 vccd1 _03904_ sky130_fd_sc_hd__and4_1
X_09351_ _03657_ _03659_ _03827_ vssd1 vssd1 vccd1 vccd1 _03829_ sky130_fd_sc_hd__nor3_1
XFILLER_0_87_561 vssd1 vssd1 vccd1 vccd1 sky130_fd_sc_hd__fill_2
X_06563_ _00901_ _00902_ net102 _00935_ vssd1 vssd1 vccd1 vccd1 _00938_ sky130_fd_sc_hd__o22ai_4
X_08302_ _02677_ _02679_ _02680_ vssd1 vssd1 vccd1 vccd1 _02682_ sky130_fd_sc_hd__a21oi_1
X_09282_ net200 net458 net465 net192 vssd1 vssd1 vccd1 vccd1 _03753_ sky130_fd_sc_hd__a22oi_1
X_05514_ net279 net287 net623 net631 vssd1 vssd1 vccd1 vccd1 _04784_ sky130_fd_sc_hd__and4_1
XFILLER_0_47_447 vssd1 vssd1 vccd1 vccd1 sky130_fd_sc_hd__fill_1
X_08233_ net179 net184 net537 net548 vssd1 vssd1 vccd1 vccd1 _02606_ sky130_fd_sc_hd__nand4_1
XFILLER_0_62_406 vssd1 vssd1 vccd1 vccd1 sky130_fd_sc_hd__decap_4
XFILLER_0_7_533 vssd1 vssd1 vccd1 vccd1 sky130_fd_sc_hd__decap_8
X_06494_ _00866_ _00867_ vssd1 vssd1 vccd1 vccd1 _00869_ sky130_fd_sc_hd__xor2_1
XFILLER_0_74_288 vssd1 vssd1 vccd1 vccd1 sky130_fd_sc_hd__decap_3
XFILLER_0_62_417 vssd1 vssd1 vccd1 vccd1 sky130_fd_sc_hd__decap_3
X_05445_ _04694_ _04696_ _04713_ _04714_ vssd1 vssd1 vccd1 vccd1 _04715_ sky130_fd_sc_hd__nor4_1
X_08164_ _02532_ _02534_ _02407_ _02409_ vssd1 vssd1 vccd1 vccd1 _02536_ sky130_fd_sc_hd__o211ai_2
X_05376_ _04645_ _04643_ _04642_ vssd1 vssd1 vccd1 vccd1 _04646_ sky130_fd_sc_hd__and3b_1
X_08095_ net160 net593 _02465_ _02466_ vssd1 vssd1 vccd1 vccd1 _02467_ sky130_fd_sc_hd__a22oi_1
X_07115_ _01483_ _01484_ _01261_ _01263_ vssd1 vssd1 vccd1 vccd1 _01486_ sky130_fd_sc_hd__o211a_1
XFILLER_0_42_141 vssd1 vssd1 vccd1 vccd1 sky130_ef_sc_hd__decap_12
X_07046_ _01297_ _01299_ _01415_ vssd1 vssd1 vccd1 vccd1 _01417_ sky130_fd_sc_hd__and3_1
XFILLER_0_2_260 vssd1 vssd1 vccd1 vccd1 sky130_fd_sc_hd__fill_1
XFILLER_0_2_271 vssd1 vssd1 vccd1 vccd1 sky130_fd_sc_hd__decap_4
X_08997_ net216 net458 net465 net208 vssd1 vssd1 vccd1 vccd1 _03441_ sky130_fd_sc_hd__a22oi_1
X_07948_ _02318_ _02319_ vssd1 vssd1 vccd1 vccd1 _02321_ sky130_fd_sc_hd__xnor2_1
X_07879_ _02217_ _02251_ _02252_ vssd1 vssd1 vccd1 vccd1 _02253_ sky130_fd_sc_hd__and3_1
X_09618_ _04119_ _03513_ vssd1 vssd1 vccd1 vccd1 _04120_ sky130_fd_sc_hd__and2b_1
XFILLER_0_38_414 vssd1 vssd1 vccd1 vccd1 sky130_fd_sc_hd__decap_6
X_09549_ net199 net209 net435 net441 vssd1 vssd1 vccd1 vccd1 _04045_ sky130_fd_sc_hd__nand4_2
XFILLER_0_38_436 vssd1 vssd1 vccd1 vccd1 sky130_fd_sc_hd__fill_1
XFILLER_0_80_236 vssd1 vssd1 vccd1 vccd1 sky130_ef_sc_hd__decap_12
XFILLER_0_33_185 vssd1 vssd1 vccd1 vccd1 sky130_fd_sc_hd__decap_3
XTAP_509 vssd1 vccd1 sky130_fd_sc_hd__tapvpwrvgnd_1
Xfanout290 net291 vssd1 vssd1 vccd1 vccd1 net290 sky130_fd_sc_hd__buf_4
XFILLER_0_69_561 vssd1 vssd1 vccd1 vccd1 sky130_fd_sc_hd__decap_4
XTAP_1292 vssd1 vccd1 sky130_fd_sc_hd__tapvpwrvgnd_1
XTAP_1281 vssd1 vccd1 sky130_fd_sc_hd__tapvpwrvgnd_1
XTAP_1270 vssd1 vccd1 sky130_fd_sc_hd__tapvpwrvgnd_1
X_05230_ _04044_ _04055_ vssd1 vssd1 vccd1 vccd1 _04066_ sky130_fd_sc_hd__or2_1
X_05161_ net377 net385 net575 net585 vssd1 vssd1 vccd1 vccd1 _03312_ sky130_fd_sc_hd__and4_1
XFILLER_0_24_163 vssd1 vssd1 vccd1 vccd1 sky130_fd_sc_hd__decap_3
XFILLER_0_52_483 vssd1 vssd1 vccd1 vccd1 sky130_fd_sc_hd__decap_3
XFILLER_0_97_79 vssd1 vssd1 vccd1 vccd1 sky130_fd_sc_hd__fill_2
X_05092_ val_a_reg.wb_helper.wbs_ack_o net4 vssd1 vssd1 vccd1 vccd1 _02561_ sky130_fd_sc_hd__and2b_1
X_08920_ _03160_ _03164_ _03161_ vssd1 vssd1 vccd1 vccd1 _03358_ sky130_fd_sc_hd__o21bai_2
X_08851_ _03278_ _03280_ _03111_ _03125_ vssd1 vssd1 vccd1 vccd1 _03282_ sky130_fd_sc_hd__a211o_4
X_07802_ _02171_ _02172_ vssd1 vssd1 vccd1 vccd1 _02173_ sky130_fd_sc_hd__nand2b_1
X_08782_ net158 net558 net579 net148 vssd1 vssd1 vccd1 vccd1 _03207_ sky130_fd_sc_hd__a22o_1
X_05994_ _00372_ _00373_ vssd1 vssd1 vccd1 vccd1 _00374_ sky130_fd_sc_hd__nand2_1
XFILLER_0_46_83 vssd1 vssd1 vccd1 vccd1 sky130_fd_sc_hd__fill_1
X_07733_ _01807_ _01810_ _02103_ _02104_ vssd1 vssd1 vccd1 vccd1 _02105_ sky130_fd_sc_hd__a211oi_4
X_07664_ _01891_ _01898_ _01897_ vssd1 vssd1 vccd1 vccd1 _02036_ sky130_fd_sc_hd__a21o_1
X_09403_ _03873_ _03883_ vssd1 vssd1 vccd1 vccd1 _03885_ sky130_fd_sc_hd__xnor2_1
X_06615_ net226 net590 _00986_ _00987_ vssd1 vssd1 vccd1 vccd1 _00989_ sky130_fd_sc_hd__a22o_1
XFILLER_0_94_339 vssd1 vssd1 vccd1 vccd1 sky130_fd_sc_hd__decap_4
XFILLER_0_87_391 vssd1 vssd1 vccd1 vccd1 sky130_fd_sc_hd__fill_1
XFILLER_0_62_82 vssd1 vssd1 vccd1 vccd1 sky130_fd_sc_hd__fill_2
X_07595_ net149 net636 _01963_ _01965_ vssd1 vssd1 vccd1 vccd1 _01967_ sky130_fd_sc_hd__and4_1
X_09334_ _03626_ _03661_ _03808_ _03809_ vssd1 vssd1 vccd1 vccd1 _03810_ sky130_fd_sc_hd__o211a_1
XFILLER_0_62_93 vssd1 vssd1 vccd1 vccd1 sky130_ef_sc_hd__decap_12
X_06546_ _00918_ _00919_ _00920_ vssd1 vssd1 vccd1 vccd1 _00921_ sky130_fd_sc_hd__nand3_1
XFILLER_0_47_233 vssd1 vssd1 vccd1 vccd1 sky130_fd_sc_hd__fill_1
X_09265_ net173 net178 net481 net489 vssd1 vssd1 vccd1 vccd1 _03734_ sky130_fd_sc_hd__nand4_2
X_06477_ net204 net627 net635 net195 vssd1 vssd1 vccd1 vccd1 _00852_ sky130_fd_sc_hd__a22oi_1
X_09196_ _03490_ _03492_ _03657_ _03658_ vssd1 vssd1 vccd1 vccd1 _03659_ sky130_fd_sc_hd__a211oi_4
X_08216_ _02427_ _02429_ _02587_ _02588_ vssd1 vssd1 vccd1 vccd1 _02589_ sky130_fd_sc_hd__o211a_1
X_05428_ net292 net622 net630 net287 vssd1 vssd1 vccd1 vccd1 _04698_ sky130_fd_sc_hd__a22oi_1
XFILLER_0_28_491 vssd1 vssd1 vccd1 vccd1 sky130_fd_sc_hd__decap_3
XFILLER_0_90_589 vssd1 vssd1 vccd1 vccd1 sky130_fd_sc_hd__fill_1
XFILLER_0_62_269 vssd1 vssd1 vccd1 vccd1 sky130_fd_sc_hd__decap_3
XFILLER_0_7_385 vssd1 vssd1 vccd1 vccd1 sky130_fd_sc_hd__decap_6
X_08147_ net300 net438 net445 net290 vssd1 vssd1 vccd1 vccd1 _02519_ sky130_fd_sc_hd__a22o_1
X_05359_ _03902_ _03924_ vssd1 vssd1 vccd1 vccd1 _04629_ sky130_fd_sc_hd__nand2_1
XFILLER_0_31_623 vssd1 vssd1 vccd1 vccd1 sky130_fd_sc_hd__fill_2
XFILLER_0_101_522 vssd1 vssd1 vccd1 vccd1 sky130_fd_sc_hd__decap_4
X_08078_ net149 net618 _02448_ _02449_ _02446_ vssd1 vssd1 vccd1 vccd1 _02450_ sky130_fd_sc_hd__a32o_1
XFILLER_0_3_580 vssd1 vssd1 vccd1 vccd1 sky130_fd_sc_hd__decap_3
XFILLER_0_30_155 vssd1 vssd1 vccd1 vccd1 sky130_fd_sc_hd__decap_4
XFILLER_0_101_533 vssd1 vssd1 vccd1 vccd1 sky130_fd_sc_hd__decap_6
XFILLER_0_30_166 vssd1 vssd1 vccd1 vccd1 sky130_fd_sc_hd__fill_1
X_07029_ _01399_ _01363_ vssd1 vssd1 vccd1 vccd1 _01400_ sky130_fd_sc_hd__nand2b_1
XFILLER_0_11_391 vssd1 vssd1 vccd1 vccd1 sky130_fd_sc_hd__fill_1
X_10040_ net638 vssd1 vssd1 vccd1 vccd1 _00036_ sky130_fd_sc_hd__inv_2
Xhold65 val_b_reg.wb_helper.wbs_ack_o vssd1 vssd1 vccd1 vccd1 net710 sky130_fd_sc_hd__dlygate4sd3_1
XFILLER_0_97_133 vssd1 vssd1 vccd1 vccd1 sky130_fd_sc_hd__fill_2
XFILLER_0_38_211 vssd1 vssd1 vccd1 vccd1 sky130_fd_sc_hd__decap_3
XFILLER_0_81_556 vssd1 vssd1 vccd1 vccd1 sky130_fd_sc_hd__fill_1
XFILLER_0_53_269 vssd1 vssd1 vccd1 vccd1 sky130_fd_sc_hd__decap_4
XANTENNA_7 net326 vssd1 vssd1 vccd1 vccd1 sky130_fd_sc_hd__diode_2
XFILLER_0_34_472 vssd1 vssd1 vccd1 vccd1 sky130_fd_sc_hd__decap_4
XFILLER_0_21_144 vssd1 vssd1 vccd1 vccd1 sky130_fd_sc_hd__fill_1
XTAP_306 vssd1 vccd1 sky130_fd_sc_hd__tapvpwrvgnd_1
XTAP_339 vssd1 vccd1 sky130_fd_sc_hd__tapvpwrvgnd_1
XTAP_328 vssd1 vccd1 sky130_fd_sc_hd__tapvpwrvgnd_1
XTAP_317 vssd1 vccd1 sky130_fd_sc_hd__tapvpwrvgnd_1
XFILLER_0_89_623 vssd1 vssd1 vccd1 vccd1 sky130_fd_sc_hd__fill_2
Xrebuffer19 _01607_ vssd1 vssd1 vccd1 vccd1 net664 sky130_fd_sc_hd__clkbuf_1
X_06400_ _00764_ _00775_ vssd1 vssd1 vccd1 vccd1 _00776_ sky130_fd_sc_hd__and2b_1
X_07380_ _01747_ _01748_ vssd1 vssd1 vccd1 vccd1 _01749_ sky130_fd_sc_hd__xnor2_1
XFILLER_0_72_512 vssd1 vssd1 vccd1 vccd1 sky130_ef_sc_hd__decap_12
XFILLER_0_8_138 vssd1 vssd1 vccd1 vccd1 sky130_fd_sc_hd__fill_2
XFILLER_0_17_406 vssd1 vssd1 vccd1 vccd1 sky130_fd_sc_hd__decap_3
X_06331_ _00585_ _00588_ _00705_ _00707_ vssd1 vssd1 vccd1 vccd1 _00708_ sky130_fd_sc_hd__a211oi_2
XFILLER_0_32_52 vssd1 vssd1 vccd1 vccd1 sky130_fd_sc_hd__decap_3
X_09050_ _03461_ _03462_ _03496_ _03497_ vssd1 vssd1 vccd1 vccd1 _03500_ sky130_fd_sc_hd__o22a_1
X_06262_ _00530_ _00638_ vssd1 vssd1 vccd1 vccd1 _00639_ sky130_fd_sc_hd__nor2_2
XFILLER_0_32_85 vssd1 vssd1 vccd1 vccd1 sky130_ef_sc_hd__decap_12
X_08001_ net237 net500 vssd1 vssd1 vccd1 vccd1 _02374_ sky130_fd_sc_hd__nand2_1
X_05213_ _03837_ _03858_ _03869_ vssd1 vssd1 vccd1 vccd1 _03880_ sky130_fd_sc_hd__nand3_1
XFILLER_0_13_623 vssd1 vssd1 vccd1 vccd1 sky130_fd_sc_hd__fill_2
X_06193_ _00452_ _00454_ _00568_ _00570_ vssd1 vssd1 vccd1 vccd1 _00571_ sky130_fd_sc_hd__a211o_1
X_05144_ _03093_ _03104_ _03028_ vssd1 vssd1 vccd1 vccd1 _03126_ sky130_fd_sc_hd__a21o_1
X_05075_ net12 net494 net126 vssd1 vssd1 vccd1 vccd1 _00083_ sky130_fd_sc_hd__mux2_1
XFILLER_0_12_155 vssd1 vssd1 vccd1 vccd1 sky130_fd_sc_hd__decap_3
X_09952_ net162 net462 vssd1 vssd1 vccd1 vccd1 _04485_ sky130_fd_sc_hd__nand2_1
XFILLER_0_40_475 vssd1 vssd1 vccd1 vccd1 sky130_fd_sc_hd__fill_1
X_08903_ _03182_ _03184_ _03337_ vssd1 vssd1 vccd1 vccd1 _03339_ sky130_fd_sc_hd__a21o_1
XFILLER_0_0_561 vssd1 vssd1 vccd1 vccd1 sky130_fd_sc_hd__decap_8
X_09883_ _04408_ _04409_ vssd1 vssd1 vccd1 vccd1 _04410_ sky130_fd_sc_hd__nor2_1
XTAP_862 vssd1 vccd1 sky130_fd_sc_hd__tapvpwrvgnd_1
XTAP_851 vssd1 vccd1 sky130_fd_sc_hd__tapvpwrvgnd_1
XTAP_840 vssd1 vccd1 sky130_fd_sc_hd__tapvpwrvgnd_1
X_08834_ _03260_ _03261_ _03262_ vssd1 vssd1 vccd1 vccd1 _03263_ sky130_fd_sc_hd__and3_4
XTAP_895 vssd1 vccd1 sky130_fd_sc_hd__tapvpwrvgnd_1
XTAP_873 vssd1 vccd1 sky130_fd_sc_hd__tapvpwrvgnd_1
XTAP_884 vssd1 vccd1 sky130_fd_sc_hd__tapvpwrvgnd_1
X_08765_ _03184_ _03185_ _03186_ vssd1 vssd1 vccd1 vccd1 _03188_ sky130_fd_sc_hd__a21o_1
XFILLER_0_79_111 vssd1 vssd1 vccd1 vccd1 sky130_fd_sc_hd__fill_1
X_07716_ _02085_ _02086_ _01918_ _01920_ vssd1 vssd1 vccd1 vccd1 _02088_ sky130_fd_sc_hd__a211oi_2
X_05977_ _00354_ _00355_ _00231_ vssd1 vssd1 vccd1 vccd1 _00357_ sky130_fd_sc_hd__o21a_1
X_08696_ _03108_ _03109_ _03110_ vssd1 vssd1 vccd1 vccd1 _03112_ sky130_fd_sc_hd__a21oi_2
XFILLER_0_73_81 vssd1 vssd1 vccd1 vccd1 sky130_ef_sc_hd__decap_12
X_07647_ net332 net340 net427 net433 vssd1 vssd1 vccd1 vccd1 _02019_ sky130_fd_sc_hd__nand4_2
X_07578_ _01500_ _01647_ _01790_ vssd1 vssd1 vccd1 vccd1 _01951_ sky130_fd_sc_hd__or3_1
X_09317_ net258 net412 _03789_ _03790_ vssd1 vssd1 vccd1 vccd1 _03791_ sky130_fd_sc_hd__o2bb2a_1
X_06529_ net330 net495 _00792_ _00793_ net512 vssd1 vssd1 vccd1 vccd1 _00904_ sky130_fd_sc_hd__a32o_1
XFILLER_0_35_225 vssd1 vssd1 vccd1 vccd1 sky130_fd_sc_hd__fill_2
X_09248_ _03713_ _03714_ net151 net524 vssd1 vssd1 vccd1 vccd1 _03715_ sky130_fd_sc_hd__o211ai_1
XFILLER_0_90_397 vssd1 vssd1 vccd1 vccd1 sky130_fd_sc_hd__decap_4
X_09179_ _03480_ _03482_ vssd1 vssd1 vccd1 vccd1 _03641_ sky130_fd_sc_hd__or2_1
XFILLER_0_50_239 vssd1 vssd1 vccd1 vccd1 sky130_fd_sc_hd__fill_1
XFILLER_0_16_472 vssd1 vssd1 vccd1 vccd1 sky130_fd_sc_hd__decap_4
Xoutput55 net55 vssd1 vssd1 vccd1 vccd1 wbs_dat_o[23] sky130_fd_sc_hd__clkbuf_4
Xoutput44 net44 vssd1 vssd1 vccd1 vccd1 wbs_dat_o[13] sky130_fd_sc_hd__buf_2
XFILLER_0_9_3 vssd1 vssd1 vccd1 vccd1 sky130_ef_sc_hd__decap_12
Xoutput66 net66 vssd1 vssd1 vccd1 vccd1 wbs_dat_o[4] sky130_fd_sc_hd__buf_2
X_10023_ net642 vssd1 vssd1 vccd1 vccd1 _00019_ sky130_fd_sc_hd__inv_2
XFILLER_0_85_169 vssd1 vssd1 vccd1 vccd1 sky130_fd_sc_hd__decap_3
XPHY_161 vssd1 vssd1 vccd1 vccd1 sky130_fd_sc_hd__decap_3
XPHY_150 vssd1 vssd1 vccd1 vccd1 sky130_fd_sc_hd__decap_3
XFILLER_0_39_586 vssd1 vssd1 vccd1 vccd1 sky130_fd_sc_hd__decap_3
XPHY_194 vssd1 vssd1 vccd1 vccd1 sky130_fd_sc_hd__decap_3
XPHY_183 vssd1 vssd1 vccd1 vccd1 sky130_fd_sc_hd__decap_3
XPHY_172 vssd1 vssd1 vccd1 vccd1 sky130_fd_sc_hd__decap_3
XFILLER_0_54_589 vssd1 vssd1 vccd1 vccd1 sky130_fd_sc_hd__fill_1
XFILLER_0_14_409 vssd1 vssd1 vccd1 vccd1 sky130_fd_sc_hd__fill_1
XFILLER_0_34_280 vssd1 vssd1 vccd1 vccd1 sky130_fd_sc_hd__decap_4
XFILLER_0_78_37 vssd1 vssd1 vccd1 vccd1 sky130_fd_sc_hd__fill_2
XFILLER_0_34_291 vssd1 vssd1 vccd1 vccd1 sky130_fd_sc_hd__decap_6
XFILLER_0_1_358 vssd1 vssd1 vccd1 vccd1 sky130_fd_sc_hd__decap_4
XFILLER_0_22_464 vssd1 vssd1 vccd1 vccd1 sky130_fd_sc_hd__fill_1
X_05900_ _00178_ _00183_ _00280_ vssd1 vssd1 vccd1 vccd1 _00281_ sky130_fd_sc_hd__nand3_1
X_06880_ _01116_ _01118_ vssd1 vssd1 vccd1 vccd1 _01252_ sky130_fd_sc_hd__nand2_1
X_05831_ net243 net253 net625 net633 vssd1 vssd1 vccd1 vccd1 _00212_ sky130_fd_sc_hd__and4_1
XFILLER_0_89_464 vssd1 vssd1 vccd1 vccd1 sky130_fd_sc_hd__fill_1
X_08550_ _02944_ _02945_ _02950_ vssd1 vssd1 vccd1 vccd1 _02953_ sky130_fd_sc_hd__a21o_1
X_05762_ _00141_ _00142_ _00140_ vssd1 vssd1 vccd1 vccd1 _00144_ sky130_fd_sc_hd__a21o_1
X_08481_ _02703_ _02705_ vssd1 vssd1 vccd1 vccd1 _02878_ sky130_fd_sc_hd__nand2_1
X_07501_ net324 net332 net438 vssd1 vssd1 vccd1 vccd1 _01873_ sky130_fd_sc_hd__and3_1
X_05693_ _04841_ _04881_ _04961_ _04962_ vssd1 vssd1 vccd1 vccd1 _04963_ sky130_fd_sc_hd__a211o_1
X_07432_ _01799_ _01798_ vssd1 vssd1 vccd1 vccd1 _01800_ sky130_fd_sc_hd__nand2b_1
XFILLER_0_45_512 vssd1 vssd1 vccd1 vccd1 sky130_fd_sc_hd__fill_1
X_09102_ _03390_ _03391_ _03238_ _03239_ vssd1 vssd1 vccd1 vccd1 _03557_ sky130_fd_sc_hd__a211oi_1
XFILLER_0_72_320 vssd1 vssd1 vccd1 vccd1 sky130_fd_sc_hd__fill_1
X_07363_ _01596_ _01598_ _01730_ vssd1 vssd1 vccd1 vccd1 _01732_ sky130_fd_sc_hd__nor3_1
XFILLER_0_17_225 vssd1 vssd1 vccd1 vccd1 sky130_fd_sc_hd__decap_4
X_06314_ _00687_ _00689_ _00566_ _00569_ vssd1 vssd1 vccd1 vccd1 _00691_ sky130_fd_sc_hd__o211ai_4
X_07294_ _01657_ _01661_ vssd1 vssd1 vccd1 vccd1 _01663_ sky130_fd_sc_hd__xnor2_1
XFILLER_0_87_3 vssd1 vssd1 vccd1 vccd1 sky130_fd_sc_hd__decap_6
X_09033_ net279 net412 _03479_ _03480_ vssd1 vssd1 vccd1 vccd1 _03481_ sky130_fd_sc_hd__o2bb2a_1
X_06245_ net262 net288 net554 net580 vssd1 vssd1 vccd1 vccd1 _00622_ sky130_fd_sc_hd__nand4_2
XFILLER_0_32_239 vssd1 vssd1 vccd1 vccd1 sky130_fd_sc_hd__decap_4
X_06176_ _00550_ _00553_ vssd1 vssd1 vccd1 vccd1 _00554_ sky130_fd_sc_hd__xnor2_2
X_05127_ _02776_ _02787_ _02930_ vssd1 vssd1 vccd1 vccd1 _02940_ sky130_fd_sc_hd__nand3_1
XFILLER_0_13_486 vssd1 vssd1 vccd1 vccd1 sky130_fd_sc_hd__decap_4
XFILLER_0_7_73 vssd1 vssd1 vccd1 vccd1 sky130_fd_sc_hd__decap_6
X_09935_ _04464_ _04465_ vssd1 vssd1 vccd1 vccd1 _04466_ sky130_fd_sc_hd__xnor2_1
X_05058_ net37 net4 net38 net142 vssd1 vssd1 vccd1 vccd1 _02221_ sky130_fd_sc_hd__and4_1
X_09866_ _04388_ _04389_ _04375_ vssd1 vssd1 vccd1 vccd1 _04391_ sky130_fd_sc_hd__o21a_1
XTAP_670 vssd1 vccd1 sky130_fd_sc_hd__tapvpwrvgnd_1
X_08817_ net140 _03242_ _03243_ _03244_ vssd1 vssd1 vccd1 vccd1 net54 sky130_fd_sc_hd__a31o_1
XTAP_681 vssd1 vccd1 sky130_fd_sc_hd__tapvpwrvgnd_1
XTAP_692 vssd1 vccd1 sky130_fd_sc_hd__tapvpwrvgnd_1
X_09797_ _04311_ _04314_ vssd1 vssd1 vccd1 vccd1 _04315_ sky130_fd_sc_hd__xnor2_1
X_08748_ _03166_ _03167_ net323 net396 vssd1 vssd1 vccd1 vccd1 _03169_ sky130_fd_sc_hd__and4bb_2
X_08679_ net168 net534 net544 net161 vssd1 vssd1 vccd1 vccd1 _03094_ sky130_fd_sc_hd__a22o_1
XFILLER_0_67_169 vssd1 vssd1 vccd1 vccd1 sky130_fd_sc_hd__decap_4
XFILLER_0_36_589 vssd1 vssd1 vccd1 vccd1 sky130_fd_sc_hd__fill_1
XFILLER_0_23_228 vssd1 vssd1 vccd1 vccd1 sky130_fd_sc_hd__decap_8
XFILLER_0_31_261 vssd1 vssd1 vccd1 vccd1 sky130_fd_sc_hd__decap_3
XFILLER_0_48_29 vssd1 vssd1 vccd1 vccd1 sky130_fd_sc_hd__decap_3
XFILLER_0_101_193 vssd1 vssd1 vccd1 vccd1 sky130_fd_sc_hd__decap_3
XFILLER_0_64_17 vssd1 vssd1 vccd1 vccd1 sky130_fd_sc_hd__decap_4
X_10006_ val_a_reg.wb_helper.wbs_ack_o val_b_reg.wb_helper.wbs_ack_o net2 vssd1 vssd1
+ vccd1 vccd1 _04543_ sky130_fd_sc_hd__mux2_1
XFILLER_0_13_10 vssd1 vssd1 vccd1 vccd1 sky130_fd_sc_hd__decap_3
XFILLER_0_39_350 vssd1 vssd1 vccd1 vccd1 sky130_fd_sc_hd__decap_6
XFILLER_0_46_309 vssd1 vssd1 vccd1 vccd1 sky130_fd_sc_hd__fill_2
XFILLER_0_13_54 vssd1 vssd1 vccd1 vccd1 sky130_fd_sc_hd__fill_2
XFILLER_0_89_47 vssd1 vssd1 vccd1 vccd1 sky130_fd_sc_hd__fill_2
XFILLER_0_54_386 vssd1 vssd1 vccd1 vccd1 sky130_fd_sc_hd__decap_6
X_06030_ _00405_ _00408_ vssd1 vssd1 vccd1 vccd1 _00409_ sky130_fd_sc_hd__and2b_1
Xfanout119 _03066_ vssd1 vssd1 vccd1 vccd1 net119 sky130_fd_sc_hd__clkbuf_4
X_07981_ _02351_ _02352_ _02353_ vssd1 vssd1 vccd1 vccd1 _02354_ sky130_fd_sc_hd__nand3_2
XFILLER_0_1_177 vssd1 vssd1 vccd1 vccd1 sky130_fd_sc_hd__fill_1
X_09720_ net261 net397 _04228_ _04229_ vssd1 vssd1 vccd1 vccd1 _04232_ sky130_fd_sc_hd__and4_1
XFILLER_0_38_40 vssd1 vssd1 vccd1 vccd1 sky130_fd_sc_hd__decap_6
X_06932_ net314 net477 net490 net304 vssd1 vssd1 vccd1 vccd1 _01304_ sky130_fd_sc_hd__a22o_1
X_09651_ _04156_ vssd1 vssd1 vccd1 vccd1 _04157_ sky130_fd_sc_hd__inv_2
X_06863_ net175 net182 net629 net637 vssd1 vssd1 vccd1 vccd1 _01235_ sky130_fd_sc_hd__and4_1
X_08602_ net334 net396 _03008_ _03009_ vssd1 vssd1 vccd1 vccd1 _03010_ sky130_fd_sc_hd__a22o_1
X_09582_ _04080_ vssd1 vssd1 vccd1 vccd1 _04081_ sky130_fd_sc_hd__inv_2
X_05814_ _00192_ _00193_ vssd1 vssd1 vccd1 vccd1 _00195_ sky130_fd_sc_hd__xor2_1
X_06794_ _01164_ _01165_ _01148_ vssd1 vssd1 vccd1 vccd1 _01167_ sky130_fd_sc_hd__a21o_1
X_08533_ net460 net144 net130 net221 _02934_ vssd1 vssd1 vccd1 vccd1 net52 sky130_fd_sc_hd__a221o_1
X_05745_ _05013_ _05014_ vssd1 vssd1 vccd1 vccd1 _05015_ sky130_fd_sc_hd__nor2_1
X_08464_ _02850_ _02857_ _02858_ vssd1 vssd1 vccd1 vccd1 _02859_ sky130_fd_sc_hd__nand3_1
Xclkbuf_3_7_0_wb_clk_i clknet_0_wb_clk_i vssd1 vssd1 vccd1 vccd1 clknet_3_7_0_wb_clk_i
+ sky130_fd_sc_hd__clkbuf_8
X_05676_ net376 net383 net504 net520 vssd1 vssd1 vccd1 vccd1 _04946_ sky130_fd_sc_hd__and4_1
XFILLER_0_92_448 vssd1 vssd1 vccd1 vccd1 sky130_fd_sc_hd__fill_1
X_08395_ net207 net500 vssd1 vssd1 vccd1 vccd1 _02783_ sky130_fd_sc_hd__nand2_1
XFILLER_0_70_71 vssd1 vssd1 vccd1 vccd1 sky130_ef_sc_hd__decap_12
X_07415_ _01636_ _01638_ _01782_ _01783_ vssd1 vssd1 vccd1 vccd1 _01784_ sky130_fd_sc_hd__a211oi_2
X_07346_ net340 net439 mul.b\[22\] net332 vssd1 vssd1 vccd1 vccd1 _01715_ sky130_fd_sc_hd__a22o_1
X_09016_ _03458_ _03460_ _03281_ _03306_ vssd1 vssd1 vccd1 vccd1 _03462_ sky130_fd_sc_hd__o211a_1
X_07277_ _01645_ _01646_ vssd1 vssd1 vccd1 vccd1 _01647_ sky130_fd_sc_hd__nand2_1
X_06228_ net244 net597 net608 net236 vssd1 vssd1 vccd1 vccd1 _00605_ sky130_fd_sc_hd__a22o_1
X_06159_ _00432_ _00434_ _00535_ vssd1 vssd1 vccd1 vccd1 _00537_ sky130_fd_sc_hd__or3_1
X_09918_ net117 _04417_ _04415_ vssd1 vssd1 vccd1 vccd1 _04447_ sky130_fd_sc_hd__o21ba_1
Xfanout631 net632 vssd1 vssd1 vccd1 vccd1 net631 sky130_fd_sc_hd__buf_2
Xfanout620 net621 vssd1 vssd1 vccd1 vccd1 net620 sky130_fd_sc_hd__clkbuf_2
Xfanout642 net645 vssd1 vssd1 vccd1 vccd1 net642 sky130_fd_sc_hd__buf_4
X_09849_ _04369_ _04370_ vssd1 vssd1 vccd1 vccd1 _04373_ sky130_fd_sc_hd__xnor2_1
XFILLER_0_68_489 vssd1 vssd1 vccd1 vccd1 sky130_fd_sc_hd__fill_1
XFILLER_0_95_297 vssd1 vssd1 vccd1 vccd1 sky130_fd_sc_hd__fill_1
XFILLER_0_24_515 vssd1 vssd1 vccd1 vccd1 sky130_fd_sc_hd__fill_2
XFILLER_0_51_345 vssd1 vssd1 vccd1 vccd1 sky130_fd_sc_hd__fill_1
XFILLER_0_91_15 vssd1 vssd1 vccd1 vccd1 sky130_ef_sc_hd__decap_12
XFILLER_0_86_242 vssd1 vssd1 vccd1 vccd1 sky130_fd_sc_hd__decap_8
XFILLER_0_86_275 vssd1 vssd1 vccd1 vccd1 sky130_fd_sc_hd__fill_1
X_05530_ _04781_ _04782_ _04798_ _04799_ vssd1 vssd1 vccd1 vccd1 _04800_ sky130_fd_sc_hd__nor4_1
XFILLER_0_86_286 vssd1 vssd1 vccd1 vccd1 sky130_fd_sc_hd__decap_3
X_05461_ _04722_ _04729_ vssd1 vssd1 vccd1 vccd1 _04731_ sky130_fd_sc_hd__nand2_1
X_08180_ _02548_ _02549_ _02550_ vssd1 vssd1 vccd1 vccd1 _02552_ sky130_fd_sc_hd__nand3_1
X_07200_ net349 net435 net441 net342 vssd1 vssd1 vccd1 vccd1 _01570_ sky130_fd_sc_hd__a22o_1
X_05392_ _04657_ _04659_ vssd1 vssd1 vccd1 vccd1 _04662_ sky130_fd_sc_hd__xor2_1
XFILLER_0_39_191 vssd1 vssd1 vccd1 vccd1 sky130_fd_sc_hd__fill_2
XFILLER_0_6_236 vssd1 vssd1 vccd1 vccd1 sky130_ef_sc_hd__decap_12
X_07131_ _01235_ _01379_ _01378_ vssd1 vssd1 vccd1 vccd1 _01501_ sky130_fd_sc_hd__a21oi_1
XFILLER_0_40_85 vssd1 vssd1 vccd1 vccd1 sky130_ef_sc_hd__decap_12
XFILLER_0_42_345 vssd1 vssd1 vccd1 vccd1 sky130_fd_sc_hd__decap_3
XFILLER_0_42_356 vssd1 vssd1 vccd1 vccd1 sky130_fd_sc_hd__decap_8
X_07062_ _01430_ _01431_ _01425_ vssd1 vssd1 vccd1 vccd1 _01433_ sky130_fd_sc_hd__a21o_1
XFILLER_0_30_507 vssd1 vssd1 vccd1 vccd1 sky130_fd_sc_hd__decap_6
XFILLER_0_100_417 vssd1 vssd1 vccd1 vccd1 sky130_fd_sc_hd__decap_3
X_06013_ _00390_ _00391_ vssd1 vssd1 vccd1 vccd1 _00392_ sky130_fd_sc_hd__nand2b_1
XFILLER_0_10_253 vssd1 vssd1 vccd1 vccd1 sky130_fd_sc_hd__decap_6
XFILLER_0_49_50 vssd1 vssd1 vccd1 vccd1 sky130_fd_sc_hd__decap_6
X_07964_ _02333_ _02334_ _02335_ vssd1 vssd1 vccd1 vccd1 _02337_ sky130_fd_sc_hd__nand3_1
X_07895_ _02099_ net725 _02267_ _02268_ vssd1 vssd1 vccd1 vccd1 _02269_ sky130_fd_sc_hd__o211ai_4
X_06915_ net375 net429 _01284_ _01285_ vssd1 vssd1 vccd1 vccd1 _01287_ sky130_fd_sc_hd__nand4_2
X_09703_ _04030_ _04032_ _04211_ vssd1 vssd1 vccd1 vccd1 _04213_ sky130_fd_sc_hd__nor3_1
X_09634_ _04118_ _04137_ vssd1 vssd1 vccd1 vccd1 _04138_ sky130_fd_sc_hd__xnor2_1
X_06846_ _01088_ _01090_ _01216_ _01217_ vssd1 vssd1 vccd1 vccd1 _01219_ sky130_fd_sc_hd__a211o_1
XFILLER_0_97_529 vssd1 vssd1 vccd1 vccd1 sky130_fd_sc_hd__decap_3
X_09565_ _04042_ _04061_ vssd1 vssd1 vccd1 vccd1 _04062_ sky130_fd_sc_hd__nand2_1
X_06777_ net365 net373 net434 net440 vssd1 vssd1 vccd1 vccd1 _01150_ sky130_fd_sc_hd__and4_1
X_09496_ _03967_ _03985_ vssd1 vssd1 vccd1 vccd1 _03987_ sky130_fd_sc_hd__xnor2_4
X_08516_ _02912_ _02913_ _02914_ vssd1 vssd1 vccd1 vccd1 _02916_ sky130_fd_sc_hd__or3_1
X_05728_ net289 net298 net598 net607 _04903_ vssd1 vssd1 vccd1 vccd1 _04998_ sky130_fd_sc_hd__a41o_1
X_08447_ net333 net404 net410 net325 vssd1 vssd1 vccd1 vccd1 _02840_ sky130_fd_sc_hd__a22o_1
X_05659_ _04913_ _04928_ vssd1 vssd1 vccd1 vccd1 _04929_ sky130_fd_sc_hd__or2_1
XFILLER_0_92_278 vssd1 vssd1 vccd1 vccd1 sky130_fd_sc_hd__decap_4
X_08378_ _02764_ vssd1 vssd1 vccd1 vccd1 _02765_ sky130_fd_sc_hd__inv_2
XFILLER_0_33_301 vssd1 vssd1 vccd1 vccd1 sky130_fd_sc_hd__fill_1
XFILLER_0_33_312 vssd1 vssd1 vccd1 vccd1 sky130_fd_sc_hd__decap_3
XFILLER_0_45_150 vssd1 vssd1 vccd1 vccd1 sky130_fd_sc_hd__decap_8
X_07329_ net367 net418 net423 net358 vssd1 vssd1 vccd1 vccd1 _01698_ sky130_fd_sc_hd__a22o_1
XFILLER_0_21_518 vssd1 vssd1 vccd1 vccd1 sky130_fd_sc_hd__decap_3
Xfanout450 net451 vssd1 vssd1 vccd1 vccd1 net450 sky130_fd_sc_hd__clkbuf_4
Xfanout483 net484 vssd1 vssd1 vccd1 vccd1 net483 sky130_fd_sc_hd__clkbuf_2
Xfanout472 net475 vssd1 vssd1 vccd1 vccd1 net472 sky130_fd_sc_hd__dlymetal6s2s_1
Xfanout461 net463 vssd1 vssd1 vccd1 vccd1 net461 sky130_fd_sc_hd__clkbuf_4
Xfanout494 mul.b\[16\] vssd1 vssd1 vccd1 vccd1 net494 sky130_fd_sc_hd__buf_4
XFILLER_0_68_253 vssd1 vssd1 vccd1 vccd1 sky130_fd_sc_hd__fill_2
XFILLER_0_83_223 vssd1 vssd1 vccd1 vccd1 sky130_fd_sc_hd__fill_1
XFILLER_0_71_418 vssd1 vssd1 vccd1 vccd1 sky130_fd_sc_hd__fill_1
XFILLER_0_51_120 vssd1 vssd1 vccd1 vccd1 sky130_fd_sc_hd__fill_2
XFILLER_0_101_57 vssd1 vssd1 vccd1 vccd1 sky130_ef_sc_hd__decap_12
XFILLER_0_10_44 vssd1 vssd1 vccd1 vccd1 sky130_fd_sc_hd__decap_4
XFILLER_0_24_356 vssd1 vssd1 vccd1 vccd1 sky130_fd_sc_hd__decap_3
XFILLER_0_19_31 vssd1 vssd1 vccd1 vccd1 sky130_fd_sc_hd__fill_1
X_06700_ net102 net101 _01072_ _01073_ vssd1 vssd1 vccd1 vccd1 _01074_ sky130_fd_sc_hd__o211ai_4
X_07680_ _02036_ _02049_ _02050_ vssd1 vssd1 vccd1 vccd1 _02052_ sky130_fd_sc_hd__nand3_1
XFILLER_0_59_231 vssd1 vssd1 vccd1 vccd1 sky130_ef_sc_hd__decap_12
X_06631_ _00873_ _00875_ _01002_ _01004_ vssd1 vssd1 vccd1 vccd1 _01005_ sky130_fd_sc_hd__a211o_2
X_09350_ _03657_ _03659_ _03827_ vssd1 vssd1 vccd1 vccd1 _03828_ sky130_fd_sc_hd__o21a_1
X_06562_ _00901_ _00902_ net102 _00935_ vssd1 vssd1 vccd1 vccd1 _00937_ sky130_fd_sc_hd__or4_4
X_08301_ _02677_ _02679_ _02680_ vssd1 vssd1 vccd1 vccd1 _02681_ sky130_fd_sc_hd__and3_1
X_09281_ _03750_ _03751_ vssd1 vssd1 vccd1 vccd1 _03752_ sky130_fd_sc_hd__nand2_1
X_05513_ net287 net623 net631 net279 vssd1 vssd1 vccd1 vccd1 _04783_ sky130_fd_sc_hd__a22oi_1
XFILLER_0_19_128 vssd1 vssd1 vccd1 vccd1 sky130_fd_sc_hd__fill_1
X_08232_ net179 net184 net537 net548 vssd1 vssd1 vccd1 vccd1 _02605_ sky130_fd_sc_hd__and4_1
X_06493_ _00866_ _00867_ vssd1 vssd1 vccd1 vccd1 _00868_ sky130_fd_sc_hd__nand2b_1
X_05444_ _04711_ _04712_ _04154_ vssd1 vssd1 vccd1 vccd1 _04714_ sky130_fd_sc_hd__o21ba_1
X_08163_ _02407_ _02409_ _02532_ _02534_ vssd1 vssd1 vccd1 vccd1 _02535_ sky130_fd_sc_hd__a211o_2
X_05375_ _04640_ _04641_ vssd1 vssd1 vccd1 vccd1 _04645_ sky130_fd_sc_hd__xor2_1
XFILLER_0_42_131 vssd1 vssd1 vccd1 vccd1 sky130_fd_sc_hd__decap_8
X_08094_ net164 net183 net557 net584 vssd1 vssd1 vccd1 vccd1 _02466_ sky130_fd_sc_hd__nand4_2
XFILLER_0_70_473 vssd1 vssd1 vccd1 vccd1 sky130_fd_sc_hd__decap_3
XFILLER_0_15_367 vssd1 vssd1 vccd1 vccd1 sky130_fd_sc_hd__decap_3
X_07114_ _01261_ _01263_ _01483_ _01484_ vssd1 vssd1 vccd1 vccd1 _01485_ sky130_fd_sc_hd__a211oi_4
XFILLER_0_42_153 vssd1 vssd1 vccd1 vccd1 sky130_fd_sc_hd__decap_8
X_07045_ _01297_ _01299_ _01415_ vssd1 vssd1 vccd1 vccd1 _01416_ sky130_fd_sc_hd__a21oi_1
XFILLER_0_100_203 vssd1 vssd1 vccd1 vccd1 sky130_fd_sc_hd__fill_1
XFILLER_0_11_551 vssd1 vssd1 vccd1 vccd1 sky130_fd_sc_hd__fill_1
X_08996_ _03438_ _03439_ vssd1 vssd1 vccd1 vccd1 _03440_ sky130_fd_sc_hd__nand2_1
X_07947_ _02318_ _02319_ vssd1 vssd1 vccd1 vccd1 _02320_ sky130_fd_sc_hd__or2_1
XFILLER_0_97_315 vssd1 vssd1 vccd1 vccd1 sky130_ef_sc_hd__decap_12
X_07878_ _02248_ _02249_ _02083_ _02085_ vssd1 vssd1 vccd1 vccd1 _02252_ sky130_fd_sc_hd__o211ai_2
XFILLER_0_97_337 vssd1 vssd1 vccd1 vccd1 sky130_fd_sc_hd__decap_8
X_09617_ _03163_ _03922_ net136 net291 vssd1 vssd1 vccd1 vccd1 _04119_ sky130_fd_sc_hd__o2bb2a_1
X_06829_ _01069_ _01071_ _01200_ _01201_ vssd1 vssd1 vccd1 vccd1 _01202_ sky130_fd_sc_hd__o211a_1
XFILLER_0_78_551 vssd1 vssd1 vccd1 vccd1 sky130_fd_sc_hd__fill_2
X_09548_ net209 net435 net441 net199 vssd1 vssd1 vccd1 vccd1 _04043_ sky130_fd_sc_hd__a22o_1
XFILLER_0_65_223 vssd1 vssd1 vccd1 vccd1 sky130_fd_sc_hd__fill_1
X_09479_ _03781_ _03783_ _03785_ vssd1 vssd1 vccd1 vccd1 _03969_ sky130_fd_sc_hd__a21oi_1
Xwire103 _04800_ vssd1 vssd1 vccd1 vccd1 net103 sky130_fd_sc_hd__buf_1
XFILLER_0_80_248 vssd1 vssd1 vccd1 vccd1 sky130_fd_sc_hd__decap_4
XFILLER_0_21_337 vssd1 vssd1 vccd1 vccd1 sky130_fd_sc_hd__decap_8
XFILLER_0_56_29 vssd1 vssd1 vccd1 vccd1 sky130_fd_sc_hd__decap_8
XFILLER_0_56_18 vssd1 vssd1 vccd1 vccd1 sky130_fd_sc_hd__decap_8
Xfanout280 net281 vssd1 vssd1 vccd1 vccd1 net280 sky130_fd_sc_hd__clkbuf_4
Xfanout291 mul.a\[12\] vssd1 vssd1 vccd1 vccd1 net291 sky130_fd_sc_hd__buf_6
XFILLER_0_88_359 vssd1 vssd1 vccd1 vccd1 sky130_fd_sc_hd__decap_4
XFILLER_0_88_337 vssd1 vssd1 vccd1 vccd1 sky130_fd_sc_hd__decap_4
XFILLER_0_96_392 vssd1 vssd1 vccd1 vccd1 sky130_fd_sc_hd__fill_1
XFILLER_0_8_309 vssd1 vssd1 vccd1 vccd1 sky130_fd_sc_hd__decap_8
XTAP_1293 vssd1 vccd1 sky130_fd_sc_hd__tapvpwrvgnd_1
XTAP_1282 vssd1 vccd1 sky130_fd_sc_hd__tapvpwrvgnd_1
XTAP_1271 vssd1 vccd1 sky130_fd_sc_hd__tapvpwrvgnd_1
XTAP_1260 vssd1 vccd1 sky130_fd_sc_hd__tapvpwrvgnd_1
XFILLER_0_84_543 vssd1 vssd1 vccd1 vccd1 sky130_fd_sc_hd__decap_6
XFILLER_0_56_267 vssd1 vssd1 vccd1 vccd1 sky130_fd_sc_hd__decap_8
XFILLER_0_44_418 vssd1 vssd1 vccd1 vccd1 sky130_fd_sc_hd__fill_2
X_05160_ _02962_ _02984_ _03268_ _03279_ vssd1 vssd1 vccd1 vccd1 _03301_ sky130_fd_sc_hd__a2bb2o_2
XFILLER_0_4_559 vssd1 vssd1 vccd1 vccd1 sky130_fd_sc_hd__fill_2
XFILLER_0_21_76 vssd1 vssd1 vccd1 vccd1 sky130_ef_sc_hd__decap_12
XFILLER_0_12_337 vssd1 vssd1 vccd1 vccd1 sky130_fd_sc_hd__fill_1
XFILLER_0_24_186 vssd1 vssd1 vccd1 vccd1 sky130_fd_sc_hd__fill_1
XFILLER_0_24_197 vssd1 vssd1 vccd1 vccd1 sky130_fd_sc_hd__decap_3
X_05091_ net5 net633 net124 vssd1 vssd1 vccd1 vccd1 _00067_ sky130_fd_sc_hd__mux2_1
X_08850_ _03111_ net108 _03278_ _03280_ vssd1 vssd1 vccd1 vccd1 _03281_ sky130_fd_sc_hd__o211ai_4
X_07801_ _02169_ _02170_ _02006_ _02009_ vssd1 vssd1 vccd1 vccd1 _02172_ sky130_fd_sc_hd__a211o_1
X_08781_ _03002_ _03005_ _03003_ vssd1 vssd1 vccd1 vccd1 _03206_ sky130_fd_sc_hd__o21bai_1
X_05993_ _00369_ _00371_ _00269_ _00272_ vssd1 vssd1 vccd1 vccd1 _00373_ sky130_fd_sc_hd__o211ai_1
X_07732_ _02101_ _02102_ _01938_ _01940_ vssd1 vssd1 vccd1 vccd1 _02104_ sky130_fd_sc_hd__o211a_4
X_07663_ _02032_ _02033_ _01862_ _01864_ vssd1 vssd1 vccd1 vccd1 _02035_ sky130_fd_sc_hd__o211a_1
XFILLER_0_94_307 vssd1 vssd1 vccd1 vccd1 sky130_fd_sc_hd__fill_1
X_09402_ _03873_ _03883_ vssd1 vssd1 vccd1 vccd1 _03884_ sky130_fd_sc_hd__and2b_1
X_06614_ net226 net590 _00986_ _00987_ vssd1 vssd1 vccd1 vccd1 _00988_ sky130_fd_sc_hd__nand4_2
X_09333_ _03770_ _03772_ _03806_ _03807_ vssd1 vssd1 vccd1 vccd1 _03809_ sky130_fd_sc_hd__o22ai_2
XFILLER_0_75_521 vssd1 vssd1 vccd1 vccd1 sky130_fd_sc_hd__decap_4
XFILLER_0_62_61 vssd1 vssd1 vccd1 vccd1 sky130_fd_sc_hd__fill_1
X_07594_ net149 net636 _01963_ _01965_ vssd1 vssd1 vccd1 vccd1 _01966_ sky130_fd_sc_hd__a22oi_1
X_06545_ net287 net532 net542 net279 vssd1 vssd1 vccd1 vccd1 _00920_ sky130_fd_sc_hd__a22o_1
XFILLER_0_90_524 vssd1 vssd1 vccd1 vccd1 sky130_fd_sc_hd__fill_1
X_09264_ net178 net481 net489 net172 vssd1 vssd1 vccd1 vccd1 _03733_ sky130_fd_sc_hd__a22o_1
X_06476_ net195 net204 net627 net635 vssd1 vssd1 vccd1 vccd1 _00851_ sky130_fd_sc_hd__and4_1
XFILLER_0_35_407 vssd1 vssd1 vccd1 vccd1 sky130_fd_sc_hd__fill_1
XFILLER_0_35_418 vssd1 vssd1 vccd1 vccd1 sky130_fd_sc_hd__decap_8
X_09195_ _03655_ _03656_ _03452_ _03455_ vssd1 vssd1 vccd1 vccd1 _03658_ sky130_fd_sc_hd__a211oi_2
X_08215_ _02585_ _02586_ _02323_ _02325_ vssd1 vssd1 vccd1 vccd1 _02588_ sky130_fd_sc_hd__a211o_1
X_05427_ net287 net292 net622 net630 vssd1 vssd1 vccd1 vccd1 _04697_ sky130_fd_sc_hd__and4_1
X_08146_ _02381_ _02388_ _02387_ vssd1 vssd1 vccd1 vccd1 _02518_ sky130_fd_sc_hd__a21o_1
XFILLER_0_70_281 vssd1 vssd1 vccd1 vccd1 sky130_fd_sc_hd__fill_2
X_05358_ _04588_ _04625_ _04626_ vssd1 vssd1 vccd1 vccd1 _04628_ sky130_fd_sc_hd__and3b_1
X_08077_ net149 net618 _02447_ net611 vssd1 vssd1 vccd1 vccd1 _02449_ sky130_fd_sc_hd__a22oi_2
XFILLER_0_15_197 vssd1 vssd1 vccd1 vccd1 sky130_fd_sc_hd__fill_1
X_05289_ net336 net343 net623 net631 vssd1 vssd1 vccd1 vccd1 _04559_ sky130_fd_sc_hd__and4_1
X_07028_ _01364_ _01397_ vssd1 vssd1 vccd1 vccd1 _01399_ sky130_fd_sc_hd__xnor2_1
X_08979_ net185 net192 net480 net489 vssd1 vssd1 vccd1 vccd1 _03422_ sky130_fd_sc_hd__nand4_1
XFILLER_0_85_329 vssd1 vssd1 vccd1 vccd1 sky130_fd_sc_hd__decap_3
XFILLER_0_66_521 vssd1 vssd1 vccd1 vccd1 sky130_fd_sc_hd__decap_8
XFILLER_0_26_418 vssd1 vssd1 vccd1 vccd1 sky130_fd_sc_hd__fill_2
XFILLER_0_26_429 vssd1 vssd1 vccd1 vccd1 sky130_fd_sc_hd__fill_1
XFILLER_0_38_289 vssd1 vssd1 vccd1 vccd1 sky130_fd_sc_hd__fill_2
XFILLER_0_81_568 vssd1 vssd1 vccd1 vccd1 sky130_fd_sc_hd__fill_1
XFILLER_0_34_462 vssd1 vssd1 vccd1 vccd1 sky130_fd_sc_hd__decap_3
XANTENNA_8 net326 vssd1 vssd1 vccd1 vccd1 sky130_fd_sc_hd__diode_2
XFILLER_0_61_281 vssd1 vssd1 vccd1 vccd1 sky130_fd_sc_hd__fill_2
XFILLER_0_21_167 vssd1 vssd1 vccd1 vccd1 sky130_fd_sc_hd__fill_1
XTAP_329 vssd1 vccd1 sky130_fd_sc_hd__tapvpwrvgnd_1
XTAP_318 vssd1 vccd1 sky130_fd_sc_hd__tapvpwrvgnd_1
XTAP_307 vssd1 vccd1 sky130_fd_sc_hd__tapvpwrvgnd_1
XFILLER_0_83_16 vssd1 vssd1 vccd1 vccd1 sky130_fd_sc_hd__decap_4
X_10099_ clknet_3_5_0_wb_clk_i _00095_ _00031_ vssd1 vssd1 vccd1 vccd1 mul.b\[28\]
+ sky130_fd_sc_hd__dfrtp_4
XFILLER_0_16_21 vssd1 vssd1 vccd1 vccd1 sky130_fd_sc_hd__decap_6
XFILLER_0_76_318 vssd1 vssd1 vccd1 vccd1 sky130_fd_sc_hd__fill_2
XFILLER_0_84_362 vssd1 vssd1 vccd1 vccd1 sky130_fd_sc_hd__fill_2
XTAP_1090 vssd1 vccd1 sky130_fd_sc_hd__tapvpwrvgnd_1
X_06330_ _00703_ _00704_ _00525_ vssd1 vssd1 vccd1 vccd1 _00707_ sky130_fd_sc_hd__a21oi_1
XFILLER_0_32_42 vssd1 vssd1 vccd1 vccd1 sky130_fd_sc_hd__decap_3
XFILLER_0_72_524 vssd1 vssd1 vccd1 vccd1 sky130_fd_sc_hd__fill_1
X_06261_ _00621_ _00636_ vssd1 vssd1 vccd1 vccd1 _00638_ sky130_fd_sc_hd__xnor2_2
XFILLER_0_32_97 vssd1 vssd1 vccd1 vccd1 sky130_fd_sc_hd__decap_4
X_08000_ net518 _02372_ _02371_ vssd1 vssd1 vccd1 vccd1 _02373_ sky130_fd_sc_hd__a21bo_1
XFILLER_0_4_301 vssd1 vssd1 vccd1 vccd1 sky130_fd_sc_hd__decap_6
X_05212_ _03476_ _03771_ _03826_ vssd1 vssd1 vccd1 vccd1 _03869_ sky130_fd_sc_hd__a21o_1
XFILLER_0_52_281 vssd1 vssd1 vccd1 vccd1 sky130_fd_sc_hd__fill_1
X_06192_ _00566_ _00567_ _00549_ vssd1 vssd1 vccd1 vccd1 _00570_ sky130_fd_sc_hd__a21oi_1
XFILLER_0_40_421 vssd1 vssd1 vccd1 vccd1 sky130_ef_sc_hd__decap_12
X_05143_ _03028_ _03093_ _03104_ vssd1 vssd1 vccd1 vccd1 _03115_ sky130_fd_sc_hd__nand3_1
X_05074_ net13 net485 net126 vssd1 vssd1 vccd1 vccd1 _00084_ sky130_fd_sc_hd__mux2_1
X_09951_ _04318_ _04321_ _04323_ _04325_ _04316_ vssd1 vssd1 vccd1 vccd1 _04484_ sky130_fd_sc_hd__a32o_1
X_08902_ _03182_ _03184_ _03337_ vssd1 vssd1 vccd1 vccd1 _03338_ sky130_fd_sc_hd__a21oi_1
X_09882_ _04234_ _04237_ _04407_ vssd1 vssd1 vccd1 vccd1 _04409_ sky130_fd_sc_hd__nor3_1
XTAP_852 vssd1 vccd1 sky130_fd_sc_hd__tapvpwrvgnd_1
XTAP_841 vssd1 vccd1 sky130_fd_sc_hd__tapvpwrvgnd_1
XTAP_830 vssd1 vccd1 sky130_fd_sc_hd__tapvpwrvgnd_1
X_08833_ _03101_ _03107_ _03100_ vssd1 vssd1 vccd1 vccd1 _03262_ sky130_fd_sc_hd__a21bo_1
XTAP_874 vssd1 vccd1 sky130_fd_sc_hd__tapvpwrvgnd_1
XTAP_885 vssd1 vccd1 sky130_fd_sc_hd__tapvpwrvgnd_1
XTAP_863 vssd1 vccd1 sky130_fd_sc_hd__tapvpwrvgnd_1
XFILLER_0_57_72 vssd1 vssd1 vccd1 vccd1 sky130_fd_sc_hd__fill_2
X_08764_ _03184_ _03185_ _03186_ vssd1 vssd1 vccd1 vccd1 _03187_ sky130_fd_sc_hd__nand3_2
XTAP_896 vssd1 vccd1 sky130_fd_sc_hd__tapvpwrvgnd_1
X_05976_ _00231_ _00354_ net683 vssd1 vssd1 vccd1 vccd1 _00356_ sky130_fd_sc_hd__nor3_4
XFILLER_0_32_3 vssd1 vssd1 vccd1 vccd1 sky130_ef_sc_hd__decap_12
X_07715_ _01918_ _01920_ _02085_ _02086_ vssd1 vssd1 vccd1 vccd1 _02087_ sky130_fd_sc_hd__o211a_2
X_08695_ _03108_ _03109_ _03110_ vssd1 vssd1 vccd1 vccd1 _03111_ sky130_fd_sc_hd__and3_2
XFILLER_0_94_115 vssd1 vssd1 vccd1 vccd1 sky130_fd_sc_hd__fill_1
XFILLER_0_79_189 vssd1 vssd1 vccd1 vccd1 sky130_fd_sc_hd__decap_3
XFILLER_0_73_93 vssd1 vssd1 vccd1 vccd1 sky130_fd_sc_hd__decap_4
X_07646_ net340 net427 net433 net332 vssd1 vssd1 vccd1 vccd1 _02018_ sky130_fd_sc_hd__a22o_1
X_07577_ _01645_ _01789_ _01788_ vssd1 vssd1 vccd1 vccd1 _01950_ sky130_fd_sc_hd__a21o_1
X_09316_ net241 net248 net417 net424 vssd1 vssd1 vccd1 vccd1 _03790_ sky130_fd_sc_hd__and4_1
X_06528_ net353 net469 _00784_ _00783_ vssd1 vssd1 vccd1 vccd1 _00903_ sky130_fd_sc_hd__a31o_1
XFILLER_0_48_587 vssd1 vssd1 vccd1 vccd1 sky130_fd_sc_hd__fill_1
X_09247_ net146 net699 net545 vssd1 vssd1 vccd1 vccd1 _03714_ sky130_fd_sc_hd__and3_1
XFILLER_0_7_161 vssd1 vssd1 vccd1 vccd1 sky130_fd_sc_hd__decap_3
X_06459_ _00833_ _00834_ vssd1 vssd1 vccd1 vccd1 _00835_ sky130_fd_sc_hd__nor2_1
X_09178_ _03631_ _03638_ vssd1 vssd1 vccd1 vccd1 _03639_ sky130_fd_sc_hd__xor2_1
X_08129_ _02498_ _02499_ _02500_ vssd1 vssd1 vccd1 vccd1 _02501_ sky130_fd_sc_hd__and3_2
XFILLER_0_31_454 vssd1 vssd1 vccd1 vccd1 sky130_fd_sc_hd__fill_1
XFILLER_0_43_281 vssd1 vssd1 vccd1 vccd1 sky130_fd_sc_hd__decap_8
XFILLER_0_31_476 vssd1 vssd1 vccd1 vccd1 sky130_fd_sc_hd__fill_1
Xoutput56 net56 vssd1 vssd1 vccd1 vccd1 wbs_dat_o[24] sky130_fd_sc_hd__clkbuf_4
Xoutput45 net45 vssd1 vssd1 vccd1 vccd1 wbs_dat_o[14] sky130_fd_sc_hd__clkbuf_4
Xoutput67 net67 vssd1 vssd1 vccd1 vccd1 wbs_dat_o[5] sky130_fd_sc_hd__buf_2
X_10022_ net642 vssd1 vssd1 vccd1 vccd1 _00018_ sky130_fd_sc_hd__inv_2
XFILLER_0_98_421 vssd1 vssd1 vccd1 vccd1 sky130_fd_sc_hd__decap_3
XFILLER_0_98_410 vssd1 vssd1 vccd1 vccd1 sky130_fd_sc_hd__decap_8
XFILLER_0_98_454 vssd1 vssd1 vccd1 vccd1 sky130_fd_sc_hd__fill_2
XFILLER_0_53_19 vssd1 vssd1 vccd1 vccd1 sky130_fd_sc_hd__fill_2
XFILLER_0_85_126 vssd1 vssd1 vccd1 vccd1 sky130_ef_sc_hd__decap_12
XPHY_151 vssd1 vssd1 vccd1 vccd1 sky130_fd_sc_hd__decap_3
XPHY_140 vssd1 vssd1 vccd1 vccd1 sky130_fd_sc_hd__decap_3
XFILLER_0_66_373 vssd1 vssd1 vccd1 vccd1 sky130_fd_sc_hd__fill_2
XFILLER_0_54_513 vssd1 vssd1 vccd1 vccd1 sky130_ef_sc_hd__decap_12
XFILLER_0_39_565 vssd1 vssd1 vccd1 vccd1 sky130_fd_sc_hd__fill_1
XFILLER_0_39_576 vssd1 vssd1 vccd1 vccd1 sky130_fd_sc_hd__decap_3
XFILLER_0_93_192 vssd1 vssd1 vccd1 vccd1 sky130_fd_sc_hd__fill_2
XPHY_184 vssd1 vssd1 vccd1 vccd1 sky130_fd_sc_hd__decap_3
XPHY_173 vssd1 vssd1 vccd1 vccd1 sky130_fd_sc_hd__decap_3
XPHY_162 vssd1 vssd1 vccd1 vccd1 sky130_fd_sc_hd__decap_3
XFILLER_0_26_215 vssd1 vssd1 vccd1 vccd1 sky130_fd_sc_hd__decap_4
XPHY_195 vssd1 vssd1 vccd1 vccd1 sky130_fd_sc_hd__decap_3
X_05830_ net253 net625 net633 net243 vssd1 vssd1 vccd1 vccd1 _00211_ sky130_fd_sc_hd__a22oi_1
XFILLER_0_89_432 vssd1 vssd1 vccd1 vccd1 sky130_fd_sc_hd__fill_1
X_07500_ net332 net438 net445 net324 vssd1 vssd1 vccd1 vccd1 _01872_ sky130_fd_sc_hd__a22o_1
X_05761_ _00140_ _00141_ _00142_ vssd1 vssd1 vccd1 vccd1 _00143_ sky130_fd_sc_hd__nand3_1
X_08480_ _02724_ _02745_ _02743_ vssd1 vssd1 vccd1 vccd1 _02877_ sky130_fd_sc_hd__a21o_1
X_05692_ _04931_ _04932_ _04960_ vssd1 vssd1 vccd1 vccd1 _04962_ sky130_fd_sc_hd__o21a_1
XFILLER_0_76_137 vssd1 vssd1 vccd1 vccd1 sky130_fd_sc_hd__decap_3
X_07431_ _01651_ _01653_ vssd1 vssd1 vccd1 vccd1 _01799_ sky130_fd_sc_hd__nor2_1
XFILLER_0_43_52 vssd1 vssd1 vccd1 vccd1 sky130_fd_sc_hd__decap_4
XFILLER_0_57_351 vssd1 vssd1 vccd1 vccd1 sky130_fd_sc_hd__decap_8
X_07362_ _01596_ _01598_ _01730_ vssd1 vssd1 vccd1 vccd1 _01731_ sky130_fd_sc_hd__o21a_1
XFILLER_0_84_170 vssd1 vssd1 vccd1 vccd1 sky130_fd_sc_hd__fill_2
X_09101_ _02924_ _03087_ _03088_ _03240_ _03394_ vssd1 vssd1 vccd1 vccd1 _03556_ sky130_fd_sc_hd__o2111a_1
X_06313_ _00566_ _00569_ _00687_ _00689_ vssd1 vssd1 vccd1 vccd1 _00690_ sky130_fd_sc_hd__a211o_2
XFILLER_0_60_505 vssd1 vssd1 vccd1 vccd1 sky130_ef_sc_hd__decap_12
X_07293_ _01657_ _01659_ _01660_ vssd1 vssd1 vccd1 vccd1 _01662_ sky130_fd_sc_hd__or3_1
X_09032_ net258 net270 net417 net424 vssd1 vssd1 vccd1 vccd1 _03480_ sky130_fd_sc_hd__and4_1
X_06244_ _00511_ _00619_ vssd1 vssd1 vccd1 vccd1 _00621_ sky130_fd_sc_hd__xnor2_2
XFILLER_0_13_421 vssd1 vssd1 vccd1 vccd1 sky130_fd_sc_hd__fill_1
X_06175_ _00551_ _00552_ vssd1 vssd1 vccd1 vccd1 _00553_ sky130_fd_sc_hd__and2b_1
XFILLER_0_25_281 vssd1 vssd1 vccd1 vccd1 sky130_fd_sc_hd__fill_1
X_05126_ _02897_ _02908_ _02864_ vssd1 vssd1 vccd1 vccd1 _02930_ sky130_fd_sc_hd__a21bo_1
XFILLER_0_7_41 vssd1 vssd1 vccd1 vccd1 sky130_fd_sc_hd__fill_1
X_09934_ _04009_ _03864_ _04313_ vssd1 vssd1 vccd1 vccd1 _04465_ sky130_fd_sc_hd__mux2_1
X_05057_ net2 _01849_ vssd1 vssd1 vccd1 vccd1 _02210_ sky130_fd_sc_hd__and2_2
X_09865_ _04375_ _04388_ _04389_ vssd1 vssd1 vccd1 vccd1 _04390_ sky130_fd_sc_hd__nor3_1
XTAP_660 vssd1 vccd1 sky130_fd_sc_hd__tapvpwrvgnd_1
X_08816_ net446 net144 net130 net205 vssd1 vssd1 vccd1 vccd1 _03244_ sky130_fd_sc_hd__a22o_1
XTAP_671 vssd1 vccd1 sky130_fd_sc_hd__tapvpwrvgnd_1
XTAP_682 vssd1 vccd1 sky130_fd_sc_hd__tapvpwrvgnd_1
XTAP_693 vssd1 vccd1 sky130_fd_sc_hd__tapvpwrvgnd_1
X_09796_ _04010_ _04313_ vssd1 vssd1 vccd1 vccd1 _04314_ sky130_fd_sc_hd__xor2_1
X_08747_ net323 net396 _03166_ _03167_ vssd1 vssd1 vccd1 vccd1 _03168_ sky130_fd_sc_hd__o2bb2a_1
X_05959_ net335 net522 vssd1 vssd1 vccd1 vccd1 _00339_ sky130_fd_sc_hd__and2_1
XFILLER_0_95_413 vssd1 vssd1 vccd1 vccd1 sky130_fd_sc_hd__decap_4
X_08678_ net140 _03090_ _03091_ _03092_ vssd1 vssd1 vccd1 vccd1 net53 sky130_fd_sc_hd__a31o_1
XFILLER_0_95_435 vssd1 vssd1 vccd1 vccd1 sky130_fd_sc_hd__decap_8
X_07629_ net391 net393 vssd1 vssd1 vccd1 vccd1 _02001_ sky130_fd_sc_hd__and2b_1
XFILLER_0_82_107 vssd1 vssd1 vccd1 vccd1 sky130_fd_sc_hd__decap_4
XFILLER_0_48_362 vssd1 vssd1 vccd1 vccd1 sky130_fd_sc_hd__fill_2
XFILLER_0_48_373 vssd1 vssd1 vccd1 vccd1 sky130_fd_sc_hd__fill_1
XFILLER_0_51_505 vssd1 vssd1 vccd1 vccd1 sky130_ef_sc_hd__decap_12
XFILLER_0_36_568 vssd1 vssd1 vccd1 vccd1 sky130_fd_sc_hd__fill_2
XFILLER_0_90_195 vssd1 vssd1 vccd1 vccd1 sky130_fd_sc_hd__fill_1
XFILLER_0_101_161 vssd1 vssd1 vccd1 vccd1 sky130_fd_sc_hd__decap_6
X_10005_ net141 _04540_ _04541_ _04542_ vssd1 vssd1 vccd1 vccd1 net64 sky130_fd_sc_hd__a31o_1
XFILLER_0_98_251 vssd1 vssd1 vccd1 vccd1 sky130_fd_sc_hd__fill_1
XFILLER_0_80_17 vssd1 vssd1 vccd1 vccd1 sky130_fd_sc_hd__fill_1
XFILLER_0_58_137 vssd1 vssd1 vccd1 vccd1 sky130_fd_sc_hd__decap_3
XFILLER_0_73_129 vssd1 vssd1 vccd1 vccd1 sky130_fd_sc_hd__decap_8
XFILLER_0_66_192 vssd1 vssd1 vccd1 vccd1 sky130_fd_sc_hd__decap_4
XFILLER_0_54_332 vssd1 vssd1 vccd1 vccd1 sky130_fd_sc_hd__decap_4
XFILLER_0_54_365 vssd1 vssd1 vccd1 vccd1 sky130_fd_sc_hd__decap_4
XFILLER_0_14_229 vssd1 vssd1 vccd1 vccd1 sky130_fd_sc_hd__decap_6
XFILLER_0_22_251 vssd1 vssd1 vccd1 vccd1 sky130_fd_sc_hd__fill_1
XFILLER_0_1_167 vssd1 vssd1 vccd1 vccd1 sky130_fd_sc_hd__fill_1
X_07980_ _02175_ _02182_ _02181_ vssd1 vssd1 vccd1 vccd1 _02353_ sky130_fd_sc_hd__a21bo_1
XFILLER_0_10_468 vssd1 vssd1 vccd1 vccd1 sky130_fd_sc_hd__decap_8
X_06931_ net303 net497 _01179_ _01178_ vssd1 vssd1 vccd1 vccd1 _01303_ sky130_fd_sc_hd__a31o_1
X_09650_ _03850_ _04005_ vssd1 vssd1 vccd1 vccd1 _04156_ sky130_fd_sc_hd__nor2_1
XFILLER_0_38_85 vssd1 vssd1 vccd1 vccd1 sky130_fd_sc_hd__decap_4
X_08601_ net314 net323 net401 net408 vssd1 vssd1 vccd1 vccd1 _03009_ sky130_fd_sc_hd__nand4_2
X_06862_ _01231_ _01232_ vssd1 vssd1 vccd1 vccd1 _01234_ sky130_fd_sc_hd__xor2_1
X_09581_ net267 net395 _04075_ _04078_ vssd1 vssd1 vccd1 vccd1 _04080_ sky130_fd_sc_hd__and4_1
X_05813_ _00192_ _00193_ vssd1 vssd1 vccd1 vccd1 _00194_ sky130_fd_sc_hd__nand2b_1
X_06793_ _01148_ _01164_ _01165_ vssd1 vssd1 vccd1 vccd1 _01166_ sky130_fd_sc_hd__nand3_2
X_08532_ _02932_ _02933_ vssd1 vssd1 vccd1 vccd1 _02934_ sky130_fd_sc_hd__nor2_1
X_05744_ _05011_ _05012_ _04927_ _04929_ vssd1 vssd1 vccd1 vccd1 _05014_ sky130_fd_sc_hd__o211a_1
X_08463_ _02855_ _02856_ _02851_ vssd1 vssd1 vccd1 vccd1 _02858_ sky130_fd_sc_hd__a21o_1
XFILLER_0_54_95 vssd1 vssd1 vccd1 vccd1 sky130_fd_sc_hd__decap_4
XFILLER_0_9_212 vssd1 vssd1 vccd1 vccd1 sky130_fd_sc_hd__fill_1
X_05675_ net383 net504 net513 net372 vssd1 vssd1 vccd1 vccd1 _04945_ sky130_fd_sc_hd__a22oi_1
XFILLER_0_18_502 vssd1 vssd1 vccd1 vccd1 sky130_fd_sc_hd__decap_6
X_07414_ _01780_ _01781_ _01538_ _01540_ vssd1 vssd1 vccd1 vccd1 _01783_ sky130_fd_sc_hd__o211a_1
X_08394_ net518 _02781_ _02780_ vssd1 vssd1 vccd1 vccd1 _02782_ sky130_fd_sc_hd__a21bo_1
XFILLER_0_57_181 vssd1 vssd1 vccd1 vccd1 sky130_fd_sc_hd__decap_4
XFILLER_0_45_321 vssd1 vssd1 vccd1 vccd1 sky130_fd_sc_hd__decap_4
XFILLER_0_70_83 vssd1 vssd1 vccd1 vccd1 sky130_fd_sc_hd__fill_1
X_07345_ _01711_ _01712_ _01562_ _01564_ vssd1 vssd1 vccd1 vccd1 _01714_ sky130_fd_sc_hd__o211a_1
XFILLER_0_33_505 vssd1 vssd1 vccd1 vccd1 sky130_fd_sc_hd__decap_8
X_07276_ _01643_ _01644_ _01487_ _01489_ vssd1 vssd1 vccd1 vccd1 _01646_ sky130_fd_sc_hd__a211o_1
X_09015_ _03281_ _03306_ _03458_ _03460_ vssd1 vssd1 vccd1 vccd1 _03461_ sky130_fd_sc_hd__a211oi_2
X_06227_ net236 net244 net597 net608 vssd1 vssd1 vccd1 vccd1 _00604_ sky130_fd_sc_hd__and4_1
X_06158_ _00432_ _00434_ _00535_ vssd1 vssd1 vccd1 vccd1 _00536_ sky130_fd_sc_hd__o21ai_2
XFILLER_0_41_582 vssd1 vssd1 vccd1 vccd1 sky130_fd_sc_hd__fill_2
X_05109_ _02711_ _02722_ _02700_ vssd1 vssd1 vccd1 vccd1 _02744_ sky130_fd_sc_hd__a21bo_1
X_06089_ _00363_ _00365_ net86 _00467_ vssd1 vssd1 vccd1 vccd1 _00468_ sky130_fd_sc_hd__a211o_4
X_09917_ _04429_ _04431_ _04428_ vssd1 vssd1 vccd1 vccd1 _04446_ sky130_fd_sc_hd__o21ba_1
Xfanout632 mul.b\[0\] vssd1 vssd1 vccd1 vccd1 net632 sky130_fd_sc_hd__clkbuf_4
Xfanout621 mul.b\[2\] vssd1 vssd1 vccd1 vccd1 net621 sky130_fd_sc_hd__buf_2
Xfanout610 net611 vssd1 vssd1 vccd1 vccd1 net610 sky130_fd_sc_hd__buf_2
XFILLER_0_95_91 vssd1 vssd1 vccd1 vccd1 sky130_fd_sc_hd__decap_6
Xfanout643 net644 vssd1 vssd1 vccd1 vccd1 net643 sky130_fd_sc_hd__buf_4
X_09848_ _04369_ _04370_ vssd1 vssd1 vccd1 vccd1 _04371_ sky130_fd_sc_hd__and2_1
XTAP_490 vssd1 vccd1 sky130_fd_sc_hd__tapvpwrvgnd_1
X_09779_ _04293_ _04294_ vssd1 vssd1 vccd1 vccd1 _04297_ sky130_fd_sc_hd__xor2_1
XFILLER_0_68_457 vssd1 vssd1 vccd1 vccd1 sky130_fd_sc_hd__decap_3
XFILLER_0_95_243 vssd1 vssd1 vccd1 vccd1 sky130_fd_sc_hd__fill_1
XFILLER_0_55_129 vssd1 vssd1 vccd1 vccd1 sky130_fd_sc_hd__fill_1
XFILLER_0_51_302 vssd1 vssd1 vccd1 vccd1 sky130_fd_sc_hd__fill_2
XFILLER_0_36_365 vssd1 vssd1 vccd1 vccd1 sky130_fd_sc_hd__decap_3
XFILLER_0_75_39 vssd1 vssd1 vccd1 vccd1 sky130_ef_sc_hd__decap_12
XFILLER_0_59_446 vssd1 vssd1 vccd1 vccd1 sky130_fd_sc_hd__fill_2
XFILLER_0_47_608 vssd1 vssd1 vccd1 vccd1 sky130_fd_sc_hd__fill_2
X_05460_ _04722_ _04729_ vssd1 vssd1 vccd1 vccd1 _04730_ sky130_fd_sc_hd__or2_1
XFILLER_0_27_343 vssd1 vssd1 vccd1 vccd1 sky130_fd_sc_hd__decap_8
X_05391_ _04644_ _04645_ vssd1 vssd1 vccd1 vccd1 _04661_ sky130_fd_sc_hd__xnor2_1
XFILLER_0_40_20 vssd1 vssd1 vccd1 vccd1 sky130_fd_sc_hd__decap_8
XFILLER_0_39_181 vssd1 vssd1 vccd1 vccd1 sky130_fd_sc_hd__decap_3
XFILLER_0_6_248 vssd1 vssd1 vccd1 vccd1 sky130_fd_sc_hd__decap_4
X_07130_ _00966_ _01499_ _01498_ vssd1 vssd1 vccd1 vccd1 _01500_ sky130_fd_sc_hd__a21oi_2
XFILLER_0_40_75 vssd1 vssd1 vccd1 vccd1 sky130_fd_sc_hd__fill_1
XFILLER_0_2_421 vssd1 vssd1 vccd1 vccd1 sky130_fd_sc_hd__decap_3
XFILLER_0_40_97 vssd1 vssd1 vccd1 vccd1 sky130_fd_sc_hd__decap_4
X_07061_ _01425_ _01430_ _01431_ vssd1 vssd1 vccd1 vccd1 _01432_ sky130_fd_sc_hd__nand3_2
XFILLER_0_2_465 vssd1 vssd1 vccd1 vccd1 sky130_fd_sc_hd__decap_8
X_06012_ _00285_ _00287_ vssd1 vssd1 vccd1 vccd1 _00391_ sky130_fd_sc_hd__nand2_1
X_07963_ _02333_ _02334_ _02335_ vssd1 vssd1 vccd1 vccd1 _02336_ sky130_fd_sc_hd__a21o_1
XFILLER_0_4_42 vssd1 vssd1 vccd1 vccd1 sky130_fd_sc_hd__decap_3
X_07894_ _02265_ _02266_ _01995_ _01997_ vssd1 vssd1 vccd1 vccd1 _02268_ sky130_fd_sc_hd__a211o_4
X_06914_ net375 net429 _01284_ _01285_ vssd1 vssd1 vccd1 vccd1 _01286_ sky130_fd_sc_hd__a22o_1
X_09702_ _04030_ _04032_ _04211_ vssd1 vssd1 vccd1 vccd1 _04212_ sky130_fd_sc_hd__o21a_1
X_09633_ _04135_ _04136_ vssd1 vssd1 vccd1 vccd1 _04137_ sky130_fd_sc_hd__and2_1
X_06845_ _01216_ _01217_ _01088_ _01090_ vssd1 vssd1 vccd1 vccd1 _01218_ sky130_fd_sc_hd__o211a_1
X_09564_ _04059_ _04060_ vssd1 vssd1 vccd1 vccd1 _04061_ sky130_fd_sc_hd__and2_1
X_08515_ _02912_ _02913_ _02914_ vssd1 vssd1 vccd1 vccd1 _02915_ sky130_fd_sc_hd__nor3_1
XFILLER_0_77_221 vssd1 vssd1 vccd1 vccd1 sky130_fd_sc_hd__decap_3
X_06776_ _01038_ _01045_ _01044_ vssd1 vssd1 vccd1 vccd1 _01149_ sky130_fd_sc_hd__a21o_1
X_09495_ _03967_ _03985_ vssd1 vssd1 vccd1 vccd1 _03986_ sky130_fd_sc_hd__and2b_1
X_05727_ _04995_ _04996_ vssd1 vssd1 vccd1 vccd1 _04997_ sky130_fd_sc_hd__or2_1
X_08446_ _02837_ _02838_ vssd1 vssd1 vccd1 vccd1 _02839_ sky130_fd_sc_hd__xor2_2
XFILLER_0_65_449 vssd1 vssd1 vccd1 vccd1 sky130_fd_sc_hd__decap_4
XFILLER_0_65_416 vssd1 vssd1 vccd1 vccd1 sky130_fd_sc_hd__fill_2
X_05658_ _04871_ _04926_ vssd1 vssd1 vccd1 vccd1 _04928_ sky130_fd_sc_hd__xnor2_2
XFILLER_0_80_408 vssd1 vssd1 vccd1 vccd1 sky130_ef_sc_hd__decap_12
X_08377_ _02762_ _02763_ vssd1 vssd1 vccd1 vccd1 _02764_ sky130_fd_sc_hd__and2b_1
X_07328_ _01552_ _01554_ vssd1 vssd1 vccd1 vccd1 _01697_ sky130_fd_sc_hd__or2_1
X_05589_ _04784_ _04858_ vssd1 vssd1 vccd1 vccd1 _04859_ sky130_fd_sc_hd__xnor2_1
XFILLER_0_18_365 vssd1 vssd1 vccd1 vccd1 sky130_fd_sc_hd__decap_4
XFILLER_0_45_162 vssd1 vssd1 vccd1 vccd1 sky130_fd_sc_hd__decap_6
XFILLER_0_33_324 vssd1 vssd1 vccd1 vccd1 sky130_fd_sc_hd__decap_6
XFILLER_0_33_357 vssd1 vssd1 vccd1 vccd1 sky130_ef_sc_hd__decap_12
X_07259_ _01568_ _01569_ _01625_ _01627_ vssd1 vssd1 vccd1 vccd1 _01629_ sky130_fd_sc_hd__or4b_1
Xfanout440 net441 vssd1 vssd1 vccd1 vccd1 net440 sky130_fd_sc_hd__clkbuf_4
Xfanout451 mul.b\[21\] vssd1 vssd1 vccd1 vccd1 net451 sky130_fd_sc_hd__clkbuf_2
Xfanout484 net485 vssd1 vssd1 vccd1 vccd1 net484 sky130_fd_sc_hd__buf_4
Xfanout473 net475 vssd1 vssd1 vccd1 vccd1 net473 sky130_fd_sc_hd__clkbuf_4
Xfanout462 net463 vssd1 vssd1 vccd1 vccd1 net462 sky130_fd_sc_hd__buf_2
Xfanout495 net496 vssd1 vssd1 vccd1 vccd1 net495 sky130_fd_sc_hd__clkbuf_4
Xmax_cap9 _01623_ vssd1 vssd1 vccd1 vccd1 net719 sky130_fd_sc_hd__buf_1
XFILLER_0_96_530 vssd1 vssd1 vccd1 vccd1 sky130_fd_sc_hd__fill_2
XFILLER_0_68_210 vssd1 vssd1 vccd1 vccd1 sky130_fd_sc_hd__fill_2
XFILLER_0_56_405 vssd1 vssd1 vccd1 vccd1 sky130_fd_sc_hd__decap_4
XFILLER_0_56_416 vssd1 vssd1 vccd1 vccd1 sky130_fd_sc_hd__decap_4
XFILLER_0_36_195 vssd1 vssd1 vccd1 vccd1 sky130_fd_sc_hd__fill_1
XFILLER_0_101_69 vssd1 vssd1 vccd1 vccd1 sky130_ef_sc_hd__decap_12
XFILLER_0_51_176 vssd1 vssd1 vccd1 vccd1 sky130_fd_sc_hd__decap_8
XFILLER_0_19_54 vssd1 vssd1 vccd1 vccd1 sky130_fd_sc_hd__fill_2
X_06630_ _01000_ _01001_ _00884_ vssd1 vssd1 vccd1 vccd1 _01004_ sky130_fd_sc_hd__o21a_1
XFILLER_0_35_53 vssd1 vssd1 vccd1 vccd1 sky130_fd_sc_hd__decap_3
XFILLER_0_35_75 vssd1 vssd1 vccd1 vccd1 sky130_ef_sc_hd__decap_12
XFILLER_0_87_552 vssd1 vssd1 vccd1 vccd1 sky130_fd_sc_hd__fill_1
XFILLER_0_59_243 vssd1 vssd1 vccd1 vccd1 sky130_fd_sc_hd__decap_8
X_06561_ _00901_ _00902_ _00934_ _00935_ vssd1 vssd1 vccd1 vccd1 _00936_ sky130_fd_sc_hd__nor4_1
X_08300_ _02548_ _02550_ _02549_ vssd1 vssd1 vccd1 vccd1 _02680_ sky130_fd_sc_hd__a21bo_1
X_09280_ net233 net430 _03747_ _03748_ vssd1 vssd1 vccd1 vccd1 _03751_ sky130_fd_sc_hd__nand4_1
X_05512_ _04779_ _04780_ _04691_ vssd1 vssd1 vccd1 vccd1 _04782_ sky130_fd_sc_hd__a21oi_1
X_06492_ _00736_ _00738_ vssd1 vssd1 vccd1 vccd1 _00867_ sky130_fd_sc_hd__nand2_1
X_08231_ net184 net537 net548 net179 vssd1 vssd1 vccd1 vccd1 _02604_ sky130_fd_sc_hd__a22o_1
XFILLER_0_51_63 vssd1 vssd1 vccd1 vccd1 sky130_fd_sc_hd__fill_1
XFILLER_0_51_41 vssd1 vssd1 vccd1 vccd1 sky130_fd_sc_hd__decap_8
X_05443_ _04711_ _04712_ _04154_ vssd1 vssd1 vccd1 vccd1 _04713_ sky130_fd_sc_hd__nor3b_1
XFILLER_0_43_611 vssd1 vssd1 vccd1 vccd1 sky130_fd_sc_hd__decap_4
XFILLER_0_82_290 vssd1 vssd1 vccd1 vccd1 sky130_fd_sc_hd__fill_1
X_08162_ _02530_ _02531_ _02518_ vssd1 vssd1 vccd1 vccd1 _02534_ sky130_fd_sc_hd__a21oi_1
XFILLER_0_15_335 vssd1 vssd1 vccd1 vccd1 sky130_fd_sc_hd__fill_1
XFILLER_0_27_173 vssd1 vssd1 vccd1 vccd1 sky130_fd_sc_hd__decap_8
X_05374_ _04642_ _04643_ vssd1 vssd1 vccd1 vccd1 _04644_ sky130_fd_sc_hd__and2_1
X_08093_ net183 net557 net584 net164 vssd1 vssd1 vccd1 vccd1 _02465_ sky130_fd_sc_hd__a22o_1
X_07113_ _01481_ _01482_ _01341_ _01343_ vssd1 vssd1 vccd1 vccd1 _01484_ sky130_fd_sc_hd__a211oi_2
XFILLER_0_30_305 vssd1 vssd1 vccd1 vccd1 sky130_fd_sc_hd__decap_3
X_07044_ _01405_ _01414_ vssd1 vssd1 vccd1 vccd1 _01415_ sky130_fd_sc_hd__xnor2_1
XFILLER_0_2_251 vssd1 vssd1 vccd1 vccd1 sky130_fd_sc_hd__fill_1
XFILLER_0_100_248 vssd1 vssd1 vccd1 vccd1 sky130_fd_sc_hd__decap_4
XFILLER_0_11_585 vssd1 vssd1 vccd1 vccd1 sky130_fd_sc_hd__fill_1
X_08995_ net248 net430 _03436_ _03437_ vssd1 vssd1 vccd1 vccd1 _03439_ sky130_fd_sc_hd__nand4_2
XFILLER_0_76_93 vssd1 vssd1 vccd1 vccd1 sky130_fd_sc_hd__fill_1
X_07946_ _02136_ _02149_ _02148_ vssd1 vssd1 vccd1 vccd1 _02319_ sky130_fd_sc_hd__a21oi_1
X_07877_ _02083_ _02085_ _02248_ _02249_ vssd1 vssd1 vccd1 vccd1 _02251_ sky130_fd_sc_hd__a211o_1
X_09616_ net117 _03984_ _03983_ vssd1 vssd1 vccd1 vccd1 _04118_ sky130_fd_sc_hd__o21ai_2
XFILLER_0_97_327 vssd1 vssd1 vccd1 vccd1 sky130_fd_sc_hd__decap_8
X_06828_ _01166_ _01167_ _01198_ _01199_ vssd1 vssd1 vccd1 vccd1 _01201_ sky130_fd_sc_hd__a22o_1
X_09547_ _03874_ _03878_ _03881_ _03884_ vssd1 vssd1 vccd1 vccd1 _04042_ sky130_fd_sc_hd__a31o_1
X_06759_ _01014_ _01130_ _01131_ vssd1 vssd1 vccd1 vccd1 _01132_ sky130_fd_sc_hd__and3_2
XFILLER_0_93_555 vssd1 vssd1 vccd1 vccd1 sky130_fd_sc_hd__decap_4
X_09478_ _03803_ _03806_ vssd1 vssd1 vccd1 vccd1 _03967_ sky130_fd_sc_hd__nor2_2
X_08429_ _02813_ _02818_ _02819_ vssd1 vssd1 vccd1 vccd1 _02821_ sky130_fd_sc_hd__nand3_2
XFILLER_0_18_162 vssd1 vssd1 vccd1 vccd1 sky130_fd_sc_hd__fill_2
Xfanout270 net271 vssd1 vssd1 vccd1 vccd1 net270 sky130_fd_sc_hd__clkbuf_4
Xfanout292 net293 vssd1 vssd1 vccd1 vccd1 net292 sky130_fd_sc_hd__clkbuf_4
Xfanout281 net283 vssd1 vssd1 vccd1 vccd1 net281 sky130_fd_sc_hd__buf_4
XFILLER_0_88_305 vssd1 vssd1 vccd1 vccd1 sky130_fd_sc_hd__decap_3
XFILLER_0_72_29 vssd1 vssd1 vccd1 vccd1 sky130_ef_sc_hd__decap_12
XFILLER_0_69_552 vssd1 vssd1 vccd1 vccd1 sky130_fd_sc_hd__decap_8
XTAP_1250 vssd1 vccd1 sky130_fd_sc_hd__tapvpwrvgnd_1
XTAP_1283 vssd1 vccd1 sky130_fd_sc_hd__tapvpwrvgnd_1
XTAP_1272 vssd1 vccd1 sky130_fd_sc_hd__tapvpwrvgnd_1
XTAP_1261 vssd1 vccd1 sky130_fd_sc_hd__tapvpwrvgnd_1
XFILLER_0_56_246 vssd1 vssd1 vccd1 vccd1 sky130_fd_sc_hd__decap_6
XTAP_1294 vssd1 vccd1 sky130_fd_sc_hd__tapvpwrvgnd_1
XFILLER_0_4_505 vssd1 vssd1 vccd1 vccd1 sky130_fd_sc_hd__decap_8
XFILLER_0_21_55 vssd1 vssd1 vccd1 vccd1 sky130_fd_sc_hd__fill_1
XFILLER_0_4_527 vssd1 vssd1 vccd1 vccd1 sky130_fd_sc_hd__decap_4
XFILLER_0_21_88 vssd1 vssd1 vccd1 vccd1 sky130_fd_sc_hd__decap_3
XFILLER_0_97_15 vssd1 vssd1 vccd1 vccd1 sky130_ef_sc_hd__decap_12
X_05090_ net16 net625 net124 vssd1 vssd1 vccd1 vccd1 _00068_ sky130_fd_sc_hd__mux2_1
X_08780_ net148 net588 _03052_ net138 net163 vssd1 vssd1 vccd1 vccd1 _03205_ sky130_fd_sc_hd__a32o_1
X_07800_ _02006_ _02009_ _02169_ _02170_ vssd1 vssd1 vccd1 vccd1 _02171_ sky130_fd_sc_hd__o211a_1
X_05992_ _00269_ _00272_ _00369_ _00371_ vssd1 vssd1 vccd1 vccd1 _00372_ sky130_fd_sc_hd__a211o_1
X_07731_ _01938_ _01940_ _02101_ _02102_ vssd1 vssd1 vccd1 vccd1 _02103_ sky130_fd_sc_hd__a211oi_4
XFILLER_0_46_85 vssd1 vssd1 vccd1 vccd1 sky130_fd_sc_hd__fill_2
X_07662_ _01862_ _01864_ _02032_ _02033_ vssd1 vssd1 vccd1 vccd1 _02034_ sky130_fd_sc_hd__a211oi_1
X_09401_ _03874_ _03882_ vssd1 vssd1 vccd1 vccd1 _03883_ sky130_fd_sc_hd__xnor2_1
X_07593_ _01964_ vssd1 vssd1 vccd1 vccd1 _01965_ sky130_fd_sc_hd__inv_2
X_06613_ net263 net552 net577 net235 vssd1 vssd1 vccd1 vccd1 _00987_ sky130_fd_sc_hd__a22o_1
X_09332_ _03770_ _03772_ _03806_ _03807_ vssd1 vssd1 vccd1 vccd1 _03808_ sky130_fd_sc_hd__or4_2
X_06544_ net279 net287 net532 net542 vssd1 vssd1 vccd1 vccd1 _00919_ sky130_fd_sc_hd__nand4_1
XFILLER_0_75_555 vssd1 vssd1 vccd1 vccd1 sky130_fd_sc_hd__decap_4
XFILLER_0_75_533 vssd1 vssd1 vccd1 vccd1 sky130_ef_sc_hd__decap_12
X_09263_ net172 net499 _03572_ _03573_ net516 vssd1 vssd1 vccd1 vccd1 _03732_ sky130_fd_sc_hd__a32o_1
XFILLER_0_7_310 vssd1 vssd1 vccd1 vccd1 sky130_fd_sc_hd__decap_4
X_06475_ _00847_ _00848_ vssd1 vssd1 vccd1 vccd1 _00850_ sky130_fd_sc_hd__xor2_1
XFILLER_0_28_460 vssd1 vssd1 vccd1 vccd1 sky130_ef_sc_hd__decap_12
X_09194_ _03452_ _03455_ _03655_ _03656_ vssd1 vssd1 vccd1 vccd1 _03657_ sky130_fd_sc_hd__o211a_2
X_08214_ _02323_ _02325_ _02585_ _02586_ vssd1 vssd1 vccd1 vccd1 _02587_ sky130_fd_sc_hd__o211ai_4
X_05426_ _04692_ _04693_ _04459_ vssd1 vssd1 vccd1 vccd1 _04696_ sky130_fd_sc_hd__a21oi_1
X_08145_ _02514_ _02515_ _02379_ _02391_ vssd1 vssd1 vccd1 vccd1 _02517_ sky130_fd_sc_hd__a211oi_2
X_05357_ _04588_ _04626_ vssd1 vssd1 vccd1 vccd1 _04627_ sky130_fd_sc_hd__nand2b_1
XFILLER_0_15_143 vssd1 vssd1 vccd1 vccd1 sky130_fd_sc_hd__fill_1
XFILLER_0_15_165 vssd1 vssd1 vccd1 vccd1 sky130_fd_sc_hd__decap_3
XFILLER_0_70_293 vssd1 vssd1 vccd1 vccd1 sky130_fd_sc_hd__fill_1
X_08076_ net610 _02447_ _02446_ vssd1 vssd1 vccd1 vccd1 _02448_ sky130_fd_sc_hd__a21bo_1
X_05288_ _03979_ _03990_ _04011_ vssd1 vssd1 vccd1 vccd1 _04558_ sky130_fd_sc_hd__a21o_1
XFILLER_0_11_360 vssd1 vssd1 vccd1 vccd1 sky130_fd_sc_hd__decap_8
X_07027_ _01364_ _01397_ vssd1 vssd1 vccd1 vccd1 _01398_ sky130_fd_sc_hd__or2_1
X_08978_ net192 net480 net489 net185 vssd1 vssd1 vccd1 vccd1 _03420_ sky130_fd_sc_hd__a22o_1
X_07929_ _02119_ _02301_ vssd1 vssd1 vccd1 vccd1 _02302_ sky130_fd_sc_hd__xnor2_2
XFILLER_0_97_146 vssd1 vssd1 vccd1 vccd1 sky130_fd_sc_hd__decap_6
XFILLER_0_78_393 vssd1 vssd1 vccd1 vccd1 sky130_fd_sc_hd__fill_1
XFILLER_0_38_224 vssd1 vssd1 vccd1 vccd1 sky130_fd_sc_hd__decap_3
XFILLER_0_38_246 vssd1 vssd1 vccd1 vccd1 sky130_fd_sc_hd__decap_3
XFILLER_0_93_385 vssd1 vssd1 vccd1 vccd1 sky130_fd_sc_hd__decap_4
XANTENNA_9 net326 vssd1 vssd1 vccd1 vccd1 sky130_fd_sc_hd__diode_2
XFILLER_0_21_102 vssd1 vssd1 vccd1 vccd1 sky130_fd_sc_hd__decap_3
XFILLER_0_34_496 vssd1 vssd1 vccd1 vccd1 sky130_fd_sc_hd__fill_1
XFILLER_0_1_519 vssd1 vssd1 vccd1 vccd1 sky130_fd_sc_hd__decap_3
XFILLER_0_21_124 vssd1 vssd1 vccd1 vccd1 sky130_fd_sc_hd__decap_3
XTAP_319 vssd1 vccd1 sky130_fd_sc_hd__tapvpwrvgnd_1
XTAP_308 vssd1 vccd1 sky130_fd_sc_hd__tapvpwrvgnd_1
X_10098_ clknet_3_5_0_wb_clk_i _00094_ _00030_ vssd1 vssd1 vccd1 vccd1 mul.b\[27\]
+ sky130_fd_sc_hd__dfrtp_2
XFILLER_0_16_11 vssd1 vssd1 vccd1 vccd1 sky130_fd_sc_hd__decap_3
XFILLER_0_88_168 vssd1 vssd1 vccd1 vccd1 sky130_fd_sc_hd__decap_6
XFILLER_0_69_393 vssd1 vssd1 vccd1 vccd1 sky130_fd_sc_hd__decap_6
XFILLER_0_84_352 vssd1 vssd1 vccd1 vccd1 sky130_fd_sc_hd__fill_1
XTAP_1091 vssd1 vccd1 sky130_fd_sc_hd__tapvpwrvgnd_1
XTAP_1080 vssd1 vccd1 sky130_fd_sc_hd__tapvpwrvgnd_1
XFILLER_0_57_577 vssd1 vssd1 vccd1 vccd1 sky130_fd_sc_hd__decap_8
XFILLER_0_29_257 vssd1 vssd1 vccd1 vccd1 sky130_fd_sc_hd__fill_1
XFILLER_0_29_279 vssd1 vssd1 vccd1 vccd1 sky130_fd_sc_hd__fill_1
XFILLER_0_72_547 vssd1 vssd1 vccd1 vccd1 sky130_ef_sc_hd__decap_12
X_06260_ _00621_ _00636_ vssd1 vssd1 vccd1 vccd1 _00637_ sky130_fd_sc_hd__or2_1
X_05211_ _03749_ _03848_ vssd1 vssd1 vccd1 vccd1 _03858_ sky130_fd_sc_hd__nor2_1
XFILLER_0_4_357 vssd1 vssd1 vccd1 vccd1 sky130_fd_sc_hd__fill_2
X_06191_ _00549_ _00566_ _00567_ vssd1 vssd1 vccd1 vccd1 _00569_ sky130_fd_sc_hd__nand3_2
X_05142_ _03061_ _03072_ _03083_ vssd1 vssd1 vccd1 vccd1 _03104_ sky130_fd_sc_hd__a21o_1
XFILLER_0_40_433 vssd1 vssd1 vccd1 vccd1 sky130_ef_sc_hd__decap_12
X_05073_ net14 net476 net126 vssd1 vssd1 vccd1 vccd1 _00085_ sky130_fd_sc_hd__mux2_1
X_09950_ net180 net441 vssd1 vssd1 vccd1 vccd1 _04483_ sky130_fd_sc_hd__nand2_1
XFILLER_0_40_455 vssd1 vssd1 vccd1 vccd1 sky130_fd_sc_hd__fill_2
X_08901_ _03327_ _03335_ vssd1 vssd1 vccd1 vccd1 _03337_ sky130_fd_sc_hd__xnor2_1
X_09881_ _04234_ _04237_ _04407_ vssd1 vssd1 vccd1 vccd1 _04408_ sky130_fd_sc_hd__o21a_1
XTAP_853 vssd1 vccd1 sky130_fd_sc_hd__tapvpwrvgnd_1
XTAP_842 vssd1 vccd1 sky130_fd_sc_hd__tapvpwrvgnd_1
XTAP_831 vssd1 vccd1 sky130_fd_sc_hd__tapvpwrvgnd_1
XTAP_820 vssd1 vccd1 sky130_fd_sc_hd__tapvpwrvgnd_1
X_08832_ _03252_ _03253_ _03259_ vssd1 vssd1 vccd1 vccd1 _03261_ sky130_fd_sc_hd__a21o_1
XTAP_886 vssd1 vccd1 sky130_fd_sc_hd__tapvpwrvgnd_1
XTAP_864 vssd1 vccd1 sky130_fd_sc_hd__tapvpwrvgnd_1
XTAP_875 vssd1 vccd1 sky130_fd_sc_hd__tapvpwrvgnd_1
X_08763_ _03019_ _03026_ _03025_ vssd1 vssd1 vccd1 vccd1 _03186_ sky130_fd_sc_hd__a21bo_1
XTAP_897 vssd1 vccd1 sky130_fd_sc_hd__tapvpwrvgnd_1
X_05975_ _00352_ _00353_ _00250_ _00253_ vssd1 vssd1 vccd1 vccd1 _00355_ sky130_fd_sc_hd__o211a_1
XFILLER_0_79_113 vssd1 vssd1 vccd1 vccd1 sky130_fd_sc_hd__decap_3
X_07714_ _02083_ _02084_ _02065_ vssd1 vssd1 vccd1 vccd1 _02086_ sky130_fd_sc_hd__a21o_1
XFILLER_0_25_3 vssd1 vssd1 vccd1 vccd1 sky130_fd_sc_hd__decap_6
X_08694_ _02945_ _02950_ _02944_ vssd1 vssd1 vccd1 vccd1 _03110_ sky130_fd_sc_hd__a21bo_1
X_07645_ net340 net432 _01872_ _01873_ net445 vssd1 vssd1 vccd1 vccd1 _02017_ sky130_fd_sc_hd__a32o_1
X_07576_ _01946_ _01947_ vssd1 vssd1 vccd1 vccd1 _01949_ sky130_fd_sc_hd__xnor2_4
X_09315_ net249 net417 net424 net241 vssd1 vssd1 vccd1 vccd1 _03789_ sky130_fd_sc_hd__a22oi_1
X_06527_ _00899_ _00900_ _00772_ _00774_ vssd1 vssd1 vccd1 vccd1 _00902_ sky130_fd_sc_hd__o211a_1
XFILLER_0_48_566 vssd1 vssd1 vccd1 vccd1 sky130_fd_sc_hd__decap_8
XFILLER_0_63_536 vssd1 vssd1 vccd1 vccd1 sky130_fd_sc_hd__decap_6
X_09246_ net697 net545 net146 vssd1 vssd1 vccd1 vccd1 _03713_ sky130_fd_sc_hd__o21ai_1
X_06458_ _00708_ _00710_ vssd1 vssd1 vccd1 vccd1 _00834_ sky130_fd_sc_hd__and2b_1
X_05409_ _04556_ _04557_ _04594_ vssd1 vssd1 vccd1 vccd1 _04679_ sky130_fd_sc_hd__o21a_1
XFILLER_0_16_452 vssd1 vssd1 vccd1 vccd1 sky130_fd_sc_hd__fill_1
X_09177_ _03636_ _03637_ vssd1 vssd1 vccd1 vccd1 _03638_ sky130_fd_sc_hd__nand2b_1
X_06389_ net387 net440 vssd1 vssd1 vccd1 vccd1 _00765_ sky130_fd_sc_hd__nand2_1
X_08128_ _02370_ _02375_ _02369_ vssd1 vssd1 vccd1 vccd1 _02500_ sky130_fd_sc_hd__a21bo_1
XFILLER_0_101_321 vssd1 vssd1 vccd1 vccd1 sky130_ef_sc_hd__decap_12
X_08059_ _02429_ _02430_ _02265_ _02267_ vssd1 vssd1 vccd1 vccd1 _02432_ sky130_fd_sc_hd__o211a_1
XFILLER_0_31_488 vssd1 vssd1 vccd1 vccd1 sky130_fd_sc_hd__decap_8
XFILLER_0_101_365 vssd1 vssd1 vccd1 vccd1 sky130_fd_sc_hd__decap_6
Xoutput57 net57 vssd1 vssd1 vccd1 vccd1 wbs_dat_o[25] sky130_fd_sc_hd__clkbuf_4
Xoutput46 net46 vssd1 vssd1 vccd1 vccd1 wbs_dat_o[15] sky130_fd_sc_hd__clkbuf_4
XFILLER_0_101_376 vssd1 vssd1 vccd1 vccd1 sky130_ef_sc_hd__decap_12
Xoutput68 net68 vssd1 vssd1 vccd1 vccd1 wbs_dat_o[6] sky130_fd_sc_hd__clkbuf_4
X_10021_ net640 vssd1 vssd1 vccd1 vccd1 _00017_ sky130_fd_sc_hd__inv_2
XFILLER_0_98_466 vssd1 vssd1 vccd1 vccd1 sky130_fd_sc_hd__decap_8
XFILLER_0_85_138 vssd1 vssd1 vccd1 vccd1 sky130_fd_sc_hd__decap_6
XPHY_152 vssd1 vssd1 vccd1 vccd1 sky130_fd_sc_hd__decap_3
XPHY_141 vssd1 vssd1 vccd1 vccd1 sky130_fd_sc_hd__decap_3
XFILLER_0_66_363 vssd1 vssd1 vccd1 vccd1 sky130_fd_sc_hd__fill_1
XPHY_130 vssd1 vssd1 vccd1 vccd1 sky130_fd_sc_hd__decap_3
XPHY_185 vssd1 vssd1 vccd1 vccd1 sky130_fd_sc_hd__decap_3
XPHY_174 vssd1 vssd1 vccd1 vccd1 sky130_fd_sc_hd__decap_3
XPHY_163 vssd1 vssd1 vccd1 vccd1 sky130_fd_sc_hd__decap_3
XFILLER_0_54_525 vssd1 vssd1 vccd1 vccd1 sky130_fd_sc_hd__decap_6
XPHY_196 vssd1 vssd1 vccd1 vccd1 sky130_fd_sc_hd__decap_3
XFILLER_0_1_305 vssd1 vssd1 vccd1 vccd1 sky130_fd_sc_hd__fill_1
XFILLER_0_1_316 vssd1 vssd1 vccd1 vccd1 sky130_fd_sc_hd__fill_1
XFILLER_0_22_477 vssd1 vssd1 vccd1 vccd1 sky130_fd_sc_hd__decap_3
XFILLER_0_27_21 vssd1 vssd1 vccd1 vccd1 sky130_fd_sc_hd__fill_1
X_05760_ net347 net531 net543 net337 vssd1 vssd1 vccd1 vccd1 _00142_ sky130_fd_sc_hd__a22o_1
XFILLER_0_27_65 vssd1 vssd1 vccd1 vccd1 sky130_ef_sc_hd__decap_12
X_05691_ _04931_ _04932_ _04960_ vssd1 vssd1 vccd1 vccd1 _04961_ sky130_fd_sc_hd__nor3_1
XFILLER_0_9_405 vssd1 vssd1 vccd1 vccd1 sky130_ef_sc_hd__decap_12
XFILLER_0_43_42 vssd1 vssd1 vccd1 vccd1 sky130_fd_sc_hd__decap_3
X_07430_ _01796_ _01797_ vssd1 vssd1 vccd1 vccd1 _01798_ sky130_fd_sc_hd__xor2_1
X_07361_ _01720_ _01728_ vssd1 vssd1 vccd1 vccd1 _01730_ sky130_fd_sc_hd__xor2_1
X_09100_ _03554_ _02929_ vssd1 vssd1 vccd1 vccd1 _03555_ sky130_fd_sc_hd__nand2b_1
XFILLER_0_57_396 vssd1 vssd1 vccd1 vccd1 sky130_fd_sc_hd__decap_4
XFILLER_0_17_216 vssd1 vssd1 vccd1 vccd1 sky130_fd_sc_hd__decap_8
X_06312_ _00685_ _00686_ _00668_ vssd1 vssd1 vccd1 vccd1 _00689_ sky130_fd_sc_hd__a21oi_2
X_09031_ net268 net416 net424 net257 vssd1 vssd1 vccd1 vccd1 _03479_ sky130_fd_sc_hd__a22oi_1
XFILLER_0_84_193 vssd1 vssd1 vccd1 vccd1 sky130_fd_sc_hd__decap_3
X_07292_ _01659_ _01660_ vssd1 vssd1 vccd1 vccd1 _01661_ sky130_fd_sc_hd__nor2_1
XFILLER_0_45_558 vssd1 vssd1 vccd1 vccd1 sky130_fd_sc_hd__fill_2
XFILLER_0_60_517 vssd1 vssd1 vccd1 vccd1 sky130_ef_sc_hd__decap_12
X_06243_ _00511_ _00619_ vssd1 vssd1 vccd1 vccd1 _00620_ sky130_fd_sc_hd__and2_1
XFILLER_0_32_208 vssd1 vssd1 vccd1 vccd1 sky130_fd_sc_hd__decap_8
X_06174_ net336 net503 net511 net328 vssd1 vssd1 vccd1 vccd1 _00552_ sky130_fd_sc_hd__a22o_1
X_05125_ _02864_ _02897_ _02908_ vssd1 vssd1 vccd1 vccd1 _02919_ sky130_fd_sc_hd__nand3_1
XFILLER_0_40_263 vssd1 vssd1 vccd1 vccd1 sky130_fd_sc_hd__decap_6
XFILLER_0_68_72 vssd1 vssd1 vccd1 vccd1 sky130_ef_sc_hd__decap_12
X_09933_ _04460_ _04463_ vssd1 vssd1 vccd1 vccd1 _04464_ sky130_fd_sc_hd__xnor2_1
X_05056_ net5 net391 net132 vssd1 vssd1 vccd1 vccd1 _00099_ sky130_fd_sc_hd__mux2_1
X_09864_ _04249_ _04251_ _04387_ vssd1 vssd1 vccd1 vccd1 _04389_ sky130_fd_sc_hd__and3_1
XFILLER_0_0_393 vssd1 vssd1 vccd1 vccd1 sky130_fd_sc_hd__decap_6
XTAP_661 vssd1 vccd1 sky130_fd_sc_hd__tapvpwrvgnd_1
XTAP_650 vssd1 vccd1 sky130_fd_sc_hd__tapvpwrvgnd_1
X_08815_ _03240_ _03241_ vssd1 vssd1 vccd1 vccd1 _03243_ sky130_fd_sc_hd__or2_1
XTAP_672 vssd1 vccd1 sky130_fd_sc_hd__tapvpwrvgnd_1
XTAP_683 vssd1 vccd1 sky130_fd_sc_hd__tapvpwrvgnd_1
XTAP_694 vssd1 vccd1 sky130_fd_sc_hd__tapvpwrvgnd_1
X_09795_ _04168_ _04312_ vssd1 vssd1 vccd1 vccd1 _04313_ sky130_fd_sc_hd__xor2_1
X_08746_ net303 net314 net401 net408 vssd1 vssd1 vccd1 vccd1 _03167_ sky130_fd_sc_hd__and4_1
X_05958_ _00334_ _00337_ vssd1 vssd1 vccd1 vccd1 _00338_ sky130_fd_sc_hd__xnor2_1
X_08677_ net453 net144 net130 net213 vssd1 vssd1 vccd1 vccd1 _03092_ sky130_fd_sc_hd__a22o_1
X_05889_ net88 _00268_ _00163_ _00165_ vssd1 vssd1 vccd1 vccd1 _00270_ sky130_fd_sc_hd__o211ai_2
X_07628_ net383 net398 vssd1 vssd1 vccd1 vccd1 _02000_ sky130_fd_sc_hd__nand2_1
XFILLER_0_75_182 vssd1 vssd1 vccd1 vccd1 sky130_fd_sc_hd__fill_1
X_07559_ _01771_ net657 _01930_ _01931_ vssd1 vssd1 vccd1 vccd1 _01932_ sky130_fd_sc_hd__a211o_1
XFILLER_0_36_514 vssd1 vssd1 vccd1 vccd1 sky130_fd_sc_hd__decap_8
XFILLER_0_48_396 vssd1 vssd1 vccd1 vccd1 sky130_fd_sc_hd__decap_8
X_09229_ _03502_ _03534_ _03693_ vssd1 vssd1 vccd1 vccd1 _03696_ sky130_fd_sc_hd__nor3_2
XFILLER_0_51_517 vssd1 vssd1 vccd1 vccd1 sky130_fd_sc_hd__decap_6
XFILLER_0_16_260 vssd1 vssd1 vccd1 vccd1 sky130_fd_sc_hd__fill_2
XFILLER_0_23_208 vssd1 vssd1 vccd1 vccd1 sky130_fd_sc_hd__decap_8
X_10004_ net394 net145 net131 net150 vssd1 vssd1 vccd1 vccd1 _04542_ sky130_fd_sc_hd__a22o_1
XFILLER_0_98_241 vssd1 vssd1 vccd1 vccd1 sky130_fd_sc_hd__fill_1
XFILLER_0_86_436 vssd1 vssd1 vccd1 vccd1 sky130_fd_sc_hd__fill_2
XFILLER_0_86_425 vssd1 vssd1 vccd1 vccd1 sky130_fd_sc_hd__fill_1
XFILLER_0_80_29 vssd1 vssd1 vccd1 vccd1 sky130_fd_sc_hd__fill_2
XFILLER_0_13_23 vssd1 vssd1 vccd1 vccd1 sky130_fd_sc_hd__fill_1
XFILLER_0_39_330 vssd1 vssd1 vccd1 vccd1 sky130_fd_sc_hd__decap_6
XFILLER_0_6_408 vssd1 vssd1 vccd1 vccd1 sky130_fd_sc_hd__fill_1
XFILLER_0_27_536 vssd1 vssd1 vccd1 vccd1 sky130_fd_sc_hd__fill_1
XFILLER_0_39_385 vssd1 vssd1 vccd1 vccd1 sky130_fd_sc_hd__fill_1
XFILLER_0_42_517 vssd1 vssd1 vccd1 vccd1 sky130_ef_sc_hd__decap_12
XFILLER_0_22_263 vssd1 vssd1 vccd1 vccd1 sky130_fd_sc_hd__decap_6
X_06930_ _01170_ _01172_ vssd1 vssd1 vccd1 vccd1 _01302_ sky130_fd_sc_hd__nand2_1
XFILLER_0_38_64 vssd1 vssd1 vccd1 vccd1 sky130_ef_sc_hd__decap_12
X_08600_ net323 net401 net408 net314 vssd1 vssd1 vccd1 vccd1 _03008_ sky130_fd_sc_hd__a22o_1
X_06861_ _01231_ _01232_ vssd1 vssd1 vccd1 vccd1 _01233_ sky130_fd_sc_hd__and2b_1
X_09580_ net267 net395 _04075_ _04078_ vssd1 vssd1 vccd1 vccd1 _04079_ sky130_fd_sc_hd__a22o_1
X_05812_ _04978_ _04980_ vssd1 vssd1 vccd1 vccd1 _00193_ sky130_fd_sc_hd__nand2_1
X_06792_ _01162_ _01163_ _01149_ vssd1 vssd1 vccd1 vccd1 _01165_ sky130_fd_sc_hd__a21o_1
X_08531_ _02926_ _02931_ _00182_ vssd1 vssd1 vccd1 vccd1 _02933_ sky130_fd_sc_hd__a21o_1
XFILLER_0_54_52 vssd1 vssd1 vccd1 vccd1 sky130_fd_sc_hd__decap_4
X_05743_ _04927_ _04929_ _05011_ _05012_ vssd1 vssd1 vccd1 vccd1 _05013_ sky130_fd_sc_hd__a211oi_2
X_08462_ _02851_ _02855_ _02856_ vssd1 vssd1 vccd1 vccd1 _02857_ sky130_fd_sc_hd__nand3_1
XFILLER_0_77_436 vssd1 vssd1 vccd1 vccd1 sky130_fd_sc_hd__fill_1
X_05674_ _04941_ _04942_ _04937_ vssd1 vssd1 vccd1 vccd1 _04944_ sky130_fd_sc_hd__a21o_1
X_07413_ _01538_ _01540_ _01780_ _01781_ vssd1 vssd1 vccd1 vccd1 _01782_ sky130_fd_sc_hd__a211oi_4
XFILLER_0_49_149 vssd1 vssd1 vccd1 vccd1 sky130_fd_sc_hd__fill_2
X_08393_ net194 net202 net508 vssd1 vssd1 vccd1 vccd1 _02781_ sky130_fd_sc_hd__and3_1
XFILLER_0_9_268 vssd1 vssd1 vccd1 vccd1 sky130_fd_sc_hd__fill_1
XFILLER_0_70_95 vssd1 vssd1 vccd1 vccd1 sky130_fd_sc_hd__decap_4
XFILLER_0_18_547 vssd1 vssd1 vccd1 vccd1 sky130_ef_sc_hd__decap_12
X_07344_ _01562_ _01564_ _01711_ _01712_ vssd1 vssd1 vccd1 vccd1 _01713_ sky130_fd_sc_hd__a211oi_2
XFILLER_0_92_3 vssd1 vssd1 vccd1 vccd1 sky130_fd_sc_hd__fill_1
XFILLER_0_72_152 vssd1 vssd1 vccd1 vccd1 sky130_fd_sc_hd__decap_4
XFILLER_0_72_141 vssd1 vssd1 vccd1 vccd1 sky130_fd_sc_hd__decap_3
X_07275_ _01487_ _01489_ _01643_ _01644_ vssd1 vssd1 vccd1 vccd1 _01645_ sky130_fd_sc_hd__o211ai_2
X_09014_ _03434_ _03435_ _03456_ _03457_ vssd1 vssd1 vccd1 vccd1 _03460_ sky130_fd_sc_hd__a22oi_2
XFILLER_0_72_185 vssd1 vssd1 vccd1 vccd1 sky130_fd_sc_hd__decap_8
XFILLER_0_60_336 vssd1 vssd1 vccd1 vccd1 sky130_fd_sc_hd__fill_1
X_06226_ net139 _00601_ _00602_ _00603_ vssd1 vssd1 vccd1 vccd1 net66 sky130_fd_sc_hd__a31o_1
XFILLER_0_79_93 vssd1 vssd1 vccd1 vccd1 sky130_ef_sc_hd__decap_12
XFILLER_0_13_274 vssd1 vssd1 vccd1 vccd1 sky130_fd_sc_hd__fill_2
X_06157_ _00533_ _00534_ vssd1 vssd1 vccd1 vccd1 _00535_ sky130_fd_sc_hd__nor2_1
X_05108_ _02700_ _02711_ _02722_ vssd1 vssd1 vccd1 vccd1 _02733_ sky130_fd_sc_hd__nand3_1
X_06088_ _00417_ _00418_ _00464_ _00465_ vssd1 vssd1 vccd1 vccd1 _00467_ sky130_fd_sc_hd__o22a_1
X_09916_ mul.b\[30\] net145 net131 net155 _04445_ vssd1 vssd1 vccd1 vccd1 net63 sky130_fd_sc_hd__a221o_1
X_05039_ net13 net247 net134 vssd1 vssd1 vccd1 vccd1 _00116_ sky130_fd_sc_hd__mux2_1
Xfanout633 net634 vssd1 vssd1 vccd1 vccd1 net633 sky130_fd_sc_hd__clkbuf_4
Xfanout622 net623 vssd1 vssd1 vccd1 vccd1 net622 sky130_fd_sc_hd__buf_2
Xfanout611 net612 vssd1 vssd1 vccd1 vccd1 net611 sky130_fd_sc_hd__clkbuf_2
Xfanout600 net601 vssd1 vssd1 vccd1 vccd1 net600 sky130_fd_sc_hd__buf_2
Xfanout644 net645 vssd1 vssd1 vccd1 vccd1 net644 sky130_fd_sc_hd__buf_4
X_09847_ _04229_ _04233_ vssd1 vssd1 vccd1 vccd1 _04370_ sky130_fd_sc_hd__nand2_1
XTAP_480 vssd1 vccd1 sky130_fd_sc_hd__tapvpwrvgnd_1
XTAP_491 vssd1 vccd1 sky130_fd_sc_hd__tapvpwrvgnd_1
X_09778_ _04293_ _04294_ vssd1 vssd1 vccd1 vccd1 _04295_ sky130_fd_sc_hd__and2b_1
X_08729_ _02965_ _02967_ _03146_ vssd1 vssd1 vccd1 vccd1 _03149_ sky130_fd_sc_hd__nor3_2
XFILLER_0_68_403 vssd1 vssd1 vccd1 vccd1 sky130_fd_sc_hd__decap_6
XFILLER_0_91_461 vssd1 vssd1 vccd1 vccd1 sky130_fd_sc_hd__fill_2
XFILLER_0_63_163 vssd1 vssd1 vccd1 vccd1 sky130_fd_sc_hd__fill_1
XFILLER_0_36_399 vssd1 vssd1 vccd1 vccd1 sky130_fd_sc_hd__fill_1
XFILLER_0_51_369 vssd1 vssd1 vccd1 vccd1 sky130_fd_sc_hd__fill_2
XFILLER_0_32_561 vssd1 vssd1 vccd1 vccd1 sky130_fd_sc_hd__fill_1
XFILLER_0_99_550 vssd1 vssd1 vccd1 vccd1 sky130_fd_sc_hd__fill_1
XFILLER_0_6_205 vssd1 vssd1 vccd1 vccd1 sky130_ef_sc_hd__decap_12
X_05390_ _04657_ _04659_ _04655_ vssd1 vssd1 vccd1 vccd1 _04660_ sky130_fd_sc_hd__o21ai_1
XFILLER_0_54_141 vssd1 vssd1 vccd1 vccd1 sky130_fd_sc_hd__decap_8
X_07060_ _01428_ _01429_ _01289_ _01291_ vssd1 vssd1 vccd1 vccd1 _01431_ sky130_fd_sc_hd__o211ai_2
X_06011_ _00388_ _00389_ vssd1 vssd1 vccd1 vccd1 _00390_ sky130_fd_sc_hd__nand2_1
XFILLER_0_23_561 vssd1 vssd1 vccd1 vccd1 sky130_fd_sc_hd__decap_8
XFILLER_0_10_222 vssd1 vssd1 vccd1 vccd1 sky130_fd_sc_hd__fill_2
X_07962_ net679 net398 vssd1 vssd1 vccd1 vccd1 _02335_ sky130_fd_sc_hd__and2_1
X_09701_ _04200_ _04210_ vssd1 vssd1 vccd1 vccd1 _04211_ sky130_fd_sc_hd__xor2_1
XFILLER_0_65_51 vssd1 vssd1 vccd1 vccd1 sky130_fd_sc_hd__decap_4
X_07893_ _01995_ _01997_ _02265_ _02266_ vssd1 vssd1 vccd1 vccd1 _02267_ sky130_fd_sc_hd__o211ai_4
XFILLER_0_4_76 vssd1 vssd1 vccd1 vccd1 sky130_fd_sc_hd__fill_1
X_06913_ net357 net365 net434 net440 vssd1 vssd1 vccd1 vccd1 _01285_ sky130_fd_sc_hd__nand4_4
XFILLER_0_97_509 vssd1 vssd1 vccd1 vccd1 sky130_fd_sc_hd__fill_1
X_09632_ _03956_ _03960_ _04134_ vssd1 vssd1 vccd1 vccd1 _04136_ sky130_fd_sc_hd__or3_1
X_06844_ _01214_ _01215_ _00981_ _00984_ vssd1 vssd1 vccd1 vccd1 _01217_ sky130_fd_sc_hd__o211a_1
X_09563_ _04048_ _04058_ vssd1 vssd1 vccd1 vccd1 _04060_ sky130_fd_sc_hd__nand2_1
XFILLER_0_77_211 vssd1 vssd1 vccd1 vccd1 sky130_fd_sc_hd__decap_3
X_08514_ _02712_ _02748_ _02747_ vssd1 vssd1 vccd1 vccd1 _02914_ sky130_fd_sc_hd__a21oi_1
X_06775_ _01029_ _01031_ vssd1 vssd1 vccd1 vccd1 _01148_ sky130_fd_sc_hd__nand2b_1
X_09494_ net117 _03984_ vssd1 vssd1 vccd1 vccd1 _03985_ sky130_fd_sc_hd__xor2_4
X_05726_ net273 net616 _04992_ _04994_ vssd1 vssd1 vccd1 vccd1 _04996_ sky130_fd_sc_hd__and4_1
X_08445_ net160 net574 vssd1 vssd1 vccd1 vccd1 _02838_ sky130_fd_sc_hd__nand2_1
XFILLER_0_81_94 vssd1 vssd1 vccd1 vccd1 sky130_fd_sc_hd__decap_4
X_05657_ _04871_ _04926_ vssd1 vssd1 vccd1 vccd1 _04927_ sky130_fd_sc_hd__nand2_1
X_08376_ _02760_ _02761_ _02590_ _02593_ vssd1 vssd1 vccd1 vccd1 _02763_ sky130_fd_sc_hd__o211ai_1
X_05588_ _04855_ _04856_ vssd1 vssd1 vccd1 vccd1 _04858_ sky130_fd_sc_hd__xor2_1
XFILLER_0_18_344 vssd1 vssd1 vccd1 vccd1 sky130_fd_sc_hd__decap_3
XFILLER_0_92_269 vssd1 vssd1 vccd1 vccd1 sky130_fd_sc_hd__fill_1
X_07327_ _01691_ _01692_ _01693_ _01694_ vssd1 vssd1 vccd1 vccd1 _01696_ sky130_fd_sc_hd__o22ai_4
XFILLER_0_73_483 vssd1 vssd1 vccd1 vccd1 sky130_fd_sc_hd__decap_3
XFILLER_0_45_196 vssd1 vssd1 vccd1 vccd1 sky130_fd_sc_hd__decap_3
XFILLER_0_33_347 vssd1 vssd1 vccd1 vccd1 sky130_fd_sc_hd__decap_6
XFILLER_0_33_369 vssd1 vssd1 vccd1 vccd1 sky130_fd_sc_hd__decap_8
X_07258_ _01568_ _01569_ _01626_ _01627_ vssd1 vssd1 vccd1 vccd1 _01628_ sky130_fd_sc_hd__and4bb_1
XFILLER_0_60_188 vssd1 vssd1 vccd1 vccd1 sky130_fd_sc_hd__decap_8
XFILLER_0_60_166 vssd1 vssd1 vccd1 vccd1 sky130_fd_sc_hd__decap_4
X_06209_ _00417_ _00585_ _00586_ vssd1 vssd1 vccd1 vccd1 _00587_ sky130_fd_sc_hd__and3_1
X_07189_ _01549_ _01557_ vssd1 vssd1 vccd1 vccd1 _01559_ sky130_fd_sc_hd__xnor2_1
Xfanout430 net431 vssd1 vssd1 vccd1 vccd1 net430 sky130_fd_sc_hd__buf_4
Xfanout441 net444 vssd1 vssd1 vccd1 vccd1 net441 sky130_fd_sc_hd__buf_4
Xfanout474 net475 vssd1 vssd1 vccd1 vccd1 net474 sky130_fd_sc_hd__clkbuf_2
Xfanout452 net453 vssd1 vssd1 vccd1 vccd1 net452 sky130_fd_sc_hd__clkbuf_4
Xfanout463 mul.b\[19\] vssd1 vssd1 vccd1 vccd1 net463 sky130_fd_sc_hd__clkbuf_4
Xfanout485 mul.b\[17\] vssd1 vssd1 vccd1 vccd1 net485 sky130_fd_sc_hd__buf_6
Xfanout496 net502 vssd1 vssd1 vccd1 vccd1 net496 sky130_fd_sc_hd__clkbuf_4
XFILLER_0_96_542 vssd1 vssd1 vccd1 vccd1 sky130_fd_sc_hd__fill_1
XFILLER_0_83_225 vssd1 vssd1 vccd1 vccd1 sky130_fd_sc_hd__decap_4
XFILLER_0_28_119 vssd1 vssd1 vccd1 vccd1 sky130_fd_sc_hd__fill_1
XFILLER_0_83_236 vssd1 vssd1 vccd1 vccd1 sky130_fd_sc_hd__decap_4
XFILLER_0_49_480 vssd1 vssd1 vccd1 vccd1 sky130_fd_sc_hd__fill_2
XFILLER_0_36_141 vssd1 vssd1 vccd1 vccd1 sky130_fd_sc_hd__decap_4
XFILLER_0_101_15 vssd1 vssd1 vccd1 vccd1 sky130_ef_sc_hd__decap_12
XFILLER_0_36_174 vssd1 vssd1 vccd1 vccd1 sky130_fd_sc_hd__decap_8
XFILLER_0_51_133 vssd1 vssd1 vccd1 vccd1 sky130_fd_sc_hd__fill_1
XFILLER_0_10_35 vssd1 vssd1 vccd1 vccd1 sky130_fd_sc_hd__fill_2
XFILLER_0_10_57 vssd1 vssd1 vccd1 vccd1 sky130_fd_sc_hd__fill_1
XFILLER_0_20_531 vssd1 vssd1 vccd1 vccd1 sky130_fd_sc_hd__fill_1
XFILLER_0_20_542 vssd1 vssd1 vccd1 vccd1 sky130_fd_sc_hd__fill_1
XFILLER_0_79_509 vssd1 vssd1 vccd1 vccd1 sky130_fd_sc_hd__fill_1
XFILLER_0_99_380 vssd1 vssd1 vccd1 vccd1 sky130_ef_sc_hd__decap_12
XFILLER_0_35_65 vssd1 vssd1 vccd1 vccd1 sky130_fd_sc_hd__decap_3
X_06560_ _00931_ _00933_ _00807_ _00810_ vssd1 vssd1 vccd1 vccd1 _00935_ sky130_fd_sc_hd__o211a_1
XFILLER_0_35_87 vssd1 vssd1 vccd1 vccd1 sky130_fd_sc_hd__decap_8
XFILLER_0_74_214 vssd1 vssd1 vccd1 vccd1 sky130_fd_sc_hd__decap_6
X_05511_ _04691_ _04779_ _04780_ vssd1 vssd1 vccd1 vccd1 _04781_ sky130_fd_sc_hd__and3_1
X_06491_ _00864_ _00865_ vssd1 vssd1 vccd1 vccd1 _00866_ sky130_fd_sc_hd__nand2_1
XFILLER_0_47_417 vssd1 vssd1 vccd1 vccd1 sky130_fd_sc_hd__decap_4
X_08230_ net140 _02601_ _02602_ _02603_ vssd1 vssd1 vccd1 vccd1 net49 sky130_fd_sc_hd__a31o_1
X_05442_ _04708_ _04709_ _04710_ vssd1 vssd1 vccd1 vccd1 _04712_ sky130_fd_sc_hd__a21oi_1
XFILLER_0_74_269 vssd1 vssd1 vccd1 vccd1 sky130_fd_sc_hd__fill_1
X_08161_ _02532_ vssd1 vssd1 vccd1 vccd1 _02533_ sky130_fd_sc_hd__inv_2
XFILLER_0_70_431 vssd1 vssd1 vccd1 vccd1 sky130_fd_sc_hd__fill_2
X_05373_ net363 net624 net632 net355 vssd1 vssd1 vccd1 vccd1 _04643_ sky130_fd_sc_hd__a22o_1
XFILLER_0_43_623 vssd1 vssd1 vccd1 vccd1 sky130_fd_sc_hd__fill_2
X_08092_ net176 net574 _02330_ _02329_ vssd1 vssd1 vccd1 vccd1 _02464_ sky130_fd_sc_hd__a31o_1
X_07112_ _01341_ _01343_ _01481_ _01482_ vssd1 vssd1 vccd1 vccd1 _01483_ sky130_fd_sc_hd__o211a_2
XFILLER_0_30_317 vssd1 vssd1 vccd1 vccd1 sky130_ef_sc_hd__decap_12
X_07043_ _01412_ _01413_ vssd1 vssd1 vccd1 vccd1 _01414_ sky130_fd_sc_hd__xnor2_1
XFILLER_0_11_520 vssd1 vssd1 vccd1 vccd1 sky130_fd_sc_hd__fill_2
X_08994_ net248 net430 _03436_ _03437_ vssd1 vssd1 vccd1 vccd1 _03438_ sky130_fd_sc_hd__a22o_1
XFILLER_0_55_3 vssd1 vssd1 vccd1 vccd1 sky130_fd_sc_hd__decap_6
X_07945_ _02303_ _02317_ vssd1 vssd1 vccd1 vccd1 _02318_ sky130_fd_sc_hd__xnor2_1
X_09615_ _04114_ _04115_ vssd1 vssd1 vccd1 vccd1 _04117_ sky130_fd_sc_hd__xor2_1
X_07876_ _02083_ _02085_ _02248_ _02249_ vssd1 vssd1 vccd1 vccd1 _02250_ sky130_fd_sc_hd__a211oi_2
XFILLER_0_92_71 vssd1 vssd1 vccd1 vccd1 sky130_ef_sc_hd__decap_12
X_06827_ _01166_ _01167_ _01198_ _01199_ vssd1 vssd1 vccd1 vccd1 _01200_ sky130_fd_sc_hd__nand4_2
XFILLER_0_78_564 vssd1 vssd1 vccd1 vccd1 sky130_fd_sc_hd__fill_1
X_09546_ _03898_ _03908_ _03907_ vssd1 vssd1 vccd1 vccd1 _04041_ sky130_fd_sc_hd__o21ba_1
X_06758_ _01115_ _01129_ vssd1 vssd1 vccd1 vccd1 _01131_ sky130_fd_sc_hd__nand2_1
X_09477_ net117 _03825_ _03824_ vssd1 vssd1 vccd1 vccd1 _03966_ sky130_fd_sc_hd__o21ba_2
XFILLER_0_93_501 vssd1 vssd1 vccd1 vccd1 sky130_fd_sc_hd__decap_3
X_05709_ net297 net589 _04977_ _04978_ vssd1 vssd1 vccd1 vccd1 _04979_ sky130_fd_sc_hd__a22o_1
X_08428_ _02816_ _02817_ _02649_ _02651_ vssd1 vssd1 vccd1 vccd1 _02819_ sky130_fd_sc_hd__a211o_1
XFILLER_0_65_225 vssd1 vssd1 vccd1 vccd1 sky130_fd_sc_hd__decap_4
X_06689_ _00917_ _00925_ _00924_ vssd1 vssd1 vccd1 vccd1 _01063_ sky130_fd_sc_hd__a21bo_1
Xwire105 _03619_ vssd1 vssd1 vccd1 vccd1 net105 sky130_fd_sc_hd__clkbuf_2
XFILLER_0_46_450 vssd1 vssd1 vccd1 vccd1 sky130_fd_sc_hd__fill_1
X_08359_ _02741_ _02742_ vssd1 vssd1 vccd1 vccd1 _02745_ sky130_fd_sc_hd__xor2_2
XFILLER_0_33_111 vssd1 vssd1 vccd1 vccd1 sky130_fd_sc_hd__fill_1
XFILLER_0_33_155 vssd1 vssd1 vccd1 vccd1 sky130_ef_sc_hd__decap_12
XFILLER_0_21_317 vssd1 vssd1 vccd1 vccd1 sky130_fd_sc_hd__fill_1
XFILLER_0_33_177 vssd1 vssd1 vccd1 vccd1 sky130_fd_sc_hd__decap_8
Xfanout260 net261 vssd1 vssd1 vccd1 vccd1 net260 sky130_fd_sc_hd__buf_2
Xfanout282 net283 vssd1 vssd1 vccd1 vccd1 net282 sky130_fd_sc_hd__buf_4
Xfanout271 mul.a\[14\] vssd1 vssd1 vccd1 vccd1 net271 sky130_fd_sc_hd__buf_4
Xfanout293 mul.a\[11\] vssd1 vssd1 vccd1 vccd1 net293 sky130_fd_sc_hd__clkbuf_2
XFILLER_0_96_372 vssd1 vssd1 vccd1 vccd1 sky130_ef_sc_hd__decap_12
XTAP_1240 vssd1 vccd1 sky130_fd_sc_hd__tapvpwrvgnd_1
XTAP_1284 vssd1 vccd1 sky130_fd_sc_hd__tapvpwrvgnd_1
XTAP_1273 vssd1 vccd1 sky130_fd_sc_hd__tapvpwrvgnd_1
XTAP_1262 vssd1 vccd1 sky130_fd_sc_hd__tapvpwrvgnd_1
XTAP_1251 vssd1 vccd1 sky130_fd_sc_hd__tapvpwrvgnd_1
XFILLER_0_29_439 vssd1 vssd1 vccd1 vccd1 sky130_fd_sc_hd__fill_2
XTAP_1295 vssd1 vccd1 sky130_fd_sc_hd__tapvpwrvgnd_1
XFILLER_0_25_623 vssd1 vssd1 vccd1 vccd1 sky130_fd_sc_hd__fill_2
XFILLER_0_97_27 vssd1 vssd1 vccd1 vccd1 sky130_fd_sc_hd__decap_6
XFILLER_0_12_317 vssd1 vssd1 vccd1 vccd1 sky130_fd_sc_hd__fill_1
X_07730_ _02099_ _02100_ _01833_ _01835_ vssd1 vssd1 vccd1 vccd1 _02102_ sky130_fd_sc_hd__o211a_4
X_05991_ _00367_ _00368_ _00222_ vssd1 vssd1 vccd1 vccd1 _00371_ sky130_fd_sc_hd__a21oi_1
X_07661_ _02030_ _02031_ _01887_ _01889_ vssd1 vssd1 vccd1 vccd1 _02033_ sky130_fd_sc_hd__a211oi_1
XFILLER_0_94_309 vssd1 vssd1 vccd1 vccd1 sky130_ef_sc_hd__decap_12
X_09400_ _03878_ _03881_ vssd1 vssd1 vccd1 vccd1 _03882_ sky130_fd_sc_hd__nand2_1
X_07592_ net154 net159 net618 net628 vssd1 vssd1 vccd1 vccd1 _01964_ sky130_fd_sc_hd__and4_1
X_06612_ net235 net262 net552 net577 vssd1 vssd1 vccd1 vccd1 _00986_ sky130_fd_sc_hd__nand4_2
X_09331_ _03803_ _03805_ _03653_ _03655_ vssd1 vssd1 vccd1 vccd1 _03807_ sky130_fd_sc_hd__o211a_1
X_06543_ net292 net523 vssd1 vssd1 vccd1 vccd1 _00918_ sky130_fd_sc_hd__and2_1
XFILLER_0_47_203 vssd1 vssd1 vccd1 vccd1 sky130_fd_sc_hd__fill_1
XFILLER_0_75_545 vssd1 vssd1 vccd1 vccd1 sky130_fd_sc_hd__decap_4
XFILLER_0_62_74 vssd1 vssd1 vccd1 vccd1 sky130_fd_sc_hd__decap_8
XFILLER_0_47_225 vssd1 vssd1 vccd1 vccd1 sky130_fd_sc_hd__decap_8
X_09262_ net178 net185 net480 net489 _03589_ vssd1 vssd1 vccd1 vccd1 _03731_ sky130_fd_sc_hd__a41o_1
X_06474_ _00847_ _00848_ vssd1 vssd1 vccd1 vccd1 _00849_ sky130_fd_sc_hd__and2b_1
X_09193_ _03652_ _03654_ _03639_ vssd1 vssd1 vccd1 vccd1 _03656_ sky130_fd_sc_hd__o21ai_1
X_08213_ _02583_ _02584_ _02422_ _02424_ vssd1 vssd1 vccd1 vccd1 _02586_ sky130_fd_sc_hd__a211o_4
X_05425_ _04694_ vssd1 vssd1 vccd1 vccd1 _04695_ sky130_fd_sc_hd__inv_2
XFILLER_0_15_111 vssd1 vssd1 vccd1 vccd1 sky130_fd_sc_hd__fill_1
XFILLER_0_28_472 vssd1 vssd1 vccd1 vccd1 sky130_fd_sc_hd__decap_4
XFILLER_0_28_483 vssd1 vssd1 vccd1 vccd1 sky130_fd_sc_hd__fill_1
X_08144_ _02379_ _02391_ _02514_ _02515_ vssd1 vssd1 vccd1 vccd1 _02516_ sky130_fd_sc_hd__o211a_1
X_05356_ _04022_ _04558_ _04587_ vssd1 vssd1 vccd1 vccd1 _04626_ sky130_fd_sc_hd__a21o_1
XFILLER_0_43_431 vssd1 vssd1 vccd1 vccd1 sky130_ef_sc_hd__decap_12
XFILLER_0_70_261 vssd1 vssd1 vccd1 vccd1 sky130_fd_sc_hd__fill_2
XFILLER_0_101_503 vssd1 vssd1 vccd1 vccd1 sky130_fd_sc_hd__fill_1
X_08075_ net149 net154 net601 vssd1 vssd1 vccd1 vccd1 _02447_ sky130_fd_sc_hd__and3_1
X_05287_ _04553_ _04554_ _02973_ vssd1 vssd1 vccd1 vccd1 _04557_ sky130_fd_sc_hd__a21boi_1
X_07026_ _01381_ _01396_ vssd1 vssd1 vccd1 vccd1 _01397_ sky130_fd_sc_hd__xnor2_1
XFILLER_0_87_71 vssd1 vssd1 vccd1 vccd1 sky130_fd_sc_hd__fill_2
X_08977_ net186 net501 _03254_ _03255_ net517 vssd1 vssd1 vccd1 vccd1 _03419_ sky130_fd_sc_hd__a32o_1
X_07928_ _02298_ _02299_ vssd1 vssd1 vccd1 vccd1 _02301_ sky130_fd_sc_hd__xor2_2
XFILLER_0_97_125 vssd1 vssd1 vccd1 vccd1 sky130_fd_sc_hd__decap_8
X_07859_ _02225_ _02226_ _02231_ vssd1 vssd1 vccd1 vccd1 _02233_ sky130_fd_sc_hd__nand3_1
X_09529_ _03859_ _03862_ vssd1 vssd1 vccd1 vccd1 _04023_ sky130_fd_sc_hd__or2_1
XFILLER_0_38_203 vssd1 vssd1 vccd1 vccd1 sky130_fd_sc_hd__fill_2
XFILLER_0_53_217 vssd1 vssd1 vccd1 vccd1 sky130_fd_sc_hd__decap_6
XFILLER_0_34_442 vssd1 vssd1 vccd1 vccd1 sky130_ef_sc_hd__decap_12
XFILLER_0_21_136 vssd1 vssd1 vccd1 vccd1 sky130_fd_sc_hd__fill_1
XTAP_309 vssd1 vccd1 sky130_fd_sc_hd__tapvpwrvgnd_1
XFILLER_0_100_580 vssd1 vssd1 vccd1 vccd1 sky130_fd_sc_hd__fill_2
X_10097_ clknet_3_4_0_wb_clk_i _00093_ _00029_ vssd1 vssd1 vccd1 vccd1 mul.b\[26\]
+ sky130_fd_sc_hd__dfrtp_4
XFILLER_0_83_29 vssd1 vssd1 vccd1 vccd1 sky130_fd_sc_hd__decap_4
XFILLER_0_16_56 vssd1 vssd1 vccd1 vccd1 sky130_fd_sc_hd__fill_1
XFILLER_0_69_350 vssd1 vssd1 vccd1 vccd1 sky130_fd_sc_hd__fill_1
XFILLER_0_57_534 vssd1 vssd1 vccd1 vccd1 sky130_fd_sc_hd__decap_3
XTAP_1092 vssd1 vccd1 sky130_fd_sc_hd__tapvpwrvgnd_1
XTAP_1081 vssd1 vccd1 sky130_fd_sc_hd__tapvpwrvgnd_1
XTAP_1070 vssd1 vccd1 sky130_fd_sc_hd__tapvpwrvgnd_1
XFILLER_0_72_537 vssd1 vssd1 vccd1 vccd1 sky130_fd_sc_hd__fill_1
XFILLER_0_72_559 vssd1 vssd1 vccd1 vccd1 sky130_fd_sc_hd__decap_6
XFILLER_0_4_314 vssd1 vssd1 vccd1 vccd1 sky130_fd_sc_hd__fill_1
X_06190_ _00549_ _00566_ _00567_ vssd1 vssd1 vccd1 vccd1 _00568_ sky130_fd_sc_hd__and3_1
X_05210_ net336 net623 net631 net328 vssd1 vssd1 vccd1 vccd1 _03848_ sky130_fd_sc_hd__a22oi_1
XFILLER_0_80_570 vssd1 vssd1 vccd1 vccd1 sky130_fd_sc_hd__decap_3
XFILLER_0_52_250 vssd1 vssd1 vccd1 vccd1 sky130_fd_sc_hd__fill_2
X_05141_ _03061_ _03072_ _03083_ vssd1 vssd1 vccd1 vccd1 _03093_ sky130_fd_sc_hd__nand3_1
XFILLER_0_13_615 vssd1 vssd1 vccd1 vccd1 sky130_fd_sc_hd__fill_1
XFILLER_0_40_445 vssd1 vssd1 vccd1 vccd1 sky130_fd_sc_hd__decap_4
X_05072_ net15 net467 net126 vssd1 vssd1 vccd1 vccd1 _00086_ sky130_fd_sc_hd__mux2_1
XFILLER_0_0_531 vssd1 vssd1 vccd1 vccd1 sky130_fd_sc_hd__fill_1
X_09880_ _04403_ _04406_ vssd1 vssd1 vccd1 vccd1 _04407_ sky130_fd_sc_hd__xor2_2
X_08900_ _03327_ _03335_ vssd1 vssd1 vccd1 vccd1 _03336_ sky130_fd_sc_hd__nand2_1
XTAP_810 vssd1 vccd1 sky130_fd_sc_hd__tapvpwrvgnd_1
X_08831_ _03252_ _03253_ _03259_ vssd1 vssd1 vccd1 vccd1 _03260_ sky130_fd_sc_hd__nand3_1
XTAP_843 vssd1 vccd1 sky130_fd_sc_hd__tapvpwrvgnd_1
XTAP_832 vssd1 vccd1 sky130_fd_sc_hd__tapvpwrvgnd_1
XTAP_821 vssd1 vccd1 sky130_fd_sc_hd__tapvpwrvgnd_1
XTAP_865 vssd1 vccd1 sky130_fd_sc_hd__tapvpwrvgnd_1
XTAP_876 vssd1 vccd1 sky130_fd_sc_hd__tapvpwrvgnd_1
XTAP_854 vssd1 vccd1 sky130_fd_sc_hd__tapvpwrvgnd_1
X_08762_ _03182_ _03183_ _03175_ vssd1 vssd1 vccd1 vccd1 _03185_ sky130_fd_sc_hd__a21o_1
XTAP_898 vssd1 vccd1 sky130_fd_sc_hd__tapvpwrvgnd_1
XTAP_887 vssd1 vccd1 sky130_fd_sc_hd__tapvpwrvgnd_1
X_05974_ _00250_ _00253_ _00352_ _00353_ vssd1 vssd1 vccd1 vccd1 _00354_ sky130_fd_sc_hd__a211oi_4
XFILLER_0_73_40 vssd1 vssd1 vccd1 vccd1 sky130_ef_sc_hd__decap_12
X_08693_ _03100_ _03101_ _03107_ vssd1 vssd1 vccd1 vccd1 _03109_ sky130_fd_sc_hd__a21o_1
X_07713_ _02065_ _02083_ _02084_ vssd1 vssd1 vccd1 vccd1 _02085_ sky130_fd_sc_hd__nand3_4
XFILLER_0_79_147 vssd1 vssd1 vccd1 vccd1 sky130_fd_sc_hd__fill_2
X_07644_ _01854_ _01856_ vssd1 vssd1 vccd1 vccd1 _02016_ sky130_fd_sc_hd__nand2_1
XFILLER_0_75_331 vssd1 vssd1 vccd1 vccd1 sky130_fd_sc_hd__decap_4
X_07575_ _01946_ _01947_ vssd1 vssd1 vccd1 vccd1 _01948_ sky130_fd_sc_hd__or2_1
X_09314_ _03643_ _03645_ vssd1 vssd1 vccd1 vccd1 _03788_ sky130_fd_sc_hd__or2_1
X_06526_ _00772_ _00774_ _00899_ _00900_ vssd1 vssd1 vccd1 vccd1 _00901_ sky130_fd_sc_hd__a211oi_4
X_09245_ _03564_ _03566_ _03565_ vssd1 vssd1 vccd1 vccd1 _03712_ sky130_fd_sc_hd__a21boi_1
X_06457_ _00831_ _00832_ vssd1 vssd1 vccd1 vccd1 _00833_ sky130_fd_sc_hd__nand2_1
XFILLER_0_63_559 vssd1 vssd1 vccd1 vccd1 sky130_fd_sc_hd__fill_1
X_05408_ _04596_ _04633_ _04634_ _04677_ vssd1 vssd1 vccd1 vccd1 _04678_ sky130_fd_sc_hd__a211o_1
X_09176_ _03634_ _03635_ _03468_ _03471_ vssd1 vssd1 vccd1 vccd1 _03637_ sky130_fd_sc_hd__a211o_1
XFILLER_0_7_196 vssd1 vssd1 vccd1 vccd1 sky130_fd_sc_hd__decap_3
X_06388_ _00659_ _00667_ _00665_ vssd1 vssd1 vccd1 vccd1 _00764_ sky130_fd_sc_hd__a21oi_2
XFILLER_0_43_250 vssd1 vssd1 vccd1 vccd1 sky130_fd_sc_hd__decap_8
X_08127_ _02491_ _02492_ _02497_ vssd1 vssd1 vccd1 vccd1 _02499_ sky130_fd_sc_hd__a21o_1
X_05339_ _04598_ _04608_ vssd1 vssd1 vccd1 vccd1 _04609_ sky130_fd_sc_hd__nor2_1
XFILLER_0_98_81 vssd1 vssd1 vccd1 vccd1 sky130_fd_sc_hd__decap_3
X_08058_ _02265_ _02267_ _02429_ _02430_ vssd1 vssd1 vccd1 vccd1 _02431_ sky130_fd_sc_hd__a211oi_4
XFILLER_0_101_333 vssd1 vssd1 vccd1 vccd1 sky130_fd_sc_hd__decap_3
Xoutput58 net58 vssd1 vssd1 vccd1 vccd1 wbs_dat_o[26] sky130_fd_sc_hd__clkbuf_4
Xoutput47 net47 vssd1 vssd1 vccd1 vccd1 wbs_dat_o[16] sky130_fd_sc_hd__clkbuf_4
X_07009_ _01378_ _01379_ vssd1 vssd1 vccd1 vccd1 _01380_ sky130_fd_sc_hd__and2b_1
XFILLER_0_101_388 vssd1 vssd1 vccd1 vccd1 sky130_fd_sc_hd__decap_4
Xoutput69 net69 vssd1 vssd1 vccd1 vccd1 wbs_dat_o[7] sky130_fd_sc_hd__clkbuf_4
X_10020_ net640 vssd1 vssd1 vccd1 vccd1 _00016_ sky130_fd_sc_hd__inv_2
XFILLER_0_98_434 vssd1 vssd1 vccd1 vccd1 sky130_fd_sc_hd__decap_3
XFILLER_0_58_309 vssd1 vssd1 vccd1 vccd1 sky130_fd_sc_hd__fill_2
XPHY_142 vssd1 vssd1 vccd1 vccd1 sky130_fd_sc_hd__decap_3
XPHY_131 vssd1 vssd1 vccd1 vccd1 sky130_fd_sc_hd__decap_3
XPHY_120 vssd1 vssd1 vccd1 vccd1 sky130_fd_sc_hd__decap_3
XPHY_175 vssd1 vssd1 vccd1 vccd1 sky130_fd_sc_hd__decap_3
XPHY_164 vssd1 vssd1 vccd1 vccd1 sky130_fd_sc_hd__decap_3
XFILLER_0_81_301 vssd1 vssd1 vccd1 vccd1 sky130_fd_sc_hd__decap_8
XPHY_153 vssd1 vssd1 vccd1 vccd1 sky130_fd_sc_hd__decap_3
XFILLER_0_26_206 vssd1 vssd1 vccd1 vccd1 sky130_fd_sc_hd__decap_4
XPHY_197 vssd1 vssd1 vccd1 vccd1 sky130_fd_sc_hd__decap_3
XPHY_186 vssd1 vssd1 vccd1 vccd1 sky130_fd_sc_hd__decap_3
XFILLER_0_78_29 vssd1 vssd1 vccd1 vccd1 sky130_fd_sc_hd__decap_8
XFILLER_0_34_272 vssd1 vssd1 vccd1 vccd1 sky130_fd_sc_hd__fill_1
XFILLER_0_27_11 vssd1 vssd1 vccd1 vccd1 sky130_fd_sc_hd__fill_1
XFILLER_0_89_401 vssd1 vssd1 vccd1 vccd1 sky130_ef_sc_hd__decap_12
XFILLER_0_27_55 vssd1 vssd1 vccd1 vccd1 sky130_fd_sc_hd__fill_1
XFILLER_0_27_77 vssd1 vssd1 vccd1 vccd1 sky130_fd_sc_hd__decap_6
X_05690_ _04839_ _04959_ vssd1 vssd1 vccd1 vccd1 _04960_ sky130_fd_sc_hd__xnor2_1
XFILLER_0_57_320 vssd1 vssd1 vccd1 vccd1 sky130_fd_sc_hd__fill_2
XPHY_0 vssd1 vssd1 vccd1 vccd1 sky130_fd_sc_hd__decap_3
XFILLER_0_91_109 vssd1 vssd1 vccd1 vccd1 sky130_fd_sc_hd__decap_3
X_07360_ _01720_ _01728_ vssd1 vssd1 vccd1 vccd1 _01729_ sky130_fd_sc_hd__or2_1
X_06311_ _00668_ _00685_ _00686_ vssd1 vssd1 vccd1 vccd1 _00688_ sky130_fd_sc_hd__nand3_2
X_09030_ _03329_ _03331_ vssd1 vssd1 vccd1 vccd1 _03478_ sky130_fd_sc_hd__or2_1
X_07291_ net159 net165 net628 net636 vssd1 vssd1 vccd1 vccd1 _01660_ sky130_fd_sc_hd__and4_1
XFILLER_0_72_378 vssd1 vssd1 vccd1 vccd1 sky130_ef_sc_hd__decap_12
XFILLER_0_60_529 vssd1 vssd1 vccd1 vccd1 sky130_fd_sc_hd__decap_3
XFILLER_0_13_401 vssd1 vssd1 vccd1 vccd1 sky130_ef_sc_hd__decap_12
X_06242_ _00617_ _00618_ vssd1 vssd1 vccd1 vccd1 _00619_ sky130_fd_sc_hd__nor2_1
XFILLER_0_53_581 vssd1 vssd1 vccd1 vccd1 sky130_fd_sc_hd__fill_1
X_06173_ net328 net336 net503 net511 vssd1 vssd1 vccd1 vccd1 _00551_ sky130_fd_sc_hd__and4_1
X_05124_ _02733_ _02798_ _02853_ vssd1 vssd1 vccd1 vccd1 _02908_ sky130_fd_sc_hd__a21o_1
X_09932_ _04461_ _04462_ vssd1 vssd1 vccd1 vccd1 _04463_ sky130_fd_sc_hd__xnor2_1
X_05055_ net16 net383 net132 vssd1 vssd1 vccd1 vccd1 _00100_ sky130_fd_sc_hd__mux2_1
X_09863_ _04249_ _04251_ _04387_ vssd1 vssd1 vccd1 vccd1 _04388_ sky130_fd_sc_hd__a21oi_1
XTAP_640 vssd1 vccd1 sky130_fd_sc_hd__tapvpwrvgnd_1
XTAP_651 vssd1 vccd1 sky130_fd_sc_hd__tapvpwrvgnd_1
X_08814_ _02924_ _02932_ _03087_ _03088_ _03240_ vssd1 vssd1 vccd1 vccd1 _03242_ sky130_fd_sc_hd__o311ai_2
XTAP_662 vssd1 vccd1 sky130_fd_sc_hd__tapvpwrvgnd_1
XTAP_673 vssd1 vccd1 sky130_fd_sc_hd__tapvpwrvgnd_1
XTAP_684 vssd1 vccd1 sky130_fd_sc_hd__tapvpwrvgnd_1
XTAP_695 vssd1 vccd1 sky130_fd_sc_hd__tapvpwrvgnd_1
X_09794_ net146 net497 vssd1 vssd1 vccd1 vccd1 _04312_ sky130_fd_sc_hd__nand2_1
X_08745_ net314 net401 net408 net304 vssd1 vssd1 vccd1 vccd1 _03166_ sky130_fd_sc_hd__a22oi_1
XFILLER_0_84_83 vssd1 vssd1 vccd1 vccd1 sky130_fd_sc_hd__fill_1
X_05957_ _00335_ _00336_ vssd1 vssd1 vccd1 vccd1 _00337_ sky130_fd_sc_hd__nor2_1
X_08676_ _02935_ _03089_ vssd1 vssd1 vccd1 vccd1 _03091_ sky130_fd_sc_hd__nand2_1
X_05888_ _00163_ _00165_ net88 _00268_ vssd1 vssd1 vccd1 vccd1 _00269_ sky130_fd_sc_hd__a211o_1
XFILLER_0_95_426 vssd1 vssd1 vccd1 vccd1 sky130_fd_sc_hd__fill_2
X_07627_ net195 net565 vssd1 vssd1 vccd1 vccd1 _01999_ sky130_fd_sc_hd__nand2_1
X_07558_ _01868_ _01869_ net648 _01929_ vssd1 vssd1 vccd1 vccd1 _01931_ sky130_fd_sc_hd__o22a_1
X_06509_ _00776_ _00778_ _00883_ vssd1 vssd1 vccd1 vccd1 _00884_ sky130_fd_sc_hd__o21ai_2
XFILLER_0_36_537 vssd1 vssd1 vccd1 vccd1 sky130_ef_sc_hd__decap_12
XFILLER_0_63_323 vssd1 vssd1 vccd1 vccd1 sky130_fd_sc_hd__decap_3
X_07489_ _01851_ _01859_ vssd1 vssd1 vccd1 vccd1 _01860_ sky130_fd_sc_hd__xnor2_1
X_09228_ _03502_ _03534_ _03693_ vssd1 vssd1 vccd1 vccd1 _03694_ sky130_fd_sc_hd__o21a_1
XFILLER_0_63_389 vssd1 vssd1 vccd1 vccd1 sky130_fd_sc_hd__decap_3
X_09159_ _03426_ _03428_ _03616_ vssd1 vssd1 vccd1 vccd1 _03619_ sky130_fd_sc_hd__nor3_1
XFILLER_0_101_152 vssd1 vssd1 vccd1 vccd1 sky130_fd_sc_hd__decap_6
X_10003_ _04439_ _04443_ _04539_ vssd1 vssd1 vccd1 vccd1 _04541_ sky130_fd_sc_hd__or3_4
XFILLER_0_98_253 vssd1 vssd1 vccd1 vccd1 sky130_ef_sc_hd__decap_12
XFILLER_0_86_448 vssd1 vssd1 vccd1 vccd1 sky130_fd_sc_hd__fill_1
XFILLER_0_82_610 vssd1 vssd1 vccd1 vccd1 sky130_fd_sc_hd__fill_2
XFILLER_0_66_150 vssd1 vssd1 vccd1 vccd1 sky130_fd_sc_hd__decap_8
XFILLER_0_13_57 vssd1 vssd1 vccd1 vccd1 sky130_ef_sc_hd__decap_12
XFILLER_0_39_364 vssd1 vssd1 vccd1 vccd1 sky130_fd_sc_hd__decap_4
XFILLER_0_39_375 vssd1 vssd1 vccd1 vccd1 sky130_fd_sc_hd__fill_1
XFILLER_0_54_345 vssd1 vssd1 vccd1 vccd1 sky130_fd_sc_hd__decap_3
XFILLER_0_89_39 vssd1 vssd1 vccd1 vccd1 sky130_fd_sc_hd__fill_1
XFILLER_0_42_529 vssd1 vssd1 vccd1 vccd1 sky130_fd_sc_hd__decap_3
XFILLER_0_22_253 vssd1 vssd1 vccd1 vccd1 sky130_fd_sc_hd__decap_6
XFILLER_0_10_448 vssd1 vssd1 vccd1 vccd1 sky130_fd_sc_hd__decap_6
XFILLER_0_22_297 vssd1 vssd1 vccd1 vccd1 sky130_fd_sc_hd__decap_8
XFILLER_0_38_32 vssd1 vssd1 vccd1 vccd1 sky130_fd_sc_hd__decap_4
X_06860_ net197 net620 _01100_ _01099_ vssd1 vssd1 vccd1 vccd1 _01232_ sky130_fd_sc_hd__a31o_1
XFILLER_0_38_76 vssd1 vssd1 vccd1 vccd1 sky130_fd_sc_hd__fill_1
X_05811_ _00190_ _00191_ vssd1 vssd1 vccd1 vccd1 _00192_ sky130_fd_sc_hd__nand2_1
X_06791_ _01149_ _01162_ _01163_ vssd1 vssd1 vccd1 vccd1 _01164_ sky130_fd_sc_hd__nand3_2
X_08530_ _02926_ _02931_ vssd1 vssd1 vccd1 vccd1 _02932_ sky130_fd_sc_hd__nor2_1
X_05742_ _04991_ _05010_ vssd1 vssd1 vccd1 vccd1 _05012_ sky130_fd_sc_hd__and2_1
X_08461_ net317 net415 _02852_ _02854_ vssd1 vssd1 vccd1 vccd1 _02856_ sky130_fd_sc_hd__nand4_2
XFILLER_0_89_275 vssd1 vssd1 vccd1 vccd1 sky130_fd_sc_hd__decap_4
X_05673_ _04937_ _04941_ _04942_ vssd1 vssd1 vccd1 vccd1 _04943_ sky130_fd_sc_hd__nand3_1
XFILLER_0_77_459 vssd1 vssd1 vccd1 vccd1 sky130_fd_sc_hd__decap_8
X_07412_ _01778_ _01779_ _01631_ _01633_ vssd1 vssd1 vccd1 vccd1 _01781_ sky130_fd_sc_hd__a211oi_2
X_08392_ net202 net508 net518 net194 vssd1 vssd1 vccd1 vccd1 _02780_ sky130_fd_sc_hd__a22o_1
XFILLER_0_70_85 vssd1 vssd1 vccd1 vccd1 sky130_fd_sc_hd__fill_1
X_07343_ _01709_ _01710_ _01585_ _01587_ vssd1 vssd1 vccd1 vccd1 _01712_ sky130_fd_sc_hd__a211oi_1
XFILLER_0_18_559 vssd1 vssd1 vccd1 vccd1 sky130_fd_sc_hd__fill_2
X_07274_ _01640_ _01642_ _01501_ vssd1 vssd1 vccd1 vccd1 _01644_ sky130_fd_sc_hd__o21ai_2
XFILLER_0_85_3 vssd1 vssd1 vccd1 vccd1 sky130_fd_sc_hd__decap_4
X_09013_ _03434_ _03435_ _03456_ _03457_ vssd1 vssd1 vccd1 vccd1 _03459_ sky130_fd_sc_hd__nand4_2
XFILLER_0_60_315 vssd1 vssd1 vccd1 vccd1 sky130_fd_sc_hd__fill_1
X_06225_ net599 net142 net128 net360 vssd1 vssd1 vccd1 vccd1 _00603_ sky130_fd_sc_hd__a22o_1
XFILLER_0_5_497 vssd1 vssd1 vccd1 vccd1 sky130_fd_sc_hd__decap_6
XFILLER_0_79_83 vssd1 vssd1 vccd1 vccd1 sky130_fd_sc_hd__decap_4
X_06156_ net379 net387 net456 net463 vssd1 vssd1 vccd1 vccd1 _00534_ sky130_fd_sc_hd__and4_1
X_05107_ net344 net594 net604 net335 vssd1 vssd1 vccd1 vccd1 _02722_ sky130_fd_sc_hd__a22o_1
X_06087_ _00417_ _00418_ _00464_ _00465_ vssd1 vssd1 vccd1 vccd1 _00466_ sky130_fd_sc_hd__nor4_1
X_09915_ _04443_ _04444_ net141 vssd1 vssd1 vccd1 vccd1 _04445_ sky130_fd_sc_hd__and3b_1
X_05038_ net14 net237 net134 vssd1 vssd1 vccd1 vccd1 _00117_ sky130_fd_sc_hd__mux2_1
Xfanout623 net624 vssd1 vssd1 vccd1 vccd1 net623 sky130_fd_sc_hd__buf_2
Xfanout612 net613 vssd1 vssd1 vccd1 vccd1 net612 sky130_fd_sc_hd__clkbuf_2
Xfanout601 net602 vssd1 vssd1 vccd1 vccd1 net601 sky130_fd_sc_hd__dlymetal6s2s_1
X_09846_ _04367_ _04368_ vssd1 vssd1 vccd1 vccd1 _04369_ sky130_fd_sc_hd__xor2_1
Xfanout634 mul.b\[0\] vssd1 vssd1 vccd1 vccd1 net634 sky130_fd_sc_hd__buf_2
Xfanout645 net1 vssd1 vssd1 vccd1 vccd1 net645 sky130_fd_sc_hd__clkbuf_4
XTAP_470 vssd1 vccd1 sky130_fd_sc_hd__tapvpwrvgnd_1
XTAP_481 vssd1 vccd1 sky130_fd_sc_hd__tapvpwrvgnd_1
XTAP_492 vssd1 vccd1 sky130_fd_sc_hd__tapvpwrvgnd_1
X_09777_ _04118_ _04137_ _04135_ vssd1 vssd1 vccd1 vccd1 _04294_ sky130_fd_sc_hd__a21bo_1
X_06989_ _01357_ _01359_ vssd1 vssd1 vccd1 vccd1 _01361_ sky130_fd_sc_hd__nand2_1
X_08728_ _02965_ _02967_ _03146_ vssd1 vssd1 vccd1 vccd1 _03147_ sky130_fd_sc_hd__o21a_2
XFILLER_0_95_223 vssd1 vssd1 vccd1 vccd1 sky130_fd_sc_hd__fill_1
XFILLER_0_95_212 vssd1 vssd1 vccd1 vccd1 sky130_fd_sc_hd__fill_1
X_08659_ _03043_ _03044_ _03070_ vssd1 vssd1 vccd1 vccd1 _03073_ sky130_fd_sc_hd__or3_1
XFILLER_0_64_610 vssd1 vssd1 vccd1 vccd1 sky130_fd_sc_hd__fill_1
XFILLER_0_76_492 vssd1 vssd1 vccd1 vccd1 sky130_fd_sc_hd__fill_1
XFILLER_0_63_131 vssd1 vssd1 vccd1 vccd1 sky130_fd_sc_hd__decap_8
XFILLER_0_48_183 vssd1 vssd1 vccd1 vccd1 sky130_fd_sc_hd__decap_6
XFILLER_0_63_175 vssd1 vssd1 vccd1 vccd1 sky130_fd_sc_hd__fill_1
XFILLER_0_86_234 vssd1 vssd1 vccd1 vccd1 sky130_fd_sc_hd__fill_1
XFILLER_0_24_34 vssd1 vssd1 vccd1 vccd1 sky130_ef_sc_hd__decap_12
XFILLER_0_6_217 vssd1 vssd1 vccd1 vccd1 sky130_fd_sc_hd__decap_4
XFILLER_0_27_323 vssd1 vssd1 vccd1 vccd1 sky130_ef_sc_hd__decap_12
XFILLER_0_27_367 vssd1 vssd1 vccd1 vccd1 sky130_fd_sc_hd__fill_1
XFILLER_0_54_197 vssd1 vssd1 vccd1 vccd1 sky130_ef_sc_hd__decap_12
XFILLER_0_54_186 vssd1 vssd1 vccd1 vccd1 sky130_fd_sc_hd__fill_1
X_06010_ _00386_ _00387_ _00324_ vssd1 vssd1 vccd1 vccd1 _00389_ sky130_fd_sc_hd__a21o_1
XFILLER_0_71_9 vssd1 vssd1 vccd1 vccd1 sky130_fd_sc_hd__fill_1
X_07961_ net351 net360 net403 net409 vssd1 vssd1 vccd1 vccd1 _02334_ sky130_fd_sc_hd__nand4_2
X_09700_ _04207_ _04209_ vssd1 vssd1 vccd1 vccd1 _04210_ sky130_fd_sc_hd__nand2_1
X_06912_ net365 net434 net440 net357 vssd1 vssd1 vccd1 vccd1 _01284_ sky130_fd_sc_hd__a22o_1
X_07892_ _02263_ _02264_ net651 _02097_ vssd1 vssd1 vccd1 vccd1 _02266_ sky130_fd_sc_hd__o211ai_4
XFILLER_0_4_66 vssd1 vssd1 vccd1 vccd1 sky130_fd_sc_hd__fill_2
X_09631_ _03956_ _03960_ _04134_ vssd1 vssd1 vccd1 vccd1 _04135_ sky130_fd_sc_hd__o21ai_1
X_06843_ _00981_ _00984_ _01214_ _01215_ vssd1 vssd1 vccd1 vccd1 _01216_ sky130_fd_sc_hd__a211oi_2
X_06774_ _01011_ _01146_ vssd1 vssd1 vccd1 vccd1 _01147_ sky130_fd_sc_hd__xnor2_1
X_09562_ _04048_ _04058_ vssd1 vssd1 vccd1 vccd1 _04059_ sky130_fd_sc_hd__or2_1
X_08513_ _02910_ _02911_ _02709_ _02750_ vssd1 vssd1 vccd1 vccd1 _02913_ sky130_fd_sc_hd__a211oi_2
X_05725_ net273 net616 _04992_ _04994_ vssd1 vssd1 vccd1 vccd1 _04995_ sky130_fd_sc_hd__a22oi_1
X_09493_ _03981_ _03982_ vssd1 vssd1 vccd1 vccd1 _03984_ sky130_fd_sc_hd__xor2_4
XFILLER_0_77_234 vssd1 vssd1 vccd1 vccd1 sky130_fd_sc_hd__fill_2
X_08444_ _02834_ _02835_ vssd1 vssd1 vccd1 vccd1 _02837_ sky130_fd_sc_hd__xnor2_2
XFILLER_0_77_289 vssd1 vssd1 vccd1 vccd1 sky130_fd_sc_hd__fill_2
X_05656_ _04924_ _04925_ vssd1 vssd1 vccd1 vccd1 _04926_ sky130_fd_sc_hd__and2_1
XFILLER_0_92_226 vssd1 vssd1 vccd1 vccd1 sky130_fd_sc_hd__decap_3
X_08375_ _02590_ _02593_ _02760_ _02761_ vssd1 vssd1 vccd1 vccd1 _02762_ sky130_fd_sc_hd__a211oi_2
XFILLER_0_58_492 vssd1 vssd1 vccd1 vccd1 sky130_fd_sc_hd__decap_6
X_05587_ _04855_ _04856_ vssd1 vssd1 vccd1 vccd1 _04857_ sky130_fd_sc_hd__nor2_1
XFILLER_0_45_120 vssd1 vssd1 vccd1 vccd1 sky130_fd_sc_hd__decap_6
XFILLER_0_73_462 vssd1 vssd1 vccd1 vccd1 sky130_fd_sc_hd__fill_1
X_07326_ _01691_ _01692_ _01693_ _01694_ vssd1 vssd1 vccd1 vccd1 _01695_ sky130_fd_sc_hd__or4_4
XFILLER_0_33_337 vssd1 vssd1 vccd1 vccd1 sky130_fd_sc_hd__decap_6
XFILLER_0_60_156 vssd1 vssd1 vccd1 vccd1 sky130_fd_sc_hd__decap_3
X_07257_ net100 _01624_ _01470_ net721 vssd1 vssd1 vccd1 vccd1 _01627_ sky130_fd_sc_hd__o211ai_2
X_07188_ _01549_ _01557_ vssd1 vssd1 vccd1 vccd1 _01558_ sky130_fd_sc_hd__nand2b_1
XFILLER_0_5_294 vssd1 vssd1 vccd1 vccd1 sky130_fd_sc_hd__fill_2
XFILLER_0_14_584 vssd1 vssd1 vccd1 vccd1 sky130_fd_sc_hd__fill_1
X_06208_ _00583_ _00584_ _00464_ net712 vssd1 vssd1 vccd1 vccd1 _00586_ sky130_fd_sc_hd__a211o_1
X_06139_ _00404_ _00409_ _00515_ vssd1 vssd1 vccd1 vccd1 _00517_ sky130_fd_sc_hd__or3_1
Xfanout420 mul.b\[26\] vssd1 vssd1 vccd1 vccd1 net420 sky130_fd_sc_hd__buf_4
Xfanout431 mul.b\[24\] vssd1 vssd1 vccd1 vccd1 net431 sky130_fd_sc_hd__clkbuf_4
Xfanout442 net444 vssd1 vssd1 vccd1 vccd1 net442 sky130_fd_sc_hd__buf_4
Xfanout453 mul.b\[21\] vssd1 vssd1 vccd1 vccd1 net453 sky130_fd_sc_hd__clkbuf_4
Xfanout475 net476 vssd1 vssd1 vccd1 vccd1 net475 sky130_fd_sc_hd__buf_2
Xfanout464 net465 vssd1 vssd1 vccd1 vccd1 net464 sky130_fd_sc_hd__buf_4
X_09829_ _04348_ _04349_ vssd1 vssd1 vccd1 vccd1 _04351_ sky130_fd_sc_hd__nor2_1
Xfanout486 net487 vssd1 vssd1 vccd1 vccd1 net486 sky130_fd_sc_hd__clkbuf_4
Xfanout497 net498 vssd1 vssd1 vccd1 vccd1 net497 sky130_fd_sc_hd__buf_2
XFILLER_0_96_565 vssd1 vssd1 vccd1 vccd1 sky130_fd_sc_hd__decap_4
XFILLER_0_64_451 vssd1 vssd1 vccd1 vccd1 sky130_fd_sc_hd__fill_1
XFILLER_0_91_281 vssd1 vssd1 vccd1 vccd1 sky130_fd_sc_hd__fill_1
XFILLER_0_64_484 vssd1 vssd1 vccd1 vccd1 sky130_fd_sc_hd__decap_4
XFILLER_0_101_27 vssd1 vssd1 vccd1 vccd1 sky130_fd_sc_hd__fill_1
XFILLER_0_36_197 vssd1 vssd1 vccd1 vccd1 sky130_fd_sc_hd__decap_4
XFILLER_0_32_392 vssd1 vssd1 vccd1 vccd1 sky130_fd_sc_hd__decap_8
Xclkbuf_3_6_0_wb_clk_i clknet_0_wb_clk_i vssd1 vssd1 vccd1 vccd1 clknet_3_6_0_wb_clk_i
+ sky130_fd_sc_hd__clkbuf_8
XFILLER_0_20_587 vssd1 vssd1 vccd1 vccd1 sky130_fd_sc_hd__fill_1
XFILLER_0_19_67 vssd1 vssd1 vccd1 vccd1 sky130_fd_sc_hd__fill_1
XFILLER_0_87_521 vssd1 vssd1 vccd1 vccd1 sky130_fd_sc_hd__fill_2
XFILLER_0_59_212 vssd1 vssd1 vccd1 vccd1 sky130_ef_sc_hd__decap_12
XFILLER_0_87_576 vssd1 vssd1 vccd1 vccd1 sky130_fd_sc_hd__decap_3
XFILLER_0_59_267 vssd1 vssd1 vccd1 vccd1 sky130_fd_sc_hd__fill_1
X_05510_ _04777_ _04778_ _04769_ vssd1 vssd1 vccd1 vccd1 _04780_ sky130_fd_sc_hd__o21ai_1
X_06490_ _00862_ _00863_ _00759_ vssd1 vssd1 vccd1 vccd1 _00865_ sky130_fd_sc_hd__a21o_1
XFILLER_0_51_54 vssd1 vssd1 vccd1 vccd1 sky130_fd_sc_hd__fill_2
X_05441_ _04708_ _04709_ _04710_ vssd1 vssd1 vccd1 vccd1 _04711_ sky130_fd_sc_hd__and3_1
X_08160_ _02518_ _02530_ _02531_ vssd1 vssd1 vccd1 vccd1 _02532_ sky130_fd_sc_hd__and3_1
XFILLER_0_51_76 vssd1 vssd1 vccd1 vccd1 sky130_fd_sc_hd__decap_6
XFILLER_0_7_548 vssd1 vssd1 vccd1 vccd1 sky130_ef_sc_hd__decap_12
XFILLER_0_15_304 vssd1 vssd1 vccd1 vccd1 sky130_fd_sc_hd__fill_2
XFILLER_0_15_315 vssd1 vssd1 vccd1 vccd1 sky130_fd_sc_hd__fill_2
XFILLER_0_27_164 vssd1 vssd1 vccd1 vccd1 sky130_fd_sc_hd__decap_4
X_05372_ net355 net363 net624 net632 vssd1 vssd1 vccd1 vccd1 _04642_ sky130_fd_sc_hd__nand4_2
X_07111_ _01478_ _01480_ _01401_ vssd1 vssd1 vccd1 vccd1 _01482_ sky130_fd_sc_hd__o21ai_1
XFILLER_0_42_101 vssd1 vssd1 vccd1 vccd1 sky130_fd_sc_hd__decap_8
X_08091_ _02308_ _02312_ vssd1 vssd1 vccd1 vccd1 _02463_ sky130_fd_sc_hd__nand2_1
XFILLER_0_27_197 vssd1 vssd1 vccd1 vccd1 sky130_fd_sc_hd__fill_2
XFILLER_0_30_329 vssd1 vssd1 vccd1 vccd1 sky130_ef_sc_hd__decap_12
X_07042_ _01269_ _01271_ _01270_ vssd1 vssd1 vccd1 vccd1 _01413_ sky130_fd_sc_hd__a21o_1
XFILLER_0_11_543 vssd1 vssd1 vccd1 vccd1 sky130_fd_sc_hd__decap_8
XFILLER_0_2_297 vssd1 vssd1 vccd1 vccd1 sky130_fd_sc_hd__decap_4
X_08993_ net230 net239 net436 net442 vssd1 vssd1 vccd1 vccd1 _03437_ sky130_fd_sc_hd__nand4_2
X_07944_ _02304_ _02315_ vssd1 vssd1 vccd1 vccd1 _02317_ sky130_fd_sc_hd__xnor2_1
XFILLER_0_48_3 vssd1 vssd1 vccd1 vccd1 sky130_fd_sc_hd__decap_3
X_07875_ _02236_ _02237_ _02247_ vssd1 vssd1 vccd1 vccd1 _02249_ sky130_fd_sc_hd__o21a_1
X_09614_ _04114_ _04115_ vssd1 vssd1 vccd1 vccd1 _04116_ sky130_fd_sc_hd__nand2b_1
X_06826_ _01196_ _01197_ _01064_ _01067_ vssd1 vssd1 vccd1 vccd1 _01199_ sky130_fd_sc_hd__o211ai_2
XFILLER_0_92_83 vssd1 vssd1 vccd1 vccd1 sky130_fd_sc_hd__fill_1
X_09545_ _04038_ _04039_ vssd1 vssd1 vccd1 vccd1 _04040_ sky130_fd_sc_hd__and2b_1
X_06757_ _01115_ _01129_ vssd1 vssd1 vccd1 vccd1 _01130_ sky130_fd_sc_hd__or2_1
X_09476_ _03962_ _03963_ vssd1 vssd1 vccd1 vccd1 _03965_ sky130_fd_sc_hd__xnor2_4
XFILLER_0_93_513 vssd1 vssd1 vccd1 vccd1 sky130_ef_sc_hd__decap_12
X_05708_ net305 net331 net553 net581 vssd1 vssd1 vccd1 vccd1 _04978_ sky130_fd_sc_hd__nand4_2
X_06688_ _01059_ _01060_ _01052_ vssd1 vssd1 vccd1 vccd1 _01062_ sky130_fd_sc_hd__a21o_1
X_08427_ _02649_ _02651_ _02816_ _02817_ vssd1 vssd1 vccd1 vccd1 _02818_ sky130_fd_sc_hd__o211ai_4
X_05639_ _04900_ _04908_ vssd1 vssd1 vccd1 vccd1 _04909_ sky130_fd_sc_hd__xnor2_1
XFILLER_0_65_259 vssd1 vssd1 vccd1 vccd1 sky130_fd_sc_hd__decap_4
X_08358_ _02741_ _02742_ vssd1 vssd1 vccd1 vccd1 _02743_ sky130_fd_sc_hd__nor2_1
XFILLER_0_61_421 vssd1 vssd1 vccd1 vccd1 sky130_fd_sc_hd__decap_3
X_08289_ net359 net393 vssd1 vssd1 vccd1 vccd1 _02668_ sky130_fd_sc_hd__and2b_1
X_07309_ _01546_ _01677_ vssd1 vssd1 vccd1 vccd1 _01678_ sky130_fd_sc_hd__and2_1
XFILLER_0_33_167 vssd1 vssd1 vccd1 vccd1 sky130_fd_sc_hd__fill_1
Xfanout250 net251 vssd1 vssd1 vccd1 vccd1 net250 sky130_fd_sc_hd__buf_4
Xfanout261 net266 vssd1 vssd1 vccd1 vccd1 net261 sky130_fd_sc_hd__buf_2
Xfanout272 net273 vssd1 vssd1 vccd1 vccd1 net272 sky130_fd_sc_hd__clkbuf_4
Xfanout283 mul.a\[13\] vssd1 vssd1 vccd1 vccd1 net283 sky130_fd_sc_hd__buf_2
Xfanout294 net296 vssd1 vssd1 vccd1 vccd1 net294 sky130_fd_sc_hd__clkbuf_4
XFILLER_0_88_318 vssd1 vssd1 vccd1 vccd1 sky130_fd_sc_hd__decap_3
XFILLER_0_69_521 vssd1 vssd1 vccd1 vccd1 sky130_ef_sc_hd__decap_12
XTAP_1241 vssd1 vccd1 sky130_fd_sc_hd__tapvpwrvgnd_1
XTAP_1230 vssd1 vccd1 sky130_fd_sc_hd__tapvpwrvgnd_1
XFILLER_0_29_429 vssd1 vssd1 vccd1 vccd1 sky130_fd_sc_hd__fill_2
XFILLER_0_96_384 vssd1 vssd1 vccd1 vccd1 sky130_fd_sc_hd__decap_8
XTAP_1274 vssd1 vccd1 sky130_fd_sc_hd__tapvpwrvgnd_1
XTAP_1263 vssd1 vccd1 sky130_fd_sc_hd__tapvpwrvgnd_1
XTAP_1252 vssd1 vccd1 sky130_fd_sc_hd__tapvpwrvgnd_1
XTAP_1296 vssd1 vccd1 sky130_fd_sc_hd__tapvpwrvgnd_1
XTAP_1285 vssd1 vccd1 sky130_fd_sc_hd__tapvpwrvgnd_1
XFILLER_0_71_207 vssd1 vssd1 vccd1 vccd1 sky130_fd_sc_hd__decap_3
XFILLER_0_52_421 vssd1 vssd1 vccd1 vccd1 sky130_fd_sc_hd__fill_1
XFILLER_0_37_462 vssd1 vssd1 vccd1 vccd1 sky130_fd_sc_hd__decap_3
XFILLER_0_21_68 vssd1 vssd1 vccd1 vccd1 sky130_fd_sc_hd__fill_1
XFILLER_0_12_307 vssd1 vssd1 vccd1 vccd1 sky130_fd_sc_hd__fill_1
XFILLER_0_20_362 vssd1 vssd1 vccd1 vccd1 sky130_fd_sc_hd__fill_2
X_05990_ _00222_ _00367_ _00368_ vssd1 vssd1 vccd1 vccd1 _00370_ sky130_fd_sc_hd__nand3_2
X_07660_ _01887_ _01889_ _02030_ _02031_ vssd1 vssd1 vccd1 vccd1 _02032_ sky130_fd_sc_hd__o211a_1
X_06611_ _00851_ _00983_ vssd1 vssd1 vccd1 vccd1 _00985_ sky130_fd_sc_hd__xnor2_1
X_07591_ net159 net618 net628 net154 vssd1 vssd1 vccd1 vccd1 _01963_ sky130_fd_sc_hd__a22o_1
X_09330_ _03653_ _03655_ _03803_ _03805_ vssd1 vssd1 vccd1 vccd1 _03806_ sky130_fd_sc_hd__a211oi_2
XFILLER_0_1_78 vssd1 vssd1 vccd1 vccd1 sky130_fd_sc_hd__fill_2
X_06542_ _00913_ _00916_ vssd1 vssd1 vccd1 vccd1 _00917_ sky130_fd_sc_hd__xor2_2
X_09261_ _03725_ _03726_ _03728_ vssd1 vssd1 vccd1 vccd1 _03730_ sky130_fd_sc_hd__a21oi_1
X_08212_ _02422_ _02424_ _02583_ _02584_ vssd1 vssd1 vccd1 vccd1 _02585_ sky130_fd_sc_hd__o211ai_4
X_06473_ net221 net617 _00719_ _00718_ vssd1 vssd1 vccd1 vccd1 _00848_ sky130_fd_sc_hd__a31o_1
X_09192_ _03639_ _03652_ _03654_ vssd1 vssd1 vccd1 vccd1 _03655_ sky130_fd_sc_hd__or3_2
X_05424_ _04459_ _04692_ _04693_ vssd1 vssd1 vccd1 vccd1 _04694_ sky130_fd_sc_hd__and3_1
XFILLER_0_16_602 vssd1 vssd1 vccd1 vccd1 sky130_fd_sc_hd__fill_2
X_08143_ _02501_ _02502_ _02512_ vssd1 vssd1 vccd1 vccd1 _02515_ sky130_fd_sc_hd__o21ai_1
XFILLER_0_55_281 vssd1 vssd1 vccd1 vccd1 sky130_fd_sc_hd__decap_4
X_05355_ _04597_ _04624_ vssd1 vssd1 vccd1 vccd1 _04625_ sky130_fd_sc_hd__nor2_1
XFILLER_0_43_443 vssd1 vssd1 vccd1 vccd1 sky130_fd_sc_hd__decap_4
X_08074_ net154 net600 net610 net149 vssd1 vssd1 vccd1 vccd1 _02446_ sky130_fd_sc_hd__a22o_1
X_05286_ _02973_ _04553_ _04554_ vssd1 vssd1 vccd1 vccd1 _04556_ sky130_fd_sc_hd__and3b_1
X_07025_ _01255_ _01394_ vssd1 vssd1 vccd1 vccd1 _01396_ sky130_fd_sc_hd__xnor2_1
XFILLER_0_101_526 vssd1 vssd1 vccd1 vccd1 sky130_fd_sc_hd__fill_1
XFILLER_0_87_61 vssd1 vssd1 vccd1 vccd1 sky130_fd_sc_hd__decap_3
XFILLER_0_11_351 vssd1 vssd1 vccd1 vccd1 sky130_fd_sc_hd__decap_4
XFILLER_0_30_159 vssd1 vssd1 vccd1 vccd1 sky130_fd_sc_hd__fill_1
XFILLER_0_87_83 vssd1 vssd1 vccd1 vccd1 sky130_fd_sc_hd__fill_2
X_08976_ net192 net199 net484 net490 _03271_ vssd1 vssd1 vccd1 vccd1 _03418_ sky130_fd_sc_hd__a41o_1
X_07927_ _02298_ _02299_ vssd1 vssd1 vccd1 vccd1 _02300_ sky130_fd_sc_hd__nand2b_1
X_07858_ _02229_ _02230_ vssd1 vssd1 vccd1 vccd1 _02231_ sky130_fd_sc_hd__xor2_1
X_07789_ net183 net574 vssd1 vssd1 vccd1 vccd1 _02160_ sky130_fd_sc_hd__nand2_1
X_06809_ _01180_ _01181_ vssd1 vssd1 vccd1 vccd1 _01182_ sky130_fd_sc_hd__xnor2_1
XFILLER_0_78_362 vssd1 vssd1 vccd1 vccd1 sky130_fd_sc_hd__fill_2
X_09528_ _03876_ _03879_ vssd1 vssd1 vccd1 vccd1 _04021_ sky130_fd_sc_hd__nor2_1
X_09459_ _03944_ _03945_ vssd1 vssd1 vccd1 vccd1 _03947_ sky130_fd_sc_hd__or2_1
XFILLER_0_19_462 vssd1 vssd1 vccd1 vccd1 sky130_fd_sc_hd__fill_1
XFILLER_0_19_484 vssd1 vssd1 vccd1 vccd1 sky130_fd_sc_hd__decap_3
XFILLER_0_46_270 vssd1 vssd1 vccd1 vccd1 sky130_fd_sc_hd__decap_4
XFILLER_0_34_421 vssd1 vssd1 vccd1 vccd1 sky130_fd_sc_hd__fill_1
XFILLER_0_34_432 vssd1 vssd1 vccd1 vccd1 sky130_fd_sc_hd__decap_3
XFILLER_0_46_281 vssd1 vssd1 vccd1 vccd1 sky130_fd_sc_hd__decap_6
XFILLER_0_34_454 vssd1 vssd1 vccd1 vccd1 sky130_fd_sc_hd__decap_8
X_10096_ clknet_3_5_0_wb_clk_i _00092_ _00028_ vssd1 vssd1 vccd1 vccd1 mul.b\[25\]
+ sky130_fd_sc_hd__dfrtp_2
XFILLER_0_88_137 vssd1 vssd1 vccd1 vccd1 sky130_fd_sc_hd__decap_3
XFILLER_0_57_502 vssd1 vssd1 vccd1 vccd1 sky130_fd_sc_hd__fill_2
XFILLER_0_84_365 vssd1 vssd1 vccd1 vccd1 sky130_fd_sc_hd__decap_3
XTAP_1082 vssd1 vccd1 sky130_fd_sc_hd__tapvpwrvgnd_1
XTAP_1071 vssd1 vccd1 sky130_fd_sc_hd__tapvpwrvgnd_1
XTAP_1060 vssd1 vccd1 sky130_fd_sc_hd__tapvpwrvgnd_1
XFILLER_0_32_34 vssd1 vssd1 vccd1 vccd1 sky130_fd_sc_hd__decap_8
XTAP_1093 vssd1 vccd1 sky130_fd_sc_hd__tapvpwrvgnd_1
XFILLER_0_32_78 vssd1 vssd1 vccd1 vccd1 sky130_fd_sc_hd__fill_1
XFILLER_0_80_560 vssd1 vssd1 vccd1 vccd1 sky130_fd_sc_hd__decap_3
XFILLER_0_4_337 vssd1 vssd1 vccd1 vccd1 sky130_fd_sc_hd__decap_3
X_05140_ net369 net377 net559 net568 vssd1 vssd1 vccd1 vccd1 _03083_ sky130_fd_sc_hd__and4_1
XFILLER_0_25_465 vssd1 vssd1 vccd1 vccd1 sky130_fd_sc_hd__fill_1
XFILLER_0_12_115 vssd1 vssd1 vccd1 vccd1 sky130_ef_sc_hd__decap_12
X_05071_ net17 net460 net126 vssd1 vssd1 vccd1 vccd1 _00087_ sky130_fd_sc_hd__mux2_1
XTAP_800 vssd1 vccd1 sky130_fd_sc_hd__tapvpwrvgnd_1
X_08830_ _03256_ _03258_ vssd1 vssd1 vccd1 vccd1 _03259_ sky130_fd_sc_hd__xor2_2
XTAP_844 vssd1 vccd1 sky130_fd_sc_hd__tapvpwrvgnd_1
XTAP_833 vssd1 vccd1 sky130_fd_sc_hd__tapvpwrvgnd_1
XTAP_822 vssd1 vccd1 sky130_fd_sc_hd__tapvpwrvgnd_1
XTAP_811 vssd1 vccd1 sky130_fd_sc_hd__tapvpwrvgnd_1
XTAP_866 vssd1 vccd1 sky130_fd_sc_hd__tapvpwrvgnd_1
XTAP_877 vssd1 vccd1 sky130_fd_sc_hd__tapvpwrvgnd_1
XTAP_855 vssd1 vccd1 sky130_fd_sc_hd__tapvpwrvgnd_1
X_08761_ _03175_ _03182_ _03183_ vssd1 vssd1 vccd1 vccd1 _03184_ sky130_fd_sc_hd__nand3_2
XTAP_899 vssd1 vccd1 sky130_fd_sc_hd__tapvpwrvgnd_1
XTAP_888 vssd1 vccd1 sky130_fd_sc_hd__tapvpwrvgnd_1
X_05973_ _00350_ _00351_ _00333_ vssd1 vssd1 vccd1 vccd1 _00353_ sky130_fd_sc_hd__o21a_1
X_08692_ _03100_ _03101_ _03107_ vssd1 vssd1 vccd1 vccd1 _03108_ sky130_fd_sc_hd__nand3_1
X_07712_ _02080_ _02081_ _02082_ vssd1 vssd1 vccd1 vccd1 _02084_ sky130_fd_sc_hd__a21o_1
XFILLER_0_73_52 vssd1 vssd1 vccd1 vccd1 sky130_fd_sc_hd__decap_4
X_07643_ _02004_ _02014_ vssd1 vssd1 vccd1 vccd1 _02015_ sky130_fd_sc_hd__xnor2_1
X_09313_ _03785_ _03786_ vssd1 vssd1 vccd1 vccd1 _03787_ sky130_fd_sc_hd__or2_1
X_07574_ _01784_ _01786_ vssd1 vssd1 vccd1 vccd1 _01947_ sky130_fd_sc_hd__nor2_1
XFILLER_0_63_505 vssd1 vssd1 vccd1 vccd1 sky130_ef_sc_hd__decap_12
X_06525_ _00787_ _00789_ _00898_ vssd1 vssd1 vccd1 vccd1 _00900_ sky130_fd_sc_hd__and3_1
XFILLER_0_48_557 vssd1 vssd1 vccd1 vccd1 sky130_fd_sc_hd__decap_3
X_09244_ net140 _03709_ _03710_ _03711_ vssd1 vssd1 vccd1 vccd1 net57 sky130_fd_sc_hd__a31o_1
X_06456_ _00829_ _00830_ _00617_ _00620_ vssd1 vssd1 vccd1 vccd1 _00832_ sky130_fd_sc_hd__a211o_1
XFILLER_0_90_335 vssd1 vssd1 vccd1 vccd1 sky130_fd_sc_hd__decap_3
X_09175_ _03468_ _03471_ _03634_ _03635_ vssd1 vssd1 vccd1 vccd1 _03636_ sky130_fd_sc_hd__o211a_1
XFILLER_0_16_421 vssd1 vssd1 vccd1 vccd1 sky130_ef_sc_hd__decap_12
X_05407_ _04629_ _04630_ _04635_ _04636_ _04676_ vssd1 vssd1 vccd1 vccd1 _04677_ sky130_fd_sc_hd__a221o_1
X_08126_ _02491_ _02492_ _02497_ vssd1 vssd1 vccd1 vccd1 _02498_ sky130_fd_sc_hd__nand3_1
X_06387_ _00761_ _00762_ vssd1 vssd1 vccd1 vccd1 _00763_ sky130_fd_sc_hd__nand2_1
XFILLER_0_16_487 vssd1 vssd1 vccd1 vccd1 sky130_fd_sc_hd__fill_2
X_05338_ net352 net624 net632 net346 vssd1 vssd1 vccd1 vccd1 _04608_ sky130_fd_sc_hd__a22oi_1
XFILLER_0_98_93 vssd1 vssd1 vccd1 vccd1 sky130_ef_sc_hd__decap_12
X_08057_ _02427_ _02428_ _02156_ _02158_ vssd1 vssd1 vccd1 vccd1 _02430_ sky130_fd_sc_hd__o211a_1
X_05269_ _04459_ _04470_ _03203_ vssd1 vssd1 vccd1 vccd1 _04492_ sky130_fd_sc_hd__o21bai_1
XFILLER_0_3_370 vssd1 vssd1 vccd1 vccd1 sky130_fd_sc_hd__decap_8
XFILLER_0_31_446 vssd1 vssd1 vccd1 vccd1 sky130_fd_sc_hd__fill_2
Xoutput48 net48 vssd1 vssd1 vccd1 vccd1 wbs_dat_o[17] sky130_fd_sc_hd__buf_2
X_07008_ _01233_ _01238_ _01377_ vssd1 vssd1 vccd1 vccd1 _01379_ sky130_fd_sc_hd__or3_1
Xoutput59 net59 vssd1 vssd1 vccd1 vccd1 wbs_dat_o[27] sky130_fd_sc_hd__clkbuf_4
XFILLER_0_11_181 vssd1 vssd1 vccd1 vccd1 sky130_ef_sc_hd__decap_12
X_08959_ net157 net698 net545 net152 vssd1 vssd1 vccd1 vccd1 _03400_ sky130_fd_sc_hd__a22o_1
XFILLER_0_85_107 vssd1 vssd1 vccd1 vccd1 sky130_fd_sc_hd__decap_4
XPHY_143 vssd1 vssd1 vccd1 vccd1 sky130_fd_sc_hd__decap_3
XFILLER_0_66_354 vssd1 vssd1 vccd1 vccd1 sky130_fd_sc_hd__decap_3
XPHY_132 vssd1 vssd1 vccd1 vccd1 sky130_fd_sc_hd__decap_3
XPHY_121 vssd1 vssd1 vccd1 vccd1 sky130_fd_sc_hd__decap_3
XPHY_110 vssd1 vssd1 vccd1 vccd1 sky130_fd_sc_hd__decap_3
XFILLER_0_93_173 vssd1 vssd1 vccd1 vccd1 sky130_fd_sc_hd__fill_1
XPHY_176 vssd1 vssd1 vccd1 vccd1 sky130_fd_sc_hd__decap_3
XPHY_165 vssd1 vssd1 vccd1 vccd1 sky130_fd_sc_hd__decap_3
XPHY_154 vssd1 vssd1 vccd1 vccd1 sky130_fd_sc_hd__decap_3
XFILLER_0_66_387 vssd1 vssd1 vccd1 vccd1 sky130_fd_sc_hd__fill_1
XPHY_198 vssd1 vssd1 vccd1 vccd1 sky130_fd_sc_hd__decap_3
XPHY_187 vssd1 vssd1 vccd1 vccd1 sky130_fd_sc_hd__decap_3
XFILLER_0_93_184 vssd1 vssd1 vccd1 vccd1 sky130_fd_sc_hd__decap_8
XFILLER_0_81_346 vssd1 vssd1 vccd1 vccd1 sky130_fd_sc_hd__fill_1
XFILLER_0_34_251 vssd1 vssd1 vccd1 vccd1 sky130_fd_sc_hd__fill_1
XFILLER_0_34_284 vssd1 vssd1 vccd1 vccd1 sky130_fd_sc_hd__fill_1
XFILLER_0_94_29 vssd1 vssd1 vccd1 vccd1 sky130_fd_sc_hd__fill_2
XFILLER_0_89_413 vssd1 vssd1 vccd1 vccd1 sky130_fd_sc_hd__fill_1
X_10079_ clknet_3_0_0_wb_clk_i _00075_ _00011_ vssd1 vssd1 vccd1 vccd1 mul.b\[8\]
+ sky130_fd_sc_hd__dfrtp_4
XFILLER_0_89_424 vssd1 vssd1 vccd1 vccd1 sky130_fd_sc_hd__decap_8
Xmax_cap90 _03499_ vssd1 vssd1 vccd1 vccd1 net90 sky130_fd_sc_hd__clkbuf_1
XFILLER_0_76_129 vssd1 vssd1 vccd1 vccd1 sky130_fd_sc_hd__fill_1
XPHY_1 vssd1 vssd1 vccd1 vccd1 sky130_fd_sc_hd__decap_3
XFILLER_0_69_192 vssd1 vssd1 vccd1 vccd1 sky130_fd_sc_hd__decap_4
XFILLER_0_9_429 vssd1 vssd1 vccd1 vccd1 sky130_fd_sc_hd__decap_6
X_06310_ _00668_ _00685_ _00686_ vssd1 vssd1 vccd1 vccd1 _00687_ sky130_fd_sc_hd__and3_1
X_07290_ _01658_ vssd1 vssd1 vccd1 vccd1 _01659_ sky130_fd_sc_hd__inv_2
X_06241_ _00509_ _00514_ _00616_ vssd1 vssd1 vccd1 vccd1 _00618_ sky130_fd_sc_hd__nor3_1
XFILLER_0_5_624 vssd1 vssd1 vccd1 vccd1 sky130_fd_sc_hd__fill_1
XFILLER_0_13_413 vssd1 vssd1 vccd1 vccd1 sky130_fd_sc_hd__decap_8
X_06172_ net345 net495 vssd1 vssd1 vccd1 vccd1 _00550_ sky130_fd_sc_hd__nand2_1
XFILLER_0_25_273 vssd1 vssd1 vccd1 vccd1 sky130_fd_sc_hd__fill_2
X_05123_ _02875_ _02886_ vssd1 vssd1 vccd1 vccd1 _02897_ sky130_fd_sc_hd__nor2_1
XFILLER_0_13_446 vssd1 vssd1 vccd1 vccd1 sky130_fd_sc_hd__fill_2
X_09931_ net157 net471 vssd1 vssd1 vccd1 vccd1 _04462_ sky130_fd_sc_hd__nand2_1
X_05054_ net27 net376 net132 vssd1 vssd1 vccd1 vccd1 _00101_ sky130_fd_sc_hd__mux2_1
XFILLER_0_68_85 vssd1 vssd1 vccd1 vccd1 sky130_fd_sc_hd__decap_6
XFILLER_0_0_351 vssd1 vssd1 vccd1 vccd1 sky130_fd_sc_hd__fill_1
XTAP_630 vssd1 vccd1 sky130_fd_sc_hd__tapvpwrvgnd_1
XTAP_641 vssd1 vccd1 sky130_fd_sc_hd__tapvpwrvgnd_1
XTAP_652 vssd1 vccd1 sky130_fd_sc_hd__tapvpwrvgnd_1
X_09862_ _04376_ _04386_ vssd1 vssd1 vccd1 vccd1 _04387_ sky130_fd_sc_hd__xnor2_1
X_08813_ _02924_ _02932_ _03087_ _03088_ vssd1 vssd1 vccd1 vccd1 _03241_ sky130_fd_sc_hd__o31a_1
XTAP_663 vssd1 vccd1 sky130_fd_sc_hd__tapvpwrvgnd_1
XTAP_674 vssd1 vccd1 sky130_fd_sc_hd__tapvpwrvgnd_1
XTAP_685 vssd1 vccd1 sky130_fd_sc_hd__tapvpwrvgnd_1
X_09793_ _04010_ _04170_ _04009_ vssd1 vssd1 vccd1 vccd1 _04311_ sky130_fd_sc_hd__o21ai_1
X_08744_ _03162_ _03164_ vssd1 vssd1 vccd1 vccd1 _03165_ sky130_fd_sc_hd__xnor2_2
XFILLER_0_84_51 vssd1 vssd1 vccd1 vccd1 sky130_fd_sc_hd__decap_4
X_05956_ net345 net354 net503 net511 vssd1 vssd1 vccd1 vccd1 _00336_ sky130_fd_sc_hd__and4_1
XFILLER_0_30_3 vssd1 vssd1 vccd1 vccd1 sky130_fd_sc_hd__decap_8
XTAP_696 vssd1 vccd1 sky130_fd_sc_hd__tapvpwrvgnd_1
X_08675_ _02935_ _03089_ vssd1 vssd1 vccd1 vccd1 _03090_ sky130_fd_sc_hd__or2_1
XFILLER_0_68_608 vssd1 vssd1 vccd1 vccd1 sky130_fd_sc_hd__fill_2
X_05887_ _00222_ _00223_ _00265_ _00266_ vssd1 vssd1 vccd1 vccd1 _00268_ sky130_fd_sc_hd__o22a_1
X_07626_ _01995_ _01996_ _01828_ _01830_ vssd1 vssd1 vccd1 vccd1 _01998_ sky130_fd_sc_hd__o211a_1
X_07557_ _01868_ _01869_ _01928_ _01929_ vssd1 vssd1 vccd1 vccd1 _01930_ sky130_fd_sc_hd__nor4_2
XFILLER_0_75_140 vssd1 vssd1 vccd1 vccd1 sky130_fd_sc_hd__decap_3
X_06508_ _00881_ _00882_ vssd1 vssd1 vccd1 vccd1 _00883_ sky130_fd_sc_hd__nor2_1
XFILLER_0_63_335 vssd1 vssd1 vccd1 vccd1 sky130_fd_sc_hd__fill_1
X_07488_ _01857_ _01858_ vssd1 vssd1 vccd1 vccd1 _01859_ sky130_fd_sc_hd__and2b_1
XFILLER_0_36_549 vssd1 vssd1 vccd1 vccd1 sky130_ef_sc_hd__decap_12
X_09227_ _03691_ _03692_ vssd1 vssd1 vccd1 vccd1 _03693_ sky130_fd_sc_hd__and2_1
XFILLER_0_16_251 vssd1 vssd1 vccd1 vccd1 sky130_fd_sc_hd__fill_1
X_06439_ _00812_ _00813_ _00779_ vssd1 vssd1 vccd1 vccd1 _00815_ sky130_fd_sc_hd__o21a_1
X_09158_ _03426_ _03428_ _03616_ vssd1 vssd1 vccd1 vccd1 _03617_ sky130_fd_sc_hd__o21a_2
XFILLER_0_31_210 vssd1 vssd1 vccd1 vccd1 sky130_fd_sc_hd__fill_1
X_09089_ _03380_ _03383_ vssd1 vssd1 vccd1 vccd1 _03543_ sky130_fd_sc_hd__and2b_1
X_08109_ _02444_ _02480_ vssd1 vssd1 vccd1 vccd1 _02481_ sky130_fd_sc_hd__nand2b_1
XFILLER_0_31_221 vssd1 vssd1 vccd1 vccd1 sky130_fd_sc_hd__decap_3
XFILLER_0_12_490 vssd1 vssd1 vccd1 vccd1 sky130_fd_sc_hd__fill_2
XFILLER_0_101_197 vssd1 vssd1 vccd1 vccd1 sky130_ef_sc_hd__decap_12
X_10002_ _04439_ _04443_ _04539_ vssd1 vssd1 vccd1 vccd1 _04540_ sky130_fd_sc_hd__o21ai_1
XFILLER_0_98_210 vssd1 vssd1 vccd1 vccd1 sky130_fd_sc_hd__decap_4
XFILLER_0_98_265 vssd1 vssd1 vccd1 vccd1 sky130_fd_sc_hd__fill_2
XFILLER_0_58_118 vssd1 vssd1 vccd1 vccd1 sky130_fd_sc_hd__decap_3
XFILLER_0_94_471 vssd1 vssd1 vccd1 vccd1 sky130_fd_sc_hd__decap_4
XFILLER_0_94_460 vssd1 vssd1 vccd1 vccd1 sky130_fd_sc_hd__fill_1
XFILLER_0_27_505 vssd1 vssd1 vccd1 vccd1 sky130_ef_sc_hd__decap_12
XFILLER_0_94_493 vssd1 vssd1 vccd1 vccd1 sky130_ef_sc_hd__decap_12
XFILLER_0_13_69 vssd1 vssd1 vccd1 vccd1 sky130_fd_sc_hd__fill_1
XFILLER_0_89_18 vssd1 vssd1 vccd1 vccd1 sky130_fd_sc_hd__decap_6
XFILLER_0_22_232 vssd1 vssd1 vccd1 vccd1 sky130_fd_sc_hd__decap_4
XFILLER_0_10_427 vssd1 vssd1 vccd1 vccd1 sky130_fd_sc_hd__fill_1
X_05810_ _00188_ _00189_ _05017_ vssd1 vssd1 vccd1 vccd1 _00191_ sky130_fd_sc_hd__a21o_1
XFILLER_0_89_232 vssd1 vssd1 vccd1 vccd1 sky130_fd_sc_hd__fill_1
X_06790_ _01160_ _01161_ _01154_ vssd1 vssd1 vccd1 vccd1 _01163_ sky130_fd_sc_hd__a21o_1
XFILLER_0_89_243 vssd1 vssd1 vccd1 vccd1 sky130_ef_sc_hd__decap_12
X_05741_ _04991_ _05010_ vssd1 vssd1 vccd1 vccd1 _05011_ sky130_fd_sc_hd__nor2_1
X_08460_ net317 net415 _02852_ _02854_ vssd1 vssd1 vccd1 vccd1 _02855_ sky130_fd_sc_hd__a22o_1
X_05672_ _04939_ _04940_ _04938_ vssd1 vssd1 vccd1 vccd1 _04942_ sky130_fd_sc_hd__a21o_1
XFILLER_0_49_118 vssd1 vssd1 vccd1 vccd1 sky130_fd_sc_hd__fill_1
X_08391_ _02774_ _02777_ _02605_ _02608_ vssd1 vssd1 vccd1 vccd1 _02779_ sky130_fd_sc_hd__a211o_1
X_07411_ _01631_ _01633_ _01778_ _01779_ vssd1 vssd1 vccd1 vccd1 _01780_ sky130_fd_sc_hd__o211a_4
XFILLER_0_92_419 vssd1 vssd1 vccd1 vccd1 sky130_fd_sc_hd__fill_1
XFILLER_0_70_20 vssd1 vssd1 vccd1 vccd1 sky130_fd_sc_hd__decap_8
X_07342_ _01585_ _01587_ _01709_ _01710_ vssd1 vssd1 vccd1 vccd1 _01711_ sky130_fd_sc_hd__o211a_1
XFILLER_0_9_248 vssd1 vssd1 vccd1 vccd1 sky130_fd_sc_hd__decap_3
XFILLER_0_9_237 vssd1 vssd1 vccd1 vccd1 sky130_fd_sc_hd__decap_4
XFILLER_0_57_173 vssd1 vssd1 vccd1 vccd1 sky130_fd_sc_hd__fill_1
XFILLER_0_45_335 vssd1 vssd1 vccd1 vccd1 sky130_fd_sc_hd__fill_1
XFILLER_0_5_410 vssd1 vssd1 vccd1 vccd1 sky130_fd_sc_hd__fill_1
X_07273_ _01501_ _01640_ _01642_ vssd1 vssd1 vccd1 vccd1 _01643_ sky130_fd_sc_hd__or3_4
XFILLER_0_45_357 vssd1 vssd1 vccd1 vccd1 sky130_fd_sc_hd__fill_2
X_09012_ _03434_ _03435_ _03456_ _03457_ vssd1 vssd1 vccd1 vccd1 _03458_ sky130_fd_sc_hd__and4_1
X_06224_ _00598_ net74 _00596_ vssd1 vssd1 vccd1 vccd1 _00602_ sky130_fd_sc_hd__o21ai_1
XFILLER_0_26_582 vssd1 vssd1 vccd1 vccd1 sky130_fd_sc_hd__decap_6
XFILLER_0_78_3 vssd1 vssd1 vccd1 vccd1 sky130_fd_sc_hd__fill_2
X_06155_ net387 net456 net463 net379 vssd1 vssd1 vccd1 vccd1 _00533_ sky130_fd_sc_hd__a22oi_1
X_05106_ net327 net614 vssd1 vssd1 vccd1 vccd1 _02711_ sky130_fd_sc_hd__and2_1
XFILLER_0_13_254 vssd1 vssd1 vccd1 vccd1 sky130_ef_sc_hd__decap_12
X_06086_ net95 _00463_ _00359_ net674 vssd1 vssd1 vccd1 vccd1 _00465_ sky130_fd_sc_hd__o211a_1
X_09914_ _04440_ _04442_ vssd1 vssd1 vccd1 vccd1 _04444_ sky130_fd_sc_hd__or2_1
X_05037_ net15 net229 net134 vssd1 vssd1 vccd1 vccd1 _00118_ sky130_fd_sc_hd__mux2_1
Xfanout624 mul.b\[1\] vssd1 vssd1 vccd1 vccd1 net624 sky130_fd_sc_hd__clkbuf_4
Xfanout613 mul.b\[3\] vssd1 vssd1 vccd1 vccd1 net613 sky130_fd_sc_hd__clkbuf_2
Xfanout602 net603 vssd1 vssd1 vccd1 vccd1 net602 sky130_fd_sc_hd__buf_2
XFILLER_0_95_61 vssd1 vssd1 vccd1 vccd1 sky130_fd_sc_hd__fill_1
X_09845_ net249 net397 vssd1 vssd1 vccd1 vccd1 _04368_ sky130_fd_sc_hd__nand2_1
XTAP_460 vssd1 vccd1 sky130_fd_sc_hd__tapvpwrvgnd_1
Xfanout635 net637 vssd1 vssd1 vccd1 vccd1 net635 sky130_fd_sc_hd__buf_2
XTAP_471 vssd1 vccd1 sky130_fd_sc_hd__tapvpwrvgnd_1
XTAP_482 vssd1 vccd1 sky130_fd_sc_hd__tapvpwrvgnd_1
XTAP_493 vssd1 vccd1 sky130_fd_sc_hd__tapvpwrvgnd_1
X_09776_ _04291_ _04292_ vssd1 vssd1 vccd1 vccd1 _04293_ sky130_fd_sc_hd__xnor2_1
X_06988_ _01357_ _01359_ vssd1 vssd1 vccd1 vccd1 _01360_ sky130_fd_sc_hd__or2_1
X_08727_ _03135_ _03144_ vssd1 vssd1 vccd1 vccd1 _03146_ sky130_fd_sc_hd__xor2_1
X_05939_ _00300_ _00318_ vssd1 vssd1 vccd1 vccd1 _00319_ sky130_fd_sc_hd__nor2_1
X_08658_ _03043_ _03044_ _03070_ vssd1 vssd1 vccd1 vccd1 _03071_ sky130_fd_sc_hd__nor3_1
X_07609_ net205 net555 _01979_ _01980_ vssd1 vssd1 vccd1 vccd1 _01981_ sky130_fd_sc_hd__a22o_1
X_08589_ _02972_ _02974_ _02994_ vssd1 vssd1 vccd1 vccd1 _02996_ sky130_fd_sc_hd__and3_1
XFILLER_0_36_324 vssd1 vssd1 vccd1 vccd1 sky130_ef_sc_hd__decap_12
XFILLER_0_36_357 vssd1 vssd1 vccd1 vccd1 sky130_fd_sc_hd__decap_6
XFILLER_0_32_574 vssd1 vssd1 vccd1 vccd1 sky130_fd_sc_hd__decap_3
XFILLER_0_59_405 vssd1 vssd1 vccd1 vccd1 sky130_fd_sc_hd__fill_2
XFILLER_0_86_257 vssd1 vssd1 vccd1 vccd1 sky130_fd_sc_hd__fill_1
XFILLER_0_67_460 vssd1 vssd1 vccd1 vccd1 sky130_fd_sc_hd__decap_6
XFILLER_0_39_162 vssd1 vssd1 vccd1 vccd1 sky130_fd_sc_hd__decap_6
XFILLER_0_27_335 vssd1 vssd1 vccd1 vccd1 sky130_fd_sc_hd__fill_1
XFILLER_0_82_441 vssd1 vssd1 vccd1 vccd1 sky130_fd_sc_hd__decap_3
XFILLER_0_42_305 vssd1 vssd1 vccd1 vccd1 sky130_fd_sc_hd__decap_3
XFILLER_0_2_402 vssd1 vssd1 vccd1 vccd1 sky130_fd_sc_hd__fill_1
XFILLER_0_23_574 vssd1 vssd1 vccd1 vccd1 sky130_fd_sc_hd__decap_3
XFILLER_0_23_585 vssd1 vssd1 vccd1 vccd1 sky130_fd_sc_hd__fill_2
XFILLER_0_50_382 vssd1 vssd1 vccd1 vccd1 sky130_fd_sc_hd__fill_2
X_07960_ net359 net403 net409 net351 vssd1 vssd1 vccd1 vccd1 _02333_ sky130_fd_sc_hd__a22o_1
XFILLER_0_49_65 vssd1 vssd1 vccd1 vccd1 sky130_fd_sc_hd__decap_3
X_06911_ _01168_ _01175_ _01174_ vssd1 vssd1 vccd1 vccd1 _01283_ sky130_fd_sc_hd__a21o_1
X_07891_ net651 _02097_ _02263_ _02264_ vssd1 vssd1 vccd1 vccd1 _02265_ sky130_fd_sc_hd__a211o_4
X_09630_ net117 _04133_ vssd1 vssd1 vccd1 vccd1 _04134_ sky130_fd_sc_hd__xor2_1
X_06842_ _01212_ _01213_ _01083_ _01085_ vssd1 vssd1 vccd1 vccd1 _01215_ sky130_fd_sc_hd__o211a_1
X_06773_ _01136_ _01144_ vssd1 vssd1 vccd1 vccd1 _01146_ sky130_fd_sc_hd__xnor2_2
X_09561_ _04054_ _04056_ vssd1 vssd1 vccd1 vccd1 _04058_ sky130_fd_sc_hd__xor2_1
X_08512_ _02709_ _02750_ _02910_ _02911_ vssd1 vssd1 vccd1 vccd1 _02912_ sky130_fd_sc_hd__o211a_1
X_05724_ _04993_ vssd1 vssd1 vccd1 vccd1 _04994_ sky130_fd_sc_hd__inv_2
X_09492_ _03981_ _03982_ vssd1 vssd1 vccd1 vccd1 _03983_ sky130_fd_sc_hd__nand2b_1
XFILLER_0_81_41 vssd1 vssd1 vccd1 vccd1 sky130_fd_sc_hd__fill_1
X_08443_ net164 net566 _02834_ vssd1 vssd1 vccd1 vccd1 _02836_ sky130_fd_sc_hd__and3_1
XFILLER_0_92_205 vssd1 vssd1 vccd1 vccd1 sky130_fd_sc_hd__fill_1
X_05655_ _04866_ _04869_ _04923_ vssd1 vssd1 vccd1 vccd1 _04925_ sky130_fd_sc_hd__or3_1
XFILLER_0_92_249 vssd1 vssd1 vccd1 vccd1 sky130_fd_sc_hd__decap_3
X_08374_ _02758_ _02759_ _02457_ _02459_ vssd1 vssd1 vccd1 vccd1 _02761_ sky130_fd_sc_hd__o211a_1
XFILLER_0_58_482 vssd1 vssd1 vccd1 vccd1 sky130_fd_sc_hd__decap_3
X_05586_ _04791_ _04793_ vssd1 vssd1 vccd1 vccd1 _04856_ sky130_fd_sc_hd__and2_1
XFILLER_0_18_313 vssd1 vssd1 vccd1 vccd1 sky130_fd_sc_hd__fill_1
XFILLER_0_45_143 vssd1 vssd1 vccd1 vccd1 sky130_fd_sc_hd__decap_3
X_07325_ net203 net210 net564 net572 vssd1 vssd1 vccd1 vccd1 _01694_ sky130_fd_sc_hd__and4_2
X_07256_ _01470_ net722 net100 _01624_ vssd1 vssd1 vccd1 vccd1 _01626_ sky130_fd_sc_hd__a211o_1
X_06207_ _00464_ net85 _00583_ _00584_ vssd1 vssd1 vccd1 vccd1 _00585_ sky130_fd_sc_hd__o211ai_4
XFILLER_0_60_179 vssd1 vssd1 vccd1 vccd1 sky130_fd_sc_hd__decap_4
X_07187_ _01550_ _01555_ vssd1 vssd1 vccd1 vccd1 _01557_ sky130_fd_sc_hd__xor2_1
X_06138_ _00404_ _00409_ _00515_ vssd1 vssd1 vccd1 vccd1 _00516_ sky130_fd_sc_hd__o21ai_2
X_06069_ _00444_ _00445_ _00446_ vssd1 vssd1 vccd1 vccd1 _00448_ sky130_fd_sc_hd__a21o_1
Xfanout410 mul.b\[28\] vssd1 vssd1 vccd1 vccd1 net410 sky130_fd_sc_hd__buf_4
Xfanout421 mul.b\[26\] vssd1 vssd1 vccd1 vccd1 net421 sky130_fd_sc_hd__clkbuf_4
Xfanout432 net433 vssd1 vssd1 vccd1 vccd1 net432 sky130_fd_sc_hd__buf_4
XFILLER_0_1_490 vssd1 vssd1 vccd1 vccd1 sky130_fd_sc_hd__decap_4
Xfanout443 net444 vssd1 vssd1 vccd1 vccd1 net443 sky130_fd_sc_hd__buf_2
Xfanout465 mul.b\[19\] vssd1 vssd1 vccd1 vccd1 net465 sky130_fd_sc_hd__clkbuf_4
Xfanout454 net456 vssd1 vssd1 vccd1 vccd1 net454 sky130_fd_sc_hd__buf_2
Xfanout476 mul.b\[18\] vssd1 vssd1 vccd1 vccd1 net476 sky130_fd_sc_hd__buf_4
Xfanout498 net501 vssd1 vssd1 vccd1 vccd1 net498 sky130_fd_sc_hd__clkbuf_2
XTAP_290 vssd1 vccd1 sky130_fd_sc_hd__tapvpwrvgnd_1
X_09828_ _04340_ _04347_ vssd1 vssd1 vccd1 vccd1 _04349_ sky130_fd_sc_hd__and2_1
Xfanout487 net488 vssd1 vssd1 vccd1 vccd1 net487 sky130_fd_sc_hd__clkbuf_4
X_09759_ _04082_ _04085_ _04273_ vssd1 vssd1 vccd1 vccd1 _04275_ sky130_fd_sc_hd__o21a_1
XFILLER_0_96_533 vssd1 vssd1 vccd1 vccd1 sky130_fd_sc_hd__decap_6
XFILLER_0_51_157 vssd1 vssd1 vccd1 vccd1 sky130_fd_sc_hd__decap_4
XFILLER_0_86_19 vssd1 vssd1 vccd1 vccd1 sky130_fd_sc_hd__fill_2
XFILLER_0_19_13 vssd1 vssd1 vccd1 vccd1 sky130_ef_sc_hd__decap_12
XFILLER_0_19_46 vssd1 vssd1 vccd1 vccd1 sky130_fd_sc_hd__decap_8
XFILLER_0_99_393 vssd1 vssd1 vccd1 vccd1 sky130_fd_sc_hd__decap_8
XFILLER_0_87_533 vssd1 vssd1 vccd1 vccd1 sky130_fd_sc_hd__decap_8
XFILLER_0_74_249 vssd1 vssd1 vccd1 vccd1 sky130_fd_sc_hd__decap_3
X_05440_ _04175_ _04263_ _04252_ vssd1 vssd1 vccd1 vccd1 _04710_ sky130_fd_sc_hd__a21bo_1
X_05371_ net615 _04601_ vssd1 vssd1 vccd1 vccd1 _04641_ sky130_fd_sc_hd__nand2_1
X_07110_ _01401_ _01478_ _01480_ vssd1 vssd1 vccd1 vccd1 _01481_ sky130_fd_sc_hd__or3_4
X_08090_ _02332_ _02340_ _02339_ vssd1 vssd1 vccd1 vccd1 _02462_ sky130_fd_sc_hd__o21bai_2
XFILLER_0_70_477 vssd1 vssd1 vccd1 vccd1 sky130_fd_sc_hd__decap_6
XFILLER_0_2_221 vssd1 vssd1 vccd1 vccd1 sky130_fd_sc_hd__decap_8
X_07041_ _01410_ _01411_ vssd1 vssd1 vccd1 vccd1 _01412_ sky130_fd_sc_hd__nand2_1
XFILLER_0_23_393 vssd1 vssd1 vccd1 vccd1 sky130_ef_sc_hd__decap_12
X_08992_ net239 net436 net442 net230 vssd1 vssd1 vccd1 vccd1 _03436_ sky130_fd_sc_hd__a22o_1
XFILLER_0_11_577 vssd1 vssd1 vccd1 vccd1 sky130_fd_sc_hd__decap_8
XFILLER_0_76_85 vssd1 vssd1 vccd1 vccd1 sky130_fd_sc_hd__decap_8
X_07943_ _02304_ _02315_ vssd1 vssd1 vccd1 vccd1 _02316_ sky130_fd_sc_hd__and2b_1
X_07874_ _02236_ _02237_ _02247_ vssd1 vssd1 vccd1 vccd1 _02248_ sky130_fd_sc_hd__nor3_2
XFILLER_0_97_308 vssd1 vssd1 vccd1 vccd1 sky130_fd_sc_hd__fill_1
X_09613_ _03919_ _03961_ _03918_ vssd1 vssd1 vccd1 vccd1 _04115_ sky130_fd_sc_hd__a21bo_1
X_06825_ _01064_ _01067_ _01196_ _01197_ vssd1 vssd1 vccd1 vccd1 _01198_ sky130_fd_sc_hd__a211o_1
XFILLER_0_78_533 vssd1 vssd1 vccd1 vccd1 sky130_fd_sc_hd__decap_6
X_09544_ _03871_ _03886_ _04037_ vssd1 vssd1 vccd1 vccd1 _04039_ sky130_fd_sc_hd__or3b_1
X_06756_ _00996_ _01128_ vssd1 vssd1 vccd1 vccd1 _01129_ sky130_fd_sc_hd__xnor2_1
X_09475_ _03962_ _03963_ vssd1 vssd1 vccd1 vccd1 _03964_ sky130_fd_sc_hd__and2b_1
X_05707_ net331 net553 net581 net305 vssd1 vssd1 vccd1 vccd1 _04977_ sky130_fd_sc_hd__a22o_1
X_06687_ _01052_ _01059_ _01060_ vssd1 vssd1 vccd1 vccd1 _01061_ sky130_fd_sc_hd__nand3_1
XFILLER_0_93_525 vssd1 vssd1 vccd1 vccd1 sky130_ef_sc_hd__decap_12
X_08426_ net264 net450 _02814_ _02815_ vssd1 vssd1 vccd1 vccd1 _02817_ sky130_fd_sc_hd__nand4_4
X_05638_ _04905_ _04906_ vssd1 vssd1 vccd1 vccd1 _04908_ sky130_fd_sc_hd__xor2_1
XFILLER_0_93_569 vssd1 vssd1 vccd1 vccd1 sky130_fd_sc_hd__fill_1
X_08357_ _02461_ _02475_ _02474_ vssd1 vssd1 vccd1 vccd1 _02742_ sky130_fd_sc_hd__a21oi_2
X_05569_ _04820_ _04838_ vssd1 vssd1 vccd1 vccd1 _04839_ sky130_fd_sc_hd__and2_1
X_08288_ _02570_ _02572_ vssd1 vssd1 vccd1 vccd1 _02666_ sky130_fd_sc_hd__nand2_1
XFILLER_0_61_444 vssd1 vssd1 vccd1 vccd1 sky130_fd_sc_hd__decap_4
XFILLER_0_33_113 vssd1 vssd1 vccd1 vccd1 sky130_fd_sc_hd__decap_8
X_07308_ _01669_ _01675_ vssd1 vssd1 vccd1 vccd1 _01677_ sky130_fd_sc_hd__xnor2_1
X_07239_ _01606_ _01607_ _01605_ vssd1 vssd1 vccd1 vccd1 _01609_ sky130_fd_sc_hd__a21o_1
XFILLER_0_14_393 vssd1 vssd1 vccd1 vccd1 sky130_fd_sc_hd__decap_6
Xfanout240 net241 vssd1 vssd1 vccd1 vccd1 net240 sky130_fd_sc_hd__buf_4
Xfanout251 mul.a\[16\] vssd1 vssd1 vccd1 vccd1 net251 sky130_fd_sc_hd__clkbuf_4
Xfanout273 net275 vssd1 vssd1 vccd1 vccd1 net273 sky130_fd_sc_hd__clkbuf_4
Xfanout262 net263 vssd1 vssd1 vccd1 vccd1 net262 sky130_fd_sc_hd__clkbuf_4
Xfanout295 net296 vssd1 vssd1 vccd1 vccd1 net295 sky130_fd_sc_hd__buf_2
Xfanout284 net291 vssd1 vssd1 vccd1 vccd1 net284 sky130_fd_sc_hd__clkbuf_4
XFILLER_0_69_500 vssd1 vssd1 vccd1 vccd1 sky130_fd_sc_hd__decap_4
XFILLER_0_69_533 vssd1 vssd1 vccd1 vccd1 sky130_fd_sc_hd__decap_6
XFILLER_0_96_363 vssd1 vssd1 vccd1 vccd1 sky130_fd_sc_hd__fill_1
XTAP_1231 vssd1 vccd1 sky130_fd_sc_hd__tapvpwrvgnd_1
XTAP_1220 vssd1 vccd1 sky130_fd_sc_hd__tapvpwrvgnd_1
XFILLER_0_84_503 vssd1 vssd1 vccd1 vccd1 sky130_fd_sc_hd__fill_1
XFILLER_0_56_205 vssd1 vssd1 vccd1 vccd1 sky130_fd_sc_hd__fill_1
XTAP_1275 vssd1 vccd1 sky130_fd_sc_hd__tapvpwrvgnd_1
XTAP_1264 vssd1 vccd1 sky130_fd_sc_hd__tapvpwrvgnd_1
XTAP_1253 vssd1 vccd1 sky130_fd_sc_hd__tapvpwrvgnd_1
XTAP_1242 vssd1 vccd1 sky130_fd_sc_hd__tapvpwrvgnd_1
XFILLER_0_56_216 vssd1 vssd1 vccd1 vccd1 sky130_ef_sc_hd__decap_12
XTAP_1297 vssd1 vccd1 sky130_fd_sc_hd__tapvpwrvgnd_1
XTAP_1286 vssd1 vccd1 sky130_fd_sc_hd__tapvpwrvgnd_1
XFILLER_0_37_441 vssd1 vssd1 vccd1 vccd1 sky130_fd_sc_hd__decap_6
XFILLER_0_92_580 vssd1 vssd1 vccd1 vccd1 sky130_fd_sc_hd__fill_1
XFILLER_0_52_400 vssd1 vssd1 vccd1 vccd1 sky130_fd_sc_hd__fill_1
XFILLER_0_24_102 vssd1 vssd1 vccd1 vccd1 sky130_fd_sc_hd__fill_1
XFILLER_0_64_293 vssd1 vssd1 vccd1 vccd1 sky130_fd_sc_hd__decap_4
XFILLER_0_21_47 vssd1 vssd1 vccd1 vccd1 sky130_fd_sc_hd__decap_3
X_06610_ _00851_ _00983_ vssd1 vssd1 vccd1 vccd1 _00984_ sky130_fd_sc_hd__nand2_1
X_07590_ _01959_ _01960_ vssd1 vssd1 vccd1 vccd1 _01962_ sky130_fd_sc_hd__xor2_1
XFILLER_0_75_503 vssd1 vssd1 vccd1 vccd1 sky130_fd_sc_hd__fill_1
XFILLER_0_1_57 vssd1 vssd1 vccd1 vccd1 sky130_fd_sc_hd__fill_2
X_06541_ net512 _00915_ _00914_ vssd1 vssd1 vccd1 vccd1 _00916_ sky130_fd_sc_hd__a21bo_1
XFILLER_0_75_525 vssd1 vssd1 vccd1 vccd1 sky130_fd_sc_hd__fill_1
X_09260_ _03725_ _03726_ _03728_ vssd1 vssd1 vccd1 vccd1 _03729_ sky130_fd_sc_hd__and3_1
X_06472_ _00845_ _00846_ vssd1 vssd1 vccd1 vccd1 _00847_ sky130_fd_sc_hd__xnor2_1
X_08211_ _02580_ _02581_ _02484_ vssd1 vssd1 vccd1 vccd1 _02584_ sky130_fd_sc_hd__o21ai_2
X_05423_ _04689_ _04690_ _04681_ vssd1 vssd1 vccd1 vccd1 _04693_ sky130_fd_sc_hd__a21o_1
X_09191_ _03483_ _03486_ _03650_ vssd1 vssd1 vccd1 vccd1 _03654_ sky130_fd_sc_hd__and3_1
XFILLER_0_83_591 vssd1 vssd1 vccd1 vccd1 sky130_fd_sc_hd__fill_1
X_08142_ _02501_ _02502_ _02512_ vssd1 vssd1 vccd1 vccd1 _02514_ sky130_fd_sc_hd__or3_4
XFILLER_0_7_379 vssd1 vssd1 vccd1 vccd1 sky130_fd_sc_hd__fill_1
XFILLER_0_15_113 vssd1 vssd1 vccd1 vccd1 sky130_fd_sc_hd__fill_2
X_05354_ net385 net568 _04622_ _04620_ vssd1 vssd1 vccd1 vccd1 _04624_ sky130_fd_sc_hd__a31oi_2
X_08073_ _02290_ _02292_ vssd1 vssd1 vccd1 vccd1 _02445_ sky130_fd_sc_hd__nor2_1
X_05285_ _04553_ _04554_ vssd1 vssd1 vccd1 vccd1 _04555_ sky130_fd_sc_hd__nand2_1
XFILLER_0_43_455 vssd1 vssd1 vccd1 vccd1 sky130_ef_sc_hd__decap_12
X_07024_ _01255_ _01394_ vssd1 vssd1 vccd1 vccd1 _01395_ sky130_fd_sc_hd__or2_1
XFILLER_0_87_51 vssd1 vssd1 vccd1 vccd1 sky130_fd_sc_hd__fill_1
XFILLER_0_60_3 vssd1 vssd1 vccd1 vccd1 sky130_fd_sc_hd__decap_8
XFILLER_0_11_341 vssd1 vssd1 vccd1 vccd1 sky130_fd_sc_hd__fill_1
XFILLER_0_11_385 vssd1 vssd1 vccd1 vccd1 sky130_fd_sc_hd__decap_6
X_08975_ _03413_ _03414_ _03415_ vssd1 vssd1 vccd1 vccd1 _03417_ sky130_fd_sc_hd__a21oi_2
X_07926_ _02120_ _02129_ _02128_ vssd1 vssd1 vccd1 vccd1 _02299_ sky130_fd_sc_hd__a21o_1
X_07857_ net245 net502 vssd1 vssd1 vccd1 vccd1 _02230_ sky130_fd_sc_hd__nand2_1
X_07788_ _02114_ _02157_ vssd1 vssd1 vccd1 vccd1 _02159_ sky130_fd_sc_hd__xor2_1
X_06808_ net302 net496 vssd1 vssd1 vccd1 vccd1 _01181_ sky130_fd_sc_hd__nand2_1
X_09527_ _04017_ _04018_ vssd1 vssd1 vccd1 vccd1 _04020_ sky130_fd_sc_hd__xor2_1
X_06739_ _00974_ _00979_ _01111_ vssd1 vssd1 vccd1 vccd1 _01112_ sky130_fd_sc_hd__o21a_1
X_09458_ _03943_ net411 net248 _03941_ vssd1 vssd1 vccd1 vccd1 _03945_ sky130_fd_sc_hd__and4b_1
XFILLER_0_81_528 vssd1 vssd1 vccd1 vccd1 sky130_fd_sc_hd__decap_3
XFILLER_0_81_517 vssd1 vssd1 vccd1 vccd1 sky130_fd_sc_hd__fill_1
X_08409_ _02795_ _02796_ _02792_ vssd1 vssd1 vccd1 vccd1 _02799_ sky130_fd_sc_hd__a21o_1
X_09389_ _03718_ _03725_ vssd1 vssd1 vccd1 vccd1 _03870_ sky130_fd_sc_hd__nand2_1
XFILLER_0_61_296 vssd1 vssd1 vccd1 vccd1 sky130_fd_sc_hd__fill_2
XFILLER_0_89_606 vssd1 vssd1 vccd1 vccd1 sky130_fd_sc_hd__fill_1
X_10095_ clknet_3_4_0_wb_clk_i _00091_ _00027_ vssd1 vssd1 vccd1 vccd1 mul.b\[24\]
+ sky130_fd_sc_hd__dfrtp_2
XFILLER_0_69_330 vssd1 vssd1 vccd1 vccd1 sky130_fd_sc_hd__decap_6
XFILLER_0_16_69 vssd1 vssd1 vccd1 vccd1 sky130_fd_sc_hd__decap_4
XFILLER_0_57_514 vssd1 vssd1 vccd1 vccd1 sky130_ef_sc_hd__decap_12
XFILLER_0_84_333 vssd1 vssd1 vccd1 vccd1 sky130_ef_sc_hd__decap_12
XTAP_1083 vssd1 vccd1 sky130_fd_sc_hd__tapvpwrvgnd_1
XTAP_1072 vssd1 vccd1 sky130_fd_sc_hd__tapvpwrvgnd_1
XTAP_1061 vssd1 vccd1 sky130_fd_sc_hd__tapvpwrvgnd_1
XTAP_1050 vssd1 vccd1 sky130_fd_sc_hd__tapvpwrvgnd_1
XFILLER_0_84_388 vssd1 vssd1 vccd1 vccd1 sky130_fd_sc_hd__fill_2
XTAP_1094 vssd1 vccd1 sky130_fd_sc_hd__tapvpwrvgnd_1
XFILLER_0_25_400 vssd1 vssd1 vccd1 vccd1 sky130_fd_sc_hd__fill_2
XFILLER_0_44_208 vssd1 vssd1 vccd1 vccd1 sky130_fd_sc_hd__fill_1
XFILLER_0_25_433 vssd1 vssd1 vccd1 vccd1 sky130_fd_sc_hd__fill_1
XFILLER_0_25_444 vssd1 vssd1 vccd1 vccd1 sky130_fd_sc_hd__decap_4
XFILLER_0_40_403 vssd1 vssd1 vccd1 vccd1 sky130_fd_sc_hd__decap_3
X_05070_ net18 net453 net126 vssd1 vssd1 vccd1 vccd1 _00088_ sky130_fd_sc_hd__mux2_1
XFILLER_0_0_522 vssd1 vssd1 vccd1 vccd1 sky130_fd_sc_hd__decap_3
XFILLER_0_40_469 vssd1 vssd1 vccd1 vccd1 sky130_fd_sc_hd__decap_6
XTAP_801 vssd1 vccd1 sky130_fd_sc_hd__tapvpwrvgnd_1
XFILLER_0_0_533 vssd1 vssd1 vccd1 vccd1 sky130_ef_sc_hd__decap_12
XFILLER_0_57_21 vssd1 vssd1 vccd1 vccd1 sky130_fd_sc_hd__fill_1
XTAP_834 vssd1 vccd1 sky130_fd_sc_hd__tapvpwrvgnd_1
XTAP_823 vssd1 vccd1 sky130_fd_sc_hd__tapvpwrvgnd_1
XTAP_812 vssd1 vccd1 sky130_fd_sc_hd__tapvpwrvgnd_1
XFILLER_0_20_171 vssd1 vssd1 vccd1 vccd1 sky130_fd_sc_hd__decap_8
XTAP_867 vssd1 vccd1 sky130_fd_sc_hd__tapvpwrvgnd_1
XTAP_856 vssd1 vccd1 sky130_fd_sc_hd__tapvpwrvgnd_1
XTAP_845 vssd1 vccd1 sky130_fd_sc_hd__tapvpwrvgnd_1
XFILLER_0_57_87 vssd1 vssd1 vccd1 vccd1 sky130_fd_sc_hd__decap_3
X_08760_ _03179_ _03180_ _03176_ vssd1 vssd1 vccd1 vccd1 _03183_ sky130_fd_sc_hd__o21ai_1
XTAP_889 vssd1 vccd1 sky130_fd_sc_hd__tapvpwrvgnd_1
XTAP_878 vssd1 vccd1 sky130_fd_sc_hd__tapvpwrvgnd_1
X_05972_ _00333_ _00350_ _00351_ vssd1 vssd1 vccd1 vccd1 _00352_ sky130_fd_sc_hd__nor3_4
XFILLER_0_79_105 vssd1 vssd1 vccd1 vccd1 sky130_fd_sc_hd__decap_6
X_08691_ _03105_ _03106_ vssd1 vssd1 vccd1 vccd1 _03107_ sky130_fd_sc_hd__xor2_1
X_07711_ _02080_ _02081_ _02082_ vssd1 vssd1 vccd1 vccd1 _02083_ sky130_fd_sc_hd__nand3_4
X_07642_ _02012_ _02013_ vssd1 vssd1 vccd1 vccd1 _02014_ sky130_fd_sc_hd__nor2_1
XFILLER_0_73_97 vssd1 vssd1 vccd1 vccd1 sky130_fd_sc_hd__fill_1
X_09312_ _03775_ _03784_ vssd1 vssd1 vccd1 vccd1 _03786_ sky130_fd_sc_hd__and2_1
X_07573_ _01945_ _01944_ vssd1 vssd1 vccd1 vccd1 _01946_ sky130_fd_sc_hd__nand2_4
X_06524_ _00787_ _00789_ _00898_ vssd1 vssd1 vccd1 vccd1 _00899_ sky130_fd_sc_hd__a21oi_2
X_09243_ net427 net144 net130 net183 vssd1 vssd1 vccd1 vccd1 _03711_ sky130_fd_sc_hd__a22o_1
XFILLER_0_63_517 vssd1 vssd1 vccd1 vccd1 sky130_ef_sc_hd__decap_12
X_06455_ _00617_ _00620_ _00829_ _00830_ vssd1 vssd1 vccd1 vccd1 _00831_ sky130_fd_sc_hd__o211ai_2
X_09174_ net294 net396 _03632_ _03633_ vssd1 vssd1 vccd1 vccd1 _03635_ sky130_fd_sc_hd__nand4_2
XFILLER_0_16_433 vssd1 vssd1 vccd1 vccd1 sky130_ef_sc_hd__decap_12
X_06386_ _00656_ _00760_ vssd1 vssd1 vccd1 vccd1 _00762_ sky130_fd_sc_hd__or2_1
X_05406_ _04635_ _04636_ _04670_ _04673_ _04675_ vssd1 vssd1 vccd1 vccd1 _04676_ sky130_fd_sc_hd__o221a_1
X_08125_ _02495_ _02496_ vssd1 vssd1 vccd1 vccd1 _02497_ sky130_fd_sc_hd__xor2_1
XFILLER_0_7_176 vssd1 vssd1 vccd1 vccd1 sky130_fd_sc_hd__decap_3
XFILLER_0_16_477 vssd1 vssd1 vccd1 vccd1 sky130_fd_sc_hd__fill_2
X_05337_ _04565_ _04600_ _04606_ vssd1 vssd1 vccd1 vccd1 _04607_ sky130_fd_sc_hd__nand3_1
X_08056_ _02156_ _02158_ _02427_ _02428_ vssd1 vssd1 vccd1 vccd1 _02429_ sky130_fd_sc_hd__a211oi_4
X_05268_ _04459_ _04470_ _03203_ vssd1 vssd1 vccd1 vccd1 _04481_ sky130_fd_sc_hd__or3b_4
XFILLER_0_31_458 vssd1 vssd1 vccd1 vccd1 sky130_ef_sc_hd__decap_12
Xoutput49 net49 vssd1 vssd1 vccd1 vccd1 wbs_dat_o[18] sky130_fd_sc_hd__clkbuf_4
X_05199_ _03629_ _03640_ _03706_ vssd1 vssd1 vccd1 vccd1 _03727_ sky130_fd_sc_hd__nand3_1
X_07007_ _01233_ _01238_ _01377_ vssd1 vssd1 vccd1 vccd1 _01378_ sky130_fd_sc_hd__o21a_1
XFILLER_0_11_193 vssd1 vssd1 vccd1 vccd1 sky130_fd_sc_hd__decap_4
X_08958_ net140 _03396_ _03397_ _03398_ vssd1 vssd1 vccd1 vccd1 net55 sky130_fd_sc_hd__a31o_1
X_08889_ _03319_ _03321_ _03167_ _03169_ vssd1 vssd1 vccd1 vccd1 _03324_ sky130_fd_sc_hd__a211o_1
X_07909_ _02275_ _02282_ vssd1 vssd1 vccd1 vccd1 _02283_ sky130_fd_sc_hd__or2_1
XFILLER_0_39_503 vssd1 vssd1 vccd1 vccd1 sky130_fd_sc_hd__fill_1
XPHY_100 vssd1 vssd1 vccd1 vccd1 sky130_fd_sc_hd__decap_3
XPHY_133 vssd1 vssd1 vccd1 vccd1 sky130_fd_sc_hd__decap_3
XPHY_122 vssd1 vssd1 vccd1 vccd1 sky130_fd_sc_hd__decap_3
XPHY_111 vssd1 vssd1 vccd1 vccd1 sky130_fd_sc_hd__decap_3
XPHY_166 vssd1 vssd1 vccd1 vccd1 sky130_fd_sc_hd__decap_3
XPHY_155 vssd1 vssd1 vccd1 vccd1 sky130_fd_sc_hd__decap_3
XPHY_144 vssd1 vssd1 vccd1 vccd1 sky130_fd_sc_hd__decap_3
XFILLER_0_54_506 vssd1 vssd1 vccd1 vccd1 sky130_fd_sc_hd__fill_1
XFILLER_0_26_219 vssd1 vssd1 vccd1 vccd1 sky130_fd_sc_hd__fill_1
XPHY_199 vssd1 vssd1 vccd1 vccd1 sky130_fd_sc_hd__decap_3
XPHY_188 vssd1 vssd1 vccd1 vccd1 sky130_fd_sc_hd__decap_3
XPHY_177 vssd1 vssd1 vccd1 vccd1 sky130_fd_sc_hd__decap_3
XFILLER_0_100_390 vssd1 vssd1 vccd1 vccd1 sky130_fd_sc_hd__fill_2
XFILLER_0_27_57 vssd1 vssd1 vccd1 vccd1 sky130_fd_sc_hd__fill_1
X_10078_ clknet_3_0_0_wb_clk_i _00074_ _00010_ vssd1 vssd1 vccd1 vccd1 mul.b\[7\]
+ sky130_fd_sc_hd__dfrtp_4
XFILLER_0_89_469 vssd1 vssd1 vccd1 vccd1 sky130_fd_sc_hd__decap_8
Xmax_cap91 _03040_ vssd1 vssd1 vccd1 vccd1 net91 sky130_fd_sc_hd__clkbuf_1
XPHY_2 vssd1 vssd1 vccd1 vccd1 sky130_fd_sc_hd__decap_3
XFILLER_0_43_34 vssd1 vssd1 vccd1 vccd1 sky130_fd_sc_hd__decap_8
Xmax_cap80 _01777_ vssd1 vssd1 vccd1 vccd1 net80 sky130_fd_sc_hd__buf_1
XFILLER_0_57_344 vssd1 vssd1 vccd1 vccd1 sky130_fd_sc_hd__decap_4
XFILLER_0_84_141 vssd1 vssd1 vccd1 vccd1 sky130_fd_sc_hd__decap_4
XFILLER_0_72_303 vssd1 vssd1 vccd1 vccd1 sky130_fd_sc_hd__decap_4
XFILLER_0_57_366 vssd1 vssd1 vccd1 vccd1 sky130_fd_sc_hd__decap_4
XFILLER_0_84_185 vssd1 vssd1 vccd1 vccd1 sky130_fd_sc_hd__decap_8
X_06240_ _00509_ _00514_ _00616_ vssd1 vssd1 vccd1 vccd1 _00617_ sky130_fd_sc_hd__o21a_1
XFILLER_0_53_561 vssd1 vssd1 vccd1 vccd1 sky130_fd_sc_hd__fill_1
XFILLER_0_53_550 vssd1 vssd1 vccd1 vccd1 sky130_fd_sc_hd__decap_8
X_06171_ _00539_ _00547_ vssd1 vssd1 vccd1 vccd1 _00549_ sky130_fd_sc_hd__xor2_1
X_05122_ net319 net622 net630 net310 vssd1 vssd1 vccd1 vccd1 _02886_ sky130_fd_sc_hd__a22oi_1
XFILLER_0_4_179 vssd1 vssd1 vccd1 vccd1 sky130_fd_sc_hd__fill_2
X_09930_ _04367_ _04368_ _04366_ vssd1 vssd1 vccd1 vccd1 _04461_ sky130_fd_sc_hd__o21ai_1
X_05053_ net30 net368 net132 vssd1 vssd1 vccd1 vccd1 _00102_ sky130_fd_sc_hd__mux2_1
XFILLER_0_40_277 vssd1 vssd1 vccd1 vccd1 sky130_fd_sc_hd__fill_2
XFILLER_0_0_363 vssd1 vssd1 vccd1 vccd1 sky130_fd_sc_hd__fill_1
XTAP_620 vssd1 vccd1 sky130_fd_sc_hd__tapvpwrvgnd_1
XTAP_631 vssd1 vccd1 sky130_fd_sc_hd__tapvpwrvgnd_1
XTAP_642 vssd1 vccd1 sky130_fd_sc_hd__tapvpwrvgnd_1
X_09861_ _04384_ _04385_ vssd1 vssd1 vccd1 vccd1 _04386_ sky130_fd_sc_hd__and2b_1
X_09792_ _04308_ _04309_ _04310_ vssd1 vssd1 vccd1 vccd1 net61 sky130_fd_sc_hd__a21o_1
X_08812_ _03238_ _03239_ vssd1 vssd1 vccd1 vccd1 _03240_ sky130_fd_sc_hd__xor2_2
XTAP_664 vssd1 vccd1 sky130_fd_sc_hd__tapvpwrvgnd_1
XTAP_653 vssd1 vccd1 sky130_fd_sc_hd__tapvpwrvgnd_1
XTAP_675 vssd1 vccd1 sky130_fd_sc_hd__tapvpwrvgnd_1
XTAP_686 vssd1 vccd1 sky130_fd_sc_hd__tapvpwrvgnd_1
X_08743_ net147 net569 vssd1 vssd1 vccd1 vccd1 _03164_ sky130_fd_sc_hd__nand2_8
X_05955_ net356 net503 net511 net347 vssd1 vssd1 vccd1 vccd1 _00335_ sky130_fd_sc_hd__a22oi_2
XTAP_697 vssd1 vccd1 sky130_fd_sc_hd__tapvpwrvgnd_1
XFILLER_0_84_85 vssd1 vssd1 vccd1 vccd1 sky130_fd_sc_hd__decap_8
XFILLER_0_23_3 vssd1 vssd1 vccd1 vccd1 sky130_fd_sc_hd__decap_6
X_08674_ _03087_ _03088_ vssd1 vssd1 vccd1 vccd1 _03089_ sky130_fd_sc_hd__and2b_1
X_05886_ _00222_ _00223_ _00265_ _00266_ vssd1 vssd1 vccd1 vccd1 _00267_ sky130_fd_sc_hd__nor4_2
X_07625_ _01828_ _01830_ _01995_ _01996_ vssd1 vssd1 vccd1 vccd1 _01997_ sky130_fd_sc_hd__a211oi_4
X_07556_ _01925_ _01927_ net677 net656 vssd1 vssd1 vccd1 vccd1 _01929_ sky130_fd_sc_hd__o211a_1
XFILLER_0_48_322 vssd1 vssd1 vccd1 vccd1 sky130_ef_sc_hd__decap_12
X_06507_ net252 net262 net560 net571 vssd1 vssd1 vccd1 vccd1 _00882_ sky130_fd_sc_hd__and4_1
X_09226_ _03665_ _03667_ _03689_ _03690_ vssd1 vssd1 vccd1 vccd1 _03692_ sky130_fd_sc_hd__o22ai_1
XFILLER_0_91_623 vssd1 vssd1 vccd1 vccd1 sky130_fd_sc_hd__fill_2
X_07487_ _01855_ _01856_ _01852_ vssd1 vssd1 vccd1 vccd1 _01858_ sky130_fd_sc_hd__a21o_1
XFILLER_0_90_166 vssd1 vssd1 vccd1 vccd1 sky130_fd_sc_hd__fill_2
XFILLER_0_8_474 vssd1 vssd1 vccd1 vccd1 sky130_fd_sc_hd__fill_2
X_06438_ _00779_ _00812_ _00813_ vssd1 vssd1 vccd1 vccd1 _00814_ sky130_fd_sc_hd__nor3_4
X_09157_ _03605_ _03614_ vssd1 vssd1 vccd1 vccd1 _03616_ sky130_fd_sc_hd__xor2_1
X_06369_ _00742_ _00743_ vssd1 vssd1 vccd1 vccd1 _00745_ sky130_fd_sc_hd__xor2_1
X_09088_ _03537_ _03538_ _03539_ vssd1 vssd1 vccd1 vccd1 _03541_ sky130_fd_sc_hd__a21oi_1
X_08108_ _02460_ _02479_ vssd1 vssd1 vccd1 vccd1 _02480_ sky130_fd_sc_hd__xor2_2
X_08039_ _02409_ _02410_ _02396_ vssd1 vssd1 vccd1 vccd1 _02412_ sky130_fd_sc_hd__a21oi_1
XFILLER_0_31_288 vssd1 vssd1 vccd1 vccd1 sky130_ef_sc_hd__decap_12
X_10001_ _04516_ _04538_ vssd1 vssd1 vccd1 vccd1 _04539_ sky130_fd_sc_hd__xnor2_4
XFILLER_0_98_233 vssd1 vssd1 vccd1 vccd1 sky130_fd_sc_hd__decap_8
XFILLER_0_39_344 vssd1 vssd1 vccd1 vccd1 sky130_fd_sc_hd__fill_1
XFILLER_0_66_141 vssd1 vssd1 vccd1 vccd1 sky130_fd_sc_hd__decap_3
XFILLER_0_27_517 vssd1 vssd1 vccd1 vccd1 sky130_fd_sc_hd__decap_8
XFILLER_0_27_528 vssd1 vssd1 vccd1 vccd1 sky130_fd_sc_hd__decap_8
XFILLER_0_54_369 vssd1 vssd1 vccd1 vccd1 sky130_fd_sc_hd__fill_1
XFILLER_0_54_358 vssd1 vssd1 vccd1 vccd1 sky130_fd_sc_hd__decap_6
XFILLER_0_22_222 vssd1 vssd1 vccd1 vccd1 sky130_fd_sc_hd__decap_3
XFILLER_0_89_200 vssd1 vssd1 vccd1 vccd1 sky130_fd_sc_hd__fill_2
XFILLER_0_89_255 vssd1 vssd1 vccd1 vccd1 sky130_fd_sc_hd__fill_1
X_05740_ _04899_ _05008_ vssd1 vssd1 vccd1 vccd1 _05010_ sky130_fd_sc_hd__xnor2_1
XFILLER_0_89_266 vssd1 vssd1 vccd1 vccd1 sky130_fd_sc_hd__decap_3
X_05671_ _04938_ _04939_ _04940_ vssd1 vssd1 vccd1 vccd1 _04941_ sky130_fd_sc_hd__nand3_1
X_08390_ _02605_ _02608_ _02774_ _02777_ vssd1 vssd1 vccd1 vccd1 _02778_ sky130_fd_sc_hd__o211ai_2
X_07410_ _01689_ _01690_ _01775_ _01776_ vssd1 vssd1 vccd1 vccd1 _01779_ sky130_fd_sc_hd__o22ai_2
XFILLER_0_70_32 vssd1 vssd1 vccd1 vccd1 sky130_fd_sc_hd__fill_2
X_07341_ _01695_ _01696_ _01707_ _01708_ vssd1 vssd1 vccd1 vccd1 _01710_ sky130_fd_sc_hd__a22o_1
XFILLER_0_73_623 vssd1 vssd1 vccd1 vccd1 sky130_fd_sc_hd__fill_2
XFILLER_0_72_111 vssd1 vssd1 vccd1 vccd1 sky130_fd_sc_hd__fill_1
XFILLER_0_57_196 vssd1 vssd1 vccd1 vccd1 sky130_fd_sc_hd__fill_1
XFILLER_0_57_185 vssd1 vssd1 vccd1 vccd1 sky130_fd_sc_hd__fill_1
XFILLER_0_18_539 vssd1 vssd1 vccd1 vccd1 sky130_fd_sc_hd__fill_1
XFILLER_0_45_325 vssd1 vssd1 vccd1 vccd1 sky130_fd_sc_hd__fill_1
X_07272_ _01638_ _01639_ _01483_ _01485_ vssd1 vssd1 vccd1 vccd1 _01642_ sky130_fd_sc_hd__a211oi_1
X_09011_ _03452_ _03453_ _03295_ _03297_ vssd1 vssd1 vccd1 vccd1 _03457_ sky130_fd_sc_hd__o211ai_4
X_06223_ _00596_ _00598_ net74 vssd1 vssd1 vccd1 vccd1 _00601_ sky130_fd_sc_hd__or3_1
XFILLER_0_79_41 vssd1 vssd1 vccd1 vccd1 sky130_fd_sc_hd__fill_1
XFILLER_0_5_477 vssd1 vssd1 vccd1 vccd1 sky130_fd_sc_hd__fill_1
X_06154_ _00530_ _00531_ vssd1 vssd1 vccd1 vccd1 _00532_ sky130_fd_sc_hd__nand2_1
X_05105_ net335 net344 net594 net604 vssd1 vssd1 vccd1 vccd1 _02700_ sky130_fd_sc_hd__nand4_2
XFILLER_0_13_266 vssd1 vssd1 vccd1 vccd1 sky130_fd_sc_hd__decap_8
XFILLER_0_41_575 vssd1 vssd1 vccd1 vccd1 sky130_fd_sc_hd__fill_1
X_06085_ _00359_ net674 net95 _00463_ vssd1 vssd1 vccd1 vccd1 _00464_ sky130_fd_sc_hd__a211oi_4
X_09913_ _04442_ _04440_ vssd1 vssd1 vccd1 vccd1 _04443_ sky130_fd_sc_hd__and2_4
X_05036_ net17 net221 net134 vssd1 vssd1 vccd1 vccd1 _00119_ sky130_fd_sc_hd__mux2_1
Xfanout614 mul.b\[2\] vssd1 vssd1 vccd1 vccd1 net614 sky130_fd_sc_hd__clkbuf_4
Xfanout603 mul.b\[4\] vssd1 vssd1 vccd1 vccd1 net603 sky130_fd_sc_hd__clkbuf_2
X_09844_ _04365_ _04366_ vssd1 vssd1 vccd1 vccd1 _04367_ sky130_fd_sc_hd__nand2_1
Xfanout625 net626 vssd1 vssd1 vccd1 vccd1 net625 sky130_fd_sc_hd__clkbuf_4
XTAP_450 vssd1 vccd1 sky130_fd_sc_hd__tapvpwrvgnd_1
Xfanout636 net637 vssd1 vssd1 vccd1 vccd1 net636 sky130_fd_sc_hd__clkbuf_4
XTAP_461 vssd1 vccd1 sky130_fd_sc_hd__tapvpwrvgnd_1
XTAP_472 vssd1 vccd1 sky130_fd_sc_hd__tapvpwrvgnd_1
XTAP_483 vssd1 vccd1 sky130_fd_sc_hd__tapvpwrvgnd_1
XTAP_494 vssd1 vccd1 sky130_fd_sc_hd__tapvpwrvgnd_1
X_09775_ _04117_ _04138_ _04116_ vssd1 vssd1 vccd1 vccd1 _04292_ sky130_fd_sc_hd__o21a_1
X_06987_ _00966_ _01095_ _01220_ _01358_ vssd1 vssd1 vccd1 vccd1 _01359_ sky130_fd_sc_hd__a31o_1
X_08726_ _03135_ _03144_ vssd1 vssd1 vccd1 vccd1 _03145_ sky130_fd_sc_hd__or2_2
X_05938_ _00212_ _00316_ vssd1 vssd1 vccd1 vccd1 _00318_ sky130_fd_sc_hd__xnor2_1
X_08657_ _03045_ _03069_ vssd1 vssd1 vccd1 vccd1 _03070_ sky130_fd_sc_hd__xnor2_1
X_05869_ _00247_ _00248_ _00249_ vssd1 vssd1 vccd1 vccd1 _00250_ sky130_fd_sc_hd__nand3_2
XFILLER_0_95_247 vssd1 vssd1 vccd1 vccd1 sky130_ef_sc_hd__decap_12
XFILLER_0_95_225 vssd1 vssd1 vccd1 vccd1 sky130_fd_sc_hd__fill_1
X_07608_ net181 net189 net573 net583 vssd1 vssd1 vccd1 vccd1 _01980_ sky130_fd_sc_hd__nand4_2
X_08588_ _02992_ _02993_ vssd1 vssd1 vccd1 vccd1 _02994_ sky130_fd_sc_hd__nor2_1
XFILLER_0_48_141 vssd1 vssd1 vccd1 vccd1 sky130_ef_sc_hd__decap_12
X_07539_ _01908_ _01909_ _01910_ vssd1 vssd1 vccd1 vccd1 _01912_ sky130_fd_sc_hd__nand3_1
XFILLER_0_36_336 vssd1 vssd1 vccd1 vccd1 sky130_fd_sc_hd__fill_1
XFILLER_0_48_163 vssd1 vssd1 vccd1 vccd1 sky130_fd_sc_hd__fill_1
XFILLER_0_36_347 vssd1 vssd1 vccd1 vccd1 sky130_fd_sc_hd__decap_4
X_09209_ _03513_ _03671_ vssd1 vssd1 vccd1 vccd1 _03674_ sky130_fd_sc_hd__xnor2_1
XFILLER_0_8_293 vssd1 vssd1 vccd1 vccd1 sky130_fd_sc_hd__fill_2
XFILLER_0_17_561 vssd1 vssd1 vccd1 vccd1 sky130_ef_sc_hd__decap_12
XFILLER_0_32_586 vssd1 vssd1 vccd1 vccd1 sky130_fd_sc_hd__fill_2
XFILLER_0_86_203 vssd1 vssd1 vccd1 vccd1 sky130_ef_sc_hd__decap_12
XFILLER_0_24_14 vssd1 vssd1 vccd1 vccd1 sky130_ef_sc_hd__decap_12
XFILLER_0_67_483 vssd1 vssd1 vccd1 vccd1 sky130_fd_sc_hd__fill_1
XFILLER_0_55_623 vssd1 vssd1 vccd1 vccd1 sky130_fd_sc_hd__fill_2
XFILLER_0_54_122 vssd1 vssd1 vccd1 vccd1 sky130_fd_sc_hd__fill_2
XFILLER_0_15_509 vssd1 vssd1 vccd1 vccd1 sky130_ef_sc_hd__decap_12
XFILLER_0_82_475 vssd1 vssd1 vccd1 vccd1 sky130_fd_sc_hd__fill_1
XFILLER_0_40_46 vssd1 vssd1 vccd1 vccd1 sky130_fd_sc_hd__decap_4
XFILLER_0_40_57 vssd1 vssd1 vccd1 vccd1 sky130_ef_sc_hd__decap_12
XFILLER_0_23_531 vssd1 vssd1 vccd1 vccd1 sky130_ef_sc_hd__decap_12
XFILLER_0_40_79 vssd1 vssd1 vccd1 vccd1 sky130_fd_sc_hd__decap_4
XFILLER_0_50_361 vssd1 vssd1 vccd1 vccd1 sky130_fd_sc_hd__decap_3
XFILLER_0_50_372 vssd1 vssd1 vccd1 vccd1 sky130_fd_sc_hd__decap_4
XFILLER_0_10_214 vssd1 vssd1 vccd1 vccd1 sky130_fd_sc_hd__decap_8
X_06910_ _01160_ _01162_ vssd1 vssd1 vccd1 vccd1 _01282_ sky130_fd_sc_hd__nand2_1
X_07890_ _02261_ _02262_ _02159_ vssd1 vssd1 vccd1 vccd1 _02264_ sky130_fd_sc_hd__o21a_1
X_06841_ _01083_ _01085_ _01212_ _01213_ vssd1 vssd1 vccd1 vccd1 _01214_ sky130_fd_sc_hd__a211oi_4
X_06772_ _01136_ _01144_ vssd1 vssd1 vccd1 vccd1 _01145_ sky130_fd_sc_hd__and2b_1
X_09560_ _04054_ _04056_ vssd1 vssd1 vccd1 vccd1 _04057_ sky130_fd_sc_hd__nand2b_1
X_09491_ _03818_ _03821_ vssd1 vssd1 vccd1 vccd1 _03982_ sky130_fd_sc_hd__nand2_2
X_08511_ _02874_ _02876_ _02907_ vssd1 vssd1 vccd1 vccd1 _02911_ sky130_fd_sc_hd__o21ai_2
X_05723_ net281 net289 net598 net607 vssd1 vssd1 vccd1 vccd1 _04993_ sky130_fd_sc_hd__and4_1
X_08442_ net164 net566 vssd1 vssd1 vccd1 vccd1 _02835_ sky130_fd_sc_hd__nand2_1
XFILLER_0_81_75 vssd1 vssd1 vccd1 vccd1 sky130_fd_sc_hd__decap_3
X_05654_ _04866_ _04869_ _04923_ vssd1 vssd1 vccd1 vccd1 _04924_ sky130_fd_sc_hd__o21ai_2
X_08373_ _02457_ _02459_ _02758_ _02759_ vssd1 vssd1 vccd1 vccd1 _02760_ sky130_fd_sc_hd__a211oi_2
X_05585_ _04845_ _04853_ vssd1 vssd1 vccd1 vccd1 _04855_ sky130_fd_sc_hd__xnor2_2
XFILLER_0_46_623 vssd1 vssd1 vccd1 vccd1 sky130_fd_sc_hd__fill_2
X_07324_ net210 net564 net572 net203 vssd1 vssd1 vccd1 vccd1 _01693_ sky130_fd_sc_hd__a22oi_4
XFILLER_0_90_3 vssd1 vssd1 vccd1 vccd1 sky130_fd_sc_hd__decap_6
X_07255_ _01470_ net721 net100 _01624_ vssd1 vssd1 vccd1 vccd1 _01625_ sky130_fd_sc_hd__a211oi_2
X_06206_ _00525_ _00526_ _00581_ _00582_ vssd1 vssd1 vccd1 vccd1 _00584_ sky130_fd_sc_hd__a2bb2o_1
X_07186_ _01550_ _01555_ vssd1 vssd1 vccd1 vccd1 _01556_ sky130_fd_sc_hd__or2_1
XFILLER_0_14_564 vssd1 vssd1 vccd1 vccd1 sky130_ef_sc_hd__decap_12
X_06137_ _00510_ _00513_ vssd1 vssd1 vccd1 vccd1 _00515_ sky130_fd_sc_hd__xnor2_1
X_06068_ _00444_ _00445_ _00446_ vssd1 vssd1 vccd1 vccd1 _00447_ sky130_fd_sc_hd__nand3_1
Xfanout400 net401 vssd1 vssd1 vccd1 vccd1 net400 sky130_fd_sc_hd__clkbuf_4
Xfanout411 net412 vssd1 vssd1 vccd1 vccd1 net411 sky130_fd_sc_hd__clkbuf_4
X_05019_ net257 vssd1 vssd1 vccd1 vccd1 _01827_ sky130_fd_sc_hd__inv_2
Xfanout422 net425 vssd1 vssd1 vccd1 vccd1 net422 sky130_fd_sc_hd__clkbuf_4
Xfanout444 mul.b\[22\] vssd1 vssd1 vccd1 vccd1 net444 sky130_fd_sc_hd__buf_2
Xfanout433 mul.b\[24\] vssd1 vssd1 vccd1 vccd1 net433 sky130_fd_sc_hd__clkbuf_4
Xfanout466 net467 vssd1 vssd1 vccd1 vccd1 net466 sky130_fd_sc_hd__buf_4
Xfanout455 net456 vssd1 vssd1 vccd1 vccd1 net455 sky130_fd_sc_hd__clkbuf_2
Xfanout499 net501 vssd1 vssd1 vccd1 vccd1 net499 sky130_fd_sc_hd__clkbuf_4
XTAP_291 vssd1 vccd1 sky130_fd_sc_hd__tapvpwrvgnd_1
XTAP_280 vssd1 vccd1 sky130_fd_sc_hd__tapvpwrvgnd_1
Xfanout488 net494 vssd1 vssd1 vccd1 vccd1 net488 sky130_fd_sc_hd__clkbuf_4
X_09827_ _04340_ _04347_ vssd1 vssd1 vccd1 vccd1 _04348_ sky130_fd_sc_hd__nor2_1
Xfanout477 net478 vssd1 vssd1 vccd1 vccd1 net477 sky130_fd_sc_hd__clkbuf_4
X_09758_ _03669_ _04272_ vssd1 vssd1 vccd1 vccd1 _04273_ sky130_fd_sc_hd__xnor2_1
X_08709_ _03111_ _03112_ _03124_ vssd1 vssd1 vccd1 vccd1 _03127_ sky130_fd_sc_hd__or3_4
X_09689_ net209 net428 _04194_ _04196_ vssd1 vssd1 vccd1 vccd1 _04198_ sky130_fd_sc_hd__a22oi_1
XFILLER_0_76_280 vssd1 vssd1 vccd1 vccd1 sky130_fd_sc_hd__decap_3
XFILLER_0_101_29 vssd1 vssd1 vccd1 vccd1 sky130_ef_sc_hd__decap_12
XFILLER_0_17_391 vssd1 vssd1 vccd1 vccd1 sky130_fd_sc_hd__fill_1
XFILLER_0_51_169 vssd1 vssd1 vccd1 vccd1 sky130_fd_sc_hd__decap_4
XFILLER_0_32_361 vssd1 vssd1 vccd1 vccd1 sky130_fd_sc_hd__decap_3
XFILLER_0_19_25 vssd1 vssd1 vccd1 vccd1 sky130_fd_sc_hd__decap_6
XFILLER_0_20_589 vssd1 vssd1 vccd1 vccd1 sky130_fd_sc_hd__fill_1
XFILLER_0_99_350 vssd1 vssd1 vccd1 vccd1 sky130_ef_sc_hd__decap_12
XFILLER_0_35_57 vssd1 vssd1 vccd1 vccd1 sky130_fd_sc_hd__decap_8
XFILLER_0_51_23 vssd1 vssd1 vccd1 vccd1 sky130_fd_sc_hd__decap_3
XFILLER_0_27_111 vssd1 vssd1 vccd1 vccd1 sky130_fd_sc_hd__fill_1
XFILLER_0_27_144 vssd1 vssd1 vccd1 vccd1 sky130_fd_sc_hd__decap_6
X_05370_ _04603_ _04605_ vssd1 vssd1 vccd1 vccd1 _04640_ sky130_fd_sc_hd__xnor2_1
XFILLER_0_43_615 vssd1 vssd1 vccd1 vccd1 sky130_fd_sc_hd__fill_1
XFILLER_0_42_114 vssd1 vssd1 vccd1 vccd1 sky130_fd_sc_hd__decap_4
XFILLER_0_30_309 vssd1 vssd1 vccd1 vccd1 sky130_fd_sc_hd__fill_1
X_07040_ _01285_ _01287_ _01408_ _01409_ vssd1 vssd1 vccd1 vccd1 _01411_ sky130_fd_sc_hd__a211o_1
XFILLER_0_2_233 vssd1 vssd1 vccd1 vccd1 sky130_ef_sc_hd__decap_12
XFILLER_0_11_567 vssd1 vssd1 vccd1 vccd1 sky130_fd_sc_hd__decap_3
X_08991_ _03431_ _03433_ _03263_ _03277_ vssd1 vssd1 vccd1 vccd1 _03435_ sky130_fd_sc_hd__a211o_1
X_07942_ _02305_ _02314_ vssd1 vssd1 vccd1 vccd1 _02315_ sky130_fd_sc_hd__xor2_1
XFILLER_0_76_97 vssd1 vssd1 vccd1 vccd1 sky130_ef_sc_hd__decap_12
X_07873_ _02238_ _02246_ vssd1 vssd1 vccd1 vccd1 _02247_ sky130_fd_sc_hd__xnor2_1
X_09612_ _04069_ _04112_ vssd1 vssd1 vccd1 vccd1 _04114_ sky130_fd_sc_hd__xnor2_2
X_06824_ _01194_ _01195_ _01177_ vssd1 vssd1 vccd1 vccd1 _01197_ sky130_fd_sc_hd__o21a_1
X_09543_ _03871_ _03886_ _04035_ _04036_ vssd1 vssd1 vccd1 vccd1 _04038_ sky130_fd_sc_hd__o211a_1
XFILLER_0_92_85 vssd1 vssd1 vccd1 vccd1 sky130_ef_sc_hd__decap_12
X_06755_ _01126_ _01127_ vssd1 vssd1 vccd1 vccd1 _01128_ sky130_fd_sc_hd__nand2_1
X_09474_ _03770_ _03808_ vssd1 vssd1 vccd1 vccd1 _03963_ sky130_fd_sc_hd__nand2b_2
XFILLER_0_78_578 vssd1 vssd1 vccd1 vccd1 sky130_fd_sc_hd__fill_2
X_05706_ _04844_ _04912_ _04910_ vssd1 vssd1 vccd1 vccd1 _04976_ sky130_fd_sc_hd__a21oi_1
X_06686_ _01056_ _01057_ _01058_ vssd1 vssd1 vccd1 vccd1 _01060_ sky130_fd_sc_hd__a21o_1
XFILLER_0_93_537 vssd1 vssd1 vccd1 vccd1 sky130_ef_sc_hd__decap_12
X_08425_ net264 net450 _02814_ _02815_ vssd1 vssd1 vccd1 vccd1 _02816_ sky130_fd_sc_hd__a22o_1
X_05637_ _04905_ _04906_ vssd1 vssd1 vccd1 vccd1 _04907_ sky130_fd_sc_hd__and2_1
XFILLER_0_93_559 vssd1 vssd1 vccd1 vccd1 sky130_fd_sc_hd__fill_1
X_08356_ _02725_ _02740_ vssd1 vssd1 vccd1 vccd1 _02741_ sky130_fd_sc_hd__xnor2_2
X_05568_ _04764_ _04837_ vssd1 vssd1 vccd1 vccd1 _04838_ sky130_fd_sc_hd__xnor2_2
X_07307_ _01675_ _01669_ vssd1 vssd1 vccd1 vccd1 _01676_ sky130_fd_sc_hd__nand2b_1
X_08287_ _02662_ _02663_ _02516_ net646 vssd1 vssd1 vccd1 vccd1 _02665_ sky130_fd_sc_hd__a211oi_2
X_05499_ _04682_ _04688_ _04687_ vssd1 vssd1 vccd1 vccd1 _04769_ sky130_fd_sc_hd__a21boi_1
XFILLER_0_6_561 vssd1 vssd1 vccd1 vccd1 sky130_fd_sc_hd__fill_1
X_07238_ _01605_ _01606_ net664 vssd1 vssd1 vccd1 vccd1 _01608_ sky130_fd_sc_hd__nand3_1
XFILLER_0_21_309 vssd1 vssd1 vccd1 vccd1 sky130_fd_sc_hd__decap_8
X_07169_ _01503_ _01537_ vssd1 vssd1 vccd1 vccd1 _01539_ sky130_fd_sc_hd__xnor2_1
Xfanout230 net233 vssd1 vssd1 vccd1 vccd1 net230 sky130_fd_sc_hd__clkbuf_4
Xfanout241 net242 vssd1 vssd1 vccd1 vccd1 net241 sky130_fd_sc_hd__buf_4
Xfanout274 net275 vssd1 vssd1 vccd1 vccd1 net274 sky130_fd_sc_hd__clkbuf_4
Xfanout252 net256 vssd1 vssd1 vccd1 vccd1 net252 sky130_fd_sc_hd__buf_4
Xfanout263 net266 vssd1 vssd1 vccd1 vccd1 net263 sky130_fd_sc_hd__clkbuf_4
Xfanout285 net286 vssd1 vssd1 vccd1 vccd1 net285 sky130_fd_sc_hd__buf_4
Xfanout296 mul.a\[11\] vssd1 vssd1 vccd1 vccd1 net296 sky130_fd_sc_hd__clkbuf_4
XFILLER_0_69_545 vssd1 vssd1 vccd1 vccd1 sky130_fd_sc_hd__decap_3
XTAP_1232 vssd1 vccd1 sky130_fd_sc_hd__tapvpwrvgnd_1
XTAP_1221 vssd1 vccd1 sky130_fd_sc_hd__tapvpwrvgnd_1
XTAP_1210 vssd1 vccd1 sky130_fd_sc_hd__tapvpwrvgnd_1
XTAP_1265 vssd1 vccd1 sky130_fd_sc_hd__tapvpwrvgnd_1
XTAP_1254 vssd1 vccd1 sky130_fd_sc_hd__tapvpwrvgnd_1
XTAP_1243 vssd1 vccd1 sky130_fd_sc_hd__tapvpwrvgnd_1
XFILLER_0_84_537 vssd1 vssd1 vccd1 vccd1 sky130_fd_sc_hd__fill_2
XFILLER_0_56_228 vssd1 vssd1 vccd1 vccd1 sky130_ef_sc_hd__decap_12
XTAP_1298 vssd1 vccd1 sky130_fd_sc_hd__tapvpwrvgnd_1
XTAP_1287 vssd1 vccd1 sky130_fd_sc_hd__tapvpwrvgnd_1
XTAP_1276 vssd1 vccd1 sky130_fd_sc_hd__tapvpwrvgnd_1
XFILLER_0_21_15 vssd1 vssd1 vccd1 vccd1 sky130_ef_sc_hd__decap_12
XFILLER_0_37_475 vssd1 vssd1 vccd1 vccd1 sky130_ef_sc_hd__decap_12
XFILLER_0_99_191 vssd1 vssd1 vccd1 vccd1 sky130_fd_sc_hd__fill_1
XFILLER_0_62_33 vssd1 vssd1 vccd1 vccd1 sky130_ef_sc_hd__decap_12
XFILLER_0_62_22 vssd1 vssd1 vccd1 vccd1 sky130_fd_sc_hd__decap_6
X_06540_ net302 net311 net504 vssd1 vssd1 vccd1 vccd1 _00915_ sky130_fd_sc_hd__and3_1
X_06471_ net211 net617 vssd1 vssd1 vccd1 vccd1 _00846_ sky130_fd_sc_hd__nand2_1
XFILLER_0_75_559 vssd1 vssd1 vccd1 vccd1 sky130_fd_sc_hd__fill_1
X_08210_ _02484_ _02580_ _02581_ vssd1 vssd1 vccd1 vccd1 _02583_ sky130_fd_sc_hd__or3_4
X_05422_ _04681_ _04689_ _04690_ vssd1 vssd1 vccd1 vccd1 _04692_ sky130_fd_sc_hd__nand3_1
XFILLER_0_28_431 vssd1 vssd1 vccd1 vccd1 sky130_fd_sc_hd__fill_1
X_09190_ _03483_ _03486_ _03650_ vssd1 vssd1 vccd1 vccd1 _03653_ sky130_fd_sc_hd__a21o_1
X_08141_ _02501_ _02502_ _02512_ vssd1 vssd1 vccd1 vccd1 _02513_ sky130_fd_sc_hd__nor3_1
XFILLER_0_55_272 vssd1 vssd1 vccd1 vccd1 sky130_fd_sc_hd__fill_1
XFILLER_0_15_103 vssd1 vssd1 vccd1 vccd1 sky130_fd_sc_hd__decap_8
X_05353_ _04620_ _04622_ vssd1 vssd1 vccd1 vccd1 _04623_ sky130_fd_sc_hd__and2b_1
X_08072_ _02359_ _02361_ vssd1 vssd1 vccd1 vccd1 _02444_ sky130_fd_sc_hd__nor2_1
XFILLER_0_70_253 vssd1 vssd1 vccd1 vccd1 sky130_fd_sc_hd__decap_6
X_05284_ _04548_ _04552_ _04033_ vssd1 vssd1 vccd1 vccd1 _04554_ sky130_fd_sc_hd__o21ai_1
XFILLER_0_15_169 vssd1 vssd1 vccd1 vccd1 sky130_ef_sc_hd__decap_12
XFILLER_0_43_467 vssd1 vssd1 vccd1 vccd1 sky130_ef_sc_hd__decap_12
XFILLER_0_11_81 vssd1 vssd1 vccd1 vccd1 sky130_fd_sc_hd__decap_8
XFILLER_0_30_128 vssd1 vssd1 vccd1 vccd1 sky130_fd_sc_hd__fill_1
X_07023_ _01392_ _01393_ vssd1 vssd1 vccd1 vccd1 _01394_ sky130_fd_sc_hd__nand2_1
XFILLER_0_101_539 vssd1 vssd1 vccd1 vccd1 sky130_fd_sc_hd__fill_1
X_08974_ _03413_ _03414_ _03415_ vssd1 vssd1 vccd1 vccd1 _03416_ sky130_fd_sc_hd__and3_2
X_07925_ _02296_ _02297_ vssd1 vssd1 vccd1 vccd1 _02298_ sky130_fd_sc_hd__nand2_1
X_07856_ net510 _02228_ _02227_ vssd1 vssd1 vccd1 vccd1 _02229_ sky130_fd_sc_hd__a21bo_1
X_07787_ _02157_ _02114_ vssd1 vssd1 vccd1 vccd1 _02158_ sky130_fd_sc_hd__nand2b_1
X_06807_ _01178_ _01179_ vssd1 vssd1 vccd1 vccd1 _01180_ sky130_fd_sc_hd__and2b_1
X_09526_ _04017_ _04018_ vssd1 vssd1 vccd1 vccd1 _04019_ sky130_fd_sc_hd__nand2_1
X_06738_ _01106_ _01109_ vssd1 vssd1 vccd1 vccd1 _01111_ sky130_fd_sc_hd__xnor2_1
XFILLER_0_93_312 vssd1 vssd1 vccd1 vccd1 sky130_fd_sc_hd__fill_2
X_09457_ net248 net411 _03942_ _03943_ vssd1 vssd1 vccd1 vccd1 _03944_ sky130_fd_sc_hd__o2bb2a_1
X_08408_ _02792_ _02795_ _02796_ vssd1 vssd1 vccd1 vccd1 _02797_ sky130_fd_sc_hd__and3_1
X_06669_ net338 net468 _01040_ _01041_ vssd1 vssd1 vccd1 vccd1 _01043_ sky130_fd_sc_hd__a22o_1
X_09388_ _03863_ _03867_ vssd1 vssd1 vccd1 vccd1 _03868_ sky130_fd_sc_hd__xor2_1
XFILLER_0_46_261 vssd1 vssd1 vccd1 vccd1 sky130_fd_sc_hd__decap_3
X_08339_ _02720_ _02721_ vssd1 vssd1 vccd1 vccd1 _02723_ sky130_fd_sc_hd__nor2_1
X_10094_ clknet_3_4_0_wb_clk_i _00090_ _00026_ vssd1 vssd1 vccd1 vccd1 mul.b\[23\]
+ sky130_fd_sc_hd__dfrtp_4
XFILLER_0_84_312 vssd1 vssd1 vccd1 vccd1 sky130_fd_sc_hd__decap_3
XTAP_1040 vssd1 vccd1 sky130_fd_sc_hd__tapvpwrvgnd_1
XFILLER_0_69_364 vssd1 vssd1 vccd1 vccd1 sky130_fd_sc_hd__fill_2
XFILLER_0_57_526 vssd1 vssd1 vccd1 vccd1 sky130_fd_sc_hd__decap_8
XFILLER_0_29_217 vssd1 vssd1 vccd1 vccd1 sky130_fd_sc_hd__fill_2
XFILLER_0_84_345 vssd1 vssd1 vccd1 vccd1 sky130_fd_sc_hd__decap_4
XTAP_1073 vssd1 vccd1 sky130_fd_sc_hd__tapvpwrvgnd_1
XTAP_1062 vssd1 vccd1 sky130_fd_sc_hd__tapvpwrvgnd_1
XTAP_1051 vssd1 vccd1 sky130_fd_sc_hd__tapvpwrvgnd_1
XFILLER_0_57_548 vssd1 vssd1 vccd1 vccd1 sky130_fd_sc_hd__decap_8
XTAP_1084 vssd1 vccd1 sky130_fd_sc_hd__tapvpwrvgnd_1
XTAP_1095 vssd1 vccd1 sky130_fd_sc_hd__tapvpwrvgnd_1
XFILLER_0_52_253 vssd1 vssd1 vccd1 vccd1 sky130_ef_sc_hd__decap_12
XFILLER_0_4_328 vssd1 vssd1 vccd1 vccd1 sky130_fd_sc_hd__decap_4
XFILLER_0_52_286 vssd1 vssd1 vccd1 vccd1 sky130_fd_sc_hd__fill_1
XFILLER_0_25_478 vssd1 vssd1 vccd1 vccd1 sky130_ef_sc_hd__decap_12
XFILLER_0_0_545 vssd1 vssd1 vccd1 vccd1 sky130_fd_sc_hd__decap_8
XFILLER_0_57_44 vssd1 vssd1 vccd1 vccd1 sky130_fd_sc_hd__decap_4
XFILLER_0_57_33 vssd1 vssd1 vccd1 vccd1 sky130_fd_sc_hd__fill_1
XTAP_835 vssd1 vccd1 sky130_fd_sc_hd__tapvpwrvgnd_1
XTAP_824 vssd1 vccd1 sky130_fd_sc_hd__tapvpwrvgnd_1
XTAP_813 vssd1 vccd1 sky130_fd_sc_hd__tapvpwrvgnd_1
XTAP_802 vssd1 vccd1 sky130_fd_sc_hd__tapvpwrvgnd_1
XFILLER_0_0_589 vssd1 vssd1 vccd1 vccd1 sky130_fd_sc_hd__fill_1
XFILLER_0_20_194 vssd1 vssd1 vccd1 vccd1 sky130_fd_sc_hd__fill_2
XTAP_868 vssd1 vccd1 sky130_fd_sc_hd__tapvpwrvgnd_1
XTAP_857 vssd1 vccd1 sky130_fd_sc_hd__tapvpwrvgnd_1
XTAP_846 vssd1 vccd1 sky130_fd_sc_hd__tapvpwrvgnd_1
XFILLER_0_57_55 vssd1 vssd1 vccd1 vccd1 sky130_fd_sc_hd__fill_1
X_07710_ _01907_ net669 _01913_ vssd1 vssd1 vccd1 vccd1 _02082_ sky130_fd_sc_hd__a21bo_1
XTAP_879 vssd1 vccd1 sky130_fd_sc_hd__tapvpwrvgnd_1
X_05971_ _00347_ _00348_ _00349_ vssd1 vssd1 vccd1 vccd1 _00351_ sky130_fd_sc_hd__a21oi_2
X_08690_ net193 net499 vssd1 vssd1 vccd1 vccd1 _03106_ sky130_fd_sc_hd__nand2_1
X_07641_ _02008_ _02010_ _02011_ vssd1 vssd1 vccd1 vccd1 _02013_ sky130_fd_sc_hd__a21oi_1
X_07572_ _01942_ _01943_ _01664_ _01667_ vssd1 vssd1 vccd1 vccd1 _01945_ sky130_fd_sc_hd__a211o_1
X_09311_ _03775_ _03784_ vssd1 vssd1 vccd1 vccd1 _03785_ sky130_fd_sc_hd__nor2_1
X_06523_ _00889_ _00897_ vssd1 vssd1 vccd1 vccd1 _00898_ sky130_fd_sc_hd__xnor2_1
XFILLER_0_48_526 vssd1 vssd1 vccd1 vccd1 sky130_fd_sc_hd__decap_6
X_09242_ _03707_ _03708_ vssd1 vssd1 vccd1 vccd1 _03710_ sky130_fd_sc_hd__nand2_1
XFILLER_0_75_389 vssd1 vssd1 vccd1 vccd1 sky130_fd_sc_hd__decap_3
XFILLER_0_63_529 vssd1 vssd1 vccd1 vccd1 sky130_fd_sc_hd__fill_1
XFILLER_0_8_623 vssd1 vssd1 vccd1 vccd1 sky130_fd_sc_hd__fill_2
XFILLER_0_7_111 vssd1 vssd1 vccd1 vccd1 sky130_fd_sc_hd__fill_1
X_06454_ _00826_ _00828_ net706 _00706_ vssd1 vssd1 vccd1 vccd1 _00830_ sky130_fd_sc_hd__o211ai_2
X_09173_ net294 net396 _03632_ _03633_ vssd1 vssd1 vccd1 vccd1 _03634_ sky130_fd_sc_hd__a22o_1
X_06385_ _00656_ _00760_ vssd1 vssd1 vccd1 vccd1 _00761_ sky130_fd_sc_hd__nand2_2
X_05405_ _04671_ _04674_ vssd1 vssd1 vccd1 vccd1 _04675_ sky130_fd_sc_hd__nand2_1
XFILLER_0_28_294 vssd1 vssd1 vccd1 vccd1 sky130_fd_sc_hd__fill_2
X_08124_ net228 net500 vssd1 vssd1 vccd1 vccd1 _02496_ sky130_fd_sc_hd__nand2_1
XFILLER_0_16_445 vssd1 vssd1 vccd1 vccd1 sky130_fd_sc_hd__decap_3
XFILLER_0_16_456 vssd1 vssd1 vccd1 vccd1 sky130_ef_sc_hd__decap_12
X_05336_ net370 net615 _04604_ _04602_ vssd1 vssd1 vccd1 vccd1 _04606_ sky130_fd_sc_hd__a31o_1
XFILLER_0_43_220 vssd1 vssd1 vccd1 vccd1 sky130_fd_sc_hd__decap_4
XFILLER_0_98_73 vssd1 vssd1 vccd1 vccd1 sky130_fd_sc_hd__decap_3
X_08055_ _02425_ _02426_ _02261_ _02263_ vssd1 vssd1 vccd1 vccd1 _02428_ sky130_fd_sc_hd__a211oi_2
X_05267_ _04438_ _04448_ _04350_ vssd1 vssd1 vccd1 vccd1 _04470_ sky130_fd_sc_hd__a21oi_1
XFILLER_0_43_297 vssd1 vssd1 vccd1 vccd1 sky130_fd_sc_hd__fill_2
X_05198_ _03629_ _03640_ _03706_ vssd1 vssd1 vccd1 vccd1 _03716_ sky130_fd_sc_hd__and3_1
Xoutput39 net39 vssd1 vssd1 vccd1 vccd1 wbs_ack_o sky130_fd_sc_hd__clkbuf_4
X_07006_ _01372_ _01375_ vssd1 vssd1 vccd1 vccd1 _01377_ sky130_fd_sc_hd__xnor2_1
X_08957_ net439 net144 net130 net196 vssd1 vssd1 vccd1 vccd1 _03398_ sky130_fd_sc_hd__a22o_1
X_08888_ _03167_ _03169_ _03319_ _03321_ vssd1 vssd1 vccd1 vccd1 _03322_ sky130_fd_sc_hd__o211a_1
X_07908_ _00965_ _02280_ _02281_ _02279_ vssd1 vssd1 vccd1 vccd1 _02282_ sky130_fd_sc_hd__a211oi_4
X_07839_ _02207_ _02208_ _02201_ vssd1 vssd1 vccd1 vccd1 _02211_ sky130_fd_sc_hd__a21o_1
XFILLER_0_39_515 vssd1 vssd1 vccd1 vccd1 sky130_ef_sc_hd__decap_12
X_09509_ net121 _04000_ vssd1 vssd1 vccd1 vccd1 _04002_ sky130_fd_sc_hd__xnor2_2
XFILLER_0_78_194 vssd1 vssd1 vccd1 vccd1 sky130_fd_sc_hd__fill_2
XPHY_134 vssd1 vssd1 vccd1 vccd1 sky130_fd_sc_hd__decap_3
XPHY_123 vssd1 vssd1 vccd1 vccd1 sky130_fd_sc_hd__decap_3
XPHY_112 vssd1 vssd1 vccd1 vccd1 sky130_fd_sc_hd__decap_3
XPHY_101 vssd1 vssd1 vccd1 vccd1 sky130_fd_sc_hd__decap_3
XFILLER_0_93_142 vssd1 vssd1 vccd1 vccd1 sky130_fd_sc_hd__fill_2
XPHY_167 vssd1 vssd1 vccd1 vccd1 sky130_fd_sc_hd__decap_3
XPHY_156 vssd1 vssd1 vccd1 vccd1 sky130_fd_sc_hd__decap_3
XPHY_145 vssd1 vssd1 vccd1 vccd1 sky130_fd_sc_hd__decap_3
XPHY_189 vssd1 vssd1 vccd1 vccd1 sky130_fd_sc_hd__decap_3
XPHY_178 vssd1 vssd1 vccd1 vccd1 sky130_fd_sc_hd__decap_3
XFILLER_0_47_581 vssd1 vssd1 vccd1 vccd1 sky130_fd_sc_hd__fill_1
XFILLER_0_22_426 vssd1 vssd1 vccd1 vccd1 sky130_fd_sc_hd__decap_6
X_10077_ clknet_3_0_0_wb_clk_i _00073_ _00009_ vssd1 vssd1 vccd1 vccd1 mul.b\[6\]
+ sky130_fd_sc_hd__dfrtp_4
XFILLER_0_76_109 vssd1 vssd1 vccd1 vccd1 sky130_fd_sc_hd__decap_4
XFILLER_0_57_312 vssd1 vssd1 vccd1 vccd1 sky130_fd_sc_hd__decap_8
XPHY_3 vssd1 vssd1 vccd1 vccd1 sky130_fd_sc_hd__decap_3
Xmax_cap81 _01208_ vssd1 vssd1 vccd1 vccd1 net81 sky130_fd_sc_hd__clkbuf_2
Xmax_cap92 _02420_ vssd1 vssd1 vccd1 vccd1 net92 sky130_fd_sc_hd__clkbuf_2
XFILLER_0_43_57 vssd1 vssd1 vccd1 vccd1 sky130_ef_sc_hd__decap_12
XFILLER_0_43_79 vssd1 vssd1 vccd1 vccd1 sky130_ef_sc_hd__decap_12
XFILLER_0_84_197 vssd1 vssd1 vccd1 vccd1 sky130_fd_sc_hd__decap_4
XFILLER_0_5_604 vssd1 vssd1 vccd1 vccd1 sky130_fd_sc_hd__fill_1
XFILLER_0_72_359 vssd1 vssd1 vccd1 vccd1 sky130_fd_sc_hd__decap_4
XFILLER_0_87_9 vssd1 vssd1 vccd1 vccd1 sky130_fd_sc_hd__fill_1
XFILLER_0_4_136 vssd1 vssd1 vccd1 vccd1 sky130_fd_sc_hd__decap_4
X_06170_ _00539_ _00547_ vssd1 vssd1 vccd1 vccd1 _00548_ sky130_fd_sc_hd__nand2_1
X_05121_ net310 net319 net622 net630 vssd1 vssd1 vccd1 vccd1 _02875_ sky130_fd_sc_hd__and4_1
X_05052_ net31 net360 net132 vssd1 vssd1 vccd1 vccd1 _00103_ sky130_fd_sc_hd__mux2_1
XFILLER_0_7_79 vssd1 vssd1 vccd1 vccd1 sky130_fd_sc_hd__fill_1
XFILLER_0_21_492 vssd1 vssd1 vccd1 vccd1 sky130_fd_sc_hd__decap_4
X_09860_ _04377_ _04382_ vssd1 vssd1 vccd1 vccd1 _04385_ sky130_fd_sc_hd__nand2_1
XTAP_610 vssd1 vccd1 sky130_fd_sc_hd__tapvpwrvgnd_1
XTAP_621 vssd1 vccd1 sky130_fd_sc_hd__tapvpwrvgnd_1
XTAP_632 vssd1 vccd1 sky130_fd_sc_hd__tapvpwrvgnd_1
XTAP_643 vssd1 vccd1 sky130_fd_sc_hd__tapvpwrvgnd_1
X_09791_ net403 net145 net131 net160 vssd1 vssd1 vccd1 vccd1 _04310_ sky130_fd_sc_hd__a22o_1
X_08811_ net121 _03082_ _03081_ vssd1 vssd1 vccd1 vccd1 _03239_ sky130_fd_sc_hd__a21boi_2
XTAP_665 vssd1 vccd1 sky130_fd_sc_hd__tapvpwrvgnd_1
XTAP_654 vssd1 vccd1 sky130_fd_sc_hd__tapvpwrvgnd_1
XTAP_676 vssd1 vccd1 sky130_fd_sc_hd__tapvpwrvgnd_1
X_08742_ net147 net569 vssd1 vssd1 vccd1 vccd1 _03163_ sky130_fd_sc_hd__and2_2
X_05954_ net364 net495 vssd1 vssd1 vccd1 vccd1 _00334_ sky130_fd_sc_hd__nand2_1
XTAP_687 vssd1 vccd1 sky130_fd_sc_hd__tapvpwrvgnd_1
XTAP_698 vssd1 vccd1 sky130_fd_sc_hd__tapvpwrvgnd_1
X_08673_ _03085_ _03086_ vssd1 vssd1 vccd1 vccd1 _03088_ sky130_fd_sc_hd__nand2_2
X_07624_ _01993_ _01994_ _01866_ _01868_ vssd1 vssd1 vccd1 vccd1 _01996_ sky130_fd_sc_hd__a211oi_2
X_05885_ _00262_ _00263_ _00264_ vssd1 vssd1 vccd1 vccd1 _00266_ sky130_fd_sc_hd__a21oi_1
XFILLER_0_16_3 vssd1 vssd1 vccd1 vccd1 sky130_fd_sc_hd__decap_8
X_07555_ net677 net656 _01925_ _01927_ vssd1 vssd1 vccd1 vccd1 _01928_ sky130_fd_sc_hd__a211oi_2
XFILLER_0_48_334 vssd1 vssd1 vccd1 vccd1 sky130_ef_sc_hd__decap_12
XFILLER_0_75_164 vssd1 vssd1 vccd1 vccd1 sky130_fd_sc_hd__decap_4
X_07486_ _01852_ _01855_ _01856_ vssd1 vssd1 vccd1 vccd1 _01857_ sky130_fd_sc_hd__and3_1
X_06506_ net262 net560 net567 net252 vssd1 vssd1 vccd1 vccd1 _00881_ sky130_fd_sc_hd__a22oi_1
X_09225_ _03665_ _03667_ _03689_ _03690_ vssd1 vssd1 vccd1 vccd1 _03691_ sky130_fd_sc_hd__or4_1
XFILLER_0_63_337 vssd1 vssd1 vccd1 vccd1 sky130_fd_sc_hd__decap_4
X_06437_ _00809_ _00811_ _00685_ _00688_ vssd1 vssd1 vccd1 vccd1 _00813_ sky130_fd_sc_hd__o211a_1
XFILLER_0_29_581 vssd1 vssd1 vccd1 vccd1 sky130_fd_sc_hd__fill_1
XFILLER_0_36_529 vssd1 vssd1 vccd1 vccd1 sky130_fd_sc_hd__decap_3
XFILLER_0_16_220 vssd1 vssd1 vccd1 vccd1 sky130_fd_sc_hd__fill_1
XFILLER_0_90_189 vssd1 vssd1 vccd1 vccd1 sky130_fd_sc_hd__decap_6
XFILLER_0_90_178 vssd1 vssd1 vccd1 vccd1 sky130_fd_sc_hd__decap_3
X_09156_ _03605_ _03614_ vssd1 vssd1 vccd1 vccd1 _03615_ sky130_fd_sc_hd__or2_1
X_06368_ _00742_ _00743_ vssd1 vssd1 vccd1 vccd1 _00744_ sky130_fd_sc_hd__nand2b_1
X_09087_ _03537_ _03538_ _03539_ vssd1 vssd1 vccd1 vccd1 _03540_ sky130_fd_sc_hd__and3_1
X_08107_ _02476_ _02477_ vssd1 vssd1 vccd1 vccd1 _02479_ sky130_fd_sc_hd__xnor2_2
X_05319_ _03716_ _03738_ _03979_ _04022_ vssd1 vssd1 vccd1 vccd1 _04589_ sky130_fd_sc_hd__o211ai_1
X_06299_ net301 net532 net542 net292 vssd1 vssd1 vccd1 vccd1 _00676_ sky130_fd_sc_hd__a22o_1
X_08038_ _02396_ _02409_ _02410_ vssd1 vssd1 vccd1 vccd1 _02411_ sky130_fd_sc_hd__and3_2
XFILLER_0_31_278 vssd1 vssd1 vccd1 vccd1 sky130_fd_sc_hd__fill_2
X_10000_ _04534_ _04537_ vssd1 vssd1 vccd1 vccd1 _04538_ sky130_fd_sc_hd__xnor2_2
X_09989_ _04521_ _04524_ vssd1 vssd1 vccd1 vccd1 _04526_ sky130_fd_sc_hd__xnor2_2
XFILLER_0_98_223 vssd1 vssd1 vccd1 vccd1 sky130_fd_sc_hd__decap_3
XFILLER_0_98_289 vssd1 vssd1 vccd1 vccd1 sky130_fd_sc_hd__fill_1
XFILLER_0_86_407 vssd1 vssd1 vccd1 vccd1 sky130_fd_sc_hd__fill_2
XFILLER_0_66_197 vssd1 vssd1 vccd1 vccd1 sky130_fd_sc_hd__decap_4
XFILLER_0_81_167 vssd1 vssd1 vccd1 vccd1 sky130_fd_sc_hd__fill_1
XFILLER_0_50_521 vssd1 vssd1 vccd1 vccd1 sky130_fd_sc_hd__decap_8
XFILLER_0_50_565 vssd1 vssd1 vccd1 vccd1 sky130_ef_sc_hd__decap_12
XFILLER_0_1_128 vssd1 vssd1 vccd1 vccd1 sky130_fd_sc_hd__decap_6
XFILLER_0_38_46 vssd1 vssd1 vccd1 vccd1 sky130_fd_sc_hd__fill_1
X_10129_ clknet_3_5_0_wb_clk_i _00123_ _00059_ vssd1 vssd1 vccd1 vccd1 mul.a\[24\]
+ sky130_fd_sc_hd__dfrtp_2
XFILLER_0_89_223 vssd1 vssd1 vccd1 vccd1 sky130_fd_sc_hd__fill_1
XFILLER_0_54_56 vssd1 vssd1 vccd1 vccd1 sky130_fd_sc_hd__fill_1
XFILLER_0_89_289 vssd1 vssd1 vccd1 vccd1 sky130_fd_sc_hd__decap_3
XFILLER_0_54_78 vssd1 vssd1 vccd1 vccd1 sky130_fd_sc_hd__decap_3
X_05670_ net347 net356 net533 net543 vssd1 vssd1 vccd1 vccd1 _04940_ sky130_fd_sc_hd__nand4_2
XFILLER_0_9_206 vssd1 vssd1 vccd1 vccd1 sky130_fd_sc_hd__decap_6
XFILLER_0_73_602 vssd1 vssd1 vccd1 vccd1 sky130_fd_sc_hd__fill_1
X_07340_ _01695_ _01696_ _01707_ _01708_ vssd1 vssd1 vccd1 vccd1 _01709_ sky130_fd_sc_hd__nand4_4
XFILLER_0_70_55 vssd1 vssd1 vccd1 vccd1 sky130_ef_sc_hd__decap_12
X_09010_ _03295_ _03297_ _03452_ _03453_ vssd1 vssd1 vccd1 vccd1 _03456_ sky130_fd_sc_hd__a211o_1
X_07271_ _01483_ _01485_ _01638_ _01639_ vssd1 vssd1 vccd1 vccd1 _01641_ sky130_fd_sc_hd__o211ai_2
XFILLER_0_60_307 vssd1 vssd1 vccd1 vccd1 sky130_fd_sc_hd__fill_1
X_06222_ _00598_ net73 vssd1 vssd1 vccd1 vccd1 _00600_ sky130_fd_sc_hd__nor2_1
XFILLER_0_79_53 vssd1 vssd1 vccd1 vccd1 sky130_fd_sc_hd__decap_3
XFILLER_0_53_381 vssd1 vssd1 vccd1 vccd1 sky130_fd_sc_hd__fill_1
X_06153_ _00423_ _00529_ vssd1 vssd1 vccd1 vccd1 _00531_ sky130_fd_sc_hd__or2_1
X_05104_ _02656_ _02667_ _02645_ vssd1 vssd1 vccd1 vccd1 _02689_ sky130_fd_sc_hd__a21o_1
X_06084_ _00419_ _00420_ _00460_ _00461_ vssd1 vssd1 vccd1 vccd1 _00463_ sky130_fd_sc_hd__o22a_1
X_09912_ _04155_ _04161_ _04305_ _04441_ vssd1 vssd1 vccd1 vccd1 _04442_ sky130_fd_sc_hd__a31o_1
X_05035_ net18 net213 net134 vssd1 vssd1 vccd1 vccd1 _00120_ sky130_fd_sc_hd__mux2_1
Xfanout604 net605 vssd1 vssd1 vccd1 vccd1 net604 sky130_fd_sc_hd__clkbuf_4
Xfanout615 mul.b\[2\] vssd1 vssd1 vccd1 vccd1 net615 sky130_fd_sc_hd__buf_2
X_09843_ net230 net239 net400 net407 vssd1 vssd1 vccd1 vccd1 _04366_ sky130_fd_sc_hd__nand4_1
Xfanout626 mul.b\[1\] vssd1 vssd1 vccd1 vccd1 net626 sky130_fd_sc_hd__buf_2
XTAP_440 vssd1 vccd1 sky130_fd_sc_hd__tapvpwrvgnd_1
XTAP_451 vssd1 vccd1 sky130_fd_sc_hd__tapvpwrvgnd_1
Xfanout637 mul.b\[0\] vssd1 vssd1 vccd1 vccd1 net637 sky130_fd_sc_hd__clkbuf_2
XTAP_462 vssd1 vccd1 sky130_fd_sc_hd__tapvpwrvgnd_1
XTAP_473 vssd1 vccd1 sky130_fd_sc_hd__tapvpwrvgnd_1
XTAP_484 vssd1 vccd1 sky130_fd_sc_hd__tapvpwrvgnd_1
X_09774_ _04268_ _04289_ vssd1 vssd1 vccd1 vccd1 _04291_ sky130_fd_sc_hd__xnor2_2
XTAP_495 vssd1 vccd1 sky130_fd_sc_hd__tapvpwrvgnd_1
X_06986_ _01093_ _01219_ _01218_ vssd1 vssd1 vccd1 vccd1 _01358_ sky130_fd_sc_hd__a21oi_1
X_08725_ _03141_ _03142_ vssd1 vssd1 vccd1 vccd1 _03144_ sky130_fd_sc_hd__xnor2_1
X_05937_ _00212_ _00316_ vssd1 vssd1 vccd1 vccd1 _00317_ sky130_fd_sc_hd__nand2_1
X_08656_ _03046_ _03067_ vssd1 vssd1 vccd1 vccd1 _03069_ sky130_fd_sc_hd__xnor2_1
X_05868_ _00139_ _00147_ _00146_ vssd1 vssd1 vccd1 vccd1 _00249_ sky130_fd_sc_hd__a21bo_1
X_08587_ _02990_ _02991_ _02818_ _02821_ vssd1 vssd1 vccd1 vccd1 _02993_ sky130_fd_sc_hd__o211a_1
X_07607_ net189 net573 net583 net181 vssd1 vssd1 vccd1 vccd1 _01979_ sky130_fd_sc_hd__a22o_1
XFILLER_0_95_259 vssd1 vssd1 vccd1 vccd1 sky130_fd_sc_hd__fill_1
X_07538_ _01908_ _01909_ _01910_ vssd1 vssd1 vccd1 vccd1 _01911_ sky130_fd_sc_hd__a21o_1
X_05799_ net2 _01849_ vssd1 vssd1 vccd1 vccd1 _00181_ sky130_fd_sc_hd__nor2_1
XFILLER_0_48_153 vssd1 vssd1 vccd1 vccd1 sky130_fd_sc_hd__fill_1
XFILLER_0_63_145 vssd1 vssd1 vccd1 vccd1 sky130_ef_sc_hd__decap_12
XFILLER_0_17_540 vssd1 vssd1 vccd1 vccd1 sky130_fd_sc_hd__fill_2
X_07469_ net195 net205 net564 net573 vssd1 vssd1 vccd1 vccd1 _01839_ sky130_fd_sc_hd__and4_1
X_09208_ _03671_ _03513_ vssd1 vssd1 vccd1 vccd1 _03672_ sky130_fd_sc_hd__and2b_1
X_09139_ _03581_ _03582_ _03594_ vssd1 vssd1 vccd1 vccd1 _03597_ sky130_fd_sc_hd__or3_2
XFILLER_0_32_521 vssd1 vssd1 vccd1 vccd1 sky130_fd_sc_hd__decap_8
XFILLER_0_44_370 vssd1 vssd1 vccd1 vccd1 sky130_fd_sc_hd__decap_6
XFILLER_0_5_3 vssd1 vssd1 vccd1 vccd1 sky130_ef_sc_hd__decap_12
XFILLER_0_86_215 vssd1 vssd1 vccd1 vccd1 sky130_fd_sc_hd__decap_4
XFILLER_0_24_26 vssd1 vssd1 vccd1 vccd1 sky130_fd_sc_hd__fill_2
XFILLER_0_39_175 vssd1 vssd1 vccd1 vccd1 sky130_fd_sc_hd__fill_1
XFILLER_0_40_69 vssd1 vssd1 vccd1 vccd1 sky130_fd_sc_hd__decap_6
XFILLER_0_82_498 vssd1 vssd1 vccd1 vccd1 sky130_ef_sc_hd__decap_12
XFILLER_0_35_381 vssd1 vssd1 vccd1 vccd1 sky130_fd_sc_hd__fill_2
XFILLER_0_2_415 vssd1 vssd1 vccd1 vccd1 sky130_fd_sc_hd__decap_4
XFILLER_0_10_259 vssd1 vssd1 vccd1 vccd1 sky130_fd_sc_hd__fill_1
X_06840_ _01210_ _01211_ _01003_ _01005_ vssd1 vssd1 vccd1 vccd1 _01213_ sky130_fd_sc_hd__o211a_1
XFILLER_0_65_55 vssd1 vssd1 vccd1 vccd1 sky130_fd_sc_hd__fill_1
X_06771_ _01142_ _01143_ vssd1 vssd1 vccd1 vccd1 _01144_ sky130_fd_sc_hd__and2_1
X_09490_ _03978_ _03980_ vssd1 vssd1 vccd1 vccd1 _03981_ sky130_fd_sc_hd__nand2_2
X_08510_ _02874_ _02876_ _02907_ vssd1 vssd1 vccd1 vccd1 _02910_ sky130_fd_sc_hd__or3_1
X_05722_ net289 net598 net607 net281 vssd1 vssd1 vccd1 vccd1 _04992_ sky130_fd_sc_hd__a22o_1
X_08441_ net350 net393 vssd1 vssd1 vccd1 vccd1 _02834_ sky130_fd_sc_hd__and2b_1
X_05653_ _04914_ _04921_ vssd1 vssd1 vccd1 vccd1 _04923_ sky130_fd_sc_hd__xnor2_1
XFILLER_0_73_410 vssd1 vssd1 vccd1 vccd1 sky130_fd_sc_hd__fill_1
X_08372_ _02756_ _02757_ _02585_ _02587_ vssd1 vssd1 vccd1 vccd1 _02759_ sky130_fd_sc_hd__o211a_1
XFILLER_0_58_473 vssd1 vssd1 vccd1 vccd1 sky130_fd_sc_hd__decap_3
X_05584_ _04845_ _04853_ vssd1 vssd1 vccd1 vccd1 _04854_ sky130_fd_sc_hd__nand2_1
XFILLER_0_14_70 vssd1 vssd1 vccd1 vccd1 sky130_ef_sc_hd__decap_12
X_07323_ net383 net391 net402 net410 vssd1 vssd1 vccd1 vccd1 _01692_ sky130_fd_sc_hd__and4_2
X_07254_ _01587_ _01588_ _01621_ _01622_ vssd1 vssd1 vccd1 vccd1 _01624_ sky130_fd_sc_hd__o22a_1
XFILLER_0_60_115 vssd1 vssd1 vccd1 vccd1 sky130_ef_sc_hd__decap_12
X_06205_ _00525_ _00526_ _00581_ _00582_ vssd1 vssd1 vccd1 vccd1 _00583_ sky130_fd_sc_hd__or4bb_4
XFILLER_0_26_392 vssd1 vssd1 vccd1 vccd1 sky130_fd_sc_hd__decap_8
XFILLER_0_60_148 vssd1 vssd1 vccd1 vccd1 sky130_fd_sc_hd__decap_8
X_07185_ _01553_ _01554_ vssd1 vssd1 vccd1 vccd1 _01555_ sky130_fd_sc_hd__or2_1
XFILLER_0_14_576 vssd1 vssd1 vccd1 vccd1 sky130_fd_sc_hd__decap_8
X_06136_ _00510_ _00513_ vssd1 vssd1 vccd1 vccd1 _00514_ sky130_fd_sc_hd__and2b_1
X_06067_ _00339_ _00341_ _00340_ vssd1 vssd1 vccd1 vccd1 _00446_ sky130_fd_sc_hd__a21bo_1
Xfanout401 net404 vssd1 vssd1 vccd1 vccd1 net401 sky130_fd_sc_hd__buf_2
Xfanout412 mul.b\[27\] vssd1 vssd1 vccd1 vccd1 net412 sky130_fd_sc_hd__buf_2
Xfanout423 net425 vssd1 vssd1 vccd1 vccd1 net423 sky130_fd_sc_hd__clkbuf_2
Xfanout445 net446 vssd1 vssd1 vccd1 vccd1 net445 sky130_fd_sc_hd__clkbuf_4
Xfanout434 net435 vssd1 vssd1 vccd1 vccd1 net434 sky130_fd_sc_hd__clkbuf_4
Xfanout456 mul.b\[20\] vssd1 vssd1 vccd1 vccd1 net456 sky130_fd_sc_hd__buf_4
Xfanout489 net490 vssd1 vssd1 vccd1 vccd1 net489 sky130_fd_sc_hd__clkbuf_4
Xfanout467 mul.b\[19\] vssd1 vssd1 vccd1 vccd1 net467 sky130_fd_sc_hd__clkbuf_4
Xfanout478 net479 vssd1 vssd1 vccd1 vccd1 net478 sky130_fd_sc_hd__clkbuf_4
XTAP_292 vssd1 vccd1 sky130_fd_sc_hd__tapvpwrvgnd_1
XTAP_281 vssd1 vccd1 sky130_fd_sc_hd__tapvpwrvgnd_1
XTAP_270 vssd1 vccd1 sky130_fd_sc_hd__tapvpwrvgnd_1
X_09826_ _04345_ _04346_ vssd1 vssd1 vccd1 vccd1 _04347_ sky130_fd_sc_hd__xnor2_1
X_09757_ net123 _04270_ vssd1 vssd1 vccd1 vccd1 _04272_ sky130_fd_sc_hd__xnor2_1
X_06969_ _01202_ _01204_ _01339_ _01340_ vssd1 vssd1 vccd1 vccd1 _01341_ sky130_fd_sc_hd__o211a_2
X_08708_ _03111_ _03112_ _03124_ vssd1 vssd1 vccd1 vccd1 _03125_ sky130_fd_sc_hd__nor3_1
XFILLER_0_96_546 vssd1 vssd1 vccd1 vccd1 sky130_fd_sc_hd__decap_3
X_09688_ _04195_ vssd1 vssd1 vccd1 vccd1 _04196_ sky130_fd_sc_hd__inv_2
X_08639_ net160 net574 _02837_ _02836_ vssd1 vssd1 vccd1 vccd1 _03051_ sky130_fd_sc_hd__a31o_1
XFILLER_0_36_145 vssd1 vssd1 vccd1 vccd1 sky130_fd_sc_hd__fill_1
XFILLER_0_9_592 vssd1 vssd1 vccd1 vccd1 sky130_fd_sc_hd__fill_1
XFILLER_0_24_307 vssd1 vssd1 vccd1 vccd1 sky130_fd_sc_hd__fill_1
XFILLER_0_24_329 vssd1 vssd1 vccd1 vccd1 sky130_fd_sc_hd__decap_3
XFILLER_0_36_189 vssd1 vssd1 vccd1 vccd1 sky130_fd_sc_hd__decap_6
XFILLER_0_32_373 vssd1 vssd1 vccd1 vccd1 sky130_fd_sc_hd__fill_2
XFILLER_0_99_362 vssd1 vssd1 vccd1 vccd1 sky130_ef_sc_hd__decap_12
XFILLER_0_87_513 vssd1 vssd1 vccd1 vccd1 sky130_fd_sc_hd__decap_8
XFILLER_0_59_204 vssd1 vssd1 vccd1 vccd1 sky130_fd_sc_hd__decap_4
XFILLER_0_35_47 vssd1 vssd1 vccd1 vccd1 sky130_fd_sc_hd__decap_3
XFILLER_0_87_546 vssd1 vssd1 vccd1 vccd1 sky130_fd_sc_hd__decap_6
XFILLER_0_74_229 vssd1 vssd1 vccd1 vccd1 sky130_ef_sc_hd__decap_12
XFILLER_0_51_57 vssd1 vssd1 vccd1 vccd1 sky130_fd_sc_hd__decap_6
XFILLER_0_7_518 vssd1 vssd1 vccd1 vccd1 sky130_ef_sc_hd__decap_12
XFILLER_0_82_251 vssd1 vssd1 vccd1 vccd1 sky130_fd_sc_hd__fill_1
XFILLER_0_82_240 vssd1 vssd1 vccd1 vccd1 sky130_fd_sc_hd__decap_3
XFILLER_0_70_402 vssd1 vssd1 vccd1 vccd1 sky130_fd_sc_hd__decap_8
XFILLER_0_82_273 vssd1 vssd1 vccd1 vccd1 sky130_fd_sc_hd__fill_1
XFILLER_0_15_329 vssd1 vssd1 vccd1 vccd1 sky130_fd_sc_hd__fill_1
XFILLER_0_42_126 vssd1 vssd1 vccd1 vccd1 sky130_fd_sc_hd__fill_2
XFILLER_0_2_245 vssd1 vssd1 vccd1 vccd1 sky130_fd_sc_hd__decap_6
XFILLER_0_62_8 vssd1 vssd1 vccd1 vccd1 sky130_fd_sc_hd__fill_2
XFILLER_0_50_181 vssd1 vssd1 vccd1 vccd1 sky130_fd_sc_hd__decap_8
X_08990_ _03263_ net107 _03431_ _03433_ vssd1 vssd1 vccd1 vccd1 _03434_ sky130_fd_sc_hd__o211ai_4
X_07941_ _02306_ _02313_ vssd1 vssd1 vccd1 vccd1 _02314_ sky130_fd_sc_hd__xnor2_1
X_07872_ _02244_ _02245_ vssd1 vssd1 vccd1 vccd1 _02246_ sky130_fd_sc_hd__and2b_1
X_09611_ _04069_ _04112_ vssd1 vssd1 vccd1 vccd1 _04113_ sky130_fd_sc_hd__and2_1
X_06823_ _01177_ _01194_ _01195_ vssd1 vssd1 vccd1 vccd1 _01196_ sky130_fd_sc_hd__nor3_2
XFILLER_0_92_53 vssd1 vssd1 vccd1 vccd1 sky130_fd_sc_hd__decap_3
X_09542_ _04035_ _04036_ vssd1 vssd1 vccd1 vccd1 _04037_ sky130_fd_sc_hd__nand2_1
X_06754_ _00990_ _00994_ _01125_ vssd1 vssd1 vccd1 vccd1 _01127_ sky130_fd_sc_hd__nand3_1
XFILLER_0_92_97 vssd1 vssd1 vccd1 vccd1 sky130_fd_sc_hd__fill_1
X_05705_ _04895_ _04973_ _04974_ vssd1 vssd1 vccd1 vccd1 _04975_ sky130_fd_sc_hd__a21o_1
XFILLER_0_93_505 vssd1 vssd1 vccd1 vccd1 sky130_fd_sc_hd__fill_1
X_09473_ _03919_ _03961_ vssd1 vssd1 vccd1 vccd1 _03962_ sky130_fd_sc_hd__xnor2_4
X_06685_ _01056_ _01057_ _01058_ vssd1 vssd1 vccd1 vccd1 _01059_ sky130_fd_sc_hd__nand3_1
X_08424_ net245 net254 net457 net464 vssd1 vssd1 vccd1 vccd1 _02815_ sky130_fd_sc_hd__nand4_4
XFILLER_0_65_229 vssd1 vssd1 vccd1 vccd1 sky130_fd_sc_hd__fill_1
X_05636_ net288 net621 _04848_ _04847_ vssd1 vssd1 vccd1 vccd1 _04906_ sky130_fd_sc_hd__a31o_1
XFILLER_0_93_549 vssd1 vssd1 vccd1 vccd1 sky130_fd_sc_hd__decap_3
X_08355_ _02726_ _02738_ vssd1 vssd1 vccd1 vccd1 _02740_ sky130_fd_sc_hd__xnor2_2
X_05567_ _04835_ _04836_ vssd1 vssd1 vccd1 vccd1 _04837_ sky130_fd_sc_hd__nand2b_1
XFILLER_0_18_112 vssd1 vssd1 vccd1 vccd1 sky130_fd_sc_hd__fill_2
X_07306_ _01545_ _01674_ vssd1 vssd1 vccd1 vccd1 _01675_ sky130_fd_sc_hd__xnor2_1
X_08286_ _02516_ net646 _02662_ _02663_ vssd1 vssd1 vccd1 vccd1 _02664_ sky130_fd_sc_hd__o211a_1
X_05498_ _04730_ _04767_ vssd1 vssd1 vccd1 vccd1 _04768_ sky130_fd_sc_hd__xnor2_1
X_07237_ net240 net534 net544 net231 vssd1 vssd1 vccd1 vccd1 _01607_ sky130_fd_sc_hd__a22o_1
XFILLER_0_33_148 vssd1 vssd1 vccd1 vccd1 sky130_fd_sc_hd__fill_1
XFILLER_0_14_373 vssd1 vssd1 vccd1 vccd1 sky130_fd_sc_hd__decap_3
X_07168_ _01503_ _01537_ vssd1 vssd1 vccd1 vccd1 _01538_ sky130_fd_sc_hd__or2_1
X_06119_ _00388_ _00392_ _00496_ vssd1 vssd1 vccd1 vccd1 _00497_ sky130_fd_sc_hd__a21o_1
X_07099_ _01328_ net115 _01468_ _01469_ vssd1 vssd1 vccd1 vccd1 _01470_ sky130_fd_sc_hd__o211ai_4
Xfanout220 net221 vssd1 vssd1 vccd1 vccd1 net220 sky130_fd_sc_hd__buf_2
Xfanout231 net233 vssd1 vssd1 vccd1 vccd1 net231 sky130_fd_sc_hd__buf_6
Xfanout264 net265 vssd1 vssd1 vccd1 vccd1 net264 sky130_fd_sc_hd__buf_4
Xfanout242 mul.a\[17\] vssd1 vssd1 vccd1 vccd1 net242 sky130_fd_sc_hd__clkbuf_4
Xfanout253 net256 vssd1 vssd1 vccd1 vccd1 net253 sky130_fd_sc_hd__buf_2
Xfanout286 net287 vssd1 vssd1 vccd1 vccd1 net286 sky130_fd_sc_hd__buf_4
Xfanout275 mul.a\[14\] vssd1 vssd1 vccd1 vccd1 net275 sky130_fd_sc_hd__clkbuf_4
Xfanout297 net298 vssd1 vssd1 vccd1 vccd1 net297 sky130_fd_sc_hd__clkbuf_4
X_09809_ _04315_ _04326_ vssd1 vssd1 vccd1 vccd1 _04329_ sky130_fd_sc_hd__nand2_1
XFILLER_0_96_365 vssd1 vssd1 vccd1 vccd1 sky130_fd_sc_hd__fill_1
XFILLER_0_96_343 vssd1 vssd1 vccd1 vccd1 sky130_ef_sc_hd__decap_12
XTAP_1222 vssd1 vccd1 sky130_fd_sc_hd__tapvpwrvgnd_1
XTAP_1211 vssd1 vccd1 sky130_fd_sc_hd__tapvpwrvgnd_1
XTAP_1200 vssd1 vccd1 sky130_fd_sc_hd__tapvpwrvgnd_1
XFILLER_0_96_398 vssd1 vssd1 vccd1 vccd1 sky130_fd_sc_hd__fill_2
XTAP_1266 vssd1 vccd1 sky130_fd_sc_hd__tapvpwrvgnd_1
XTAP_1255 vssd1 vccd1 sky130_fd_sc_hd__tapvpwrvgnd_1
XTAP_1244 vssd1 vccd1 sky130_fd_sc_hd__tapvpwrvgnd_1
XTAP_1233 vssd1 vccd1 sky130_fd_sc_hd__tapvpwrvgnd_1
XTAP_1299 vssd1 vccd1 sky130_fd_sc_hd__tapvpwrvgnd_1
XTAP_1288 vssd1 vccd1 sky130_fd_sc_hd__tapvpwrvgnd_1
XTAP_1277 vssd1 vccd1 sky130_fd_sc_hd__tapvpwrvgnd_1
XFILLER_0_21_27 vssd1 vssd1 vccd1 vccd1 sky130_ef_sc_hd__decap_12
XFILLER_0_37_454 vssd1 vssd1 vccd1 vccd1 sky130_fd_sc_hd__decap_8
XFILLER_0_37_487 vssd1 vssd1 vccd1 vccd1 sky130_fd_sc_hd__decap_6
XFILLER_0_46_79 vssd1 vssd1 vccd1 vccd1 sky130_fd_sc_hd__decap_4
XFILLER_0_1_15 vssd1 vssd1 vccd1 vccd1 sky130_ef_sc_hd__decap_12
XFILLER_0_75_505 vssd1 vssd1 vccd1 vccd1 sky130_fd_sc_hd__decap_8
XFILLER_0_62_45 vssd1 vssd1 vccd1 vccd1 sky130_ef_sc_hd__decap_12
XFILLER_0_87_387 vssd1 vssd1 vccd1 vccd1 sky130_fd_sc_hd__decap_4
X_06470_ _00843_ _00844_ vssd1 vssd1 vccd1 vccd1 _00845_ sky130_fd_sc_hd__nand2b_1
XFILLER_0_75_549 vssd1 vssd1 vccd1 vccd1 sky130_fd_sc_hd__fill_1
X_05421_ _04681_ _04689_ _04690_ vssd1 vssd1 vccd1 vccd1 _04691_ sky130_fd_sc_hd__and3_1
XFILLER_0_28_443 vssd1 vssd1 vccd1 vccd1 sky130_ef_sc_hd__decap_12
XFILLER_0_90_508 vssd1 vssd1 vccd1 vccd1 sky130_ef_sc_hd__decap_12
X_08140_ _02503_ _02511_ vssd1 vssd1 vccd1 vccd1 _02512_ sky130_fd_sc_hd__xnor2_1
XFILLER_0_7_359 vssd1 vssd1 vccd1 vccd1 sky130_fd_sc_hd__decap_3
X_05352_ _04616_ _04618_ _04619_ _04580_ vssd1 vssd1 vccd1 vccd1 _04622_ sky130_fd_sc_hd__a2bb2o_1
X_08071_ _02302_ _02321_ _02320_ vssd1 vssd1 vccd1 vccd1 _02443_ sky130_fd_sc_hd__o21ai_2
X_05283_ _04033_ _04548_ _04552_ vssd1 vssd1 vccd1 vccd1 _04553_ sky130_fd_sc_hd__or3_4
XFILLER_0_3_532 vssd1 vssd1 vccd1 vccd1 sky130_ef_sc_hd__decap_12
X_07022_ _01249_ _01253_ _01391_ vssd1 vssd1 vccd1 vccd1 _01393_ sky130_fd_sc_hd__nand3_1
XFILLER_0_43_479 vssd1 vssd1 vccd1 vccd1 sky130_fd_sc_hd__decap_8
XFILLER_0_87_31 vssd1 vssd1 vccd1 vccd1 sky130_fd_sc_hd__fill_1
X_08973_ _03253_ _03259_ _03252_ vssd1 vssd1 vccd1 vccd1 _03415_ sky130_fd_sc_hd__a21bo_1
X_07924_ _02121_ _02295_ vssd1 vssd1 vccd1 vccd1 _02297_ sky130_fd_sc_hd__nand2_1
XFILLER_0_46_3 vssd1 vssd1 vccd1 vccd1 sky130_fd_sc_hd__decap_4
X_07855_ net228 net237 net694 vssd1 vssd1 vccd1 vccd1 _02228_ sky130_fd_sc_hd__and3_1
X_07786_ _02115_ _02155_ vssd1 vssd1 vccd1 vccd1 _02157_ sky130_fd_sc_hd__xnor2_1
X_06806_ net294 net505 net514 net284 vssd1 vssd1 vccd1 vccd1 _01179_ sky130_fd_sc_hd__a22o_1
X_09525_ _03863_ _03867_ _04009_ vssd1 vssd1 vccd1 vccd1 _04018_ sky130_fd_sc_hd__o21ai_1
X_06737_ _01106_ _01109_ vssd1 vssd1 vccd1 vccd1 _01110_ sky130_fd_sc_hd__and2b_1
Xclkbuf_3_5_0_wb_clk_i clknet_0_wb_clk_i vssd1 vssd1 vccd1 vccd1 clknet_3_5_0_wb_clk_i
+ sky130_fd_sc_hd__clkbuf_8
XFILLER_0_78_365 vssd1 vssd1 vccd1 vccd1 sky130_fd_sc_hd__decap_4
X_09456_ net230 net239 net416 net422 vssd1 vssd1 vccd1 vccd1 _03943_ sky130_fd_sc_hd__and4_1
X_06668_ net338 net468 _01040_ _01041_ vssd1 vssd1 vccd1 vccd1 _01042_ sky130_fd_sc_hd__nand4_2
XFILLER_0_93_324 vssd1 vssd1 vccd1 vccd1 sky130_ef_sc_hd__decap_12
X_08407_ net231 net474 _02793_ _02794_ vssd1 vssd1 vccd1 vccd1 _02796_ sky130_fd_sc_hd__nand4_2
XFILLER_0_66_549 vssd1 vssd1 vccd1 vccd1 sky130_fd_sc_hd__decap_3
X_05619_ _04887_ _04888_ vssd1 vssd1 vccd1 vccd1 _04889_ sky130_fd_sc_hd__xnor2_1
XFILLER_0_93_379 vssd1 vssd1 vccd1 vccd1 sky130_fd_sc_hd__fill_1
X_09387_ net524 _03866_ _03864_ vssd1 vssd1 vccd1 vccd1 _03867_ sky130_fd_sc_hd__a21bo_1
X_06599_ net211 net617 _00844_ _00843_ vssd1 vssd1 vccd1 vccd1 _00973_ sky130_fd_sc_hd__a31o_1
XFILLER_0_46_251 vssd1 vssd1 vccd1 vccd1 sky130_fd_sc_hd__fill_1
X_08338_ _02451_ _02453_ _02719_ vssd1 vssd1 vccd1 vccd1 _02721_ sky130_fd_sc_hd__nor3_1
XFILLER_0_46_295 vssd1 vssd1 vccd1 vccd1 sky130_fd_sc_hd__fill_2
X_08269_ _02643_ _02644_ vssd1 vssd1 vccd1 vccd1 _02646_ sky130_fd_sc_hd__xor2_1
XFILLER_0_6_381 vssd1 vssd1 vccd1 vccd1 sky130_fd_sc_hd__fill_1
X_10093_ clknet_3_5_0_wb_clk_i _00089_ _00025_ vssd1 vssd1 vccd1 vccd1 mul.b\[22\]
+ sky130_fd_sc_hd__dfrtp_4
XFILLER_0_69_321 vssd1 vssd1 vccd1 vccd1 sky130_fd_sc_hd__fill_2
XFILLER_0_16_27 vssd1 vssd1 vccd1 vccd1 sky130_fd_sc_hd__fill_1
XTAP_1030 vssd1 vccd1 sky130_fd_sc_hd__tapvpwrvgnd_1
XFILLER_0_29_207 vssd1 vssd1 vccd1 vccd1 sky130_fd_sc_hd__decap_3
XFILLER_0_96_195 vssd1 vssd1 vccd1 vccd1 sky130_fd_sc_hd__fill_1
XTAP_1074 vssd1 vccd1 sky130_fd_sc_hd__tapvpwrvgnd_1
XTAP_1063 vssd1 vccd1 sky130_fd_sc_hd__tapvpwrvgnd_1
XTAP_1052 vssd1 vccd1 sky130_fd_sc_hd__tapvpwrvgnd_1
XTAP_1041 vssd1 vccd1 sky130_fd_sc_hd__tapvpwrvgnd_1
XFILLER_0_32_15 vssd1 vssd1 vccd1 vccd1 sky130_ef_sc_hd__decap_12
XTAP_1085 vssd1 vccd1 sky130_fd_sc_hd__tapvpwrvgnd_1
XTAP_1096 vssd1 vccd1 sky130_fd_sc_hd__tapvpwrvgnd_1
XFILLER_0_4_307 vssd1 vssd1 vccd1 vccd1 sky130_fd_sc_hd__fill_1
XFILLER_0_37_273 vssd1 vssd1 vccd1 vccd1 sky130_fd_sc_hd__decap_6
XFILLER_0_80_541 vssd1 vssd1 vccd1 vccd1 sky130_fd_sc_hd__decap_8
XFILLER_0_52_265 vssd1 vssd1 vccd1 vccd1 sky130_ef_sc_hd__decap_12
XFILLER_0_0_513 vssd1 vssd1 vccd1 vccd1 sky130_fd_sc_hd__decap_3
XFILLER_0_40_449 vssd1 vssd1 vccd1 vccd1 sky130_fd_sc_hd__fill_1
XTAP_825 vssd1 vccd1 sky130_fd_sc_hd__tapvpwrvgnd_1
XTAP_814 vssd1 vccd1 sky130_fd_sc_hd__tapvpwrvgnd_1
XTAP_803 vssd1 vccd1 sky130_fd_sc_hd__tapvpwrvgnd_1
XTAP_858 vssd1 vccd1 sky130_fd_sc_hd__tapvpwrvgnd_1
XTAP_847 vssd1 vccd1 sky130_fd_sc_hd__tapvpwrvgnd_1
XTAP_836 vssd1 vccd1 sky130_fd_sc_hd__tapvpwrvgnd_1
X_05970_ _00347_ _00348_ _00349_ vssd1 vssd1 vccd1 vccd1 _00350_ sky130_fd_sc_hd__and3_4
XTAP_869 vssd1 vccd1 sky130_fd_sc_hd__tapvpwrvgnd_1
X_07640_ _02008_ _02010_ _02011_ vssd1 vssd1 vccd1 vccd1 _02012_ sky130_fd_sc_hd__and3_1
X_07571_ _01664_ _01667_ _01942_ _01943_ vssd1 vssd1 vccd1 vccd1 _01944_ sky130_fd_sc_hd__o211ai_2
X_09310_ _03781_ _03783_ vssd1 vssd1 vccd1 vccd1 _03784_ sky130_fd_sc_hd__xnor2_1
X_06522_ _00895_ _00896_ vssd1 vssd1 vccd1 vccd1 _00897_ sky130_fd_sc_hd__xnor2_1
XFILLER_0_75_335 vssd1 vssd1 vccd1 vccd1 sky130_fd_sc_hd__fill_1
XFILLER_0_48_549 vssd1 vssd1 vccd1 vccd1 sky130_fd_sc_hd__decap_8
X_09241_ _03707_ _03708_ vssd1 vssd1 vccd1 vccd1 _03709_ sky130_fd_sc_hd__or2_1
X_06453_ net705 _00706_ _00826_ _00828_ vssd1 vssd1 vccd1 vccd1 _00829_ sky130_fd_sc_hd__a211o_1
XFILLER_0_90_316 vssd1 vssd1 vccd1 vccd1 sky130_fd_sc_hd__fill_1
X_09172_ net276 net284 net399 net405 vssd1 vssd1 vccd1 vccd1 _03633_ sky130_fd_sc_hd__nand4_2
XFILLER_0_56_593 vssd1 vssd1 vccd1 vccd1 sky130_fd_sc_hd__fill_1
X_06384_ _00758_ _00759_ vssd1 vssd1 vccd1 vccd1 _00760_ sky130_fd_sc_hd__nor2_1
X_05404_ _04637_ _04653_ _04672_ vssd1 vssd1 vccd1 vccd1 _04674_ sky130_fd_sc_hd__o21ai_1
X_08123_ net519 _02494_ _02493_ vssd1 vssd1 vccd1 vccd1 _02495_ sky130_fd_sc_hd__a21bo_1
X_05335_ _04602_ _04604_ vssd1 vssd1 vccd1 vccd1 _04605_ sky130_fd_sc_hd__and2b_1
X_08054_ _02261_ _02263_ _02425_ _02426_ vssd1 vssd1 vccd1 vccd1 _02427_ sky130_fd_sc_hd__o211a_2
X_05266_ _04350_ _04438_ _04448_ vssd1 vssd1 vccd1 vccd1 _04459_ sky130_fd_sc_hd__and3_1
XFILLER_0_31_438 vssd1 vssd1 vccd1 vccd1 sky130_fd_sc_hd__decap_8
X_07005_ _01372_ _01375_ vssd1 vssd1 vccd1 vccd1 _01376_ sky130_fd_sc_hd__and2b_1
XFILLER_0_101_337 vssd1 vssd1 vccd1 vccd1 sky130_ef_sc_hd__decap_12
X_05197_ _03684_ _03695_ vssd1 vssd1 vccd1 vccd1 _03706_ sky130_fd_sc_hd__and2_1
X_08956_ _03394_ _03395_ vssd1 vssd1 vccd1 vccd1 _03397_ sky130_fd_sc_hd__nand2_1
XFILLER_0_98_405 vssd1 vssd1 vccd1 vccd1 sky130_fd_sc_hd__fill_1
X_08887_ net315 net395 _03316_ _03318_ vssd1 vssd1 vccd1 vccd1 _03321_ sky130_fd_sc_hd__nand4_1
X_07907_ net73 _00962_ _01499_ net72 vssd1 vssd1 vccd1 vccd1 _02281_ sky130_fd_sc_hd__and4_1
X_07838_ _02201_ _02207_ _02208_ vssd1 vssd1 vccd1 vccd1 _02209_ sky130_fd_sc_hd__nand3_2
X_09508_ _03997_ _03998_ vssd1 vssd1 vccd1 vccd1 _04000_ sky130_fd_sc_hd__xnor2_4
X_07769_ net196 net557 net584 net176 vssd1 vssd1 vccd1 vccd1 _02140_ sky130_fd_sc_hd__a22o_1
XFILLER_0_39_527 vssd1 vssd1 vccd1 vccd1 sky130_fd_sc_hd__decap_6
XPHY_124 vssd1 vssd1 vccd1 vccd1 sky130_fd_sc_hd__decap_3
XPHY_113 vssd1 vssd1 vccd1 vccd1 sky130_fd_sc_hd__decap_3
XPHY_102 vssd1 vssd1 vccd1 vccd1 sky130_fd_sc_hd__decap_3
X_09439_ _03923_ vssd1 vssd1 vccd1 vccd1 _03925_ sky130_fd_sc_hd__inv_2
XPHY_157 vssd1 vssd1 vccd1 vccd1 sky130_fd_sc_hd__decap_3
XPHY_146 vssd1 vssd1 vccd1 vccd1 sky130_fd_sc_hd__decap_3
XPHY_135 vssd1 vssd1 vccd1 vccd1 sky130_fd_sc_hd__decap_3
XPHY_179 vssd1 vssd1 vccd1 vccd1 sky130_fd_sc_hd__decap_3
XPHY_168 vssd1 vssd1 vccd1 vccd1 sky130_fd_sc_hd__decap_3
XFILLER_0_19_273 vssd1 vssd1 vccd1 vccd1 sky130_fd_sc_hd__decap_3
XFILLER_0_62_574 vssd1 vssd1 vccd1 vccd1 sky130_fd_sc_hd__decap_8
XFILLER_0_34_265 vssd1 vssd1 vccd1 vccd1 sky130_fd_sc_hd__fill_2
XFILLER_0_62_596 vssd1 vssd1 vccd1 vccd1 sky130_fd_sc_hd__decap_6
X_10076_ clknet_3_3_0_wb_clk_i _00072_ _00008_ vssd1 vssd1 vccd1 vccd1 mul.b\[5\]
+ sky130_fd_sc_hd__dfrtp_4
XFILLER_0_27_37 vssd1 vssd1 vccd1 vccd1 sky130_fd_sc_hd__decap_4
Xmax_cap82 net714 vssd1 vssd1 vccd1 vccd1 net82 sky130_fd_sc_hd__clkbuf_2
XFILLER_0_43_25 vssd1 vssd1 vccd1 vccd1 sky130_fd_sc_hd__fill_2
XFILLER_0_57_335 vssd1 vssd1 vccd1 vccd1 sky130_fd_sc_hd__fill_1
Xmax_cap93 _01930_ vssd1 vssd1 vccd1 vccd1 net93 sky130_fd_sc_hd__buf_1
XPHY_4 vssd1 vssd1 vccd1 vccd1 sky130_fd_sc_hd__decap_3
XFILLER_0_84_132 vssd1 vssd1 vccd1 vccd1 sky130_fd_sc_hd__fill_1
XFILLER_0_72_316 vssd1 vssd1 vccd1 vccd1 sky130_fd_sc_hd__decap_4
XFILLER_0_38_571 vssd1 vssd1 vccd1 vccd1 sky130_fd_sc_hd__fill_1
XFILLER_0_53_530 vssd1 vssd1 vccd1 vccd1 sky130_ef_sc_hd__decap_12
XFILLER_0_4_104 vssd1 vssd1 vccd1 vccd1 sky130_ef_sc_hd__decap_12
XFILLER_0_25_221 vssd1 vssd1 vccd1 vccd1 sky130_fd_sc_hd__decap_3
XFILLER_0_80_360 vssd1 vssd1 vccd1 vccd1 sky130_fd_sc_hd__decap_4
X_05120_ _02733_ _02798_ _02853_ vssd1 vssd1 vccd1 vccd1 _02864_ sky130_fd_sc_hd__nand3_1
XFILLER_0_40_202 vssd1 vssd1 vccd1 vccd1 sky130_ef_sc_hd__decap_12
XFILLER_0_68_11 vssd1 vssd1 vccd1 vccd1 sky130_fd_sc_hd__decap_3
XFILLER_0_53_596 vssd1 vssd1 vccd1 vccd1 sky130_fd_sc_hd__fill_2
X_05051_ net32 net351 net132 vssd1 vssd1 vccd1 vccd1 _00104_ sky130_fd_sc_hd__mux2_1
XFILLER_0_68_66 vssd1 vssd1 vccd1 vccd1 sky130_fd_sc_hd__decap_3
XFILLER_0_0_343 vssd1 vssd1 vccd1 vccd1 sky130_fd_sc_hd__decap_8
XFILLER_0_21_460 vssd1 vssd1 vccd1 vccd1 sky130_fd_sc_hd__decap_4
XTAP_600 vssd1 vccd1 sky130_fd_sc_hd__tapvpwrvgnd_1
X_08810_ net120 _03237_ vssd1 vssd1 vccd1 vccd1 _03238_ sky130_fd_sc_hd__xnor2_2
XFILLER_0_0_365 vssd1 vssd1 vccd1 vccd1 sky130_ef_sc_hd__decap_12
XTAP_611 vssd1 vccd1 sky130_fd_sc_hd__tapvpwrvgnd_1
XTAP_622 vssd1 vccd1 sky130_fd_sc_hd__tapvpwrvgnd_1
XTAP_633 vssd1 vccd1 sky130_fd_sc_hd__tapvpwrvgnd_1
X_09790_ _04305_ _04306_ net141 vssd1 vssd1 vccd1 vccd1 _04309_ sky130_fd_sc_hd__o21a_1
XTAP_655 vssd1 vccd1 sky130_fd_sc_hd__tapvpwrvgnd_1
XTAP_644 vssd1 vccd1 sky130_fd_sc_hd__tapvpwrvgnd_1
XTAP_666 vssd1 vccd1 sky130_fd_sc_hd__tapvpwrvgnd_1
XTAP_677 vssd1 vccd1 sky130_fd_sc_hd__tapvpwrvgnd_1
X_08741_ _03160_ _03161_ vssd1 vssd1 vccd1 vccd1 _03162_ sky130_fd_sc_hd__nor2_1
X_05953_ _00229_ _00332_ vssd1 vssd1 vccd1 vccd1 _00333_ sky130_fd_sc_hd__xnor2_2
XTAP_688 vssd1 vccd1 sky130_fd_sc_hd__tapvpwrvgnd_1
XTAP_699 vssd1 vccd1 sky130_fd_sc_hd__tapvpwrvgnd_1
X_08672_ _03086_ _03085_ vssd1 vssd1 vccd1 vccd1 _03087_ sky130_fd_sc_hd__nor2_2
X_05884_ _00262_ _00263_ _00264_ vssd1 vssd1 vccd1 vccd1 _00265_ sky130_fd_sc_hd__and3_2
X_07623_ _01866_ _01868_ _01993_ _01994_ vssd1 vssd1 vccd1 vccd1 _01995_ sky130_fd_sc_hd__o211a_2
XFILLER_0_17_70 vssd1 vssd1 vccd1 vccd1 sky130_fd_sc_hd__decap_6
XFILLER_0_75_110 vssd1 vssd1 vccd1 vccd1 sky130_fd_sc_hd__fill_2
X_07554_ _01889_ _01890_ _01923_ _01924_ vssd1 vssd1 vccd1 vccd1 _01927_ sky130_fd_sc_hd__a2bb2oi_1
X_07485_ net368 net413 _01853_ _01854_ vssd1 vssd1 vccd1 vccd1 _01856_ sky130_fd_sc_hd__nand4_1
X_06505_ _00749_ _00751_ _00878_ vssd1 vssd1 vccd1 vccd1 _00880_ sky130_fd_sc_hd__and3_1
XFILLER_0_48_346 vssd1 vssd1 vccd1 vccd1 sky130_fd_sc_hd__decap_8
X_09224_ _03687_ _03688_ _03525_ _03527_ vssd1 vssd1 vccd1 vccd1 _03690_ sky130_fd_sc_hd__o211a_1
XFILLER_0_75_198 vssd1 vssd1 vccd1 vccd1 sky130_fd_sc_hd__fill_2
XFILLER_0_75_176 vssd1 vssd1 vccd1 vccd1 sky130_fd_sc_hd__decap_6
X_06436_ _00685_ _00688_ _00809_ _00811_ vssd1 vssd1 vccd1 vccd1 _00812_ sky130_fd_sc_hd__a211oi_4
XFILLER_0_90_146 vssd1 vssd1 vccd1 vccd1 sky130_fd_sc_hd__decap_3
X_09155_ _03611_ _03612_ vssd1 vssd1 vccd1 vccd1 _03614_ sky130_fd_sc_hd__xnor2_1
X_06367_ _00622_ _00624_ vssd1 vssd1 vccd1 vccd1 _00743_ sky130_fd_sc_hd__nand2_1
XFILLER_0_44_574 vssd1 vssd1 vccd1 vccd1 sky130_fd_sc_hd__decap_8
X_09086_ _03353_ _03375_ _03374_ vssd1 vssd1 vccd1 vccd1 _03539_ sky130_fd_sc_hd__a21o_1
X_08106_ _02476_ _02477_ vssd1 vssd1 vccd1 vccd1 _02478_ sky130_fd_sc_hd__or2_1
X_05318_ _04022_ _04558_ _04587_ vssd1 vssd1 vccd1 vccd1 _04588_ sky130_fd_sc_hd__and3_1
XFILLER_0_16_287 vssd1 vssd1 vccd1 vccd1 sky130_fd_sc_hd__decap_3
XFILLER_0_16_298 vssd1 vssd1 vccd1 vccd1 sky130_fd_sc_hd__fill_2
X_06298_ net292 net301 net532 net542 vssd1 vssd1 vccd1 vccd1 _00675_ sky130_fd_sc_hd__nand4_1
X_08037_ _02407_ _02408_ _02401_ vssd1 vssd1 vccd1 vccd1 _02410_ sky130_fd_sc_hd__a21o_1
X_05249_ _04175_ _04252_ _04263_ vssd1 vssd1 vccd1 vccd1 _04274_ sky130_fd_sc_hd__nand3_1
XFILLER_0_12_482 vssd1 vssd1 vccd1 vccd1 sky130_fd_sc_hd__decap_8
XFILLER_0_101_167 vssd1 vssd1 vccd1 vccd1 sky130_fd_sc_hd__fill_1
X_09988_ _04522_ _04523_ vssd1 vssd1 vccd1 vccd1 _04524_ sky130_fd_sc_hd__xnor2_1
X_08939_ _03351_ _03352_ _03376_ vssd1 vssd1 vccd1 vccd1 _03379_ sky130_fd_sc_hd__o21ai_1
XFILLER_0_98_279 vssd1 vssd1 vccd1 vccd1 sky130_fd_sc_hd__decap_3
XFILLER_0_86_419 vssd1 vssd1 vccd1 vccd1 sky130_fd_sc_hd__fill_1
XFILLER_0_67_600 vssd1 vssd1 vccd1 vccd1 sky130_fd_sc_hd__fill_2
XFILLER_0_94_452 vssd1 vssd1 vccd1 vccd1 sky130_fd_sc_hd__decap_8
XFILLER_0_81_113 vssd1 vssd1 vccd1 vccd1 sky130_fd_sc_hd__fill_1
XFILLER_0_35_530 vssd1 vssd1 vccd1 vccd1 sky130_fd_sc_hd__decap_6
XFILLER_0_35_552 vssd1 vssd1 vccd1 vccd1 sky130_fd_sc_hd__decap_8
XFILLER_0_50_577 vssd1 vssd1 vccd1 vccd1 sky130_fd_sc_hd__decap_6
XFILLER_0_1_118 vssd1 vssd1 vccd1 vccd1 sky130_fd_sc_hd__fill_1
XFILLER_0_10_419 vssd1 vssd1 vccd1 vccd1 sky130_fd_sc_hd__fill_1
XFILLER_0_38_36 vssd1 vssd1 vccd1 vccd1 sky130_fd_sc_hd__fill_1
X_10128_ clknet_3_4_0_wb_clk_i _00122_ _00058_ vssd1 vssd1 vccd1 vccd1 mul.a\[23\]
+ sky130_fd_sc_hd__dfrtp_1
X_10059_ net645 vssd1 vssd1 vccd1 vccd1 _00055_ sky130_fd_sc_hd__inv_2
XFILLER_0_89_279 vssd1 vssd1 vccd1 vccd1 sky130_fd_sc_hd__fill_1
XFILLER_0_57_132 vssd1 vssd1 vccd1 vccd1 sky130_ef_sc_hd__decap_12
XFILLER_0_18_508 vssd1 vssd1 vccd1 vccd1 sky130_fd_sc_hd__fill_1
XFILLER_0_57_165 vssd1 vssd1 vccd1 vccd1 sky130_fd_sc_hd__decap_3
X_07270_ _01483_ _01485_ _01638_ _01639_ vssd1 vssd1 vccd1 vccd1 _01640_ sky130_fd_sc_hd__o211a_1
XFILLER_0_72_135 vssd1 vssd1 vccd1 vccd1 sky130_fd_sc_hd__decap_4
X_06221_ _00183_ _00280_ _00377_ _00481_ vssd1 vssd1 vccd1 vccd1 _00599_ sky130_fd_sc_hd__nor4_2
XFILLER_0_26_541 vssd1 vssd1 vccd1 vccd1 sky130_fd_sc_hd__decap_3
XFILLER_0_45_349 vssd1 vssd1 vccd1 vccd1 sky130_fd_sc_hd__decap_8
XFILLER_0_5_435 vssd1 vssd1 vccd1 vccd1 sky130_fd_sc_hd__fill_2
XFILLER_0_53_393 vssd1 vssd1 vccd1 vccd1 sky130_fd_sc_hd__decap_6
XFILLER_0_53_371 vssd1 vssd1 vccd1 vccd1 sky130_fd_sc_hd__fill_1
X_06152_ _00423_ _00529_ vssd1 vssd1 vccd1 vccd1 _00530_ sky130_fd_sc_hd__nand2_2
XFILLER_0_26_596 vssd1 vssd1 vccd1 vccd1 sky130_fd_sc_hd__fill_1
X_05103_ _02645_ _02656_ _02667_ vssd1 vssd1 vccd1 vccd1 _02678_ sky130_fd_sc_hd__nand3_1
X_06083_ _00419_ _00420_ _00460_ _00461_ vssd1 vssd1 vccd1 vccd1 _00462_ sky130_fd_sc_hd__nor4_1
XFILLER_0_41_566 vssd1 vssd1 vccd1 vccd1 sky130_fd_sc_hd__fill_2
X_09911_ _04153_ _04302_ _04304_ vssd1 vssd1 vccd1 vccd1 _04441_ sky130_fd_sc_hd__a21oi_1
X_05034_ net19 net204 net134 vssd1 vssd1 vccd1 vccd1 _00121_ sky130_fd_sc_hd__mux2_1
Xfanout605 net606 vssd1 vssd1 vccd1 vccd1 net605 sky130_fd_sc_hd__clkbuf_4
XFILLER_0_0_162 vssd1 vssd1 vccd1 vccd1 sky130_fd_sc_hd__decap_6
X_09842_ net239 net400 net407 net230 vssd1 vssd1 vccd1 vccd1 _04365_ sky130_fd_sc_hd__a22o_1
XFILLER_0_0_195 vssd1 vssd1 vccd1 vccd1 sky130_fd_sc_hd__fill_1
Xfanout638 net641 vssd1 vssd1 vccd1 vccd1 net638 sky130_fd_sc_hd__buf_4
Xfanout616 net621 vssd1 vssd1 vccd1 vccd1 net616 sky130_fd_sc_hd__buf_2
XTAP_441 vssd1 vccd1 sky130_fd_sc_hd__tapvpwrvgnd_1
XTAP_430 vssd1 vccd1 sky130_fd_sc_hd__tapvpwrvgnd_1
Xfanout627 net629 vssd1 vssd1 vccd1 vccd1 net627 sky130_fd_sc_hd__buf_2
X_09773_ _04268_ _04289_ vssd1 vssd1 vccd1 vccd1 _04290_ sky130_fd_sc_hd__nand2_1
XTAP_452 vssd1 vccd1 sky130_fd_sc_hd__tapvpwrvgnd_1
XTAP_463 vssd1 vccd1 sky130_fd_sc_hd__tapvpwrvgnd_1
XTAP_474 vssd1 vccd1 sky130_fd_sc_hd__tapvpwrvgnd_1
XTAP_485 vssd1 vccd1 sky130_fd_sc_hd__tapvpwrvgnd_1
X_08724_ _03141_ _03142_ vssd1 vssd1 vccd1 vccd1 _03143_ sky130_fd_sc_hd__nand2_2
XTAP_496 vssd1 vccd1 sky130_fd_sc_hd__tapvpwrvgnd_1
X_06985_ _01355_ _01356_ vssd1 vssd1 vccd1 vccd1 _01357_ sky130_fd_sc_hd__and2_1
X_05936_ _00314_ _00315_ vssd1 vssd1 vccd1 vccd1 _00316_ sky130_fd_sc_hd__and2_1
X_08655_ _03067_ _03046_ vssd1 vssd1 vccd1 vccd1 _03068_ sky130_fd_sc_hd__and2b_1
XFILLER_0_68_419 vssd1 vssd1 vccd1 vccd1 sky130_fd_sc_hd__fill_1
X_05867_ _00245_ _00246_ _00238_ vssd1 vssd1 vccd1 vccd1 _00248_ sky130_fd_sc_hd__a21o_1
X_08586_ _02818_ _02821_ _02990_ _02991_ vssd1 vssd1 vccd1 vccd1 _02992_ sky130_fd_sc_hd__a211oi_2
X_07606_ _01815_ _01817_ vssd1 vssd1 vccd1 vccd1 _01978_ sky130_fd_sc_hd__nand2_1
X_07537_ net231 net527 vssd1 vssd1 vccd1 vccd1 _01910_ sky130_fd_sc_hd__and2_1
X_05798_ _04975_ _00179_ vssd1 vssd1 vccd1 vccd1 _00180_ sky130_fd_sc_hd__nand2_1
X_07468_ net205 net564 net573 net195 vssd1 vssd1 vccd1 vccd1 _01837_ sky130_fd_sc_hd__a22oi_1
X_09207_ _03163_ _03464_ net137 net315 vssd1 vssd1 vccd1 vccd1 _03671_ sky130_fd_sc_hd__o2bb2a_1
XFILLER_0_63_157 vssd1 vssd1 vccd1 vccd1 sky130_fd_sc_hd__decap_6
X_07399_ _01765_ _01766_ _01616_ _01618_ vssd1 vssd1 vccd1 vccd1 _01768_ sky130_fd_sc_hd__a211o_1
X_06419_ _00791_ _00794_ vssd1 vssd1 vccd1 vccd1 _00795_ sky130_fd_sc_hd__xor2_1
X_09138_ _03581_ _03582_ _03594_ vssd1 vssd1 vccd1 vccd1 _03595_ sky130_fd_sc_hd__nor3_1
XFILLER_0_32_533 vssd1 vssd1 vccd1 vccd1 sky130_ef_sc_hd__decap_12
XFILLER_0_71_190 vssd1 vssd1 vccd1 vccd1 sky130_fd_sc_hd__decap_6
XFILLER_0_32_555 vssd1 vssd1 vccd1 vccd1 sky130_fd_sc_hd__decap_6
XFILLER_0_32_566 vssd1 vssd1 vccd1 vccd1 sky130_fd_sc_hd__decap_8
X_09069_ _03357_ _03363_ _03362_ vssd1 vssd1 vccd1 vccd1 _03521_ sky130_fd_sc_hd__a21oi_2
XFILLER_0_4_490 vssd1 vssd1 vccd1 vccd1 sky130_fd_sc_hd__fill_1
XFILLER_0_12_290 vssd1 vssd1 vccd1 vccd1 sky130_fd_sc_hd__decap_3
XFILLER_0_39_143 vssd1 vssd1 vccd1 vccd1 sky130_fd_sc_hd__decap_6
XFILLER_0_54_157 vssd1 vssd1 vccd1 vccd1 sky130_fd_sc_hd__decap_8
XFILLER_0_62_190 vssd1 vssd1 vccd1 vccd1 sky130_fd_sc_hd__decap_6
XFILLER_0_49_57 vssd1 vssd1 vccd1 vccd1 sky130_fd_sc_hd__decap_8
X_06770_ _01140_ _01141_ _01139_ vssd1 vssd1 vccd1 vccd1 _01143_ sky130_fd_sc_hd__o21ai_1
X_05721_ _04924_ _04989_ vssd1 vssd1 vccd1 vccd1 _04991_ sky130_fd_sc_hd__xnor2_1
X_08440_ _02828_ _02830_ _02638_ _02662_ vssd1 vssd1 vccd1 vccd1 _02833_ sky130_fd_sc_hd__o211a_1
XFILLER_0_81_33 vssd1 vssd1 vccd1 vccd1 sky130_fd_sc_hd__decap_8
X_05652_ _04921_ _04914_ vssd1 vssd1 vccd1 vccd1 _04922_ sky130_fd_sc_hd__nand2b_1
XFILLER_0_85_271 vssd1 vssd1 vccd1 vccd1 sky130_fd_sc_hd__fill_2
X_08371_ _02585_ _02587_ _02756_ _02757_ vssd1 vssd1 vccd1 vccd1 _02758_ sky130_fd_sc_hd__a211oi_2
XFILLER_0_58_463 vssd1 vssd1 vccd1 vccd1 sky130_fd_sc_hd__fill_2
X_05583_ _04850_ _04851_ vssd1 vssd1 vccd1 vccd1 _04853_ sky130_fd_sc_hd__xnor2_2
X_07322_ net391 net402 net410 net383 vssd1 vssd1 vccd1 vccd1 _01691_ sky130_fd_sc_hd__a22oi_4
XFILLER_0_14_82 vssd1 vssd1 vccd1 vccd1 sky130_fd_sc_hd__fill_2
XFILLER_0_61_617 vssd1 vssd1 vccd1 vccd1 sky130_fd_sc_hd__fill_2
XFILLER_0_61_606 vssd1 vssd1 vccd1 vccd1 sky130_fd_sc_hd__fill_1
X_07253_ _01587_ _01588_ _01621_ _01622_ vssd1 vssd1 vccd1 vccd1 _01623_ sky130_fd_sc_hd__nor4_1
X_07184_ _01551_ _01552_ net384 net413 vssd1 vssd1 vccd1 vccd1 _01554_ sky130_fd_sc_hd__and4bb_1
X_06204_ _00579_ _00580_ _00460_ net717 vssd1 vssd1 vccd1 vccd1 _00582_ sky130_fd_sc_hd__a211o_1
XFILLER_0_14_544 vssd1 vssd1 vccd1 vccd1 sky130_ef_sc_hd__decap_12
X_06135_ _00511_ _00512_ vssd1 vssd1 vccd1 vccd1 _00513_ sky130_fd_sc_hd__nor2_1
XFILLER_0_41_352 vssd1 vssd1 vccd1 vccd1 sky130_fd_sc_hd__decap_3
X_06066_ _00442_ _00443_ _00441_ vssd1 vssd1 vccd1 vccd1 _00445_ sky130_fd_sc_hd__a21o_1
Xfanout402 net404 vssd1 vssd1 vccd1 vccd1 net402 sky130_fd_sc_hd__buf_4
Xfanout413 net415 vssd1 vssd1 vccd1 vccd1 net413 sky130_fd_sc_hd__clkbuf_4
Xfanout424 net425 vssd1 vssd1 vccd1 vccd1 net424 sky130_fd_sc_hd__clkbuf_4
Xfanout457 net458 vssd1 vssd1 vccd1 vccd1 net457 sky130_fd_sc_hd__buf_4
Xfanout446 mul.b\[22\] vssd1 vssd1 vccd1 vccd1 net446 sky130_fd_sc_hd__clkbuf_4
Xfanout435 mul.b\[23\] vssd1 vssd1 vccd1 vccd1 net435 sky130_fd_sc_hd__clkbuf_4
XTAP_260 vssd1 vccd1 sky130_fd_sc_hd__tapvpwrvgnd_1
X_09825_ _04202_ _04205_ vssd1 vssd1 vccd1 vccd1 _04346_ sky130_fd_sc_hd__or2_1
Xfanout479 net485 vssd1 vssd1 vccd1 vccd1 net479 sky130_fd_sc_hd__clkbuf_4
XTAP_293 vssd1 vccd1 sky130_fd_sc_hd__tapvpwrvgnd_1
XTAP_282 vssd1 vccd1 sky130_fd_sc_hd__tapvpwrvgnd_1
XTAP_271 vssd1 vccd1 sky130_fd_sc_hd__tapvpwrvgnd_1
Xfanout468 net470 vssd1 vssd1 vccd1 vccd1 net468 sky130_fd_sc_hd__buf_2
X_09756_ _04270_ net123 vssd1 vssd1 vccd1 vccd1 _04271_ sky130_fd_sc_hd__and2b_1
X_06968_ _01337_ _01338_ _01281_ vssd1 vssd1 vccd1 vccd1 _01340_ sky130_fd_sc_hd__a21o_1
X_08707_ _03113_ _03122_ vssd1 vssd1 vccd1 vccd1 _03124_ sky130_fd_sc_hd__xnor2_1
X_05919_ _00196_ _00297_ vssd1 vssd1 vccd1 vccd1 _00299_ sky130_fd_sc_hd__and2_1
X_09687_ net191 net199 net435 net441 vssd1 vssd1 vccd1 vccd1 _04195_ sky130_fd_sc_hd__and4_1
X_08638_ _02884_ _02890_ vssd1 vssd1 vccd1 vccd1 _03049_ sky130_fd_sc_hd__nand2_1
X_06899_ net389 net418 net423 net382 vssd1 vssd1 vccd1 vccd1 _01271_ sky130_fd_sc_hd__a22o_1
XFILLER_0_83_219 vssd1 vssd1 vccd1 vccd1 sky130_fd_sc_hd__decap_4
X_08569_ _02970_ _02971_ _02789_ _02802_ vssd1 vssd1 vccd1 vccd1 _02974_ sky130_fd_sc_hd__a211o_4
XFILLER_0_76_260 vssd1 vssd1 vccd1 vccd1 sky130_fd_sc_hd__decap_8
XFILLER_0_49_496 vssd1 vssd1 vccd1 vccd1 sky130_fd_sc_hd__decap_8
XFILLER_0_64_477 vssd1 vssd1 vccd1 vccd1 sky130_fd_sc_hd__fill_1
XFILLER_0_91_274 vssd1 vssd1 vccd1 vccd1 sky130_fd_sc_hd__decap_6
XFILLER_0_51_127 vssd1 vssd1 vccd1 vccd1 sky130_fd_sc_hd__decap_6
XFILLER_0_51_149 vssd1 vssd1 vccd1 vccd1 sky130_fd_sc_hd__decap_3
XFILLER_0_20_536 vssd1 vssd1 vccd1 vccd1 sky130_fd_sc_hd__decap_6
XFILLER_0_35_15 vssd1 vssd1 vccd1 vccd1 sky130_ef_sc_hd__decap_12
XFILLER_0_55_499 vssd1 vssd1 vccd1 vccd1 sky130_fd_sc_hd__decap_4
XFILLER_0_11_536 vssd1 vssd1 vccd1 vccd1 sky130_fd_sc_hd__fill_1
X_07940_ _02309_ _02311_ vssd1 vssd1 vccd1 vccd1 _02313_ sky130_fd_sc_hd__or2_1
XFILLER_0_76_33 vssd1 vssd1 vccd1 vccd1 sky130_ef_sc_hd__decap_12
XFILLER_0_76_66 vssd1 vssd1 vccd1 vccd1 sky130_fd_sc_hd__decap_8
X_07871_ _02242_ _02243_ _02239_ vssd1 vssd1 vccd1 vccd1 _02245_ sky130_fd_sc_hd__a21o_1
X_09610_ _04070_ _04109_ vssd1 vssd1 vccd1 vccd1 _04112_ sky130_fd_sc_hd__xnor2_2
X_06822_ _01191_ _01192_ _01193_ vssd1 vssd1 vccd1 vccd1 _01195_ sky130_fd_sc_hd__a21oi_1
X_09541_ _04020_ _04034_ vssd1 vssd1 vccd1 vccd1 _04036_ sky130_fd_sc_hd__or2_1
X_06753_ _00990_ _00994_ _01125_ vssd1 vssd1 vccd1 vccd1 _01126_ sky130_fd_sc_hd__a21o_1
XFILLER_0_78_514 vssd1 vssd1 vccd1 vccd1 sky130_ef_sc_hd__decap_12
X_05704_ _04971_ _04972_ vssd1 vssd1 vccd1 vccd1 _04974_ sky130_fd_sc_hd__and2_1
X_09472_ _03920_ _03959_ vssd1 vssd1 vccd1 vccd1 _03961_ sky130_fd_sc_hd__xnor2_4
X_06684_ _00918_ _00920_ _00919_ vssd1 vssd1 vccd1 vccd1 _01058_ sky130_fd_sc_hd__a21bo_1
X_08423_ net254 net457 net464 net245 vssd1 vssd1 vccd1 vccd1 _02814_ sky130_fd_sc_hd__a22o_1
XFILLER_0_65_219 vssd1 vssd1 vccd1 vccd1 sky130_fd_sc_hd__decap_4
X_05635_ _04903_ _04904_ vssd1 vssd1 vccd1 vccd1 _04905_ sky130_fd_sc_hd__nor2_1
X_08354_ _02738_ _02726_ vssd1 vssd1 vccd1 vccd1 _02739_ sky130_fd_sc_hd__and2b_1
X_05566_ _04833_ _04834_ vssd1 vssd1 vccd1 vccd1 _04836_ sky130_fd_sc_hd__nand2_1
XFILLER_0_18_102 vssd1 vssd1 vccd1 vccd1 sky130_fd_sc_hd__decap_3
XFILLER_0_18_135 vssd1 vssd1 vccd1 vccd1 sky130_fd_sc_hd__decap_4
X_07305_ _01672_ _01673_ vssd1 vssd1 vccd1 vccd1 _01674_ sky130_fd_sc_hd__nand2_1
XFILLER_0_46_477 vssd1 vssd1 vccd1 vccd1 sky130_ef_sc_hd__decap_12
X_08285_ _02638_ _02639_ _02661_ vssd1 vssd1 vccd1 vccd1 _02663_ sky130_fd_sc_hd__a21o_1
X_05497_ _04752_ _04765_ vssd1 vssd1 vccd1 vccd1 _04767_ sky130_fd_sc_hd__xnor2_2
X_07236_ net231 net240 net697 net544 vssd1 vssd1 vccd1 vccd1 _01606_ sky130_fd_sc_hd__nand4_1
XFILLER_0_14_363 vssd1 vssd1 vccd1 vccd1 sky130_fd_sc_hd__fill_1
X_07167_ _01521_ _01535_ vssd1 vssd1 vccd1 vccd1 _01537_ sky130_fd_sc_hd__xnor2_1
X_06118_ _00493_ _00494_ vssd1 vssd1 vccd1 vccd1 _00496_ sky130_fd_sc_hd__xor2_1
X_07098_ _01465_ _01466_ _01448_ vssd1 vssd1 vccd1 vccd1 _01469_ sky130_fd_sc_hd__o21ai_2
Xfanout232 net233 vssd1 vssd1 vccd1 vccd1 net232 sky130_fd_sc_hd__clkbuf_2
Xfanout221 mul.a\[20\] vssd1 vssd1 vccd1 vccd1 net221 sky130_fd_sc_hd__clkbuf_4
Xfanout210 net213 vssd1 vssd1 vccd1 vccd1 net210 sky130_fd_sc_hd__buf_4
XFILLER_0_10_580 vssd1 vssd1 vccd1 vccd1 sky130_fd_sc_hd__decap_8
X_06049_ net364 net371 net478 net487 vssd1 vssd1 vccd1 vccd1 _00428_ sky130_fd_sc_hd__and4_1
Xfanout254 net255 vssd1 vssd1 vccd1 vccd1 net254 sky130_fd_sc_hd__buf_4
Xfanout265 net266 vssd1 vssd1 vccd1 vccd1 net265 sky130_fd_sc_hd__buf_2
Xfanout243 net247 vssd1 vssd1 vccd1 vccd1 net243 sky130_fd_sc_hd__clkbuf_4
Xfanout276 net279 vssd1 vssd1 vccd1 vccd1 net276 sky130_fd_sc_hd__buf_2
Xfanout287 net291 vssd1 vssd1 vccd1 vccd1 net287 sky130_fd_sc_hd__buf_6
XFILLER_0_5_91 vssd1 vssd1 vccd1 vccd1 sky130_fd_sc_hd__fill_2
Xfanout298 mul.a\[11\] vssd1 vssd1 vccd1 vccd1 net298 sky130_fd_sc_hd__clkbuf_4
X_09808_ _04315_ _04326_ vssd1 vssd1 vccd1 vccd1 _04327_ sky130_fd_sc_hd__or2_1
X_09739_ _04240_ _04250_ vssd1 vssd1 vccd1 vccd1 _04253_ sky130_fd_sc_hd__xnor2_1
XFILLER_0_96_300 vssd1 vssd1 vccd1 vccd1 sky130_fd_sc_hd__decap_8
XFILLER_0_96_355 vssd1 vssd1 vccd1 vccd1 sky130_fd_sc_hd__decap_8
XTAP_1223 vssd1 vccd1 sky130_fd_sc_hd__tapvpwrvgnd_1
XTAP_1212 vssd1 vccd1 sky130_fd_sc_hd__tapvpwrvgnd_1
XTAP_1201 vssd1 vccd1 sky130_fd_sc_hd__tapvpwrvgnd_1
XTAP_1256 vssd1 vccd1 sky130_fd_sc_hd__tapvpwrvgnd_1
XTAP_1245 vssd1 vccd1 sky130_fd_sc_hd__tapvpwrvgnd_1
XTAP_1234 vssd1 vccd1 sky130_fd_sc_hd__tapvpwrvgnd_1
XFILLER_0_84_517 vssd1 vssd1 vccd1 vccd1 sky130_ef_sc_hd__decap_12
XFILLER_0_37_400 vssd1 vssd1 vccd1 vccd1 sky130_fd_sc_hd__decap_8
XTAP_1289 vssd1 vccd1 sky130_fd_sc_hd__tapvpwrvgnd_1
XTAP_1278 vssd1 vccd1 sky130_fd_sc_hd__tapvpwrvgnd_1
XTAP_1267 vssd1 vccd1 sky130_fd_sc_hd__tapvpwrvgnd_1
XFILLER_0_21_39 vssd1 vssd1 vccd1 vccd1 sky130_fd_sc_hd__decap_8
XFILLER_0_24_138 vssd1 vssd1 vccd1 vccd1 sky130_fd_sc_hd__fill_2
XFILLER_0_20_399 vssd1 vssd1 vccd1 vccd1 sky130_ef_sc_hd__decap_12
XFILLER_0_46_47 vssd1 vssd1 vccd1 vccd1 sky130_ef_sc_hd__decap_12
XFILLER_0_87_322 vssd1 vssd1 vccd1 vccd1 sky130_fd_sc_hd__decap_4
XFILLER_0_1_27 vssd1 vssd1 vccd1 vccd1 sky130_ef_sc_hd__decap_12
XFILLER_0_87_344 vssd1 vssd1 vccd1 vccd1 sky130_fd_sc_hd__decap_4
XFILLER_0_62_57 vssd1 vssd1 vccd1 vccd1 sky130_fd_sc_hd__decap_4
X_05420_ _04687_ _04688_ _04682_ vssd1 vssd1 vccd1 vccd1 _04690_ sky130_fd_sc_hd__a21o_1
XFILLER_0_83_561 vssd1 vssd1 vccd1 vccd1 sky130_fd_sc_hd__decap_8
X_05351_ net385 net568 vssd1 vssd1 vccd1 vccd1 _04621_ sky130_fd_sc_hd__nand2_1
XFILLER_0_28_455 vssd1 vssd1 vccd1 vccd1 sky130_fd_sc_hd__fill_2
XFILLER_0_83_583 vssd1 vssd1 vccd1 vccd1 sky130_fd_sc_hd__decap_8
XFILLER_0_55_285 vssd1 vssd1 vccd1 vccd1 sky130_fd_sc_hd__fill_1
XFILLER_0_28_477 vssd1 vssd1 vccd1 vccd1 sky130_fd_sc_hd__decap_6
X_08070_ _02119_ _02301_ _02300_ vssd1 vssd1 vccd1 vccd1 _02442_ sky130_fd_sc_hd__o21a_1
X_05282_ _04550_ _04551_ _03629_ vssd1 vssd1 vccd1 vccd1 _04552_ sky130_fd_sc_hd__a21boi_1
XFILLER_0_43_447 vssd1 vssd1 vccd1 vccd1 sky130_fd_sc_hd__fill_1
XFILLER_0_70_277 vssd1 vssd1 vccd1 vccd1 sky130_fd_sc_hd__fill_2
XFILLER_0_3_544 vssd1 vssd1 vccd1 vccd1 sky130_ef_sc_hd__decap_12
XFILLER_0_30_108 vssd1 vssd1 vccd1 vccd1 sky130_ef_sc_hd__decap_12
X_07021_ _01249_ _01253_ _01391_ vssd1 vssd1 vccd1 vccd1 _01392_ sky130_fd_sc_hd__a21o_1
XFILLER_0_23_160 vssd1 vssd1 vccd1 vccd1 sky130_fd_sc_hd__decap_8
XFILLER_0_11_355 vssd1 vssd1 vccd1 vccd1 sky130_fd_sc_hd__fill_1
X_08972_ _03405_ _03406_ _03412_ vssd1 vssd1 vccd1 vccd1 _03414_ sky130_fd_sc_hd__a21o_1
XFILLER_0_11_399 vssd1 vssd1 vccd1 vccd1 sky130_fd_sc_hd__decap_6
X_07923_ _02121_ _02295_ vssd1 vssd1 vccd1 vccd1 _02296_ sky130_fd_sc_hd__or2_1
X_07854_ net237 net510 net694 net228 vssd1 vssd1 vccd1 vccd1 _02227_ sky130_fd_sc_hd__a22o_1
XFILLER_0_39_3 vssd1 vssd1 vccd1 vccd1 sky130_ef_sc_hd__decap_12
X_06805_ net284 net293 net505 net514 vssd1 vssd1 vccd1 vccd1 _01178_ sky130_fd_sc_hd__and4_1
X_07785_ _02115_ _02155_ vssd1 vssd1 vccd1 vccd1 _02156_ sky130_fd_sc_hd__nand2_1
X_09524_ _04010_ _04016_ vssd1 vssd1 vccd1 vccd1 _04017_ sky130_fd_sc_hd__xor2_1
X_06736_ _01107_ _01108_ vssd1 vssd1 vccd1 vccd1 _01109_ sky130_fd_sc_hd__nor2_1
X_09455_ _03941_ vssd1 vssd1 vccd1 vccd1 _03942_ sky130_fd_sc_hd__inv_2
X_06667_ net330 net477 net486 net321 vssd1 vssd1 vccd1 vccd1 _01041_ sky130_fd_sc_hd__a22o_1
XFILLER_0_93_347 vssd1 vssd1 vccd1 vccd1 sky130_fd_sc_hd__fill_1
X_08406_ net231 net474 _02793_ _02794_ vssd1 vssd1 vccd1 vccd1 _02795_ sky130_fd_sc_hd__a22o_1
X_05618_ _04718_ _04808_ _04806_ vssd1 vssd1 vccd1 vccd1 _04888_ sky130_fd_sc_hd__a21oi_1
XFILLER_0_19_422 vssd1 vssd1 vccd1 vccd1 sky130_ef_sc_hd__decap_12
X_09386_ _03714_ _03865_ vssd1 vssd1 vccd1 vccd1 _03866_ sky130_fd_sc_hd__or2_1
X_06598_ _00970_ _00971_ vssd1 vssd1 vccd1 vccd1 _00972_ sky130_fd_sc_hd__xnor2_1
X_08337_ _02451_ _02453_ _02719_ vssd1 vssd1 vccd1 vccd1 _02720_ sky130_fd_sc_hd__o21a_1
X_05549_ net331 net339 net563 net571 vssd1 vssd1 vccd1 vccd1 _04819_ sky130_fd_sc_hd__and4_1
X_08268_ net299 net432 vssd1 vssd1 vccd1 vccd1 _02644_ sky130_fd_sc_hd__nand2_1
XFILLER_0_6_371 vssd1 vssd1 vccd1 vccd1 sky130_fd_sc_hd__decap_3
X_07219_ net295 net304 net483 net492 _01443_ vssd1 vssd1 vccd1 vccd1 _01589_ sky130_fd_sc_hd__a41o_1
X_08199_ _02557_ _02570_ _02571_ vssd1 vssd1 vccd1 vccd1 _02572_ sky130_fd_sc_hd__nand3_2
XFILLER_0_42_480 vssd1 vssd1 vccd1 vccd1 sky130_fd_sc_hd__decap_6
XFILLER_0_14_193 vssd1 vssd1 vccd1 vccd1 sky130_fd_sc_hd__decap_3
X_10092_ clknet_3_7_0_wb_clk_i _00088_ _00024_ vssd1 vssd1 vccd1 vccd1 mul.b\[21\]
+ sky130_fd_sc_hd__dfrtp_2
XFILLER_0_16_17 vssd1 vssd1 vccd1 vccd1 sky130_fd_sc_hd__fill_1
XTAP_1031 vssd1 vccd1 sky130_fd_sc_hd__tapvpwrvgnd_1
XTAP_1020 vssd1 vccd1 sky130_fd_sc_hd__tapvpwrvgnd_1
XFILLER_0_96_174 vssd1 vssd1 vccd1 vccd1 sky130_fd_sc_hd__fill_2
XTAP_1064 vssd1 vccd1 sky130_fd_sc_hd__tapvpwrvgnd_1
XTAP_1053 vssd1 vccd1 sky130_fd_sc_hd__tapvpwrvgnd_1
XTAP_1042 vssd1 vccd1 sky130_fd_sc_hd__tapvpwrvgnd_1
XFILLER_0_69_399 vssd1 vssd1 vccd1 vccd1 sky130_fd_sc_hd__fill_1
XFILLER_0_32_27 vssd1 vssd1 vccd1 vccd1 sky130_fd_sc_hd__fill_1
XTAP_1086 vssd1 vccd1 sky130_fd_sc_hd__tapvpwrvgnd_1
XTAP_1097 vssd1 vccd1 sky130_fd_sc_hd__tapvpwrvgnd_1
XTAP_1075 vssd1 vccd1 sky130_fd_sc_hd__tapvpwrvgnd_1
XFILLER_0_37_263 vssd1 vssd1 vccd1 vccd1 sky130_fd_sc_hd__decap_4
XFILLER_0_80_531 vssd1 vssd1 vccd1 vccd1 sky130_fd_sc_hd__fill_1
XFILLER_0_37_296 vssd1 vssd1 vccd1 vccd1 sky130_fd_sc_hd__decap_3
XFILLER_0_52_277 vssd1 vssd1 vccd1 vccd1 sky130_fd_sc_hd__decap_4
XFILLER_0_13_609 vssd1 vssd1 vccd1 vccd1 sky130_fd_sc_hd__fill_2
XTAP_826 vssd1 vccd1 sky130_fd_sc_hd__tapvpwrvgnd_1
XTAP_815 vssd1 vccd1 sky130_fd_sc_hd__tapvpwrvgnd_1
XTAP_804 vssd1 vccd1 sky130_fd_sc_hd__tapvpwrvgnd_1
XTAP_859 vssd1 vccd1 sky130_fd_sc_hd__tapvpwrvgnd_1
XTAP_848 vssd1 vccd1 sky130_fd_sc_hd__tapvpwrvgnd_1
XFILLER_0_57_57 vssd1 vssd1 vccd1 vccd1 sky130_fd_sc_hd__fill_2
XTAP_837 vssd1 vccd1 sky130_fd_sc_hd__tapvpwrvgnd_1
XFILLER_0_25_9 vssd1 vssd1 vccd1 vccd1 sky130_fd_sc_hd__fill_1
X_07570_ _01940_ _01941_ _01780_ _01782_ vssd1 vssd1 vccd1 vccd1 _01943_ sky130_fd_sc_hd__a211o_1
X_06521_ net380 net447 _00768_ _00767_ net461 vssd1 vssd1 vccd1 vccd1 _00896_ sky130_fd_sc_hd__a32o_1
X_09240_ _03550_ _03560_ vssd1 vssd1 vccd1 vccd1 _03708_ sky130_fd_sc_hd__or2_1
X_06452_ _00824_ _00825_ _00639_ _00641_ vssd1 vssd1 vccd1 vccd1 _00828_ sky130_fd_sc_hd__a211oi_2
X_09171_ net284 net399 net405 net276 vssd1 vssd1 vccd1 vccd1 _03632_ sky130_fd_sc_hd__a22o_1
XFILLER_0_56_583 vssd1 vssd1 vccd1 vccd1 sky130_fd_sc_hd__decap_4
XFILLER_0_56_572 vssd1 vssd1 vccd1 vccd1 sky130_fd_sc_hd__decap_4
X_05403_ _04671_ _04672_ vssd1 vssd1 vccd1 vccd1 _04673_ sky130_fd_sc_hd__and2b_1
X_06383_ net262 net272 net560 net571 vssd1 vssd1 vccd1 vccd1 _00759_ sky130_fd_sc_hd__and4_1
XFILLER_0_83_391 vssd1 vssd1 vccd1 vccd1 sky130_fd_sc_hd__fill_1
X_08122_ net212 net221 net509 vssd1 vssd1 vccd1 vccd1 _02494_ sky130_fd_sc_hd__and3_1
X_05334_ net386 net596 net606 net378 vssd1 vssd1 vccd1 vccd1 _04604_ sky130_fd_sc_hd__a22o_1
XFILLER_0_43_211 vssd1 vssd1 vccd1 vccd1 sky130_fd_sc_hd__decap_3
X_08053_ _02422_ _02423_ _02326_ vssd1 vssd1 vccd1 vccd1 _02426_ sky130_fd_sc_hd__o21ai_1
XFILLER_0_101_305 vssd1 vssd1 vccd1 vccd1 sky130_fd_sc_hd__decap_3
X_05265_ _04416_ _04427_ _04361_ vssd1 vssd1 vccd1 vccd1 _04448_ sky130_fd_sc_hd__a21o_1
X_07004_ _01373_ _01374_ vssd1 vssd1 vccd1 vccd1 _01375_ sky130_fd_sc_hd__nor2_1
X_05196_ net386 net540 _03662_ _03673_ vssd1 vssd1 vccd1 vccd1 _03695_ sky130_fd_sc_hd__a22o_1
XFILLER_0_101_349 vssd1 vssd1 vccd1 vccd1 sky130_ef_sc_hd__decap_12
X_08955_ _03394_ _03395_ vssd1 vssd1 vccd1 vccd1 _03396_ sky130_fd_sc_hd__or2_1
X_07906_ _01499_ net72 vssd1 vssd1 vccd1 vccd1 _02280_ sky130_fd_sc_hd__and2_1
X_08886_ net315 net395 _03316_ _03318_ vssd1 vssd1 vccd1 vccd1 _03320_ sky130_fd_sc_hd__and4_1
XFILLER_0_47_90 vssd1 vssd1 vccd1 vccd1 sky130_fd_sc_hd__decap_3
X_07837_ _02204_ _02205_ _02043_ _02045_ vssd1 vssd1 vccd1 vccd1 _02208_ sky130_fd_sc_hd__o211ai_2
X_07768_ net196 net565 _02003_ _02002_ vssd1 vssd1 vccd1 vccd1 _02139_ sky130_fd_sc_hd__a31o_1
X_09507_ _03998_ _03997_ vssd1 vssd1 vccd1 vccd1 _03999_ sky130_fd_sc_hd__and2b_1
XFILLER_0_78_163 vssd1 vssd1 vccd1 vccd1 sky130_fd_sc_hd__decap_4
XFILLER_0_78_141 vssd1 vssd1 vccd1 vccd1 sky130_fd_sc_hd__fill_1
X_06719_ _00951_ _00953_ _01090_ _01091_ vssd1 vssd1 vccd1 vccd1 _01093_ sky130_fd_sc_hd__o211ai_1
XFILLER_0_93_122 vssd1 vssd1 vccd1 vccd1 sky130_fd_sc_hd__decap_6
XFILLER_0_78_185 vssd1 vssd1 vccd1 vccd1 sky130_fd_sc_hd__fill_2
X_07699_ net220 net538 _02066_ _02068_ vssd1 vssd1 vccd1 vccd1 _02071_ sky130_fd_sc_hd__nand4_1
XPHY_125 vssd1 vssd1 vccd1 vccd1 sky130_fd_sc_hd__decap_3
XPHY_114 vssd1 vssd1 vccd1 vccd1 sky130_fd_sc_hd__decap_3
XPHY_103 vssd1 vssd1 vccd1 vccd1 sky130_fd_sc_hd__decap_3
X_09438_ _03164_ _03922_ vssd1 vssd1 vccd1 vccd1 _03923_ sky130_fd_sc_hd__xnor2_1
XPHY_158 vssd1 vssd1 vccd1 vccd1 sky130_fd_sc_hd__decap_3
XPHY_147 vssd1 vssd1 vccd1 vccd1 sky130_fd_sc_hd__decap_3
XPHY_136 vssd1 vssd1 vccd1 vccd1 sky130_fd_sc_hd__decap_3
X_09369_ _03846_ _03847_ vssd1 vssd1 vccd1 vccd1 _03849_ sky130_fd_sc_hd__or2_1
XPHY_169 vssd1 vssd1 vccd1 vccd1 sky130_fd_sc_hd__decap_3
XFILLER_0_81_317 vssd1 vssd1 vccd1 vccd1 sky130_fd_sc_hd__decap_6
XFILLER_0_74_380 vssd1 vssd1 vccd1 vccd1 sky130_fd_sc_hd__decap_8
XFILLER_0_47_594 vssd1 vssd1 vccd1 vccd1 sky130_fd_sc_hd__fill_1
XFILLER_0_22_439 vssd1 vssd1 vccd1 vccd1 sky130_fd_sc_hd__fill_2
XFILLER_0_27_16 vssd1 vssd1 vccd1 vccd1 sky130_fd_sc_hd__fill_1
X_10075_ clknet_3_3_0_wb_clk_i _00071_ _00007_ vssd1 vssd1 vccd1 vccd1 mul.b\[4\]
+ sky130_fd_sc_hd__dfrtp_4
XFILLER_0_97_461 vssd1 vssd1 vccd1 vccd1 sky130_fd_sc_hd__decap_4
Xmax_cap72 _02276_ vssd1 vssd1 vccd1 vccd1 net72 sky130_fd_sc_hd__clkbuf_1
XFILLER_0_85_623 vssd1 vssd1 vccd1 vccd1 sky130_fd_sc_hd__fill_2
XPHY_5 vssd1 vssd1 vccd1 vccd1 sky130_fd_sc_hd__decap_3
Xmax_cap83 net715 vssd1 vssd1 vccd1 vccd1 net83 sky130_fd_sc_hd__buf_1
Xmax_cap94 _01204_ vssd1 vssd1 vccd1 vccd1 net94 sky130_fd_sc_hd__clkbuf_2
XFILLER_0_65_391 vssd1 vssd1 vccd1 vccd1 sky130_fd_sc_hd__fill_1
XFILLER_0_53_542 vssd1 vssd1 vccd1 vccd1 sky130_fd_sc_hd__fill_1
XFILLER_0_4_116 vssd1 vssd1 vccd1 vccd1 sky130_ef_sc_hd__decap_12
XFILLER_0_25_244 vssd1 vssd1 vccd1 vccd1 sky130_fd_sc_hd__decap_3
XFILLER_0_40_214 vssd1 vssd1 vccd1 vccd1 sky130_fd_sc_hd__fill_2
XFILLER_0_68_34 vssd1 vssd1 vccd1 vccd1 sky130_fd_sc_hd__decap_6
XFILLER_0_7_48 vssd1 vssd1 vccd1 vccd1 sky130_fd_sc_hd__decap_4
X_05050_ net33 net339 net132 vssd1 vssd1 vccd1 vccd1 _00105_ sky130_fd_sc_hd__mux2_1
XFILLER_0_0_333 vssd1 vssd1 vccd1 vccd1 sky130_fd_sc_hd__decap_3
XFILLER_0_0_377 vssd1 vssd1 vccd1 vccd1 sky130_ef_sc_hd__decap_12
XTAP_601 vssd1 vccd1 sky130_fd_sc_hd__tapvpwrvgnd_1
XTAP_612 vssd1 vccd1 sky130_fd_sc_hd__tapvpwrvgnd_1
XTAP_623 vssd1 vccd1 sky130_fd_sc_hd__tapvpwrvgnd_1
XTAP_634 vssd1 vccd1 sky130_fd_sc_hd__tapvpwrvgnd_1
XFILLER_0_0_399 vssd1 vssd1 vccd1 vccd1 sky130_fd_sc_hd__fill_1
XTAP_656 vssd1 vccd1 sky130_fd_sc_hd__tapvpwrvgnd_1
XTAP_645 vssd1 vccd1 sky130_fd_sc_hd__tapvpwrvgnd_1
XTAP_667 vssd1 vccd1 sky130_fd_sc_hd__tapvpwrvgnd_1
X_08740_ net153 net566 _03158_ vssd1 vssd1 vccd1 vccd1 _03161_ sky130_fd_sc_hd__and3_1
XFILLER_0_84_55 vssd1 vssd1 vccd1 vccd1 sky130_fd_sc_hd__fill_1
X_05952_ _00325_ _00330_ vssd1 vssd1 vccd1 vccd1 _00332_ sky130_fd_sc_hd__xnor2_1
XTAP_678 vssd1 vccd1 sky130_fd_sc_hd__tapvpwrvgnd_1
XTAP_689 vssd1 vccd1 sky130_fd_sc_hd__tapvpwrvgnd_1
X_08671_ _02770_ _02920_ _02918_ vssd1 vssd1 vccd1 vccd1 _03086_ sky130_fd_sc_hd__a21oi_1
X_05883_ _05016_ _05017_ _00159_ _00158_ _00157_ vssd1 vssd1 vccd1 vccd1 _00264_ sky130_fd_sc_hd__o32ai_2
X_07622_ _01991_ _01992_ _01975_ vssd1 vssd1 vccd1 vccd1 _01994_ sky130_fd_sc_hd__o21ai_1
XFILLER_0_88_494 vssd1 vssd1 vccd1 vccd1 sky130_ef_sc_hd__decap_12
X_07553_ _01889_ _01890_ _01923_ _01924_ vssd1 vssd1 vccd1 vccd1 _01926_ sky130_fd_sc_hd__or4bb_4
X_07484_ net368 net413 _01853_ _01854_ vssd1 vssd1 vccd1 vccd1 _01855_ sky130_fd_sc_hd__a22o_1
X_06504_ _00749_ _00751_ _00878_ vssd1 vssd1 vccd1 vccd1 _00879_ sky130_fd_sc_hd__a21oi_2
X_09223_ _03525_ _03527_ _03687_ _03688_ vssd1 vssd1 vccd1 vccd1 _03689_ sky130_fd_sc_hd__a211oi_2
X_06435_ _00807_ _00808_ _00790_ vssd1 vssd1 vccd1 vccd1 _00811_ sky130_fd_sc_hd__a21oi_2
XFILLER_0_90_125 vssd1 vssd1 vccd1 vccd1 sky130_ef_sc_hd__decap_12
X_09154_ _03611_ _03612_ vssd1 vssd1 vccd1 vccd1 _03613_ sky130_fd_sc_hd__nand2_1
XFILLER_0_56_391 vssd1 vssd1 vccd1 vccd1 sky130_fd_sc_hd__fill_1
XFILLER_0_8_477 vssd1 vssd1 vccd1 vccd1 sky130_fd_sc_hd__fill_1
XFILLER_0_71_350 vssd1 vssd1 vccd1 vccd1 sky130_fd_sc_hd__decap_3
X_08105_ _02303_ _02317_ _02316_ vssd1 vssd1 vccd1 vccd1 _02477_ sky130_fd_sc_hd__a21oi_2
X_06366_ _00740_ _00741_ vssd1 vssd1 vccd1 vccd1 _00742_ sky130_fd_sc_hd__nand2_1
X_09085_ _03534_ _03535_ _03536_ vssd1 vssd1 vccd1 vccd1 _03538_ sky130_fd_sc_hd__o21ai_1
X_05317_ _04583_ _04586_ _04582_ vssd1 vssd1 vccd1 vccd1 _04587_ sky130_fd_sc_hd__a21bo_1
X_06297_ net311 net522 vssd1 vssd1 vccd1 vccd1 _00674_ sky130_fd_sc_hd__and2_1
XFILLER_0_31_225 vssd1 vssd1 vccd1 vccd1 sky130_fd_sc_hd__decap_6
XFILLER_0_101_102 vssd1 vssd1 vccd1 vccd1 sky130_fd_sc_hd__decap_3
X_08036_ _02401_ _02407_ _02408_ vssd1 vssd1 vccd1 vccd1 _02409_ sky130_fd_sc_hd__nand3_2
X_05248_ _04219_ _04230_ _04241_ vssd1 vssd1 vccd1 vccd1 _04263_ sky130_fd_sc_hd__a21o_1
XFILLER_0_31_247 vssd1 vssd1 vccd1 vccd1 sky130_fd_sc_hd__fill_1
XFILLER_0_101_146 vssd1 vssd1 vccd1 vccd1 sky130_fd_sc_hd__fill_1
X_05179_ net328 net622 net630 net320 vssd1 vssd1 vccd1 vccd1 _03509_ sky130_fd_sc_hd__a22oi_1
X_09987_ net147 net588 net138 _04403_ _04404_ vssd1 vssd1 vccd1 vccd1 _04523_ sky130_fd_sc_hd__a32o_1
X_08938_ _03351_ _03352_ _03376_ vssd1 vssd1 vccd1 vccd1 _03377_ sky130_fd_sc_hd__or3_1
XFILLER_0_98_214 vssd1 vssd1 vccd1 vccd1 sky130_fd_sc_hd__fill_1
X_08869_ _03143_ _03145_ _03299_ _03300_ vssd1 vssd1 vccd1 vccd1 _03302_ sky130_fd_sc_hd__a211oi_2
XFILLER_0_98_247 vssd1 vssd1 vccd1 vccd1 sky130_fd_sc_hd__decap_4
XFILLER_0_94_475 vssd1 vssd1 vccd1 vccd1 sky130_fd_sc_hd__fill_1
XFILLER_0_66_166 vssd1 vssd1 vccd1 vccd1 sky130_ef_sc_hd__decap_12
XFILLER_0_81_147 vssd1 vssd1 vccd1 vccd1 sky130_fd_sc_hd__fill_2
XFILLER_0_81_169 vssd1 vssd1 vccd1 vccd1 sky130_fd_sc_hd__decap_4
XFILLER_0_50_545 vssd1 vssd1 vccd1 vccd1 sky130_fd_sc_hd__fill_1
XFILLER_0_22_236 vssd1 vssd1 vccd1 vccd1 sky130_fd_sc_hd__fill_1
XFILLER_0_50_589 vssd1 vssd1 vccd1 vccd1 sky130_fd_sc_hd__decap_3
XFILLER_0_22_269 vssd1 vssd1 vccd1 vccd1 sky130_fd_sc_hd__fill_1
XFILLER_0_38_15 vssd1 vssd1 vccd1 vccd1 sky130_fd_sc_hd__decap_6
X_10127_ clknet_3_4_0_wb_clk_i _00121_ _00057_ vssd1 vssd1 vccd1 vccd1 mul.a\[22\]
+ sky130_fd_sc_hd__dfrtp_1
X_10058_ net645 vssd1 vssd1 vccd1 vccd1 _00054_ sky130_fd_sc_hd__inv_2
XFILLER_0_54_25 vssd1 vssd1 vccd1 vccd1 sky130_fd_sc_hd__decap_3
XFILLER_0_77_409 vssd1 vssd1 vccd1 vccd1 sky130_fd_sc_hd__fill_2
XFILLER_0_57_111 vssd1 vssd1 vccd1 vccd1 sky130_fd_sc_hd__fill_1
XFILLER_0_57_144 vssd1 vssd1 vccd1 vccd1 sky130_fd_sc_hd__decap_8
XFILLER_0_85_464 vssd1 vssd1 vccd1 vccd1 sky130_fd_sc_hd__decap_4
XFILLER_0_72_103 vssd1 vssd1 vccd1 vccd1 sky130_fd_sc_hd__decap_8
X_06220_ _00377_ _00378_ _00481_ _00597_ _00480_ vssd1 vssd1 vccd1 vccd1 _00598_ sky130_fd_sc_hd__o32ai_4
XFILLER_0_38_380 vssd1 vssd1 vccd1 vccd1 sky130_ef_sc_hd__decap_12
XFILLER_0_72_169 vssd1 vssd1 vccd1 vccd1 sky130_fd_sc_hd__decap_8
XFILLER_0_26_575 vssd1 vssd1 vccd1 vccd1 sky130_fd_sc_hd__fill_1
X_06151_ _00527_ _00528_ vssd1 vssd1 vccd1 vccd1 _00529_ sky130_fd_sc_hd__nor2_1
X_05102_ net335 net594 net604 net327 vssd1 vssd1 vccd1 vccd1 _02667_ sky130_fd_sc_hd__a22o_1
X_06082_ _00458_ _00459_ _00354_ _00356_ vssd1 vssd1 vccd1 vccd1 _00461_ sky130_fd_sc_hd__a211oi_2
XFILLER_0_41_545 vssd1 vssd1 vccd1 vccd1 sky130_fd_sc_hd__fill_1
X_09910_ _04436_ _04437_ vssd1 vssd1 vccd1 vccd1 _04440_ sky130_fd_sc_hd__xnor2_2
X_05033_ net20 net195 net135 vssd1 vssd1 vccd1 vccd1 _00122_ sky130_fd_sc_hd__mux2_1
Xfanout606 mul.b\[3\] vssd1 vssd1 vccd1 vccd1 net606 sky130_fd_sc_hd__clkbuf_4
XFILLER_0_0_141 vssd1 vssd1 vccd1 vccd1 sky130_fd_sc_hd__decap_3
X_09841_ _03164_ _04363_ vssd1 vssd1 vccd1 vccd1 _04364_ sky130_fd_sc_hd__xnor2_2
Xfanout617 net621 vssd1 vssd1 vccd1 vccd1 net617 sky130_fd_sc_hd__clkbuf_4
XTAP_420 vssd1 vccd1 sky130_fd_sc_hd__tapvpwrvgnd_1
XTAP_442 vssd1 vccd1 sky130_fd_sc_hd__tapvpwrvgnd_1
XTAP_431 vssd1 vccd1 sky130_fd_sc_hd__tapvpwrvgnd_1
Xfanout639 net641 vssd1 vssd1 vccd1 vccd1 net639 sky130_fd_sc_hd__buf_4
Xfanout628 net629 vssd1 vssd1 vccd1 vccd1 net628 sky130_fd_sc_hd__clkbuf_4
X_09772_ _04269_ _04288_ vssd1 vssd1 vccd1 vccd1 _04289_ sky130_fd_sc_hd__xnor2_2
XTAP_453 vssd1 vccd1 sky130_fd_sc_hd__tapvpwrvgnd_1
XTAP_464 vssd1 vccd1 sky130_fd_sc_hd__tapvpwrvgnd_1
XTAP_475 vssd1 vccd1 sky130_fd_sc_hd__tapvpwrvgnd_1
X_06984_ _01353_ _01354_ _01214_ _01216_ vssd1 vssd1 vccd1 vccd1 _01356_ sky130_fd_sc_hd__a211o_1
X_08723_ net232 net241 net458 net465 _02985_ vssd1 vssd1 vccd1 vccd1 _03142_ sky130_fd_sc_hd__a41o_1
X_05935_ _00209_ _00214_ _00313_ vssd1 vssd1 vccd1 vccd1 _00315_ sky130_fd_sc_hd__or3_1
XTAP_486 vssd1 vccd1 sky130_fd_sc_hd__tapvpwrvgnd_1
XTAP_497 vssd1 vccd1 sky130_fd_sc_hd__tapvpwrvgnd_1
XFILLER_0_28_92 vssd1 vssd1 vccd1 vccd1 sky130_fd_sc_hd__decap_3
XFILLER_0_21_3 vssd1 vssd1 vccd1 vccd1 sky130_fd_sc_hd__fill_2
XFILLER_0_95_206 vssd1 vssd1 vccd1 vccd1 sky130_fd_sc_hd__decap_6
X_08654_ _03065_ net119 vssd1 vssd1 vccd1 vccd1 _03067_ sky130_fd_sc_hd__xnor2_1
X_05866_ _00238_ _00245_ _00246_ vssd1 vssd1 vccd1 vccd1 _00247_ sky130_fd_sc_hd__nand3_1
XFILLER_0_95_239 vssd1 vssd1 vccd1 vccd1 sky130_fd_sc_hd__decap_4
XFILLER_0_95_217 vssd1 vssd1 vccd1 vccd1 sky130_fd_sc_hd__decap_6
X_08585_ _02988_ _02989_ _02975_ vssd1 vssd1 vccd1 vccd1 _02991_ sky130_fd_sc_hd__a21oi_1
X_07605_ _01840_ _01847_ _01846_ vssd1 vssd1 vccd1 vccd1 _01977_ sky130_fd_sc_hd__a21oi_1
X_05797_ _00176_ _00177_ vssd1 vssd1 vccd1 vccd1 _00179_ sky130_fd_sc_hd__xnor2_1
XFILLER_0_49_623 vssd1 vssd1 vccd1 vccd1 sky130_fd_sc_hd__fill_2
XFILLER_0_76_453 vssd1 vssd1 vccd1 vccd1 sky130_fd_sc_hd__decap_4
X_07536_ net220 net223 net537 net547 vssd1 vssd1 vccd1 vccd1 _01909_ sky130_fd_sc_hd__nand4_2
XFILLER_0_48_133 vssd1 vssd1 vccd1 vccd1 sky130_fd_sc_hd__fill_1
XFILLER_0_76_486 vssd1 vssd1 vccd1 vccd1 sky130_fd_sc_hd__decap_6
XFILLER_0_91_434 vssd1 vssd1 vccd1 vccd1 sky130_ef_sc_hd__decap_12
X_09206_ _03669_ vssd1 vssd1 vccd1 vccd1 _03670_ sky130_fd_sc_hd__inv_2
XFILLER_0_17_520 vssd1 vssd1 vccd1 vccd1 sky130_fd_sc_hd__fill_1
X_07467_ _01832_ _01834_ _01683_ _01685_ vssd1 vssd1 vccd1 vccd1 _01836_ sky130_fd_sc_hd__o211ai_2
X_07398_ _01616_ net114 _01765_ _01766_ vssd1 vssd1 vccd1 vccd1 _01767_ sky130_fd_sc_hd__o211ai_2
X_06418_ net511 _00793_ _00792_ vssd1 vssd1 vccd1 vccd1 _00794_ sky130_fd_sc_hd__a21bo_1
X_09137_ _03583_ _03592_ vssd1 vssd1 vccd1 vccd1 _03594_ sky130_fd_sc_hd__xnor2_2
X_06349_ _00722_ _00723_ vssd1 vssd1 vccd1 vccd1 _00725_ sky130_fd_sc_hd__xor2_1
XFILLER_0_32_512 vssd1 vssd1 vccd1 vccd1 sky130_fd_sc_hd__fill_2
X_09068_ _03506_ _03517_ vssd1 vssd1 vccd1 vccd1 _03519_ sky130_fd_sc_hd__xor2_2
XFILLER_0_32_545 vssd1 vssd1 vccd1 vccd1 sky130_fd_sc_hd__decap_6
X_08019_ _02379_ _02380_ _02390_ vssd1 vssd1 vccd1 vccd1 _02392_ sky130_fd_sc_hd__or3_2
XFILLER_0_99_523 vssd1 vssd1 vccd1 vccd1 sky130_fd_sc_hd__decap_6
XFILLER_0_99_556 vssd1 vssd1 vccd1 vccd1 sky130_fd_sc_hd__fill_1
XFILLER_0_94_261 vssd1 vssd1 vccd1 vccd1 sky130_fd_sc_hd__fill_1
XFILLER_0_67_475 vssd1 vssd1 vccd1 vccd1 sky130_fd_sc_hd__fill_2
XFILLER_0_54_114 vssd1 vssd1 vccd1 vccd1 sky130_fd_sc_hd__decap_8
XFILLER_0_42_309 vssd1 vssd1 vccd1 vccd1 sky130_ef_sc_hd__decap_12
XFILLER_0_82_489 vssd1 vssd1 vccd1 vccd1 sky130_fd_sc_hd__decap_4
XFILLER_0_23_556 vssd1 vssd1 vccd1 vccd1 sky130_fd_sc_hd__decap_4
XFILLER_0_65_24 vssd1 vssd1 vccd1 vccd1 sky130_fd_sc_hd__fill_2
XFILLER_0_65_13 vssd1 vssd1 vccd1 vccd1 sky130_fd_sc_hd__fill_2
XFILLER_0_65_57 vssd1 vssd1 vccd1 vccd1 sky130_fd_sc_hd__fill_1
XFILLER_0_65_68 vssd1 vssd1 vccd1 vccd1 sky130_ef_sc_hd__decap_12
X_05720_ _04924_ _04989_ vssd1 vssd1 vccd1 vccd1 _04990_ sky130_fd_sc_hd__nor2_1
X_05651_ _04819_ _04919_ vssd1 vssd1 vccd1 vccd1 _04921_ sky130_fd_sc_hd__xnor2_1
X_08370_ _02753_ _02754_ _02481_ _02483_ vssd1 vssd1 vccd1 vccd1 _02757_ sky130_fd_sc_hd__o211a_1
X_05582_ _04851_ _04850_ vssd1 vssd1 vccd1 vccd1 _04852_ sky130_fd_sc_hd__nand2b_1
X_07321_ _01687_ _01688_ _01534_ _01536_ vssd1 vssd1 vccd1 vccd1 _01690_ sky130_fd_sc_hd__o211a_1
X_07252_ _01619_ _01620_ _01465_ _01467_ vssd1 vssd1 vccd1 vccd1 _01622_ sky130_fd_sc_hd__a211oi_1
XFILLER_0_5_211 vssd1 vssd1 vccd1 vccd1 sky130_ef_sc_hd__decap_12
X_07183_ net384 net413 _01551_ _01552_ vssd1 vssd1 vccd1 vccd1 _01553_ sky130_fd_sc_hd__o2bb2a_1
XFILLER_0_5_233 vssd1 vssd1 vccd1 vccd1 sky130_fd_sc_hd__fill_2
X_06203_ _00460_ net717 _00579_ _00580_ vssd1 vssd1 vccd1 vccd1 _00581_ sky130_fd_sc_hd__o211ai_4
XFILLER_0_26_372 vssd1 vssd1 vccd1 vccd1 sky130_ef_sc_hd__decap_12
XFILLER_0_60_139 vssd1 vssd1 vccd1 vccd1 sky130_fd_sc_hd__fill_1
XFILLER_0_53_191 vssd1 vssd1 vccd1 vccd1 sky130_fd_sc_hd__fill_1
XFILLER_0_5_277 vssd1 vssd1 vccd1 vccd1 sky130_fd_sc_hd__decap_3
XFILLER_0_5_266 vssd1 vssd1 vccd1 vccd1 sky130_fd_sc_hd__decap_8
XFILLER_0_14_556 vssd1 vssd1 vccd1 vccd1 sky130_fd_sc_hd__fill_1
X_06134_ net226 net626 net634 net219 vssd1 vssd1 vccd1 vccd1 _00512_ sky130_fd_sc_hd__a22oi_1
XFILLER_0_69_3 vssd1 vssd1 vccd1 vccd1 sky130_fd_sc_hd__decap_8
X_06065_ _00441_ _00442_ _00443_ vssd1 vssd1 vccd1 vccd1 _00444_ sky130_fd_sc_hd__nand3_1
Xfanout403 net404 vssd1 vssd1 vccd1 vccd1 net403 sky130_fd_sc_hd__buf_2
Xfanout414 net415 vssd1 vssd1 vccd1 vccd1 net414 sky130_fd_sc_hd__clkbuf_4
Xfanout425 mul.b\[25\] vssd1 vssd1 vccd1 vccd1 net425 sky130_fd_sc_hd__buf_2
Xfanout436 net437 vssd1 vssd1 vccd1 vccd1 net436 sky130_fd_sc_hd__buf_4
XTAP_250 vssd1 vccd1 sky130_fd_sc_hd__tapvpwrvgnd_1
Xfanout447 net448 vssd1 vssd1 vccd1 vccd1 net447 sky130_fd_sc_hd__clkbuf_4
X_09824_ _04343_ _04344_ vssd1 vssd1 vccd1 vccd1 _04345_ sky130_fd_sc_hd__xnor2_1
Xfanout458 mul.b\[20\] vssd1 vssd1 vccd1 vccd1 net458 sky130_fd_sc_hd__clkbuf_4
XTAP_283 vssd1 vccd1 sky130_fd_sc_hd__tapvpwrvgnd_1
XTAP_272 vssd1 vccd1 sky130_fd_sc_hd__tapvpwrvgnd_1
XTAP_261 vssd1 vccd1 sky130_fd_sc_hd__tapvpwrvgnd_1
Xfanout469 net470 vssd1 vssd1 vccd1 vccd1 net469 sky130_fd_sc_hd__clkbuf_4
X_09755_ _03163_ _04072_ net136 net276 vssd1 vssd1 vccd1 vccd1 _04270_ sky130_fd_sc_hd__o2bb2a_1
XTAP_294 vssd1 vccd1 sky130_fd_sc_hd__tapvpwrvgnd_1
X_06967_ _01281_ _01337_ _01338_ vssd1 vssd1 vccd1 vccd1 _01339_ sky130_fd_sc_hd__nand3_2
X_08706_ _03113_ _03122_ vssd1 vssd1 vccd1 vccd1 _03123_ sky130_fd_sc_hd__and2_1
X_05918_ _00196_ _00297_ vssd1 vssd1 vccd1 vccd1 _00298_ sky130_fd_sc_hd__nor2_1
X_09686_ net199 net435 net441 net191 vssd1 vssd1 vccd1 vccd1 _04194_ sky130_fd_sc_hd__a22o_1
X_06898_ net382 net389 net418 net423 vssd1 vssd1 vccd1 vccd1 _01270_ sky130_fd_sc_hd__and4_1
X_08637_ _02839_ _02847_ _02846_ vssd1 vssd1 vccd1 vccd1 _03048_ sky130_fd_sc_hd__o21bai_1
X_05849_ _00227_ _00229_ vssd1 vssd1 vccd1 vccd1 _00230_ sky130_fd_sc_hd__and2_1
XFILLER_0_96_559 vssd1 vssd1 vccd1 vccd1 sky130_fd_sc_hd__fill_1
X_08568_ _02789_ net110 _02970_ _02971_ vssd1 vssd1 vccd1 vccd1 _02972_ sky130_fd_sc_hd__o211ai_4
X_08499_ _02725_ _02740_ _02739_ vssd1 vssd1 vccd1 vccd1 _02898_ sky130_fd_sc_hd__a21oi_1
XFILLER_0_76_272 vssd1 vssd1 vccd1 vccd1 sky130_fd_sc_hd__decap_8
X_07519_ net269 net500 _01746_ _01745_ vssd1 vssd1 vccd1 vccd1 _01892_ sky130_fd_sc_hd__a31o_1
XFILLER_0_9_561 vssd1 vssd1 vccd1 vccd1 sky130_fd_sc_hd__decap_3
XFILLER_0_36_125 vssd1 vssd1 vccd1 vccd1 sky130_fd_sc_hd__fill_2
XFILLER_0_24_309 vssd1 vssd1 vccd1 vccd1 sky130_ef_sc_hd__decap_12
XFILLER_0_44_180 vssd1 vssd1 vccd1 vccd1 sky130_fd_sc_hd__decap_4
XFILLER_0_35_27 vssd1 vssd1 vccd1 vccd1 sky130_ef_sc_hd__decap_12
XFILLER_0_51_15 vssd1 vssd1 vccd1 vccd1 sky130_fd_sc_hd__decap_8
XFILLER_0_82_253 vssd1 vssd1 vccd1 vccd1 sky130_fd_sc_hd__decap_8
XFILLER_0_82_286 vssd1 vssd1 vccd1 vccd1 sky130_fd_sc_hd__decap_4
XFILLER_0_35_191 vssd1 vssd1 vccd1 vccd1 sky130_fd_sc_hd__fill_1
XFILLER_0_42_139 vssd1 vssd1 vccd1 vccd1 sky130_fd_sc_hd__fill_1
XFILLER_0_50_172 vssd1 vssd1 vccd1 vccd1 sky130_fd_sc_hd__fill_1
XFILLER_0_55_9 vssd1 vssd1 vccd1 vccd1 sky130_fd_sc_hd__fill_1
XFILLER_0_11_559 vssd1 vssd1 vccd1 vccd1 sky130_fd_sc_hd__fill_1
XFILLER_0_76_45 vssd1 vssd1 vccd1 vccd1 sky130_ef_sc_hd__decap_12
XFILLER_0_76_78 vssd1 vssd1 vccd1 vccd1 sky130_fd_sc_hd__decap_6
X_07870_ _02239_ _02242_ _02243_ vssd1 vssd1 vccd1 vccd1 _02244_ sky130_fd_sc_hd__and3_1
X_06821_ _01191_ _01192_ _01193_ vssd1 vssd1 vccd1 vccd1 _01194_ sky130_fd_sc_hd__and3_1
X_09540_ _04020_ _04034_ vssd1 vssd1 vccd1 vccd1 _04035_ sky130_fd_sc_hd__nand2_1
X_06752_ _01122_ _01123_ vssd1 vssd1 vccd1 vccd1 _01125_ sky130_fd_sc_hd__xor2_1
X_09471_ _03959_ _03920_ vssd1 vssd1 vccd1 vccd1 _03960_ sky130_fd_sc_hd__and2b_1
XFILLER_0_78_526 vssd1 vssd1 vccd1 vccd1 sky130_fd_sc_hd__decap_6
X_05703_ _04971_ _04972_ vssd1 vssd1 vccd1 vccd1 _04973_ sky130_fd_sc_hd__or2_1
X_08422_ _02811_ _02812_ vssd1 vssd1 vccd1 vccd1 _02813_ sky130_fd_sc_hd__xor2_1
X_06683_ _01054_ _01055_ _01053_ vssd1 vssd1 vccd1 vccd1 _01057_ sky130_fd_sc_hd__a21o_1
XFILLER_0_58_261 vssd1 vssd1 vccd1 vccd1 sky130_fd_sc_hd__decap_8
X_05634_ net281 net616 _04901_ _04902_ vssd1 vssd1 vccd1 vccd1 _04904_ sky130_fd_sc_hd__a22oi_1
X_08353_ _02727_ _02737_ vssd1 vssd1 vccd1 vccd1 _02738_ sky130_fd_sc_hd__xnor2_2
XFILLER_0_86_592 vssd1 vssd1 vccd1 vccd1 sky130_fd_sc_hd__fill_1
X_05565_ _04833_ _04834_ vssd1 vssd1 vccd1 vccd1 _04835_ sky130_fd_sc_hd__nor2_1
X_08284_ _02638_ _02639_ _02661_ vssd1 vssd1 vccd1 vccd1 _02662_ sky130_fd_sc_hd__nand3_2
X_07304_ net190 net592 _01670_ _01671_ vssd1 vssd1 vccd1 vccd1 _01673_ sky130_fd_sc_hd__nand4_1
XFILLER_0_61_404 vssd1 vssd1 vccd1 vccd1 sky130_fd_sc_hd__decap_6
X_07235_ net250 net524 vssd1 vssd1 vccd1 vccd1 _01605_ sky130_fd_sc_hd__and2_1
XFILLER_0_6_531 vssd1 vssd1 vccd1 vccd1 sky130_fd_sc_hd__fill_1
X_05496_ _04752_ _04765_ vssd1 vssd1 vccd1 vccd1 _04766_ sky130_fd_sc_hd__or2_1
XFILLER_0_41_81 vssd1 vssd1 vccd1 vccd1 sky130_fd_sc_hd__decap_3
XFILLER_0_61_459 vssd1 vssd1 vccd1 vccd1 sky130_fd_sc_hd__decap_8
X_07166_ _01521_ _01535_ vssd1 vssd1 vccd1 vccd1 _01536_ sky130_fd_sc_hd__or2_1
X_07097_ _01448_ _01465_ _01466_ vssd1 vssd1 vccd1 vccd1 _01468_ sky130_fd_sc_hd__or3_4
X_06117_ _00493_ _00494_ vssd1 vssd1 vccd1 vccd1 _00495_ sky130_fd_sc_hd__nand2b_1
X_06048_ net379 net469 vssd1 vssd1 vccd1 vccd1 _00427_ sky130_fd_sc_hd__nand2_1
Xfanout222 net224 vssd1 vssd1 vccd1 vccd1 net222 sky130_fd_sc_hd__clkbuf_4
Xfanout200 net206 vssd1 vssd1 vccd1 vccd1 net200 sky130_fd_sc_hd__clkbuf_2
Xfanout211 net213 vssd1 vssd1 vccd1 vccd1 net211 sky130_fd_sc_hd__clkbuf_2
Xfanout255 net256 vssd1 vssd1 vccd1 vccd1 net255 sky130_fd_sc_hd__clkbuf_2
Xfanout233 net234 vssd1 vssd1 vccd1 vccd1 net233 sky130_fd_sc_hd__buf_4
Xfanout244 net247 vssd1 vssd1 vccd1 vccd1 net244 sky130_fd_sc_hd__clkbuf_2
X_07999_ net220 net228 net508 vssd1 vssd1 vccd1 vccd1 _02372_ sky130_fd_sc_hd__and3_1
Xfanout299 net300 vssd1 vssd1 vccd1 vccd1 net299 sky130_fd_sc_hd__buf_4
Xfanout266 mul.a\[15\] vssd1 vssd1 vccd1 vccd1 net266 sky130_fd_sc_hd__clkbuf_4
Xfanout288 net289 vssd1 vssd1 vccd1 vccd1 net288 sky130_fd_sc_hd__clkbuf_4
X_09807_ _04316_ _04325_ vssd1 vssd1 vccd1 vccd1 _04326_ sky130_fd_sc_hd__xnor2_1
Xfanout277 net278 vssd1 vssd1 vccd1 vccd1 net277 sky130_fd_sc_hd__clkbuf_4
X_09738_ _04240_ _04250_ vssd1 vssd1 vccd1 vccd1 _04251_ sky130_fd_sc_hd__nand2_1
XTAP_1213 vssd1 vccd1 sky130_fd_sc_hd__tapvpwrvgnd_1
XTAP_1202 vssd1 vccd1 sky130_fd_sc_hd__tapvpwrvgnd_1
X_09669_ _04173_ _04174_ vssd1 vssd1 vccd1 vccd1 _04176_ sky130_fd_sc_hd__nor2_1
XTAP_1257 vssd1 vccd1 sky130_fd_sc_hd__tapvpwrvgnd_1
XTAP_1246 vssd1 vccd1 sky130_fd_sc_hd__tapvpwrvgnd_1
XTAP_1235 vssd1 vccd1 sky130_fd_sc_hd__tapvpwrvgnd_1
XTAP_1224 vssd1 vccd1 sky130_fd_sc_hd__tapvpwrvgnd_1
XFILLER_0_84_529 vssd1 vssd1 vccd1 vccd1 sky130_fd_sc_hd__decap_3
XTAP_1279 vssd1 vccd1 sky130_fd_sc_hd__tapvpwrvgnd_1
XTAP_1268 vssd1 vccd1 sky130_fd_sc_hd__tapvpwrvgnd_1
XFILLER_0_92_562 vssd1 vssd1 vccd1 vccd1 sky130_fd_sc_hd__fill_1
XFILLER_0_64_253 vssd1 vssd1 vccd1 vccd1 sky130_fd_sc_hd__fill_1
XFILLER_0_9_391 vssd1 vssd1 vccd1 vccd1 sky130_fd_sc_hd__fill_1
XFILLER_0_60_481 vssd1 vssd1 vccd1 vccd1 sky130_ef_sc_hd__decap_12
XFILLER_0_32_172 vssd1 vssd1 vccd1 vccd1 sky130_fd_sc_hd__decap_8
XFILLER_0_46_59 vssd1 vssd1 vccd1 vccd1 sky130_ef_sc_hd__decap_12
XFILLER_0_87_334 vssd1 vssd1 vccd1 vccd1 sky130_fd_sc_hd__fill_2
XFILLER_0_1_39 vssd1 vssd1 vccd1 vccd1 sky130_ef_sc_hd__decap_12
XFILLER_0_55_253 vssd1 vssd1 vccd1 vccd1 sky130_fd_sc_hd__decap_3
XFILLER_0_7_328 vssd1 vssd1 vccd1 vccd1 sky130_fd_sc_hd__decap_8
X_05350_ _04616_ _04618_ _04619_ _04580_ vssd1 vssd1 vccd1 vccd1 _04620_ sky130_fd_sc_hd__and4bb_1
X_05281_ net97 _04546_ _03727_ vssd1 vssd1 vccd1 vccd1 _04551_ sky130_fd_sc_hd__o21ai_1
XFILLER_0_3_501 vssd1 vssd1 vccd1 vccd1 sky130_fd_sc_hd__decap_3
XFILLER_0_15_139 vssd1 vssd1 vccd1 vccd1 sky130_fd_sc_hd__decap_4
X_07020_ _01388_ _01389_ vssd1 vssd1 vccd1 vccd1 _01391_ sky130_fd_sc_hd__xor2_1
XFILLER_0_70_289 vssd1 vssd1 vccd1 vccd1 sky130_fd_sc_hd__decap_4
XFILLER_0_3_556 vssd1 vssd1 vccd1 vccd1 sky130_fd_sc_hd__decap_4
XFILLER_0_87_99 vssd1 vssd1 vccd1 vccd1 sky130_fd_sc_hd__decap_8
X_08971_ _03405_ _03406_ _03412_ vssd1 vssd1 vccd1 vccd1 _03413_ sky130_fd_sc_hd__nand3_1
XFILLER_0_11_378 vssd1 vssd1 vccd1 vccd1 sky130_fd_sc_hd__fill_1
X_07922_ _02293_ _02294_ vssd1 vssd1 vccd1 vccd1 _02295_ sky130_fd_sc_hd__xnor2_1
X_07853_ _02222_ _02224_ _02067_ _02070_ vssd1 vssd1 vccd1 vccd1 _02226_ sky130_fd_sc_hd__a211o_1
X_06804_ _01168_ _01176_ vssd1 vssd1 vccd1 vccd1 _01177_ sky130_fd_sc_hd__xnor2_1
X_07784_ _02135_ _02153_ vssd1 vssd1 vccd1 vccd1 _02155_ sky130_fd_sc_hd__xnor2_1
X_06735_ net188 net627 net635 net181 vssd1 vssd1 vccd1 vccd1 _01108_ sky130_fd_sc_hd__a22oi_1
X_09523_ _04014_ _04015_ vssd1 vssd1 vccd1 vccd1 _04016_ sky130_fd_sc_hd__or2_1
XFILLER_0_66_529 vssd1 vssd1 vccd1 vccd1 sky130_fd_sc_hd__decap_3
X_09454_ net241 net416 net424 net233 vssd1 vssd1 vccd1 vccd1 _03941_ sky130_fd_sc_hd__a22o_1
X_06666_ net321 net330 net477 net486 vssd1 vssd1 vccd1 vccd1 _01040_ sky130_fd_sc_hd__nand4_2
X_08405_ net215 net223 net482 net491 vssd1 vssd1 vccd1 vccd1 _02794_ sky130_fd_sc_hd__nand4_2
XFILLER_0_59_581 vssd1 vssd1 vccd1 vccd1 sky130_fd_sc_hd__fill_1
X_09385_ net152 net524 _03713_ vssd1 vssd1 vccd1 vccd1 _03865_ sky130_fd_sc_hd__a21oi_1
X_05617_ _04802_ _04884_ vssd1 vssd1 vccd1 vccd1 _04887_ sky130_fd_sc_hd__xnor2_1
X_08336_ _02120_ _02718_ vssd1 vssd1 vccd1 vccd1 _02719_ sky130_fd_sc_hd__xnor2_1
XFILLER_0_19_434 vssd1 vssd1 vccd1 vccd1 sky130_ef_sc_hd__decap_12
X_06597_ net203 net620 vssd1 vssd1 vccd1 vccd1 _00971_ sky130_fd_sc_hd__nand2_1
XFILLER_0_74_595 vssd1 vssd1 vccd1 vccd1 sky130_fd_sc_hd__fill_2
XFILLER_0_74_573 vssd1 vssd1 vccd1 vccd1 sky130_ef_sc_hd__decap_12
X_05548_ net339 net562 net570 net331 vssd1 vssd1 vccd1 vccd1 _04818_ sky130_fd_sc_hd__a22oi_1
X_08267_ net445 _02642_ _02641_ vssd1 vssd1 vccd1 vccd1 _02643_ sky130_fd_sc_hd__a21bo_1
XFILLER_0_61_245 vssd1 vssd1 vccd1 vccd1 sky130_fd_sc_hd__decap_6
XFILLER_0_61_223 vssd1 vssd1 vccd1 vccd1 sky130_fd_sc_hd__fill_1
X_05479_ _04711_ _04713_ vssd1 vssd1 vccd1 vccd1 _04749_ sky130_fd_sc_hd__or2_1
X_08198_ _02567_ _02568_ _02569_ vssd1 vssd1 vccd1 vccd1 _02571_ sky130_fd_sc_hd__a21o_1
X_07218_ _01585_ _01586_ _01430_ _01432_ vssd1 vssd1 vccd1 vccd1 _01588_ sky130_fd_sc_hd__o211a_1
XFILLER_0_14_172 vssd1 vssd1 vccd1 vccd1 sky130_ef_sc_hd__decap_12
X_07149_ _01517_ _01518_ vssd1 vssd1 vccd1 vccd1 _01519_ sky130_fd_sc_hd__and2_1
X_10091_ clknet_3_7_0_wb_clk_i _00087_ _00023_ vssd1 vssd1 vccd1 vccd1 mul.b\[20\]
+ sky130_fd_sc_hd__dfrtp_4
XFILLER_0_16_29 vssd1 vssd1 vccd1 vccd1 sky130_fd_sc_hd__decap_6
XFILLER_0_84_304 vssd1 vssd1 vccd1 vccd1 sky130_fd_sc_hd__decap_4
XTAP_1021 vssd1 vccd1 sky130_fd_sc_hd__tapvpwrvgnd_1
XTAP_1010 vssd1 vccd1 sky130_fd_sc_hd__tapvpwrvgnd_1
XTAP_1065 vssd1 vccd1 sky130_fd_sc_hd__tapvpwrvgnd_1
XTAP_1054 vssd1 vccd1 sky130_fd_sc_hd__tapvpwrvgnd_1
XTAP_1043 vssd1 vccd1 sky130_fd_sc_hd__tapvpwrvgnd_1
XTAP_1032 vssd1 vccd1 sky130_fd_sc_hd__tapvpwrvgnd_1
XTAP_1087 vssd1 vccd1 sky130_fd_sc_hd__tapvpwrvgnd_1
XTAP_1098 vssd1 vccd1 sky130_fd_sc_hd__tapvpwrvgnd_1
XTAP_1076 vssd1 vccd1 sky130_fd_sc_hd__tapvpwrvgnd_1
XFILLER_0_92_392 vssd1 vssd1 vccd1 vccd1 sky130_fd_sc_hd__fill_2
XFILLER_0_52_223 vssd1 vssd1 vccd1 vccd1 sky130_fd_sc_hd__decap_6
XTAP_816 vssd1 vccd1 sky130_fd_sc_hd__tapvpwrvgnd_1
XTAP_805 vssd1 vccd1 sky130_fd_sc_hd__tapvpwrvgnd_1
XTAP_849 vssd1 vccd1 sky130_fd_sc_hd__tapvpwrvgnd_1
XTAP_838 vssd1 vccd1 sky130_fd_sc_hd__tapvpwrvgnd_1
XTAP_827 vssd1 vccd1 sky130_fd_sc_hd__tapvpwrvgnd_1
XFILLER_0_20_186 vssd1 vssd1 vccd1 vccd1 sky130_fd_sc_hd__decap_8
XFILLER_0_20_197 vssd1 vssd1 vccd1 vccd1 sky130_fd_sc_hd__decap_3
XFILLER_0_73_57 vssd1 vssd1 vccd1 vccd1 sky130_ef_sc_hd__decap_12
X_06520_ _00893_ _00894_ vssd1 vssd1 vccd1 vccd1 _00895_ sky130_fd_sc_hd__nand2_1
XFILLER_0_75_337 vssd1 vssd1 vccd1 vccd1 sky130_fd_sc_hd__decap_3
X_06451_ _00639_ _00641_ _00824_ _00825_ vssd1 vssd1 vccd1 vccd1 _00827_ sky130_fd_sc_hd__o211ai_4
XFILLER_0_56_551 vssd1 vssd1 vccd1 vccd1 sky130_ef_sc_hd__decap_12
XFILLER_0_8_615 vssd1 vssd1 vccd1 vccd1 sky130_fd_sc_hd__fill_2
X_05402_ _04598_ _04615_ _04613_ vssd1 vssd1 vccd1 vccd1 _04672_ sky130_fd_sc_hd__a21oi_1
X_09170_ _03164_ _03630_ vssd1 vssd1 vccd1 vccd1 _03631_ sky130_fd_sc_hd__xnor2_1
XFILLER_0_7_147 vssd1 vssd1 vccd1 vccd1 sky130_fd_sc_hd__decap_3
XFILLER_0_16_404 vssd1 vssd1 vccd1 vccd1 sky130_fd_sc_hd__fill_1
X_06382_ net271 net560 net567 net266 vssd1 vssd1 vccd1 vccd1 _00758_ sky130_fd_sc_hd__a22oi_1
X_08121_ net220 net508 net519 net207 vssd1 vssd1 vccd1 vccd1 _02493_ sky130_fd_sc_hd__a22o_1
XFILLER_0_22_83 vssd1 vssd1 vccd1 vccd1 sky130_fd_sc_hd__fill_1
XFILLER_0_22_94 vssd1 vssd1 vccd1 vccd1 sky130_ef_sc_hd__decap_12
XFILLER_0_28_286 vssd1 vssd1 vccd1 vccd1 sky130_fd_sc_hd__decap_8
X_05333_ net370 net615 vssd1 vssd1 vccd1 vccd1 _04603_ sky130_fd_sc_hd__nand2_1
X_08052_ _02326_ _02422_ _02423_ vssd1 vssd1 vccd1 vccd1 _02425_ sky130_fd_sc_hd__or3_1
X_05264_ _04361_ _04416_ _04427_ vssd1 vssd1 vccd1 vccd1 _04438_ sky130_fd_sc_hd__nand3_1
XFILLER_0_43_267 vssd1 vssd1 vccd1 vccd1 sky130_fd_sc_hd__decap_6
XFILLER_0_43_289 vssd1 vssd1 vccd1 vccd1 sky130_fd_sc_hd__fill_2
X_07003_ net175 net629 net637 net170 vssd1 vssd1 vccd1 vccd1 _01374_ sky130_fd_sc_hd__a22oi_1
X_05195_ net385 net540 _03662_ _03673_ vssd1 vssd1 vccd1 vccd1 _03684_ sky130_fd_sc_hd__nand4_1
X_08954_ _03238_ _03239_ _03242_ vssd1 vssd1 vccd1 vccd1 _03395_ sky130_fd_sc_hd__o21ai_1
XFILLER_0_51_3 vssd1 vssd1 vccd1 vccd1 sky130_ef_sc_hd__decap_12
XFILLER_0_11_197 vssd1 vssd1 vccd1 vccd1 sky130_fd_sc_hd__fill_1
X_07905_ _01498_ _02276_ _02277_ _02278_ _02108_ vssd1 vssd1 vccd1 vccd1 _02279_ sky130_fd_sc_hd__a2111o_1
X_08885_ net315 net395 _03316_ _03318_ vssd1 vssd1 vccd1 vccd1 _03319_ sky130_fd_sc_hd__a22o_1
XFILLER_0_98_418 vssd1 vssd1 vccd1 vccd1 sky130_fd_sc_hd__fill_2
X_07836_ _02043_ _02045_ _02204_ _02205_ vssd1 vssd1 vccd1 vccd1 _02207_ sky130_fd_sc_hd__a211o_1
X_07767_ _01980_ _01982_ vssd1 vssd1 vccd1 vccd1 _02138_ sky130_fd_sc_hd__and2_1
X_09506_ _03834_ _03838_ vssd1 vssd1 vccd1 vccd1 _03998_ sky130_fd_sc_hd__nor2_2
XFILLER_0_78_131 vssd1 vssd1 vccd1 vccd1 sky130_fd_sc_hd__decap_8
XFILLER_0_2_71 vssd1 vssd1 vccd1 vccd1 sky130_ef_sc_hd__decap_12
X_06718_ _00951_ _00953_ _01090_ _01091_ vssd1 vssd1 vccd1 vccd1 _01092_ sky130_fd_sc_hd__o211a_1
XFILLER_0_78_175 vssd1 vssd1 vccd1 vccd1 sky130_fd_sc_hd__decap_4
X_07698_ net220 net538 _02066_ _02068_ vssd1 vssd1 vccd1 vccd1 _02070_ sky130_fd_sc_hd__and4_1
XPHY_115 vssd1 vssd1 vccd1 vccd1 sky130_fd_sc_hd__decap_3
XPHY_104 vssd1 vssd1 vccd1 vccd1 sky130_fd_sc_hd__decap_3
X_09437_ net291 net136 _03921_ _03310_ vssd1 vssd1 vccd1 vccd1 _03922_ sky130_fd_sc_hd__o22a_1
XPHY_148 vssd1 vssd1 vccd1 vccd1 sky130_fd_sc_hd__decap_3
XPHY_137 vssd1 vssd1 vccd1 vccd1 sky130_fd_sc_hd__decap_3
XPHY_126 vssd1 vssd1 vccd1 vccd1 sky130_fd_sc_hd__decap_3
X_06649_ _01020_ _01021_ vssd1 vssd1 vccd1 vccd1 _01023_ sky130_fd_sc_hd__xor2_1
XFILLER_0_47_540 vssd1 vssd1 vccd1 vccd1 sky130_fd_sc_hd__fill_2
X_09368_ net120 _03702_ _03701_ vssd1 vssd1 vccd1 vccd1 _03847_ sky130_fd_sc_hd__a21boi_1
XFILLER_0_93_167 vssd1 vssd1 vccd1 vccd1 sky130_fd_sc_hd__fill_1
XPHY_159 vssd1 vssd1 vccd1 vccd1 sky130_fd_sc_hd__decap_3
X_08319_ _02684_ _02698_ _02699_ vssd1 vssd1 vccd1 vccd1 _02701_ sky130_fd_sc_hd__and3_1
X_09299_ net99 _03769_ _03599_ _03624_ vssd1 vssd1 vccd1 vccd1 _03772_ sky130_fd_sc_hd__o211a_1
XFILLER_0_6_180 vssd1 vssd1 vccd1 vccd1 sky130_ef_sc_hd__decap_12
XFILLER_0_22_407 vssd1 vssd1 vccd1 vccd1 sky130_fd_sc_hd__decap_4
XFILLER_0_34_245 vssd1 vssd1 vccd1 vccd1 sky130_fd_sc_hd__decap_6
XFILLER_0_62_587 vssd1 vssd1 vccd1 vccd1 sky130_fd_sc_hd__fill_1
XFILLER_0_22_418 vssd1 vssd1 vccd1 vccd1 sky130_fd_sc_hd__fill_2
X_10074_ clknet_3_3_0_wb_clk_i _00070_ _00006_ vssd1 vssd1 vccd1 vccd1 mul.b\[3\]
+ sky130_fd_sc_hd__dfrtp_4
XFILLER_0_69_153 vssd1 vssd1 vccd1 vccd1 sky130_fd_sc_hd__decap_8
XFILLER_0_69_131 vssd1 vssd1 vccd1 vccd1 sky130_fd_sc_hd__fill_1
Xmax_cap73 net74 vssd1 vssd1 vccd1 vccd1 net73 sky130_fd_sc_hd__clkbuf_2
XPHY_6 vssd1 vssd1 vccd1 vccd1 sky130_fd_sc_hd__decap_3
Xmax_cap95 _00462_ vssd1 vssd1 vccd1 vccd1 net95 sky130_fd_sc_hd__clkbuf_2
Xmax_cap84 _00701_ vssd1 vssd1 vccd1 vccd1 net84 sky130_fd_sc_hd__buf_1
XFILLER_0_84_145 vssd1 vssd1 vccd1 vccd1 sky130_fd_sc_hd__fill_1
XFILLER_0_57_359 vssd1 vssd1 vccd1 vccd1 sky130_fd_sc_hd__fill_1
XFILLER_0_72_307 vssd1 vssd1 vccd1 vccd1 sky130_fd_sc_hd__fill_1
XFILLER_0_4_128 vssd1 vssd1 vccd1 vccd1 sky130_fd_sc_hd__fill_1
XFILLER_0_80_373 vssd1 vssd1 vccd1 vccd1 sky130_fd_sc_hd__fill_1
XFILLER_0_40_237 vssd1 vssd1 vccd1 vccd1 sky130_ef_sc_hd__decap_12
XFILLER_0_0_389 vssd1 vssd1 vccd1 vccd1 sky130_fd_sc_hd__decap_3
XTAP_602 vssd1 vccd1 sky130_fd_sc_hd__tapvpwrvgnd_1
XTAP_613 vssd1 vccd1 sky130_fd_sc_hd__tapvpwrvgnd_1
XTAP_624 vssd1 vccd1 sky130_fd_sc_hd__tapvpwrvgnd_1
XTAP_635 vssd1 vccd1 sky130_fd_sc_hd__tapvpwrvgnd_1
XTAP_657 vssd1 vccd1 sky130_fd_sc_hd__tapvpwrvgnd_1
XTAP_646 vssd1 vccd1 sky130_fd_sc_hd__tapvpwrvgnd_1
XTAP_668 vssd1 vccd1 sky130_fd_sc_hd__tapvpwrvgnd_1
X_05951_ _00325_ _00330_ vssd1 vssd1 vccd1 vccd1 _00331_ sky130_fd_sc_hd__nand2_1
XTAP_679 vssd1 vccd1 sky130_fd_sc_hd__tapvpwrvgnd_1
X_08670_ net121 _03084_ vssd1 vssd1 vccd1 vccd1 _03085_ sky130_fd_sc_hd__xor2_2
X_05882_ _00224_ _00225_ _00259_ _00260_ vssd1 vssd1 vccd1 vccd1 _00263_ sky130_fd_sc_hd__o22ai_1
X_07621_ _01975_ _01991_ _01992_ vssd1 vssd1 vccd1 vccd1 _01993_ sky130_fd_sc_hd__or3_1
XFILLER_0_88_451 vssd1 vssd1 vccd1 vccd1 sky130_fd_sc_hd__decap_8
XFILLER_0_88_440 vssd1 vssd1 vccd1 vccd1 sky130_fd_sc_hd__decap_6
X_07552_ _01889_ _01890_ _01923_ _01924_ vssd1 vssd1 vccd1 vccd1 _01925_ sky130_fd_sc_hd__and4bb_1
X_06503_ _00761_ _00876_ vssd1 vssd1 vccd1 vccd1 _00878_ sky130_fd_sc_hd__xnor2_1
X_07483_ net350 net359 net420 net427 vssd1 vssd1 vccd1 vccd1 _01854_ sky130_fd_sc_hd__nand4_2
X_09222_ _03494_ _03496_ _03686_ vssd1 vssd1 vccd1 vccd1 _03688_ sky130_fd_sc_hd__nor3_1
XFILLER_0_8_434 vssd1 vssd1 vccd1 vccd1 sky130_fd_sc_hd__decap_4
X_06434_ _00790_ _00807_ _00808_ vssd1 vssd1 vccd1 vccd1 _00810_ sky130_fd_sc_hd__nand3_1
XFILLER_0_29_573 vssd1 vssd1 vccd1 vccd1 sky130_fd_sc_hd__decap_8
XFILLER_0_99_3 vssd1 vssd1 vccd1 vccd1 sky130_ef_sc_hd__decap_12
XFILLER_0_90_137 vssd1 vssd1 vccd1 vccd1 sky130_fd_sc_hd__decap_3
X_09153_ _03442_ _03445_ vssd1 vssd1 vccd1 vccd1 _03612_ sky130_fd_sc_hd__or2_1
XFILLER_0_75_189 vssd1 vssd1 vccd1 vccd1 sky130_fd_sc_hd__decap_6
XFILLER_0_8_489 vssd1 vssd1 vccd1 vccd1 sky130_fd_sc_hd__fill_2
X_06365_ _00738_ _00739_ _00644_ vssd1 vssd1 vccd1 vccd1 _00741_ sky130_fd_sc_hd__a21o_1
X_08104_ _02461_ _02475_ vssd1 vssd1 vccd1 vccd1 _02476_ sky130_fd_sc_hd__xnor2_2
X_05316_ _03148_ _04585_ vssd1 vssd1 vccd1 vccd1 _04586_ sky130_fd_sc_hd__nor2_1
XFILLER_0_44_543 vssd1 vssd1 vccd1 vccd1 sky130_ef_sc_hd__decap_12
X_09084_ _03534_ _03535_ _03536_ vssd1 vssd1 vccd1 vccd1 _03537_ sky130_fd_sc_hd__or3_1
X_06296_ _00669_ _00672_ vssd1 vssd1 vccd1 vccd1 _00673_ sky130_fd_sc_hd__xnor2_2
XFILLER_0_44_598 vssd1 vssd1 vccd1 vccd1 sky130_fd_sc_hd__decap_4
X_08035_ _02405_ _02406_ _02203_ _02206_ vssd1 vssd1 vccd1 vccd1 _02408_ sky130_fd_sc_hd__o211ai_2
X_05247_ _04219_ _04230_ _04241_ vssd1 vssd1 vccd1 vccd1 _04252_ sky130_fd_sc_hd__nand3_1
X_05178_ _02842_ _03432_ _03487_ vssd1 vssd1 vccd1 vccd1 _03498_ sky130_fd_sc_hd__nand3_1
XFILLER_0_101_169 vssd1 vssd1 vccd1 vccd1 sky130_ef_sc_hd__decap_12
X_09986_ _04334_ _04354_ _04352_ vssd1 vssd1 vccd1 vccd1 _04522_ sky130_fd_sc_hd__a21o_1
X_08937_ _03353_ _03375_ vssd1 vssd1 vccd1 vccd1 _03376_ sky130_fd_sc_hd__xnor2_1
X_08868_ _03121_ _03123_ _03298_ vssd1 vssd1 vccd1 vccd1 _03300_ sky130_fd_sc_hd__nor3_2
X_07819_ _02174_ _02186_ _02188_ vssd1 vssd1 vccd1 vccd1 _02190_ sky130_fd_sc_hd__or3_1
X_08799_ _03199_ _03200_ _03224_ vssd1 vssd1 vccd1 vccd1 _03226_ sky130_fd_sc_hd__nor3_1
XFILLER_0_94_421 vssd1 vssd1 vccd1 vccd1 sky130_ef_sc_hd__decap_12
XFILLER_0_79_484 vssd1 vssd1 vccd1 vccd1 sky130_fd_sc_hd__fill_2
XFILLER_0_79_473 vssd1 vssd1 vccd1 vccd1 sky130_fd_sc_hd__decap_4
XFILLER_0_39_304 vssd1 vssd1 vccd1 vccd1 sky130_fd_sc_hd__decap_3
XFILLER_0_13_19 vssd1 vssd1 vccd1 vccd1 sky130_fd_sc_hd__decap_4
XFILLER_0_39_337 vssd1 vssd1 vccd1 vccd1 sky130_fd_sc_hd__fill_2
XFILLER_0_66_178 vssd1 vssd1 vccd1 vccd1 sky130_fd_sc_hd__decap_4
XFILLER_0_81_126 vssd1 vssd1 vccd1 vccd1 sky130_fd_sc_hd__decap_8
XFILLER_0_47_381 vssd1 vssd1 vccd1 vccd1 sky130_fd_sc_hd__decap_4
XFILLER_0_62_351 vssd1 vssd1 vccd1 vccd1 sky130_fd_sc_hd__fill_2
X_10126_ clknet_3_7_0_wb_clk_i _00120_ _00056_ vssd1 vssd1 vccd1 vccd1 mul.a\[21\]
+ sky130_fd_sc_hd__dfrtp_1
X_10057_ net645 vssd1 vssd1 vccd1 vccd1 _00053_ sky130_fd_sc_hd__inv_2
XFILLER_0_54_37 vssd1 vssd1 vccd1 vccd1 sky130_fd_sc_hd__fill_2
XFILLER_0_97_281 vssd1 vssd1 vccd1 vccd1 sky130_ef_sc_hd__decap_12
XFILLER_0_85_443 vssd1 vssd1 vccd1 vccd1 sky130_fd_sc_hd__decap_4
XFILLER_0_38_392 vssd1 vssd1 vccd1 vccd1 sky130_fd_sc_hd__fill_1
XFILLER_0_45_329 vssd1 vssd1 vccd1 vccd1 sky130_fd_sc_hd__decap_6
XFILLER_0_79_45 vssd1 vssd1 vccd1 vccd1 sky130_fd_sc_hd__decap_8
XFILLER_0_5_459 vssd1 vssd1 vccd1 vccd1 sky130_fd_sc_hd__fill_1
X_06150_ net280 net288 net563 net570 vssd1 vssd1 vccd1 vccd1 _00528_ sky130_fd_sc_hd__and4_1
X_05101_ net327 net335 net594 net604 vssd1 vssd1 vccd1 vccd1 _02656_ sky130_fd_sc_hd__nand4_1
XFILLER_0_13_248 vssd1 vssd1 vccd1 vccd1 sky130_fd_sc_hd__fill_2
X_06081_ _00354_ _00356_ _00458_ _00459_ vssd1 vssd1 vccd1 vccd1 _00460_ sky130_fd_sc_hd__o211a_2
X_05032_ net21 net190 net135 vssd1 vssd1 vccd1 vccd1 _00123_ sky130_fd_sc_hd__mux2_1
X_09840_ net257 net137 _04362_ vssd1 vssd1 vccd1 vccd1 _04363_ sky130_fd_sc_hd__o21a_1
Xfanout607 net609 vssd1 vssd1 vccd1 vccd1 net607 sky130_fd_sc_hd__buf_2
XTAP_410 vssd1 vccd1 sky130_fd_sc_hd__tapvpwrvgnd_1
XTAP_421 vssd1 vccd1 sky130_fd_sc_hd__tapvpwrvgnd_1
XTAP_432 vssd1 vccd1 sky130_fd_sc_hd__tapvpwrvgnd_1
Xfanout629 mul.b\[1\] vssd1 vssd1 vccd1 vccd1 net629 sky130_fd_sc_hd__clkbuf_2
Xfanout618 net619 vssd1 vssd1 vccd1 vccd1 net618 sky130_fd_sc_hd__buf_2
XFILLER_0_95_77 vssd1 vssd1 vccd1 vccd1 sky130_fd_sc_hd__decap_6
X_09771_ _04286_ _04287_ vssd1 vssd1 vccd1 vccd1 _04288_ sky130_fd_sc_hd__nor2_1
XTAP_443 vssd1 vccd1 sky130_fd_sc_hd__tapvpwrvgnd_1
XTAP_454 vssd1 vccd1 sky130_fd_sc_hd__tapvpwrvgnd_1
XTAP_465 vssd1 vccd1 sky130_fd_sc_hd__tapvpwrvgnd_1
XTAP_476 vssd1 vccd1 sky130_fd_sc_hd__tapvpwrvgnd_1
X_06983_ _01214_ _01216_ _01353_ _01354_ vssd1 vssd1 vccd1 vccd1 _01355_ sky130_fd_sc_hd__o211ai_2
X_08722_ _03139_ _03140_ vssd1 vssd1 vccd1 vccd1 _03141_ sky130_fd_sc_hd__nor2_1
X_05934_ _00209_ _00214_ _00313_ vssd1 vssd1 vccd1 vccd1 _00314_ sky130_fd_sc_hd__o21ai_2
XTAP_487 vssd1 vccd1 sky130_fd_sc_hd__tapvpwrvgnd_1
XTAP_498 vssd1 vccd1 sky130_fd_sc_hd__tapvpwrvgnd_1
X_08653_ _02901_ net121 vssd1 vssd1 vccd1 vccd1 _03066_ sky130_fd_sc_hd__or2_1
XFILLER_0_14_3 vssd1 vssd1 vccd1 vccd1 sky130_fd_sc_hd__decap_4
X_05865_ _00242_ _00243_ _00244_ vssd1 vssd1 vccd1 vccd1 _00246_ sky130_fd_sc_hd__a21o_1
X_08584_ _02975_ _02988_ _02989_ vssd1 vssd1 vccd1 vccd1 _02990_ sky130_fd_sc_hd__and3_2
X_05796_ _00176_ _00177_ vssd1 vssd1 vccd1 vccd1 _00178_ sky130_fd_sc_hd__nand2_2
X_07604_ _01813_ _01819_ _01818_ vssd1 vssd1 vccd1 vccd1 _01976_ sky130_fd_sc_hd__a21o_1
XFILLER_0_76_421 vssd1 vssd1 vccd1 vccd1 sky130_fd_sc_hd__decap_4
X_07535_ net223 net537 net547 net215 vssd1 vssd1 vccd1 vccd1 _01908_ sky130_fd_sc_hd__a22o_1
XFILLER_0_48_112 vssd1 vssd1 vccd1 vccd1 sky130_fd_sc_hd__fill_2
X_07466_ _01683_ _01685_ _01832_ _01834_ vssd1 vssd1 vccd1 vccd1 _01835_ sky130_fd_sc_hd__a211o_2
X_09205_ net138 _03512_ vssd1 vssd1 vccd1 vccd1 _03669_ sky130_fd_sc_hd__and2b_4
XFILLER_0_91_446 vssd1 vssd1 vccd1 vccd1 sky130_fd_sc_hd__fill_2
XFILLER_0_76_498 vssd1 vssd1 vccd1 vccd1 sky130_ef_sc_hd__decap_12
XFILLER_0_8_253 vssd1 vssd1 vccd1 vccd1 sky130_fd_sc_hd__decap_3
X_06417_ net311 net321 net503 vssd1 vssd1 vccd1 vccd1 _00793_ sky130_fd_sc_hd__and3_1
XFILLER_0_48_189 vssd1 vssd1 vccd1 vccd1 sky130_fd_sc_hd__fill_1
X_07397_ net660 _01763_ _01744_ vssd1 vssd1 vccd1 vccd1 _01766_ sky130_fd_sc_hd__o21ai_1
XFILLER_0_17_554 vssd1 vssd1 vccd1 vccd1 sky130_fd_sc_hd__decap_6
X_09136_ _03583_ _03592_ vssd1 vssd1 vccd1 vccd1 _03593_ sky130_fd_sc_hd__and2_1
X_06348_ _00722_ _00723_ vssd1 vssd1 vccd1 vccd1 _00724_ sky130_fd_sc_hd__and2b_1
X_09067_ _03506_ _03517_ vssd1 vssd1 vccd1 vccd1 _03518_ sky130_fd_sc_hd__and2_1
X_06279_ _00546_ _00548_ _00655_ vssd1 vssd1 vccd1 vccd1 _00656_ sky130_fd_sc_hd__a21oi_2
X_08018_ _02379_ _02380_ _02390_ vssd1 vssd1 vccd1 vccd1 _02391_ sky130_fd_sc_hd__nor3_1
XFILLER_0_12_270 vssd1 vssd1 vccd1 vccd1 sky130_ef_sc_hd__decap_12
X_09969_ _03163_ _04502_ vssd1 vssd1 vccd1 vccd1 _04504_ sky130_fd_sc_hd__xnor2_1
XFILLER_0_99_546 vssd1 vssd1 vccd1 vccd1 sky130_fd_sc_hd__decap_4
XFILLER_0_24_29 vssd1 vssd1 vccd1 vccd1 sky130_fd_sc_hd__fill_1
XFILLER_0_54_137 vssd1 vssd1 vccd1 vccd1 sky130_fd_sc_hd__decap_3
XFILLER_0_82_457 vssd1 vssd1 vccd1 vccd1 sky130_fd_sc_hd__decap_8
XFILLER_0_90_490 vssd1 vssd1 vccd1 vccd1 sky130_fd_sc_hd__decap_3
XFILLER_0_50_343 vssd1 vssd1 vccd1 vccd1 sky130_fd_sc_hd__decap_4
X_10109_ clknet_3_3_0_wb_clk_i _00103_ _00039_ vssd1 vssd1 vccd1 vccd1 mul.a\[4\]
+ sky130_fd_sc_hd__dfrtp_2
X_05650_ _04819_ _04919_ vssd1 vssd1 vccd1 vccd1 _04920_ sky130_fd_sc_hd__nand2_1
X_05581_ _04786_ _04788_ vssd1 vssd1 vccd1 vccd1 _04851_ sky130_fd_sc_hd__and2_1
XFILLER_0_18_307 vssd1 vssd1 vccd1 vccd1 sky130_fd_sc_hd__fill_1
X_07320_ _01534_ _01536_ _01687_ _01688_ vssd1 vssd1 vccd1 vccd1 _01689_ sky130_fd_sc_hd__a211oi_4
XFILLER_0_14_95 vssd1 vssd1 vccd1 vccd1 sky130_fd_sc_hd__fill_1
X_07251_ _01465_ _01467_ _01619_ _01620_ vssd1 vssd1 vccd1 vccd1 _01621_ sky130_fd_sc_hd__o211a_2
XFILLER_0_45_137 vssd1 vssd1 vccd1 vccd1 sky130_fd_sc_hd__fill_2
X_07182_ net367 net375 net418 net423 vssd1 vssd1 vccd1 vccd1 _01552_ sky130_fd_sc_hd__and4_1
XFILLER_0_5_245 vssd1 vssd1 vccd1 vccd1 sky130_fd_sc_hd__fill_1
XFILLER_0_5_223 vssd1 vssd1 vccd1 vccd1 sky130_fd_sc_hd__fill_1
X_06202_ _00576_ _00577_ _00532_ vssd1 vssd1 vccd1 vccd1 _00580_ sky130_fd_sc_hd__o21ai_2
XFILLER_0_26_362 vssd1 vssd1 vccd1 vccd1 sky130_fd_sc_hd__fill_2
X_06133_ net219 net226 net626 net634 vssd1 vssd1 vccd1 vccd1 _00511_ sky130_fd_sc_hd__and4_1
XFILLER_0_26_384 vssd1 vssd1 vccd1 vccd1 sky130_fd_sc_hd__decap_3
XFILLER_0_30_61 vssd1 vssd1 vccd1 vccd1 sky130_fd_sc_hd__fill_1
XFILLER_0_30_72 vssd1 vssd1 vccd1 vccd1 sky130_fd_sc_hd__decap_4
X_06064_ net320 net530 net540 net310 vssd1 vssd1 vccd1 vccd1 _00443_ sky130_fd_sc_hd__a22o_1
Xfanout404 mul.b\[29\] vssd1 vssd1 vccd1 vccd1 net404 sky130_fd_sc_hd__buf_2
Xfanout415 mul.b\[27\] vssd1 vssd1 vccd1 vccd1 net415 sky130_fd_sc_hd__clkbuf_4
Xfanout426 net427 vssd1 vssd1 vccd1 vccd1 net426 sky130_fd_sc_hd__buf_4
Xfanout437 mul.b\[23\] vssd1 vssd1 vccd1 vccd1 net437 sky130_fd_sc_hd__clkbuf_4
Xfanout448 net451 vssd1 vssd1 vccd1 vccd1 net448 sky130_fd_sc_hd__buf_4
XTAP_251 vssd1 vccd1 sky130_fd_sc_hd__tapvpwrvgnd_1
XTAP_240 vssd1 vccd1 sky130_fd_sc_hd__tapvpwrvgnd_1
X_09823_ net180 net447 vssd1 vssd1 vccd1 vccd1 _04344_ sky130_fd_sc_hd__nand2_1
Xfanout459 net460 vssd1 vssd1 vccd1 vccd1 net459 sky130_fd_sc_hd__buf_4
XTAP_284 vssd1 vccd1 sky130_fd_sc_hd__tapvpwrvgnd_1
XTAP_273 vssd1 vccd1 sky130_fd_sc_hd__tapvpwrvgnd_1
XTAP_262 vssd1 vccd1 sky130_fd_sc_hd__tapvpwrvgnd_1
X_09754_ net117 _04133_ _04131_ vssd1 vssd1 vccd1 vccd1 _04269_ sky130_fd_sc_hd__o21a_1
XTAP_295 vssd1 vccd1 sky130_fd_sc_hd__tapvpwrvgnd_1
X_06966_ _01335_ _01336_ net724 _01200_ vssd1 vssd1 vccd1 vccd1 _01338_ sky130_fd_sc_hd__o211ai_2
X_08705_ _03114_ _03120_ vssd1 vssd1 vccd1 vccd1 _03122_ sky130_fd_sc_hd__xnor2_1
X_09685_ _04191_ _04192_ vssd1 vssd1 vccd1 vccd1 _04193_ sky130_fd_sc_hd__nand2_1
X_05917_ _00295_ _00296_ vssd1 vssd1 vccd1 vccd1 _00297_ sky130_fd_sc_hd__nand2_1
X_06897_ net382 net429 _01151_ _01150_ vssd1 vssd1 vccd1 vccd1 _01269_ sky130_fd_sc_hd__a31o_1
X_08636_ _02882_ _02888_ _02890_ _02892_ _02881_ vssd1 vssd1 vccd1 vccd1 _03047_ sky130_fd_sc_hd__a32o_1
X_05848_ _00228_ vssd1 vssd1 vccd1 vccd1 _00229_ sky130_fd_sc_hd__inv_2
X_08567_ _02955_ _02956_ _02968_ vssd1 vssd1 vccd1 vccd1 _02971_ sky130_fd_sc_hd__o21ai_2
X_05779_ _04835_ _04956_ _04836_ _04764_ vssd1 vssd1 vccd1 vccd1 _00161_ sky130_fd_sc_hd__or4bb_1
X_08498_ _02879_ _02895_ vssd1 vssd1 vccd1 vccd1 _02896_ sky130_fd_sc_hd__xnor2_1
XFILLER_0_71_90 vssd1 vssd1 vccd1 vccd1 sky130_ef_sc_hd__decap_12
XFILLER_0_64_424 vssd1 vssd1 vccd1 vccd1 sky130_fd_sc_hd__fill_1
X_07518_ _01738_ _01740_ vssd1 vssd1 vccd1 vccd1 _01891_ sky130_fd_sc_hd__nand2_1
XFILLER_0_64_468 vssd1 vssd1 vccd1 vccd1 sky130_fd_sc_hd__fill_1
X_07449_ net181 net592 _01814_ _01815_ vssd1 vssd1 vccd1 vccd1 _01817_ sky130_fd_sc_hd__nand4_1
X_09119_ net516 _03573_ _03572_ vssd1 vssd1 vccd1 vccd1 _03575_ sky130_fd_sc_hd__a21bo_1
XFILLER_0_32_365 vssd1 vssd1 vccd1 vccd1 sky130_fd_sc_hd__fill_1
XFILLER_0_3_3 vssd1 vssd1 vccd1 vccd1 sky130_ef_sc_hd__decap_12
XFILLER_0_35_39 vssd1 vssd1 vccd1 vccd1 sky130_fd_sc_hd__decap_8
XFILLER_0_51_49 vssd1 vssd1 vccd1 vccd1 sky130_fd_sc_hd__fill_2
XFILLER_0_55_446 vssd1 vssd1 vccd1 vccd1 sky130_fd_sc_hd__fill_2
XFILLER_0_42_118 vssd1 vssd1 vccd1 vccd1 sky130_fd_sc_hd__fill_1
XFILLER_0_76_24 vssd1 vssd1 vccd1 vccd1 sky130_fd_sc_hd__fill_1
XFILLER_0_50_195 vssd1 vssd1 vccd1 vccd1 sky130_fd_sc_hd__fill_1
XFILLER_0_76_57 vssd1 vssd1 vccd1 vccd1 sky130_fd_sc_hd__fill_2
X_06820_ _01052_ _01060_ _01059_ vssd1 vssd1 vccd1 vccd1 _01193_ sky130_fd_sc_hd__a21bo_1
XFILLER_0_92_45 vssd1 vssd1 vccd1 vccd1 sky130_fd_sc_hd__fill_2
X_06751_ _01122_ _01123_ vssd1 vssd1 vccd1 vccd1 _01124_ sky130_fd_sc_hd__nand2b_1
X_09470_ _03956_ _03958_ vssd1 vssd1 vccd1 vccd1 _03959_ sky130_fd_sc_hd__or2_2
X_05702_ net76 _04886_ _04888_ _04890_ vssd1 vssd1 vccd1 vccd1 _04972_ sky130_fd_sc_hd__o31a_1
X_06682_ _01053_ _01054_ _01055_ vssd1 vssd1 vccd1 vccd1 _01056_ sky130_fd_sc_hd__nand3_1
X_08421_ net286 net430 vssd1 vssd1 vccd1 vccd1 _02812_ sky130_fd_sc_hd__nand2_1
XFILLER_0_86_560 vssd1 vssd1 vccd1 vccd1 sky130_fd_sc_hd__fill_1
XFILLER_0_58_240 vssd1 vssd1 vccd1 vccd1 sky130_ef_sc_hd__decap_12
X_05633_ net281 net616 _04901_ _04902_ vssd1 vssd1 vccd1 vccd1 _04903_ sky130_fd_sc_hd__and4_1
X_08352_ _02728_ _02736_ vssd1 vssd1 vccd1 vccd1 _02737_ sky130_fd_sc_hd__xnor2_2
X_05564_ net388 net513 _04761_ _04760_ vssd1 vssd1 vccd1 vccd1 _04834_ sky130_fd_sc_hd__a31oi_2
X_08283_ _02659_ _02660_ vssd1 vssd1 vccd1 vccd1 _02661_ sky130_fd_sc_hd__nor2_1
X_05495_ _04728_ _04763_ vssd1 vssd1 vccd1 vccd1 _04765_ sky130_fd_sc_hd__xnor2_2
X_07303_ net190 net592 _01670_ _01671_ vssd1 vssd1 vccd1 vccd1 _01672_ sky130_fd_sc_hd__a22o_1
XFILLER_0_73_276 vssd1 vssd1 vccd1 vccd1 sky130_fd_sc_hd__decap_4
X_07234_ _01602_ _01603_ vssd1 vssd1 vccd1 vccd1 _01604_ sky130_fd_sc_hd__xnor2_1
XFILLER_0_33_107 vssd1 vssd1 vccd1 vccd1 sky130_fd_sc_hd__decap_4
XFILLER_0_41_60 vssd1 vssd1 vccd1 vccd1 sky130_fd_sc_hd__decap_8
XFILLER_0_81_3 vssd1 vssd1 vccd1 vccd1 sky130_ef_sc_hd__decap_12
XFILLER_0_6_587 vssd1 vssd1 vccd1 vccd1 sky130_fd_sc_hd__fill_1
XFILLER_0_14_332 vssd1 vssd1 vccd1 vccd1 sky130_fd_sc_hd__decap_4
XFILLER_0_6_598 vssd1 vssd1 vccd1 vccd1 sky130_fd_sc_hd__fill_1
XFILLER_0_14_354 vssd1 vssd1 vccd1 vccd1 sky130_fd_sc_hd__fill_1
XFILLER_0_14_365 vssd1 vssd1 vccd1 vccd1 sky130_fd_sc_hd__decap_8
X_07165_ _01392_ _01533_ vssd1 vssd1 vccd1 vccd1 _01535_ sky130_fd_sc_hd__xnor2_1
X_07096_ _01448_ _01465_ _01466_ vssd1 vssd1 vccd1 vccd1 _01467_ sky130_fd_sc_hd__nor3_1
X_06116_ _00384_ _00386_ vssd1 vssd1 vccd1 vccd1 _00494_ sky130_fd_sc_hd__nand2_1
X_06047_ _00334_ _00335_ _00336_ vssd1 vssd1 vccd1 vccd1 _00426_ sky130_fd_sc_hd__o21ba_1
Xfanout201 net202 vssd1 vssd1 vccd1 vccd1 net201 sky130_fd_sc_hd__clkbuf_4
Xfanout212 net213 vssd1 vssd1 vccd1 vccd1 net212 sky130_fd_sc_hd__buf_2
Xfanout223 net224 vssd1 vssd1 vccd1 vccd1 net223 sky130_fd_sc_hd__clkbuf_4
Xfanout245 net246 vssd1 vssd1 vccd1 vccd1 net245 sky130_fd_sc_hd__clkbuf_4
Xfanout234 net238 vssd1 vssd1 vccd1 vccd1 net234 sky130_fd_sc_hd__buf_6
Xfanout256 mul.a\[16\] vssd1 vssd1 vccd1 vccd1 net256 sky130_fd_sc_hd__clkbuf_4
XFILLER_0_5_71 vssd1 vssd1 vccd1 vccd1 sky130_fd_sc_hd__fill_1
X_07998_ net228 net508 net518 net220 vssd1 vssd1 vccd1 vccd1 _02371_ sky130_fd_sc_hd__a22o_1
Xfanout267 net268 vssd1 vssd1 vccd1 vccd1 net267 sky130_fd_sc_hd__buf_2
X_09806_ _04318_ _04324_ vssd1 vssd1 vccd1 vccd1 _04325_ sky130_fd_sc_hd__xnor2_1
Xfanout289 net291 vssd1 vssd1 vccd1 vccd1 net289 sky130_fd_sc_hd__buf_4
Xfanout278 net279 vssd1 vssd1 vccd1 vccd1 net278 sky130_fd_sc_hd__buf_4
X_09737_ _04242_ _04248_ vssd1 vssd1 vccd1 vccd1 _04250_ sky130_fd_sc_hd__xnor2_1
X_06949_ _01318_ _01319_ _01317_ vssd1 vssd1 vccd1 vccd1 _01321_ sky130_fd_sc_hd__a21o_1
XTAP_1214 vssd1 vccd1 sky130_fd_sc_hd__tapvpwrvgnd_1
XTAP_1203 vssd1 vccd1 sky130_fd_sc_hd__tapvpwrvgnd_1
X_09668_ _04171_ _04172_ vssd1 vssd1 vccd1 vccd1 _04174_ sky130_fd_sc_hd__nor2_1
XTAP_1247 vssd1 vccd1 sky130_fd_sc_hd__tapvpwrvgnd_1
XTAP_1236 vssd1 vccd1 sky130_fd_sc_hd__tapvpwrvgnd_1
XTAP_1225 vssd1 vccd1 sky130_fd_sc_hd__tapvpwrvgnd_1
X_08619_ _03025_ _03026_ _03019_ vssd1 vssd1 vccd1 vccd1 _03029_ sky130_fd_sc_hd__a21o_1
X_09599_ _04089_ _04098_ vssd1 vssd1 vccd1 vccd1 _04100_ sky130_fd_sc_hd__nand2_1
XTAP_1269 vssd1 vccd1 sky130_fd_sc_hd__tapvpwrvgnd_1
XTAP_1258 vssd1 vccd1 sky130_fd_sc_hd__tapvpwrvgnd_1
XFILLER_0_77_571 vssd1 vssd1 vccd1 vccd1 sky130_fd_sc_hd__fill_1
XFILLER_0_52_416 vssd1 vssd1 vccd1 vccd1 sky130_fd_sc_hd__decap_4
XFILLER_0_60_493 vssd1 vssd1 vccd1 vccd1 sky130_ef_sc_hd__decap_12
XFILLER_0_20_302 vssd1 vssd1 vccd1 vccd1 sky130_fd_sc_hd__decap_6
XFILLER_0_20_313 vssd1 vssd1 vccd1 vccd1 sky130_fd_sc_hd__fill_1
XFILLER_0_99_173 vssd1 vssd1 vccd1 vccd1 sky130_fd_sc_hd__decap_8
XFILLER_0_83_552 vssd1 vssd1 vccd1 vccd1 sky130_fd_sc_hd__decap_8
XFILLER_0_83_530 vssd1 vssd1 vccd1 vccd1 sky130_fd_sc_hd__decap_3
XFILLER_0_11_30 vssd1 vssd1 vccd1 vccd1 sky130_fd_sc_hd__fill_1
X_05280_ _03727_ net97 _04546_ vssd1 vssd1 vccd1 vccd1 _04550_ sky130_fd_sc_hd__or3_1
XFILLER_0_70_246 vssd1 vssd1 vccd1 vccd1 sky130_fd_sc_hd__decap_6
XFILLER_0_23_140 vssd1 vssd1 vccd1 vccd1 sky130_fd_sc_hd__decap_4
XFILLER_0_11_313 vssd1 vssd1 vccd1 vccd1 sky130_fd_sc_hd__decap_3
XFILLER_0_11_335 vssd1 vssd1 vccd1 vccd1 sky130_fd_sc_hd__fill_1
X_08970_ _03409_ _03411_ vssd1 vssd1 vccd1 vccd1 _03412_ sky130_fd_sc_hd__xor2_1
X_07921_ _02122_ _02125_ _02124_ vssd1 vssd1 vccd1 vccd1 _02294_ sky130_fd_sc_hd__o21ai_1
X_07852_ _02067_ _02070_ _02222_ _02224_ vssd1 vssd1 vccd1 vccd1 _02225_ sky130_fd_sc_hd__o211ai_2
Xinput1 wb_rst_i vssd1 vssd1 vccd1 vccd1 net1 sky130_fd_sc_hd__clkbuf_2
X_06803_ _01174_ _01175_ vssd1 vssd1 vccd1 vccd1 _01176_ sky130_fd_sc_hd__and2b_1
X_07783_ _02135_ _02153_ vssd1 vssd1 vccd1 vccd1 _02154_ sky130_fd_sc_hd__nand2b_1
XFILLER_0_36_82 vssd1 vssd1 vccd1 vccd1 sky130_fd_sc_hd__fill_2
X_09522_ _04012_ _04013_ net156 net497 vssd1 vssd1 vccd1 vccd1 _04015_ sky130_fd_sc_hd__and4bb_1
XFILLER_0_78_335 vssd1 vssd1 vccd1 vccd1 sky130_fd_sc_hd__fill_1
X_06734_ net181 net188 net627 net635 vssd1 vssd1 vccd1 vccd1 _01107_ sky130_fd_sc_hd__and4_1
X_09453_ _03748_ _03751_ vssd1 vssd1 vccd1 vccd1 _03940_ sky130_fd_sc_hd__nand2_1
X_06665_ net321 net495 _00914_ _00915_ net512 vssd1 vssd1 vccd1 vccd1 _01039_ sky130_fd_sc_hd__a32o_1
X_08404_ net223 net482 net491 net215 vssd1 vssd1 vccd1 vccd1 _02793_ sky130_fd_sc_hd__a22o_1
XFILLER_0_59_571 vssd1 vssd1 vccd1 vccd1 sky130_fd_sc_hd__fill_1
X_09384_ net526 net691 net546 net146 vssd1 vssd1 vccd1 vccd1 _03864_ sky130_fd_sc_hd__o31a_1
X_05616_ _04802_ _04884_ vssd1 vssd1 vccd1 vccd1 _04886_ sky130_fd_sc_hd__and2b_1
X_08335_ _02716_ _02717_ vssd1 vssd1 vccd1 vccd1 _02718_ sky130_fd_sc_hd__xnor2_1
XFILLER_0_52_92 vssd1 vssd1 vccd1 vccd1 sky130_ef_sc_hd__decap_12
XFILLER_0_52_70 vssd1 vssd1 vccd1 vccd1 sky130_ef_sc_hd__decap_12
XFILLER_0_19_446 vssd1 vssd1 vccd1 vccd1 sky130_fd_sc_hd__fill_2
X_06596_ _00968_ _00969_ vssd1 vssd1 vccd1 vccd1 _00970_ sky130_fd_sc_hd__nand2b_1
X_05547_ _04796_ _04798_ vssd1 vssd1 vccd1 vccd1 _04817_ sky130_fd_sc_hd__or2_1
X_08266_ net282 net290 net438 vssd1 vssd1 vccd1 vccd1 _02642_ sky130_fd_sc_hd__and3_1
X_05478_ _04595_ _04632_ _04678_ _04679_ _04747_ vssd1 vssd1 vccd1 vccd1 _04748_ sky130_fd_sc_hd__a311o_1
XFILLER_0_46_287 vssd1 vssd1 vccd1 vccd1 sky130_fd_sc_hd__fill_1
X_08197_ _02567_ _02568_ _02569_ vssd1 vssd1 vccd1 vccd1 _02570_ sky130_fd_sc_hd__nand3_1
X_07217_ _01430_ _01432_ _01585_ _01586_ vssd1 vssd1 vccd1 vccd1 _01587_ sky130_fd_sc_hd__a211oi_2
XFILLER_0_14_162 vssd1 vssd1 vccd1 vccd1 sky130_fd_sc_hd__fill_1
X_07148_ _01371_ _01376_ _01516_ vssd1 vssd1 vccd1 vccd1 _01518_ sky130_fd_sc_hd__or3_1
XFILLER_0_14_184 vssd1 vssd1 vccd1 vccd1 sky130_fd_sc_hd__fill_1
X_07079_ net277 net507 net517 net269 vssd1 vssd1 vccd1 vccd1 _01450_ sky130_fd_sc_hd__a22o_1
X_10090_ clknet_3_7_0_wb_clk_i _00086_ _00022_ vssd1 vssd1 vccd1 vccd1 mul.b\[19\]
+ sky130_fd_sc_hd__dfrtp_4
XFILLER_0_97_611 vssd1 vssd1 vccd1 vccd1 sky130_fd_sc_hd__decap_4
XTAP_1022 vssd1 vccd1 sky130_fd_sc_hd__tapvpwrvgnd_1
XTAP_1011 vssd1 vccd1 sky130_fd_sc_hd__tapvpwrvgnd_1
XTAP_1000 vssd1 vccd1 sky130_fd_sc_hd__tapvpwrvgnd_1
XTAP_1055 vssd1 vccd1 sky130_fd_sc_hd__tapvpwrvgnd_1
XTAP_1044 vssd1 vccd1 sky130_fd_sc_hd__tapvpwrvgnd_1
XTAP_1033 vssd1 vccd1 sky130_fd_sc_hd__tapvpwrvgnd_1
XTAP_1088 vssd1 vccd1 sky130_fd_sc_hd__tapvpwrvgnd_1
XTAP_1099 vssd1 vccd1 sky130_fd_sc_hd__tapvpwrvgnd_1
XTAP_1077 vssd1 vccd1 sky130_fd_sc_hd__tapvpwrvgnd_1
XTAP_1066 vssd1 vccd1 sky130_fd_sc_hd__tapvpwrvgnd_1
XFILLER_0_65_541 vssd1 vssd1 vccd1 vccd1 sky130_fd_sc_hd__decap_4
XFILLER_0_80_500 vssd1 vssd1 vccd1 vccd1 sky130_fd_sc_hd__decap_8
XFILLER_0_80_533 vssd1 vssd1 vccd1 vccd1 sky130_fd_sc_hd__fill_2
XFILLER_0_0_505 vssd1 vssd1 vccd1 vccd1 sky130_fd_sc_hd__decap_8
XFILLER_0_57_15 vssd1 vssd1 vccd1 vccd1 sky130_fd_sc_hd__decap_6
XTAP_817 vssd1 vccd1 sky130_fd_sc_hd__tapvpwrvgnd_1
XTAP_806 vssd1 vccd1 sky130_fd_sc_hd__tapvpwrvgnd_1
XTAP_839 vssd1 vccd1 sky130_fd_sc_hd__tapvpwrvgnd_1
XTAP_828 vssd1 vccd1 sky130_fd_sc_hd__tapvpwrvgnd_1
XFILLER_0_73_69 vssd1 vssd1 vccd1 vccd1 sky130_ef_sc_hd__decap_12
X_06450_ _00639_ _00641_ _00824_ _00825_ vssd1 vssd1 vccd1 vccd1 _00826_ sky130_fd_sc_hd__o211a_1
XFILLER_0_68_390 vssd1 vssd1 vccd1 vccd1 sky130_fd_sc_hd__fill_2
XFILLER_0_56_530 vssd1 vssd1 vccd1 vccd1 sky130_fd_sc_hd__fill_2
X_05401_ _04621_ _04623_ vssd1 vssd1 vccd1 vccd1 _04671_ sky130_fd_sc_hd__xnor2_1
XFILLER_0_56_563 vssd1 vssd1 vccd1 vccd1 sky130_fd_sc_hd__fill_1
X_06381_ _00635_ _00637_ _00754_ vssd1 vssd1 vccd1 vccd1 _00757_ sky130_fd_sc_hd__and3_1
XFILLER_0_83_393 vssd1 vssd1 vccd1 vccd1 sky130_fd_sc_hd__decap_3
XFILLER_0_71_544 vssd1 vssd1 vccd1 vccd1 sky130_fd_sc_hd__fill_2
X_08120_ _02488_ _02490_ _02364_ _02367_ vssd1 vssd1 vccd1 vccd1 _02492_ sky130_fd_sc_hd__a211o_1
X_05332_ net378 net386 net596 net606 vssd1 vssd1 vccd1 vccd1 _04602_ sky130_fd_sc_hd__and4_1
XFILLER_0_71_566 vssd1 vssd1 vccd1 vccd1 sky130_fd_sc_hd__decap_4
X_08051_ _02326_ _02422_ _02423_ vssd1 vssd1 vccd1 vccd1 _02424_ sky130_fd_sc_hd__nor3_2
X_05263_ _04394_ _04405_ _03651_ vssd1 vssd1 vccd1 vccd1 _04427_ sky130_fd_sc_hd__a21o_1
XFILLER_0_3_321 vssd1 vssd1 vccd1 vccd1 sky130_fd_sc_hd__fill_1
X_07002_ net170 net175 net629 net637 vssd1 vssd1 vccd1 vccd1 _01373_ sky130_fd_sc_hd__and4_1
XFILLER_0_11_132 vssd1 vssd1 vccd1 vccd1 sky130_fd_sc_hd__fill_1
X_05194_ net369 net559 net568 net361 vssd1 vssd1 vccd1 vccd1 _03673_ sky130_fd_sc_hd__a22o_1
X_08953_ _03392_ _03393_ vssd1 vssd1 vccd1 vccd1 _03394_ sky130_fd_sc_hd__nor2_1
X_07904_ _01948_ _02107_ vssd1 vssd1 vccd1 vccd1 _02278_ sky130_fd_sc_hd__nor2_1
X_08884_ _03317_ vssd1 vssd1 vccd1 vccd1 _03318_ sky130_fd_sc_hd__inv_2
X_07835_ net299 net452 _02202_ _02203_ vssd1 vssd1 vccd1 vccd1 _02206_ sky130_fd_sc_hd__nand4_2
X_07766_ _02004_ _02014_ _02012_ vssd1 vssd1 vccd1 vccd1 _02137_ sky130_fd_sc_hd__a21oi_1
X_09505_ _03995_ _03996_ vssd1 vssd1 vccd1 vccd1 _03997_ sky130_fd_sc_hd__xor2_4
XFILLER_0_78_154 vssd1 vssd1 vccd1 vccd1 sky130_fd_sc_hd__fill_2
XFILLER_0_2_83 vssd1 vssd1 vccd1 vccd1 sky130_fd_sc_hd__fill_1
X_06717_ _01087_ _01089_ _00967_ vssd1 vssd1 vccd1 vccd1 _01091_ sky130_fd_sc_hd__o21ai_1
XFILLER_0_93_113 vssd1 vssd1 vccd1 vccd1 sky130_fd_sc_hd__fill_2
X_09436_ net284 net392 vssd1 vssd1 vccd1 vccd1 _03921_ sky130_fd_sc_hd__and2b_1
X_07697_ net220 net538 _02066_ _02068_ vssd1 vssd1 vccd1 vccd1 _02069_ sky130_fd_sc_hd__a22o_1
XPHY_116 vssd1 vssd1 vccd1 vccd1 sky130_fd_sc_hd__decap_3
XPHY_105 vssd1 vssd1 vccd1 vccd1 sky130_fd_sc_hd__decap_3
XPHY_149 vssd1 vssd1 vccd1 vccd1 sky130_fd_sc_hd__decap_3
XPHY_138 vssd1 vssd1 vccd1 vccd1 sky130_fd_sc_hd__decap_3
XPHY_127 vssd1 vssd1 vccd1 vccd1 sky130_fd_sc_hd__decap_3
X_06648_ net389 net429 _01020_ vssd1 vssd1 vccd1 vccd1 _01022_ sky130_fd_sc_hd__and3_1
X_09367_ _03844_ _03845_ vssd1 vssd1 vccd1 vccd1 _03846_ sky130_fd_sc_hd__nand2_1
X_06579_ _00951_ _00952_ _00731_ _00734_ vssd1 vssd1 vccd1 vccd1 _00954_ sky130_fd_sc_hd__o211a_1
X_08318_ _02694_ _02695_ _02696_ vssd1 vssd1 vccd1 vccd1 _02699_ sky130_fd_sc_hd__a21o_1
X_09298_ _03599_ _03624_ net98 _03769_ vssd1 vssd1 vccd1 vccd1 _03770_ sky130_fd_sc_hd__a211oi_2
XFILLER_0_62_533 vssd1 vssd1 vccd1 vccd1 sky130_fd_sc_hd__decap_6
X_08249_ _02506_ _02508_ vssd1 vssd1 vccd1 vccd1 _02624_ sky130_fd_sc_hd__nand2_1
XFILLER_0_6_192 vssd1 vssd1 vccd1 vccd1 sky130_fd_sc_hd__decap_4
XFILLER_0_30_496 vssd1 vssd1 vccd1 vccd1 sky130_fd_sc_hd__decap_8
X_10073_ clknet_3_2_0_wb_clk_i _00069_ _00005_ vssd1 vssd1 vccd1 vccd1 mul.b\[2\]
+ sky130_fd_sc_hd__dfrtp_4
XFILLER_0_97_441 vssd1 vssd1 vccd1 vccd1 sky130_fd_sc_hd__fill_2
Xmax_cap96 _00261_ vssd1 vssd1 vccd1 vccd1 net96 sky130_fd_sc_hd__buf_1
XPHY_7 vssd1 vssd1 vccd1 vccd1 sky130_fd_sc_hd__decap_3
Xmax_cap85 net712 vssd1 vssd1 vccd1 vccd1 net85 sky130_fd_sc_hd__buf_1
XFILLER_0_65_393 vssd1 vssd1 vccd1 vccd1 sky130_fd_sc_hd__fill_2
XFILLER_0_25_213 vssd1 vssd1 vccd1 vccd1 sky130_fd_sc_hd__decap_8
XFILLER_0_53_577 vssd1 vssd1 vccd1 vccd1 sky130_fd_sc_hd__decap_4
XFILLER_0_7_28 vssd1 vssd1 vccd1 vccd1 sky130_fd_sc_hd__fill_2
XFILLER_0_40_249 vssd1 vssd1 vccd1 vccd1 sky130_fd_sc_hd__decap_3
Xclkbuf_3_4_0_wb_clk_i clknet_0_wb_clk_i vssd1 vssd1 vccd1 vccd1 clknet_3_4_0_wb_clk_i
+ sky130_fd_sc_hd__clkbuf_8
XFILLER_0_68_58 vssd1 vssd1 vccd1 vccd1 sky130_fd_sc_hd__decap_8
XFILLER_0_0_357 vssd1 vssd1 vccd1 vccd1 sky130_fd_sc_hd__decap_6
XTAP_603 vssd1 vccd1 sky130_fd_sc_hd__tapvpwrvgnd_1
XTAP_614 vssd1 vccd1 sky130_fd_sc_hd__tapvpwrvgnd_1
XTAP_625 vssd1 vccd1 sky130_fd_sc_hd__tapvpwrvgnd_1
XTAP_636 vssd1 vccd1 sky130_fd_sc_hd__tapvpwrvgnd_1
XTAP_658 vssd1 vccd1 sky130_fd_sc_hd__tapvpwrvgnd_1
XTAP_647 vssd1 vccd1 sky130_fd_sc_hd__tapvpwrvgnd_1
XFILLER_0_84_35 vssd1 vssd1 vccd1 vccd1 sky130_fd_sc_hd__decap_8
X_05950_ _00326_ _00329_ vssd1 vssd1 vccd1 vccd1 _00330_ sky130_fd_sc_hd__xnor2_1
XTAP_669 vssd1 vccd1 sky130_fd_sc_hd__tapvpwrvgnd_1
XFILLER_0_84_68 vssd1 vssd1 vccd1 vccd1 sky130_fd_sc_hd__decap_4
X_05881_ _00224_ _00225_ _00259_ _00260_ vssd1 vssd1 vccd1 vccd1 _00262_ sky130_fd_sc_hd__or4_1
X_07620_ _01989_ _01990_ _01822_ _01824_ vssd1 vssd1 vccd1 vccd1 _01992_ sky130_fd_sc_hd__o211a_1
X_07551_ _01921_ _01922_ net662 _01764_ vssd1 vssd1 vccd1 vccd1 _01924_ sky130_fd_sc_hd__a211o_1
XFILLER_0_88_485 vssd1 vssd1 vccd1 vccd1 sky130_fd_sc_hd__fill_2
X_06502_ _00761_ _00876_ vssd1 vssd1 vccd1 vccd1 _00877_ sky130_fd_sc_hd__nor2_1
X_07482_ net359 net420 net427 net350 vssd1 vssd1 vccd1 vccd1 _01853_ sky130_fd_sc_hd__a22o_1
XFILLER_0_29_541 vssd1 vssd1 vccd1 vccd1 sky130_fd_sc_hd__decap_8
X_09221_ _03494_ _03496_ _03686_ vssd1 vssd1 vccd1 vccd1 _03687_ sky130_fd_sc_hd__o21a_1
XFILLER_0_8_446 vssd1 vssd1 vccd1 vccd1 sky130_fd_sc_hd__fill_2
X_06433_ _00790_ _00807_ _00808_ vssd1 vssd1 vccd1 vccd1 _00809_ sky130_fd_sc_hd__and3_1
X_09152_ _03609_ _03610_ vssd1 vssd1 vccd1 vccd1 _03611_ sky130_fd_sc_hd__nor2_1
X_06364_ _00644_ _00738_ _00739_ vssd1 vssd1 vccd1 vccd1 _00740_ sky130_fd_sc_hd__nand3_1
X_08103_ _02462_ _02473_ vssd1 vssd1 vccd1 vccd1 _02475_ sky130_fd_sc_hd__xnor2_2
XFILLER_0_16_235 vssd1 vssd1 vccd1 vccd1 sky130_fd_sc_hd__decap_3
X_05315_ net385 net559 net568 net377 vssd1 vssd1 vccd1 vccd1 _04585_ sky130_fd_sc_hd__a22oi_1
XFILLER_0_44_555 vssd1 vssd1 vccd1 vccd1 sky130_fd_sc_hd__decap_3
X_09083_ _03351_ _03377_ vssd1 vssd1 vccd1 vccd1 _03536_ sky130_fd_sc_hd__and2b_1
X_06295_ _00670_ _00671_ vssd1 vssd1 vccd1 vccd1 _00672_ sky130_fd_sc_hd__nor2_1
X_08034_ _02203_ _02206_ _02405_ _02406_ vssd1 vssd1 vccd1 vccd1 _02407_ sky130_fd_sc_hd__a211o_1
X_05246_ _02645_ _02667_ _02656_ vssd1 vssd1 vccd1 vccd1 _04241_ sky130_fd_sc_hd__a21bo_1
XFILLER_0_101_126 vssd1 vssd1 vccd1 vccd1 sky130_fd_sc_hd__decap_8
X_05177_ _03454_ _03465_ _03443_ vssd1 vssd1 vccd1 vccd1 _03487_ sky130_fd_sc_hd__a21bo_1
X_09985_ _04517_ _04520_ vssd1 vssd1 vccd1 vccd1 _04521_ sky130_fd_sc_hd__xnor2_1
X_08936_ _03354_ _03373_ vssd1 vssd1 vccd1 vccd1 _03375_ sky130_fd_sc_hd__xnor2_1
X_08867_ _03121_ _03123_ _03298_ vssd1 vssd1 vccd1 vccd1 _03299_ sky130_fd_sc_hd__o21a_2
X_07818_ _02174_ _02186_ _02188_ vssd1 vssd1 vccd1 vccd1 _02189_ sky130_fd_sc_hd__nor3_1
X_08798_ _03201_ _03223_ vssd1 vssd1 vccd1 vccd1 _03224_ sky130_fd_sc_hd__xnor2_1
XFILLER_0_94_411 vssd1 vssd1 vccd1 vccd1 sky130_fd_sc_hd__fill_1
X_07749_ _02117_ _02119_ vssd1 vssd1 vccd1 vccd1 _02120_ sky130_fd_sc_hd__and2_2
XFILLER_0_94_433 vssd1 vssd1 vccd1 vccd1 sky130_ef_sc_hd__decap_12
XFILLER_0_79_496 vssd1 vssd1 vccd1 vccd1 sky130_fd_sc_hd__decap_8
XFILLER_0_66_113 vssd1 vssd1 vccd1 vccd1 sky130_fd_sc_hd__fill_2
XFILLER_0_94_477 vssd1 vssd1 vccd1 vccd1 sky130_fd_sc_hd__decap_3
X_09419_ net199 net448 _03899_ _03901_ vssd1 vssd1 vccd1 vccd1 _03903_ sky130_fd_sc_hd__a22oi_1
XFILLER_0_35_511 vssd1 vssd1 vccd1 vccd1 sky130_fd_sc_hd__fill_1
XFILLER_0_35_522 vssd1 vssd1 vccd1 vccd1 sky130_fd_sc_hd__fill_1
XFILLER_0_62_363 vssd1 vssd1 vccd1 vccd1 sky130_fd_sc_hd__fill_1
X_10125_ clknet_3_7_0_wb_clk_i _00119_ _00055_ vssd1 vssd1 vccd1 vccd1 mul.a\[20\]
+ sky130_fd_sc_hd__dfrtp_2
X_10056_ net642 vssd1 vssd1 vccd1 vccd1 _00052_ sky130_fd_sc_hd__inv_2
XFILLER_0_97_260 vssd1 vssd1 vccd1 vccd1 sky130_ef_sc_hd__decap_12
XFILLER_0_57_113 vssd1 vssd1 vccd1 vccd1 sky130_ef_sc_hd__decap_12
XFILLER_0_70_48 vssd1 vssd1 vccd1 vccd1 sky130_fd_sc_hd__fill_2
XFILLER_0_70_37 vssd1 vssd1 vccd1 vccd1 sky130_fd_sc_hd__fill_1
XFILLER_0_53_330 vssd1 vssd1 vccd1 vccd1 sky130_fd_sc_hd__decap_6
XFILLER_0_5_416 vssd1 vssd1 vccd1 vccd1 sky130_fd_sc_hd__fill_2
XFILLER_0_26_533 vssd1 vssd1 vccd1 vccd1 sky130_fd_sc_hd__decap_8
XFILLER_0_26_555 vssd1 vssd1 vccd1 vccd1 sky130_fd_sc_hd__decap_3
XFILLER_0_41_503 vssd1 vssd1 vccd1 vccd1 sky130_fd_sc_hd__fill_1
XFILLER_0_41_514 vssd1 vssd1 vccd1 vccd1 sky130_fd_sc_hd__decap_6
XFILLER_0_79_57 vssd1 vssd1 vccd1 vccd1 sky130_ef_sc_hd__decap_12
X_05100_ net319 net614 vssd1 vssd1 vccd1 vccd1 _02645_ sky130_fd_sc_hd__and2_1
X_06080_ _00456_ _00457_ _00424_ vssd1 vssd1 vccd1 vccd1 _00459_ sky130_fd_sc_hd__a21o_1
XFILLER_0_41_558 vssd1 vssd1 vccd1 vccd1 sky130_fd_sc_hd__fill_2
X_05031_ net22 net183 net135 vssd1 vssd1 vccd1 vccd1 _00124_ sky130_fd_sc_hd__mux2_1
XTAP_400 vssd1 vccd1 sky130_fd_sc_hd__tapvpwrvgnd_1
XTAP_411 vssd1 vccd1 sky130_fd_sc_hd__tapvpwrvgnd_1
Xfanout608 net609 vssd1 vssd1 vccd1 vccd1 net608 sky130_fd_sc_hd__buf_2
XTAP_422 vssd1 vccd1 sky130_fd_sc_hd__tapvpwrvgnd_1
XTAP_433 vssd1 vccd1 sky130_fd_sc_hd__tapvpwrvgnd_1
Xfanout619 net620 vssd1 vssd1 vccd1 vccd1 net619 sky130_fd_sc_hd__buf_2
X_09770_ _04107_ _04111_ _04284_ vssd1 vssd1 vccd1 vccd1 _04287_ sky130_fd_sc_hd__nor3_1
XTAP_444 vssd1 vccd1 sky130_fd_sc_hd__tapvpwrvgnd_1
XTAP_455 vssd1 vccd1 sky130_fd_sc_hd__tapvpwrvgnd_1
XTAP_466 vssd1 vccd1 sky130_fd_sc_hd__tapvpwrvgnd_1
X_06982_ _01350_ _01352_ _01224_ vssd1 vssd1 vccd1 vccd1 _01354_ sky130_fd_sc_hd__o21ai_1
X_08721_ _03136_ _03138_ net241 net450 vssd1 vssd1 vccd1 vccd1 _03140_ sky130_fd_sc_hd__and4bb_1
X_05933_ _00308_ _00311_ vssd1 vssd1 vccd1 vccd1 _00313_ sky130_fd_sc_hd__xnor2_1
XTAP_477 vssd1 vccd1 sky130_fd_sc_hd__tapvpwrvgnd_1
XTAP_488 vssd1 vccd1 sky130_fd_sc_hd__tapvpwrvgnd_1
XTAP_499 vssd1 vccd1 sky130_fd_sc_hd__tapvpwrvgnd_1
XFILLER_0_28_72 vssd1 vssd1 vccd1 vccd1 sky130_ef_sc_hd__decap_12
X_08652_ _03062_ _03063_ vssd1 vssd1 vccd1 vccd1 _03065_ sky130_fd_sc_hd__xnor2_1
X_05864_ _00242_ _00243_ _00244_ vssd1 vssd1 vccd1 vccd1 _00245_ sky130_fd_sc_hd__nand3_1
X_07603_ _01803_ _01974_ vssd1 vssd1 vccd1 vccd1 _01975_ sky130_fd_sc_hd__xnor2_1
X_08583_ _02986_ _02987_ _02980_ vssd1 vssd1 vccd1 vccd1 _02989_ sky130_fd_sc_hd__a21o_1
X_05795_ _04896_ _04970_ _04969_ vssd1 vssd1 vccd1 vccd1 _00177_ sky130_fd_sc_hd__a21o_1
XFILLER_0_88_293 vssd1 vssd1 vccd1 vccd1 sky130_ef_sc_hd__decap_12
X_07534_ _01905_ _01906_ vssd1 vssd1 vccd1 vccd1 _01907_ sky130_fd_sc_hd__nor2_1
X_07465_ _01830_ _01831_ _01711_ _01713_ vssd1 vssd1 vccd1 vccd1 _01834_ sky130_fd_sc_hd__a211oi_2
XFILLER_0_48_157 vssd1 vssd1 vccd1 vccd1 sky130_fd_sc_hd__decap_6
X_09204_ _03466_ _03474_ _03473_ vssd1 vssd1 vccd1 vccd1 _03668_ sky130_fd_sc_hd__a21o_1
XFILLER_0_8_232 vssd1 vssd1 vccd1 vccd1 sky130_fd_sc_hd__fill_2
X_06416_ net321 net503 net511 net311 vssd1 vssd1 vccd1 vccd1 _00792_ sky130_fd_sc_hd__a22o_1
XFILLER_0_36_319 vssd1 vssd1 vccd1 vccd1 sky130_fd_sc_hd__fill_2
X_07396_ _01744_ _01762_ _01763_ vssd1 vssd1 vccd1 vccd1 _01765_ sky130_fd_sc_hd__or3_4
XFILLER_0_8_276 vssd1 vssd1 vccd1 vccd1 sky130_fd_sc_hd__decap_4
XFILLER_0_71_160 vssd1 vssd1 vccd1 vccd1 sky130_fd_sc_hd__decap_8
X_09135_ _03584_ _03590_ vssd1 vssd1 vccd1 vccd1 _03592_ sky130_fd_sc_hd__xnor2_2
X_06347_ net227 net617 _00605_ _00604_ vssd1 vssd1 vccd1 vccd1 _00723_ sky130_fd_sc_hd__a31o_1
XFILLER_0_44_363 vssd1 vssd1 vccd1 vccd1 sky130_fd_sc_hd__fill_1
X_09066_ _03507_ _03516_ vssd1 vssd1 vccd1 vccd1 _03517_ sky130_fd_sc_hd__xnor2_2
X_06278_ _00534_ _00653_ vssd1 vssd1 vccd1 vccd1 _00655_ sky130_fd_sc_hd__xnor2_1
X_08017_ _02381_ _02389_ vssd1 vssd1 vccd1 vccd1 _02390_ sky130_fd_sc_hd__xnor2_2
X_05229_ net362 net559 net568 net354 vssd1 vssd1 vccd1 vccd1 _04055_ sky130_fd_sc_hd__a22oi_1
XFILLER_0_12_282 vssd1 vssd1 vccd1 vccd1 sky130_fd_sc_hd__decap_8
X_09968_ net122 _04501_ vssd1 vssd1 vccd1 vccd1 _04502_ sky130_fd_sc_hd__xnor2_1
X_08919_ net148 net588 _03207_ _03053_ net158 vssd1 vssd1 vccd1 vccd1 _03357_ sky130_fd_sc_hd__a32o_1
X_09899_ _04266_ _04290_ _04426_ vssd1 vssd1 vccd1 vccd1 _04428_ sky130_fd_sc_hd__a21oi_1
XFILLER_0_86_219 vssd1 vssd1 vccd1 vccd1 sky130_fd_sc_hd__fill_1
XFILLER_0_39_113 vssd1 vssd1 vccd1 vccd1 sky130_ef_sc_hd__decap_12
XFILLER_0_39_135 vssd1 vssd1 vccd1 vccd1 sky130_fd_sc_hd__fill_2
XFILLER_0_54_149 vssd1 vssd1 vccd1 vccd1 sky130_fd_sc_hd__decap_3
XFILLER_0_40_29 vssd1 vssd1 vccd1 vccd1 sky130_fd_sc_hd__decap_4
XFILLER_0_50_322 vssd1 vssd1 vccd1 vccd1 sky130_fd_sc_hd__fill_1
XFILLER_0_2_419 vssd1 vssd1 vccd1 vccd1 sky130_fd_sc_hd__fill_1
XFILLER_0_23_569 vssd1 vssd1 vccd1 vccd1 sky130_fd_sc_hd__fill_1
XFILLER_0_49_27 vssd1 vssd1 vccd1 vccd1 sky130_fd_sc_hd__fill_1
X_10108_ clknet_3_2_0_wb_clk_i _00102_ _00038_ vssd1 vssd1 vccd1 vccd1 mul.a\[3\]
+ sky130_fd_sc_hd__dfrtp_4
X_10039_ net638 vssd1 vssd1 vccd1 vccd1 _00035_ sky130_fd_sc_hd__inv_2
X_05580_ _04846_ _04849_ vssd1 vssd1 vccd1 vccd1 _04850_ sky130_fd_sc_hd__xnor2_2
XFILLER_0_85_241 vssd1 vssd1 vccd1 vccd1 sky130_fd_sc_hd__fill_2
XFILLER_0_14_41 vssd1 vssd1 vccd1 vccd1 sky130_fd_sc_hd__decap_8
XFILLER_0_14_85 vssd1 vssd1 vccd1 vccd1 sky130_fd_sc_hd__fill_1
XFILLER_0_45_105 vssd1 vssd1 vccd1 vccd1 sky130_fd_sc_hd__fill_2
X_07250_ _01616_ _01617_ _01599_ vssd1 vssd1 vccd1 vccd1 _01620_ sky130_fd_sc_hd__o21ai_1
X_07181_ net375 net418 net423 net366 vssd1 vssd1 vccd1 vccd1 _01551_ sky130_fd_sc_hd__a22oi_1
X_06201_ _00532_ _00576_ _00577_ vssd1 vssd1 vccd1 vccd1 _00579_ sky130_fd_sc_hd__or3_4
X_06132_ _00507_ _00508_ vssd1 vssd1 vccd1 vccd1 _00510_ sky130_fd_sc_hd__xor2_1
XFILLER_0_41_344 vssd1 vssd1 vccd1 vccd1 sky130_fd_sc_hd__decap_8
X_06063_ net310 net319 net530 net540 vssd1 vssd1 vccd1 vccd1 _00442_ sky130_fd_sc_hd__nand4_1
XFILLER_0_22_580 vssd1 vssd1 vccd1 vccd1 sky130_fd_sc_hd__fill_2
XFILLER_0_41_388 vssd1 vssd1 vccd1 vccd1 sky130_fd_sc_hd__decap_4
Xfanout405 net406 vssd1 vssd1 vccd1 vccd1 net405 sky130_fd_sc_hd__buf_2
Xfanout427 mul.b\[25\] vssd1 vssd1 vccd1 vccd1 net427 sky130_fd_sc_hd__buf_4
Xfanout416 net419 vssd1 vssd1 vccd1 vccd1 net416 sky130_fd_sc_hd__clkbuf_4
Xfanout438 net439 vssd1 vssd1 vccd1 vccd1 net438 sky130_fd_sc_hd__buf_4
XTAP_230 vssd1 vccd1 sky130_fd_sc_hd__tapvpwrvgnd_1
XTAP_241 vssd1 vccd1 sky130_fd_sc_hd__tapvpwrvgnd_1
X_09822_ _04341_ _04342_ vssd1 vssd1 vccd1 vccd1 _04343_ sky130_fd_sc_hd__nor2_1
X_09753_ _04266_ _04267_ vssd1 vssd1 vccd1 vccd1 _04268_ sky130_fd_sc_hd__and2_1
Xfanout449 net451 vssd1 vssd1 vccd1 vccd1 net449 sky130_fd_sc_hd__clkbuf_4
XTAP_274 vssd1 vccd1 sky130_fd_sc_hd__tapvpwrvgnd_1
XTAP_263 vssd1 vccd1 sky130_fd_sc_hd__tapvpwrvgnd_1
XTAP_252 vssd1 vccd1 sky130_fd_sc_hd__tapvpwrvgnd_1
X_08704_ _03120_ _03114_ vssd1 vssd1 vccd1 vccd1 _03121_ sky130_fd_sc_hd__and2b_1
XTAP_296 vssd1 vccd1 sky130_fd_sc_hd__tapvpwrvgnd_1
XTAP_285 vssd1 vccd1 sky130_fd_sc_hd__tapvpwrvgnd_1
X_06965_ net724 _01200_ _01335_ _01336_ vssd1 vssd1 vccd1 vccd1 _01337_ sky130_fd_sc_hd__a211o_2
X_09684_ _04189_ _04190_ _04019_ _04035_ vssd1 vssd1 vccd1 vccd1 _04192_ sky130_fd_sc_hd__o211ai_1
X_05916_ _00190_ _00194_ _00294_ vssd1 vssd1 vccd1 vccd1 _00296_ sky130_fd_sc_hd__nand3_1
X_06896_ _01265_ _01267_ vssd1 vssd1 vccd1 vccd1 _01268_ sky130_fd_sc_hd__nand2_1
X_08635_ _02867_ _02869_ vssd1 vssd1 vccd1 vccd1 _03046_ sky130_fd_sc_hd__nand2_1
XFILLER_0_55_81 vssd1 vssd1 vccd1 vccd1 sky130_ef_sc_hd__decap_12
X_05847_ net380 net388 net479 net488 vssd1 vssd1 vccd1 vccd1 _00228_ sky130_fd_sc_hd__and4_1
X_08566_ _02955_ _02956_ _02968_ vssd1 vssd1 vccd1 vccd1 _02970_ sky130_fd_sc_hd__or3_4
X_07517_ _01887_ _01888_ _01727_ _01729_ vssd1 vssd1 vccd1 vccd1 _01890_ sky130_fd_sc_hd__o211a_1
X_05778_ _05018_ _00159_ vssd1 vssd1 vccd1 vccd1 _00160_ sky130_fd_sc_hd__xnor2_1
XFILLER_0_37_617 vssd1 vssd1 vccd1 vccd1 sky130_fd_sc_hd__fill_2
X_08497_ _02880_ _02893_ vssd1 vssd1 vccd1 vccd1 _02895_ sky130_fd_sc_hd__xnor2_1
XFILLER_0_9_541 vssd1 vssd1 vccd1 vccd1 sky130_fd_sc_hd__decap_3
XFILLER_0_36_105 vssd1 vssd1 vccd1 vccd1 sky130_fd_sc_hd__fill_1
XFILLER_0_36_116 vssd1 vssd1 vccd1 vccd1 sky130_fd_sc_hd__decap_3
XFILLER_0_64_447 vssd1 vssd1 vccd1 vccd1 sky130_fd_sc_hd__decap_4
X_07448_ net181 net592 _01814_ _01815_ vssd1 vssd1 vccd1 vccd1 _01816_ sky130_fd_sc_hd__a22o_1
X_07379_ net269 net501 vssd1 vssd1 vccd1 vccd1 _01748_ sky130_fd_sc_hd__nand2_1
XFILLER_0_17_363 vssd1 vssd1 vccd1 vccd1 sky130_fd_sc_hd__fill_1
X_09118_ net161 net167 net506 vssd1 vssd1 vccd1 vccd1 _03573_ sky130_fd_sc_hd__and3_1
X_09049_ _03461_ _03462_ _03496_ _03497_ vssd1 vssd1 vccd1 vccd1 _03499_ sky130_fd_sc_hd__nor4_1
XFILLER_0_99_333 vssd1 vssd1 vccd1 vccd1 sky130_fd_sc_hd__decap_3
XFILLER_0_59_208 vssd1 vssd1 vccd1 vccd1 sky130_fd_sc_hd__fill_1
XFILLER_0_55_414 vssd1 vssd1 vccd1 vccd1 sky130_ef_sc_hd__decap_12
XFILLER_0_27_105 vssd1 vssd1 vccd1 vccd1 sky130_fd_sc_hd__decap_6
XFILLER_0_50_141 vssd1 vssd1 vccd1 vccd1 sky130_ef_sc_hd__decap_12
XFILLER_0_23_355 vssd1 vssd1 vccd1 vccd1 sky130_fd_sc_hd__decap_3
X_06750_ _00986_ _00988_ vssd1 vssd1 vccd1 vccd1 _01123_ sky130_fd_sc_hd__nand2_1
X_05701_ _04896_ _04970_ vssd1 vssd1 vccd1 vccd1 _04971_ sky130_fd_sc_hd__xnor2_1
X_06681_ net279 net689 net546 net271 vssd1 vssd1 vccd1 vccd1 _01055_ sky130_fd_sc_hd__a22o_1
X_08420_ net443 _02810_ _02808_ vssd1 vssd1 vccd1 vccd1 _02811_ sky130_fd_sc_hd__a21bo_1
X_05632_ net298 net598 net607 net289 vssd1 vssd1 vccd1 vccd1 _04902_ sky130_fd_sc_hd__a22o_1
XFILLER_0_25_40 vssd1 vssd1 vccd1 vccd1 sky130_fd_sc_hd__decap_8
X_08351_ _02731_ _02734_ vssd1 vssd1 vccd1 vccd1 _02736_ sky130_fd_sc_hd__or2_1
X_05563_ _04823_ _04832_ vssd1 vssd1 vccd1 vccd1 _04833_ sky130_fd_sc_hd__xor2_1
XFILLER_0_19_617 vssd1 vssd1 vccd1 vccd1 sky130_fd_sc_hd__fill_2
X_08282_ _02657_ _02658_ _02528_ _02530_ vssd1 vssd1 vccd1 vccd1 _02660_ sky130_fd_sc_hd__o211a_1
XFILLER_0_73_233 vssd1 vssd1 vccd1 vccd1 sky130_fd_sc_hd__fill_2
X_05494_ _04728_ _04763_ vssd1 vssd1 vccd1 vccd1 _04764_ sky130_fd_sc_hd__and2_1
X_07302_ net197 net219 net555 net582 vssd1 vssd1 vccd1 vccd1 _01671_ sky130_fd_sc_hd__nand4_1
XFILLER_0_61_428 vssd1 vssd1 vccd1 vccd1 sky130_fd_sc_hd__decap_3
X_07233_ net277 net499 vssd1 vssd1 vccd1 vccd1 _01603_ sky130_fd_sc_hd__nand2_1
XFILLER_0_73_288 vssd1 vssd1 vccd1 vccd1 sky130_fd_sc_hd__decap_4
X_07164_ _01392_ _01533_ vssd1 vssd1 vccd1 vccd1 _01534_ sky130_fd_sc_hd__or2_1
XFILLER_0_74_3 vssd1 vssd1 vccd1 vccd1 sky130_fd_sc_hd__decap_6
X_07095_ net720 _01463_ _01464_ vssd1 vssd1 vccd1 vccd1 _01466_ sky130_fd_sc_hd__a21oi_2
X_06115_ _00491_ _00492_ vssd1 vssd1 vccd1 vccd1 _00493_ sky130_fd_sc_hd__nand2_1
XFILLER_0_41_152 vssd1 vssd1 vccd1 vccd1 sky130_fd_sc_hd__decap_6
X_06046_ net388 net470 _00328_ _00327_ vssd1 vssd1 vccd1 vccd1 _00425_ sky130_fd_sc_hd__a31o_1
Xfanout202 net206 vssd1 vssd1 vccd1 vccd1 net202 sky130_fd_sc_hd__buf_2
Xfanout213 net214 vssd1 vssd1 vccd1 vccd1 net213 sky130_fd_sc_hd__buf_2
Xfanout224 net225 vssd1 vssd1 vccd1 vccd1 net224 sky130_fd_sc_hd__buf_2
Xfanout246 net247 vssd1 vssd1 vccd1 vccd1 net246 sky130_fd_sc_hd__clkbuf_2
Xfanout235 net238 vssd1 vssd1 vccd1 vccd1 net235 sky130_fd_sc_hd__buf_4
Xfanout268 net271 vssd1 vssd1 vccd1 vccd1 net268 sky130_fd_sc_hd__clkbuf_2
Xfanout257 net261 vssd1 vssd1 vccd1 vccd1 net257 sky130_fd_sc_hd__clkbuf_4
X_07997_ _02366_ _02368_ _02219_ _02223_ vssd1 vssd1 vccd1 vccd1 _02370_ sky130_fd_sc_hd__a211o_1
XFILLER_0_5_83 vssd1 vssd1 vccd1 vccd1 sky130_fd_sc_hd__decap_8
X_09805_ _04321_ _04323_ vssd1 vssd1 vccd1 vccd1 _04324_ sky130_fd_sc_hd__nand2_1
Xfanout279 mul.a\[13\] vssd1 vssd1 vccd1 vccd1 net279 sky130_fd_sc_hd__buf_4
X_09736_ _04248_ _04242_ vssd1 vssd1 vccd1 vccd1 _04249_ sky130_fd_sc_hd__nand2b_1
X_06948_ _01317_ _01318_ _01319_ vssd1 vssd1 vccd1 vccd1 _01320_ sky130_fd_sc_hd__nand3_1
X_09667_ _04171_ _04172_ vssd1 vssd1 vccd1 vccd1 _04173_ sky130_fd_sc_hd__and2_1
X_08618_ _03019_ _03025_ _03026_ vssd1 vssd1 vccd1 vccd1 _03027_ sky130_fd_sc_hd__nand3_1
XTAP_1204 vssd1 vccd1 sky130_fd_sc_hd__tapvpwrvgnd_1
XFILLER_0_69_539 vssd1 vssd1 vccd1 vccd1 sky130_fd_sc_hd__fill_1
X_06879_ _01249_ _01250_ vssd1 vssd1 vccd1 vccd1 _01251_ sky130_fd_sc_hd__nand2_1
XTAP_1248 vssd1 vccd1 sky130_fd_sc_hd__tapvpwrvgnd_1
XTAP_1237 vssd1 vccd1 sky130_fd_sc_hd__tapvpwrvgnd_1
XTAP_1226 vssd1 vccd1 sky130_fd_sc_hd__tapvpwrvgnd_1
XTAP_1215 vssd1 vccd1 sky130_fd_sc_hd__tapvpwrvgnd_1
X_09598_ _04090_ _04096_ vssd1 vssd1 vccd1 vccd1 _04098_ sky130_fd_sc_hd__xnor2_1
XTAP_1259 vssd1 vccd1 sky130_fd_sc_hd__tapvpwrvgnd_1
X_08549_ _02944_ _02945_ _02950_ vssd1 vssd1 vccd1 vccd1 _02952_ sky130_fd_sc_hd__nand3_1
XFILLER_0_37_414 vssd1 vssd1 vccd1 vccd1 sky130_ef_sc_hd__decap_12
XFILLER_0_92_531 vssd1 vssd1 vccd1 vccd1 sky130_fd_sc_hd__fill_1
XFILLER_0_64_233 vssd1 vssd1 vccd1 vccd1 sky130_fd_sc_hd__decap_6
XFILLER_0_37_447 vssd1 vssd1 vccd1 vccd1 sky130_fd_sc_hd__fill_1
XFILLER_0_9_393 vssd1 vssd1 vccd1 vccd1 sky130_ef_sc_hd__decap_12
XFILLER_0_17_160 vssd1 vssd1 vccd1 vccd1 sky130_fd_sc_hd__fill_2
XFILLER_0_45_480 vssd1 vssd1 vccd1 vccd1 sky130_ef_sc_hd__decap_12
XFILLER_0_32_141 vssd1 vssd1 vccd1 vccd1 sky130_fd_sc_hd__decap_6
XFILLER_0_95_380 vssd1 vssd1 vccd1 vccd1 sky130_fd_sc_hd__decap_8
XFILLER_0_55_222 vssd1 vssd1 vccd1 vccd1 sky130_fd_sc_hd__fill_2
XFILLER_0_55_211 vssd1 vssd1 vccd1 vccd1 sky130_fd_sc_hd__decap_6
XFILLER_0_55_266 vssd1 vssd1 vccd1 vccd1 sky130_fd_sc_hd__decap_6
XFILLER_0_70_236 vssd1 vssd1 vccd1 vccd1 sky130_fd_sc_hd__decap_3
XFILLER_0_87_13 vssd1 vssd1 vccd1 vccd1 sky130_ef_sc_hd__decap_12
XFILLER_0_87_35 vssd1 vssd1 vccd1 vccd1 sky130_ef_sc_hd__decap_12
XFILLER_0_23_196 vssd1 vssd1 vccd1 vccd1 sky130_ef_sc_hd__decap_12
X_07920_ _02291_ _02292_ vssd1 vssd1 vccd1 vccd1 _02293_ sky130_fd_sc_hd__nor2_1
X_07851_ net220 net528 _02218_ _02220_ vssd1 vssd1 vccd1 vccd1 _02224_ sky130_fd_sc_hd__nand4_1
XFILLER_0_46_7 vssd1 vssd1 vccd1 vccd1 sky130_fd_sc_hd__fill_1
X_07782_ _02150_ _02151_ vssd1 vssd1 vccd1 vccd1 _02153_ sky130_fd_sc_hd__xnor2_1
Xinput2 wbs_adr_i[2] vssd1 vssd1 vccd1 vccd1 net2 sky130_fd_sc_hd__clkbuf_2
X_06802_ _01172_ _01173_ _01169_ vssd1 vssd1 vccd1 vccd1 _01175_ sky130_fd_sc_hd__a21o_1
X_06733_ _01103_ _01104_ vssd1 vssd1 vccd1 vccd1 _01106_ sky130_fd_sc_hd__xor2_1
X_09521_ net156 net497 _04012_ _04013_ vssd1 vssd1 vccd1 vccd1 _04014_ sky130_fd_sc_hd__o2bb2a_1
XFILLER_0_78_369 vssd1 vssd1 vccd1 vccd1 sky130_fd_sc_hd__fill_1
XFILLER_0_78_347 vssd1 vssd1 vccd1 vccd1 sky130_fd_sc_hd__fill_2
X_09452_ _03790_ _03792_ vssd1 vssd1 vccd1 vccd1 _03939_ sky130_fd_sc_hd__or2_1
X_06664_ _00905_ _00907_ vssd1 vssd1 vccd1 vccd1 _01038_ sky130_fd_sc_hd__nand2_1
X_08403_ net215 net500 _02613_ _02614_ net519 vssd1 vssd1 vccd1 vccd1 _02792_ sky130_fd_sc_hd__a32o_1
XFILLER_0_59_561 vssd1 vssd1 vccd1 vccd1 sky130_fd_sc_hd__decap_3
X_09383_ _03861_ _03862_ vssd1 vssd1 vccd1 vccd1 _03863_ sky130_fd_sc_hd__or2_1
X_05615_ _04695_ _04716_ net103 _04801_ _04884_ vssd1 vssd1 vccd1 vccd1 _04885_ sky130_fd_sc_hd__a2111oi_1
X_06595_ net218 net603 net613 net210 vssd1 vssd1 vccd1 vccd1 _00969_ sky130_fd_sc_hd__a22o_1
XFILLER_0_74_542 vssd1 vssd1 vccd1 vccd1 sky130_fd_sc_hd__fill_1
X_08334_ net618 _02446_ _02449_ vssd1 vssd1 vccd1 vccd1 _02717_ sky130_fd_sc_hd__a21o_1
XFILLER_0_52_82 vssd1 vssd1 vccd1 vccd1 sky130_fd_sc_hd__fill_2
X_05546_ _04813_ _04814_ _04815_ _04748_ vssd1 vssd1 vccd1 vccd1 _04816_ sky130_fd_sc_hd__a22o_1
XFILLER_0_46_233 vssd1 vssd1 vccd1 vccd1 sky130_fd_sc_hd__decap_4
X_08265_ net290 net438 net445 net282 vssd1 vssd1 vccd1 vccd1 _02641_ sky130_fd_sc_hd__a22o_1
XFILLER_0_61_225 vssd1 vssd1 vccd1 vccd1 sky130_fd_sc_hd__decap_8
X_05477_ _02973_ _04555_ _04744_ _04745_ _04553_ vssd1 vssd1 vccd1 vccd1 _04747_ sky130_fd_sc_hd__o221a_1
X_08196_ _02343_ _02350_ _02349_ vssd1 vssd1 vccd1 vccd1 _02569_ sky130_fd_sc_hd__a21bo_1
X_07216_ _01445_ _01447_ _01584_ vssd1 vssd1 vccd1 vccd1 _01586_ sky130_fd_sc_hd__nor3_1
XFILLER_0_14_141 vssd1 vssd1 vccd1 vccd1 sky130_fd_sc_hd__decap_6
X_07147_ _01371_ _01376_ _01516_ vssd1 vssd1 vccd1 vccd1 _01517_ sky130_fd_sc_hd__o21ai_2
XFILLER_0_42_494 vssd1 vssd1 vccd1 vccd1 sky130_fd_sc_hd__decap_8
XFILLER_0_100_544 vssd1 vssd1 vccd1 vccd1 sky130_fd_sc_hd__decap_3
X_07078_ net269 net277 net507 net517 vssd1 vssd1 vccd1 vccd1 _01449_ sky130_fd_sc_hd__and4_1
X_06029_ _00406_ _00407_ vssd1 vssd1 vccd1 vccd1 _00408_ sky130_fd_sc_hd__nor2_1
XFILLER_0_97_623 vssd1 vssd1 vccd1 vccd1 sky130_fd_sc_hd__fill_2
X_09719_ net261 net397 _04228_ _04229_ vssd1 vssd1 vccd1 vccd1 _04231_ sky130_fd_sc_hd__a22o_1
XTAP_1012 vssd1 vccd1 sky130_fd_sc_hd__tapvpwrvgnd_1
XTAP_1001 vssd1 vccd1 sky130_fd_sc_hd__tapvpwrvgnd_1
XFILLER_0_96_166 vssd1 vssd1 vccd1 vccd1 sky130_fd_sc_hd__decap_8
XTAP_1056 vssd1 vccd1 sky130_fd_sc_hd__tapvpwrvgnd_1
XTAP_1045 vssd1 vccd1 sky130_fd_sc_hd__tapvpwrvgnd_1
XTAP_1034 vssd1 vccd1 sky130_fd_sc_hd__tapvpwrvgnd_1
XTAP_1023 vssd1 vccd1 sky130_fd_sc_hd__tapvpwrvgnd_1
XTAP_1089 vssd1 vccd1 sky130_fd_sc_hd__tapvpwrvgnd_1
XTAP_1078 vssd1 vccd1 sky130_fd_sc_hd__tapvpwrvgnd_1
XTAP_1067 vssd1 vccd1 sky130_fd_sc_hd__tapvpwrvgnd_1
XFILLER_0_37_222 vssd1 vssd1 vccd1 vccd1 sky130_fd_sc_hd__fill_2
XFILLER_0_37_233 vssd1 vssd1 vccd1 vccd1 sky130_fd_sc_hd__decap_4
XFILLER_0_65_553 vssd1 vssd1 vccd1 vccd1 sky130_fd_sc_hd__decap_4
XFILLER_0_37_255 vssd1 vssd1 vccd1 vccd1 sky130_fd_sc_hd__fill_2
XFILLER_0_25_417 vssd1 vssd1 vccd1 vccd1 sky130_ef_sc_hd__decap_12
XFILLER_0_37_288 vssd1 vssd1 vccd1 vccd1 sky130_fd_sc_hd__decap_8
XFILLER_0_80_589 vssd1 vssd1 vccd1 vccd1 sky130_fd_sc_hd__fill_1
XFILLER_0_21_623 vssd1 vssd1 vccd1 vccd1 sky130_fd_sc_hd__fill_2
XFILLER_0_33_472 vssd1 vssd1 vccd1 vccd1 sky130_ef_sc_hd__decap_12
XTAP_807 vssd1 vccd1 sky130_fd_sc_hd__tapvpwrvgnd_1
XTAP_829 vssd1 vccd1 sky130_fd_sc_hd__tapvpwrvgnd_1
XTAP_818 vssd1 vccd1 sky130_fd_sc_hd__tapvpwrvgnd_1
XFILLER_0_48_509 vssd1 vssd1 vccd1 vccd1 sky130_fd_sc_hd__decap_6
XFILLER_0_87_177 vssd1 vssd1 vccd1 vccd1 sky130_fd_sc_hd__decap_8
XFILLER_0_7_105 vssd1 vssd1 vccd1 vccd1 sky130_fd_sc_hd__decap_6
X_05400_ _04650_ _04653_ _04669_ _04651_ vssd1 vssd1 vccd1 vccd1 _04670_ sky130_fd_sc_hd__a31o_1
XFILLER_0_22_52 vssd1 vssd1 vccd1 vccd1 sky130_ef_sc_hd__decap_12
X_06380_ _00635_ _00637_ _00754_ vssd1 vssd1 vccd1 vccd1 _00756_ sky130_fd_sc_hd__a21o_1
XFILLER_0_22_85 vssd1 vssd1 vccd1 vccd1 sky130_fd_sc_hd__decap_4
X_05331_ net378 net386 net606 vssd1 vssd1 vccd1 vccd1 _04601_ sky130_fd_sc_hd__and3_1
XFILLER_0_43_225 vssd1 vssd1 vccd1 vccd1 sky130_fd_sc_hd__decap_3
XFILLER_0_71_578 vssd1 vssd1 vccd1 vccd1 sky130_fd_sc_hd__decap_3
X_08050_ net92 _02421_ _02256_ _02259_ vssd1 vssd1 vccd1 vccd1 _02423_ sky130_fd_sc_hd__o211a_1
X_05262_ _03651_ _04394_ _04405_ vssd1 vssd1 vccd1 vccd1 _04416_ sky130_fd_sc_hd__nand3_1
XFILLER_0_43_258 vssd1 vssd1 vccd1 vccd1 sky130_fd_sc_hd__fill_1
XFILLER_0_71_589 vssd1 vssd1 vccd1 vccd1 sky130_fd_sc_hd__fill_1
X_07001_ _01369_ _01370_ vssd1 vssd1 vccd1 vccd1 _01372_ sky130_fd_sc_hd__xor2_1
XFILLER_0_11_111 vssd1 vssd1 vccd1 vccd1 sky130_fd_sc_hd__fill_1
X_05193_ _03651_ vssd1 vssd1 vccd1 vccd1 _03662_ sky130_fd_sc_hd__inv_2
XFILLER_0_3_388 vssd1 vssd1 vccd1 vccd1 sky130_fd_sc_hd__decap_4
X_08952_ _03390_ _03391_ vssd1 vssd1 vccd1 vccd1 _03393_ sky130_fd_sc_hd__nor2_1
X_08883_ net294 net303 net401 net406 vssd1 vssd1 vccd1 vccd1 _03317_ sky130_fd_sc_hd__and4_1
X_07903_ _01949_ _01950_ _02109_ vssd1 vssd1 vccd1 vccd1 _02277_ sky130_fd_sc_hd__nor3_1
X_07834_ net299 net452 _02202_ _02203_ vssd1 vssd1 vccd1 vccd1 _02205_ sky130_fd_sc_hd__and4_1
XFILLER_0_37_3 vssd1 vssd1 vccd1 vccd1 sky130_ef_sc_hd__decap_12
XFILLER_0_47_82 vssd1 vssd1 vccd1 vccd1 sky130_fd_sc_hd__decap_8
X_07765_ _01839_ _01981_ _01982_ _01985_ vssd1 vssd1 vccd1 vccd1 _02136_ sky130_fd_sc_hd__a31o_1
X_09504_ _03828_ _03830_ vssd1 vssd1 vccd1 vccd1 _03996_ sky130_fd_sc_hd__or2_2
XFILLER_0_78_122 vssd1 vssd1 vccd1 vccd1 sky130_fd_sc_hd__decap_4
X_07696_ net212 net393 net548 vssd1 vssd1 vccd1 vccd1 _02068_ sky130_fd_sc_hd__nand3_1
X_06716_ _00967_ _01087_ _01089_ vssd1 vssd1 vccd1 vccd1 _01090_ sky130_fd_sc_hd__or3_4
X_09435_ _03799_ _03801_ vssd1 vssd1 vccd1 vccd1 _03920_ sky130_fd_sc_hd__nand2b_2
XFILLER_0_66_328 vssd1 vssd1 vccd1 vccd1 sky130_fd_sc_hd__decap_6
XFILLER_0_66_306 vssd1 vssd1 vccd1 vccd1 sky130_fd_sc_hd__fill_2
XFILLER_0_63_92 vssd1 vssd1 vccd1 vccd1 sky130_fd_sc_hd__decap_6
XPHY_106 vssd1 vssd1 vccd1 vccd1 sky130_fd_sc_hd__decap_3
X_06647_ net389 net428 vssd1 vssd1 vccd1 vccd1 _01021_ sky130_fd_sc_hd__nand2_1
XPHY_139 vssd1 vssd1 vccd1 vccd1 sky130_fd_sc_hd__decap_3
XPHY_128 vssd1 vssd1 vccd1 vccd1 sky130_fd_sc_hd__decap_3
XFILLER_0_59_391 vssd1 vssd1 vccd1 vccd1 sky130_fd_sc_hd__fill_1
XPHY_117 vssd1 vssd1 vccd1 vccd1 sky130_fd_sc_hd__decap_3
XFILLER_0_19_200 vssd1 vssd1 vccd1 vccd1 sky130_fd_sc_hd__decap_6
X_09366_ net120 _03843_ vssd1 vssd1 vccd1 vccd1 _03845_ sky130_fd_sc_hd__or2_1
XFILLER_0_93_169 vssd1 vssd1 vccd1 vccd1 sky130_fd_sc_hd__decap_4
XFILLER_0_81_309 vssd1 vssd1 vccd1 vccd1 sky130_fd_sc_hd__fill_1
X_06578_ _00731_ _00734_ _00951_ _00952_ vssd1 vssd1 vccd1 vccd1 _00953_ sky130_fd_sc_hd__a211oi_2
XFILLER_0_47_575 vssd1 vssd1 vccd1 vccd1 sky130_fd_sc_hd__decap_6
X_08317_ _02694_ _02695_ _02696_ vssd1 vssd1 vccd1 vccd1 _02698_ sky130_fd_sc_hd__nand3_1
X_09297_ _03745_ _03746_ _03766_ _03767_ vssd1 vssd1 vccd1 vccd1 _03769_ sky130_fd_sc_hd__o22a_1
XFILLER_0_74_361 vssd1 vssd1 vccd1 vccd1 sky130_fd_sc_hd__decap_3
X_05529_ _04796_ _04797_ _04697_ vssd1 vssd1 vccd1 vccd1 _04799_ sky130_fd_sc_hd__o21ba_1
XFILLER_0_47_586 vssd1 vssd1 vccd1 vccd1 sky130_fd_sc_hd__fill_2
X_08248_ _02618_ _02619_ _02620_ vssd1 vssd1 vccd1 vccd1 _02622_ sky130_fd_sc_hd__a21oi_2
XFILLER_0_15_461 vssd1 vssd1 vccd1 vccd1 sky130_fd_sc_hd__decap_4
X_08179_ _02548_ _02549_ _02550_ vssd1 vssd1 vccd1 vccd1 _02551_ sky130_fd_sc_hd__a21o_1
XFILLER_0_30_475 vssd1 vssd1 vccd1 vccd1 sky130_fd_sc_hd__fill_1
XFILLER_0_100_363 vssd1 vssd1 vccd1 vccd1 sky130_fd_sc_hd__fill_1
X_10072_ clknet_3_2_0_wb_clk_i _00068_ _00004_ vssd1 vssd1 vccd1 vccd1 mul.b\[1\]
+ sky130_fd_sc_hd__dfrtp_4
XFILLER_0_69_111 vssd1 vssd1 vccd1 vccd1 sky130_fd_sc_hd__fill_1
XFILLER_0_69_100 vssd1 vssd1 vccd1 vccd1 sky130_fd_sc_hd__decap_4
XFILLER_0_97_475 vssd1 vssd1 vccd1 vccd1 sky130_fd_sc_hd__fill_1
XFILLER_0_69_177 vssd1 vssd1 vccd1 vccd1 sky130_fd_sc_hd__fill_2
Xmax_cap97 _04545_ vssd1 vssd1 vccd1 vccd1 net97 sky130_fd_sc_hd__buf_1
XPHY_8 vssd1 vssd1 vccd1 vccd1 sky130_fd_sc_hd__decap_3
Xmax_cap75 _00592_ vssd1 vssd1 vccd1 vccd1 net75 sky130_fd_sc_hd__clkbuf_1
Xmax_cap86 _00466_ vssd1 vssd1 vccd1 vccd1 net86 sky130_fd_sc_hd__buf_1
XFILLER_0_84_114 vssd1 vssd1 vccd1 vccd1 sky130_fd_sc_hd__fill_1
XFILLER_0_53_523 vssd1 vssd1 vccd1 vccd1 sky130_fd_sc_hd__fill_1
XFILLER_0_25_225 vssd1 vssd1 vccd1 vccd1 sky130_fd_sc_hd__decap_6
XFILLER_0_0_325 vssd1 vssd1 vccd1 vccd1 sky130_fd_sc_hd__decap_8
XTAP_604 vssd1 vccd1 sky130_fd_sc_hd__tapvpwrvgnd_1
XTAP_615 vssd1 vccd1 sky130_fd_sc_hd__tapvpwrvgnd_1
XTAP_626 vssd1 vccd1 sky130_fd_sc_hd__tapvpwrvgnd_1
XTAP_637 vssd1 vccd1 sky130_fd_sc_hd__tapvpwrvgnd_1
XTAP_659 vssd1 vccd1 sky130_fd_sc_hd__tapvpwrvgnd_1
XTAP_648 vssd1 vccd1 sky130_fd_sc_hd__tapvpwrvgnd_1
X_05880_ _00224_ _00225_ _00259_ _00260_ vssd1 vssd1 vccd1 vccd1 _00261_ sky130_fd_sc_hd__nor4_1
XFILLER_0_17_52 vssd1 vssd1 vccd1 vccd1 sky130_fd_sc_hd__fill_1
XFILLER_0_23_9 vssd1 vssd1 vccd1 vccd1 sky130_fd_sc_hd__fill_1
X_07550_ net661 _01764_ _01921_ _01922_ vssd1 vssd1 vccd1 vccd1 _01923_ sky130_fd_sc_hd__o211ai_2
XFILLER_0_17_85 vssd1 vssd1 vccd1 vccd1 sky130_fd_sc_hd__decap_8
XFILLER_0_88_475 vssd1 vssd1 vccd1 vccd1 sky130_fd_sc_hd__fill_1
X_06501_ _00859_ _00874_ vssd1 vssd1 vccd1 vccd1 _00876_ sky130_fd_sc_hd__xnor2_1
XFILLER_0_48_306 vssd1 vssd1 vccd1 vccd1 sky130_fd_sc_hd__fill_2
X_09220_ net118 _03683_ vssd1 vssd1 vccd1 vccd1 _03686_ sky130_fd_sc_hd__xor2_1
X_07481_ net350 net433 _01715_ _01716_ vssd1 vssd1 vccd1 vccd1 _01852_ sky130_fd_sc_hd__a31o_1
XFILLER_0_75_147 vssd1 vssd1 vccd1 vccd1 sky130_fd_sc_hd__decap_6
X_06432_ _00804_ _00805_ _00806_ vssd1 vssd1 vccd1 vccd1 _00808_ sky130_fd_sc_hd__a21o_1
XFILLER_0_90_117 vssd1 vssd1 vccd1 vccd1 sky130_fd_sc_hd__decap_3
X_09151_ _03606_ _03608_ net216 net449 vssd1 vssd1 vccd1 vccd1 _03610_ sky130_fd_sc_hd__and4bb_1
XFILLER_0_16_214 vssd1 vssd1 vccd1 vccd1 sky130_fd_sc_hd__decap_6
X_06363_ net243 net590 _00736_ _00737_ vssd1 vssd1 vccd1 vccd1 _00739_ sky130_fd_sc_hd__a22o_1
XFILLER_0_44_512 vssd1 vssd1 vccd1 vccd1 sky130_ef_sc_hd__decap_12
X_09082_ _03502_ _03503_ _03533_ vssd1 vssd1 vccd1 vccd1 _03535_ sky130_fd_sc_hd__o21a_1
X_08102_ _02473_ _02462_ vssd1 vssd1 vccd1 vccd1 _02474_ sky130_fd_sc_hd__and2b_1
XFILLER_0_16_247 vssd1 vssd1 vccd1 vccd1 sky130_fd_sc_hd__decap_4
X_05314_ _04582_ _04583_ vssd1 vssd1 vccd1 vccd1 _04584_ sky130_fd_sc_hd__nand2_1
X_08033_ net291 net452 _02402_ _02404_ vssd1 vssd1 vccd1 vccd1 _02406_ sky130_fd_sc_hd__and4_2
XFILLER_0_16_269 vssd1 vssd1 vccd1 vccd1 sky130_fd_sc_hd__fill_2
X_06294_ net320 net328 net503 net511 vssd1 vssd1 vccd1 vccd1 _00671_ sky130_fd_sc_hd__and4_1
XFILLER_0_31_206 vssd1 vssd1 vccd1 vccd1 sky130_fd_sc_hd__decap_4
X_05245_ _04197_ _04208_ _04186_ vssd1 vssd1 vccd1 vccd1 _04230_ sky130_fd_sc_hd__a21o_1
X_05176_ _03443_ _03454_ _03465_ vssd1 vssd1 vccd1 vccd1 _03476_ sky130_fd_sc_hd__nand3_1
X_09984_ _04518_ _04519_ vssd1 vssd1 vccd1 vccd1 _04520_ sky130_fd_sc_hd__xor2_1
X_08935_ _03354_ _03373_ vssd1 vssd1 vccd1 vccd1 _03374_ sky130_fd_sc_hd__and2b_1
X_08866_ _03287_ _03296_ vssd1 vssd1 vccd1 vccd1 _03298_ sky130_fd_sc_hd__xor2_1
X_08797_ _03202_ _03221_ vssd1 vssd1 vccd1 vccd1 _03223_ sky130_fd_sc_hd__xnor2_1
X_07817_ _02183_ _02184_ _02185_ vssd1 vssd1 vccd1 vccd1 _02188_ sky130_fd_sc_hd__a21oi_1
X_07748_ _02118_ vssd1 vssd1 vccd1 vccd1 _02119_ sky130_fd_sc_hd__inv_2
XFILLER_0_67_615 vssd1 vssd1 vccd1 vccd1 sky130_fd_sc_hd__fill_1
XFILLER_0_94_445 vssd1 vssd1 vccd1 vccd1 sky130_fd_sc_hd__fill_2
X_07679_ _02036_ _02049_ _02050_ vssd1 vssd1 vccd1 vccd1 _02051_ sky130_fd_sc_hd__and3_1
XFILLER_0_66_158 vssd1 vssd1 vccd1 vccd1 sky130_fd_sc_hd__fill_2
XFILLER_0_54_309 vssd1 vssd1 vccd1 vccd1 sky130_fd_sc_hd__fill_2
X_09418_ _03900_ vssd1 vssd1 vccd1 vccd1 _03901_ sky130_fd_sc_hd__inv_2
XFILLER_0_47_350 vssd1 vssd1 vccd1 vccd1 sky130_fd_sc_hd__fill_1
X_09349_ net117 _03825_ vssd1 vssd1 vccd1 vccd1 _03827_ sky130_fd_sc_hd__xor2_1
X_10124_ clknet_3_7_0_wb_clk_i _00118_ _00054_ vssd1 vssd1 vccd1 vccd1 mul.a\[19\]
+ sky130_fd_sc_hd__dfrtp_2
X_10055_ net642 vssd1 vssd1 vccd1 vccd1 _00051_ sky130_fd_sc_hd__inv_2
XFILLER_0_54_17 vssd1 vssd1 vccd1 vccd1 sky130_fd_sc_hd__decap_8
XFILLER_0_85_401 vssd1 vssd1 vccd1 vccd1 sky130_fd_sc_hd__fill_1
XFILLER_0_97_272 vssd1 vssd1 vccd1 vccd1 sky130_fd_sc_hd__fill_2
XFILLER_0_45_309 vssd1 vssd1 vccd1 vccd1 sky130_ef_sc_hd__decap_12
XFILLER_0_72_117 vssd1 vssd1 vccd1 vccd1 sky130_fd_sc_hd__decap_8
XFILLER_0_38_350 vssd1 vssd1 vccd1 vccd1 sky130_fd_sc_hd__decap_8
XFILLER_0_72_139 vssd1 vssd1 vccd1 vccd1 sky130_fd_sc_hd__fill_1
XFILLER_0_5_406 vssd1 vssd1 vccd1 vccd1 sky130_fd_sc_hd__decap_4
XFILLER_0_53_375 vssd1 vssd1 vccd1 vccd1 sky130_fd_sc_hd__decap_6
XFILLER_0_80_194 vssd1 vssd1 vccd1 vccd1 sky130_fd_sc_hd__fill_2
XFILLER_0_79_69 vssd1 vssd1 vccd1 vccd1 sky130_fd_sc_hd__decap_8
XFILLER_0_13_217 vssd1 vssd1 vccd1 vccd1 sky130_fd_sc_hd__fill_2
XFILLER_0_13_239 vssd1 vssd1 vccd1 vccd1 sky130_fd_sc_hd__decap_4
X_05030_ net23 net176 net135 vssd1 vssd1 vccd1 vccd1 _00125_ sky130_fd_sc_hd__mux2_1
XFILLER_0_0_111 vssd1 vssd1 vccd1 vccd1 sky130_fd_sc_hd__fill_1
XFILLER_0_0_133 vssd1 vssd1 vccd1 vccd1 sky130_fd_sc_hd__decap_3
XFILLER_0_95_57 vssd1 vssd1 vccd1 vccd1 sky130_fd_sc_hd__decap_4
XFILLER_0_95_46 vssd1 vssd1 vccd1 vccd1 sky130_fd_sc_hd__fill_2
XTAP_401 vssd1 vccd1 sky130_fd_sc_hd__tapvpwrvgnd_1
XTAP_412 vssd1 vccd1 sky130_fd_sc_hd__tapvpwrvgnd_1
Xfanout609 mul.b\[3\] vssd1 vssd1 vccd1 vccd1 net609 sky130_fd_sc_hd__buf_2
XTAP_423 vssd1 vccd1 sky130_fd_sc_hd__tapvpwrvgnd_1
XTAP_445 vssd1 vccd1 sky130_fd_sc_hd__tapvpwrvgnd_1
XTAP_434 vssd1 vccd1 sky130_fd_sc_hd__tapvpwrvgnd_1
XTAP_456 vssd1 vccd1 sky130_fd_sc_hd__tapvpwrvgnd_1
XTAP_467 vssd1 vccd1 sky130_fd_sc_hd__tapvpwrvgnd_1
X_06981_ _01224_ _01350_ _01352_ vssd1 vssd1 vccd1 vccd1 _01353_ sky130_fd_sc_hd__or3_4
X_08720_ net240 net450 _03136_ _03138_ vssd1 vssd1 vccd1 vccd1 _03139_ sky130_fd_sc_hd__o2bb2a_1
X_05932_ _00308_ _00311_ vssd1 vssd1 vccd1 vccd1 _00312_ sky130_fd_sc_hd__and2b_1
XTAP_478 vssd1 vccd1 sky130_fd_sc_hd__tapvpwrvgnd_1
XTAP_489 vssd1 vccd1 sky130_fd_sc_hd__tapvpwrvgnd_1
X_08651_ _03062_ _03063_ vssd1 vssd1 vccd1 vccd1 _03064_ sky130_fd_sc_hd__or2_1
X_05863_ _00140_ _00142_ _00141_ vssd1 vssd1 vccd1 vccd1 _00244_ sky130_fd_sc_hd__a21bo_1
X_07602_ _01971_ _01972_ vssd1 vssd1 vccd1 vccd1 _01974_ sky130_fd_sc_hd__xor2_1
X_08582_ _02980_ _02986_ _02987_ vssd1 vssd1 vccd1 vccd1 _02988_ sky130_fd_sc_hd__nand3_4
XFILLER_0_76_401 vssd1 vssd1 vccd1 vccd1 sky130_fd_sc_hd__fill_2
X_05794_ _04976_ _00174_ vssd1 vssd1 vccd1 vccd1 _00176_ sky130_fd_sc_hd__xnor2_1
X_07533_ _01901_ _01903_ _01904_ vssd1 vssd1 vccd1 vccd1 _01906_ sky130_fd_sc_hd__and3_1
X_07464_ _01832_ vssd1 vssd1 vccd1 vccd1 _01833_ sky130_fd_sc_hd__inv_2
X_09203_ _03663_ _03664_ _03461_ net90 vssd1 vssd1 vccd1 vccd1 _03667_ sky130_fd_sc_hd__a211oi_1
XFILLER_0_63_106 vssd1 vssd1 vccd1 vccd1 sky130_fd_sc_hd__decap_6
X_06415_ net330 net495 vssd1 vssd1 vccd1 vccd1 _00791_ sky130_fd_sc_hd__nand2_1
X_09134_ _03590_ _03584_ vssd1 vssd1 vccd1 vccd1 _03591_ sky130_fd_sc_hd__and2b_1
XFILLER_0_63_139 vssd1 vssd1 vccd1 vccd1 sky130_fd_sc_hd__fill_1
X_07395_ _01744_ net660 _01763_ vssd1 vssd1 vccd1 vccd1 _01764_ sky130_fd_sc_hd__nor3_1
XFILLER_0_17_545 vssd1 vssd1 vccd1 vccd1 sky130_fd_sc_hd__decap_6
X_06346_ _00720_ _00721_ vssd1 vssd1 vccd1 vccd1 _00722_ sky130_fd_sc_hd__xnor2_1
X_09065_ _03508_ net123 vssd1 vssd1 vccd1 vccd1 _03516_ sky130_fd_sc_hd__xnor2_1
X_06277_ _00534_ _00653_ vssd1 vssd1 vccd1 vccd1 _00654_ sky130_fd_sc_hd__and2_1
X_08016_ _02387_ _02388_ vssd1 vssd1 vccd1 vccd1 _02389_ sky130_fd_sc_hd__and2b_1
X_05228_ net354 net362 net559 net568 vssd1 vssd1 vccd1 vccd1 _04044_ sky130_fd_sc_hd__and4_1
XFILLER_0_8_83 vssd1 vssd1 vccd1 vccd1 sky130_fd_sc_hd__fill_1
XFILLER_0_12_250 vssd1 vssd1 vccd1 vccd1 sky130_fd_sc_hd__fill_2
X_05159_ _02962_ _02984_ _03268_ _03279_ vssd1 vssd1 vccd1 vccd1 _03290_ sky130_fd_sc_hd__or4bb_4
X_09967_ _04388_ _04390_ vssd1 vssd1 vccd1 vccd1 _04501_ sky130_fd_sc_hd__or2_1
X_08918_ _03165_ _03172_ _03171_ vssd1 vssd1 vccd1 vccd1 _03355_ sky130_fd_sc_hd__a21bo_1
XTAP_990 vssd1 vccd1 sky130_fd_sc_hd__tapvpwrvgnd_1
X_09898_ _04424_ _04425_ vssd1 vssd1 vccd1 vccd1 _04426_ sky130_fd_sc_hd__nand2_1
X_08849_ _03263_ _03264_ _03276_ vssd1 vssd1 vccd1 vccd1 _03280_ sky130_fd_sc_hd__o21ai_2
XFILLER_0_67_401 vssd1 vssd1 vccd1 vccd1 sky130_fd_sc_hd__fill_2
XFILLER_0_27_309 vssd1 vssd1 vccd1 vccd1 sky130_fd_sc_hd__decap_3
XFILLER_0_82_404 vssd1 vssd1 vccd1 vccd1 sky130_fd_sc_hd__decap_4
XFILLER_0_39_169 vssd1 vssd1 vccd1 vccd1 sky130_fd_sc_hd__decap_6
XFILLER_0_50_301 vssd1 vssd1 vccd1 vccd1 sky130_fd_sc_hd__fill_1
XFILLER_0_35_342 vssd1 vssd1 vccd1 vccd1 sky130_ef_sc_hd__decap_12
XFILLER_0_90_481 vssd1 vssd1 vccd1 vccd1 sky130_fd_sc_hd__fill_1
XFILLER_0_62_161 vssd1 vssd1 vccd1 vccd1 sky130_ef_sc_hd__decap_12
X_10107_ clknet_3_2_0_wb_clk_i _00101_ _00037_ vssd1 vssd1 vccd1 vccd1 mul.a\[2\]
+ sky130_fd_sc_hd__dfrtp_1
X_10038_ net643 vssd1 vssd1 vccd1 vccd1 _00034_ sky130_fd_sc_hd__inv_2
XFILLER_0_81_15 vssd1 vssd1 vccd1 vccd1 sky130_ef_sc_hd__decap_12
XFILLER_0_18_309 vssd1 vssd1 vccd1 vccd1 sky130_fd_sc_hd__decap_4
X_06200_ _00532_ _00576_ _00577_ vssd1 vssd1 vccd1 vccd1 _00578_ sky130_fd_sc_hd__nor3_1
XFILLER_0_90_9 vssd1 vssd1 vccd1 vccd1 sky130_fd_sc_hd__fill_1
X_07180_ net444 _01422_ _01423_ _01424_ vssd1 vssd1 vccd1 vccd1 _01550_ sky130_fd_sc_hd__o2bb2a_1
XFILLER_0_5_225 vssd1 vssd1 vccd1 vccd1 sky130_fd_sc_hd__decap_8
XFILLER_0_26_353 vssd1 vssd1 vccd1 vccd1 sky130_fd_sc_hd__decap_4
XFILLER_0_81_481 vssd1 vssd1 vccd1 vccd1 sky130_fd_sc_hd__fill_2
XFILLER_0_14_526 vssd1 vssd1 vccd1 vccd1 sky130_fd_sc_hd__decap_6
X_06131_ _00507_ _00508_ vssd1 vssd1 vccd1 vccd1 _00509_ sky130_fd_sc_hd__and2b_1
X_06062_ net327 net522 vssd1 vssd1 vccd1 vccd1 _00441_ sky130_fd_sc_hd__and2_1
Xfanout406 net407 vssd1 vssd1 vccd1 vccd1 net406 sky130_fd_sc_hd__clkbuf_2
Xfanout417 net419 vssd1 vssd1 vccd1 vccd1 net417 sky130_fd_sc_hd__clkbuf_2
Xfanout439 mul.b\[23\] vssd1 vssd1 vccd1 vccd1 net439 sky130_fd_sc_hd__clkbuf_4
XTAP_231 vssd1 vccd1 sky130_fd_sc_hd__tapvpwrvgnd_1
XTAP_220 vssd1 vccd1 sky130_fd_sc_hd__tapvpwrvgnd_1
XTAP_242 vssd1 vccd1 sky130_fd_sc_hd__tapvpwrvgnd_1
Xfanout428 net431 vssd1 vssd1 vccd1 vccd1 net428 sky130_fd_sc_hd__clkbuf_4
X_09821_ net166 net172 net455 net462 vssd1 vssd1 vccd1 vccd1 _04342_ sky130_fd_sc_hd__and4_1
X_09752_ _04068_ _04113_ _04265_ vssd1 vssd1 vccd1 vccd1 _04267_ sky130_fd_sc_hd__or3_1
XTAP_275 vssd1 vccd1 sky130_fd_sc_hd__tapvpwrvgnd_1
XTAP_264 vssd1 vccd1 sky130_fd_sc_hd__tapvpwrvgnd_1
XTAP_253 vssd1 vccd1 sky130_fd_sc_hd__tapvpwrvgnd_1
X_08703_ _03118_ _03119_ vssd1 vssd1 vccd1 vccd1 _03120_ sky130_fd_sc_hd__or2_1
XTAP_297 vssd1 vccd1 sky130_fd_sc_hd__tapvpwrvgnd_1
XTAP_286 vssd1 vccd1 sky130_fd_sc_hd__tapvpwrvgnd_1
X_06964_ _01333_ _01334_ _01301_ vssd1 vssd1 vccd1 vccd1 _01336_ sky130_fd_sc_hd__o21ba_1
X_09683_ _04019_ _04035_ _04189_ _04190_ vssd1 vssd1 vccd1 vccd1 _04191_ sky130_fd_sc_hd__a211o_1
X_05915_ _00190_ _00194_ _00294_ vssd1 vssd1 vccd1 vccd1 _00295_ sky130_fd_sc_hd__a21o_1
X_06895_ _01266_ vssd1 vssd1 vccd1 vccd1 _01267_ sky130_fd_sc_hd__inv_2
XFILLER_0_96_518 vssd1 vssd1 vccd1 vccd1 sky130_ef_sc_hd__decap_12
X_08634_ _02896_ _02898_ _02899_ _02903_ vssd1 vssd1 vccd1 vccd1 _03045_ sky130_fd_sc_hd__a2bb2o_1
XFILLER_0_55_93 vssd1 vssd1 vccd1 vccd1 sky130_ef_sc_hd__decap_12
X_05846_ net388 net479 net488 net380 vssd1 vssd1 vccd1 vccd1 _00227_ sky130_fd_sc_hd__a22o_1
X_08565_ _02955_ _02956_ _02968_ vssd1 vssd1 vccd1 vccd1 _02969_ sky130_fd_sc_hd__nor3_1
X_05777_ _00157_ _00158_ vssd1 vssd1 vccd1 vccd1 _00159_ sky130_fd_sc_hd__xnor2_1
XFILLER_0_76_253 vssd1 vssd1 vccd1 vccd1 sky130_fd_sc_hd__fill_2
X_07516_ _01727_ _01729_ _01887_ _01888_ vssd1 vssd1 vccd1 vccd1 _01889_ sky130_fd_sc_hd__a211oi_2
X_08496_ _02893_ _02880_ vssd1 vssd1 vccd1 vccd1 _02894_ sky130_fd_sc_hd__and2b_1
XFILLER_0_91_212 vssd1 vssd1 vccd1 vccd1 sky130_ef_sc_hd__decap_12
XFILLER_0_29_180 vssd1 vssd1 vccd1 vccd1 sky130_fd_sc_hd__decap_3
X_07447_ net189 net211 net555 net582 vssd1 vssd1 vccd1 vccd1 _01815_ sky130_fd_sc_hd__nand4_1
X_07378_ _01745_ _01746_ vssd1 vssd1 vccd1 vccd1 _01747_ sky130_fd_sc_hd__and2b_1
XFILLER_0_51_109 vssd1 vssd1 vccd1 vccd1 sky130_fd_sc_hd__decap_3
XFILLER_0_72_481 vssd1 vssd1 vccd1 vccd1 sky130_ef_sc_hd__decap_12
X_09117_ net167 net506 net516 net161 vssd1 vssd1 vccd1 vccd1 _03572_ sky130_fd_sc_hd__a22o_1
X_06329_ _00525_ net704 _00704_ vssd1 vssd1 vccd1 vccd1 _00706_ sky130_fd_sc_hd__nand3_1
X_09048_ _03494_ _03495_ _03339_ _03341_ vssd1 vssd1 vccd1 vccd1 _03497_ sky130_fd_sc_hd__o211a_1
XFILLER_0_99_345 vssd1 vssd1 vccd1 vccd1 sky130_fd_sc_hd__fill_1
XFILLER_0_55_426 vssd1 vssd1 vccd1 vccd1 sky130_fd_sc_hd__decap_6
XFILLER_0_51_29 vssd1 vssd1 vccd1 vccd1 sky130_ef_sc_hd__decap_12
XFILLER_0_42_109 vssd1 vssd1 vccd1 vccd1 sky130_fd_sc_hd__fill_2
XFILLER_0_50_153 vssd1 vssd1 vccd1 vccd1 sky130_ef_sc_hd__decap_12
XFILLER_0_23_378 vssd1 vssd1 vccd1 vccd1 sky130_fd_sc_hd__fill_2
XFILLER_0_50_197 vssd1 vssd1 vccd1 vccd1 sky130_fd_sc_hd__decap_4
X_05700_ _04967_ _04968_ vssd1 vssd1 vccd1 vccd1 _04970_ sky130_fd_sc_hd__xnor2_1
X_06680_ net271 net279 net532 net542 vssd1 vssd1 vccd1 vccd1 _01054_ sky130_fd_sc_hd__nand4_1
X_05631_ net289 net298 net598 net607 vssd1 vssd1 vccd1 vccd1 _04901_ sky130_fd_sc_hd__nand4_1
X_08350_ _02734_ vssd1 vssd1 vccd1 vccd1 _02735_ sky130_fd_sc_hd__inv_2
XFILLER_0_58_253 vssd1 vssd1 vccd1 vccd1 sky130_fd_sc_hd__decap_4
X_05562_ _04830_ _04831_ vssd1 vssd1 vccd1 vccd1 _04832_ sky130_fd_sc_hd__nand2_1
X_07301_ net219 net555 net582 net197 vssd1 vssd1 vccd1 vccd1 _01670_ sky130_fd_sc_hd__a22o_1
X_08281_ _02528_ _02530_ _02657_ _02658_ vssd1 vssd1 vccd1 vccd1 _02659_ sky130_fd_sc_hd__a211oi_4
XFILLER_0_73_245 vssd1 vssd1 vccd1 vccd1 sky130_ef_sc_hd__decap_12
X_05493_ _04753_ _04762_ vssd1 vssd1 vccd1 vccd1 _04763_ sky130_fd_sc_hd__xnor2_2
XFILLER_0_18_139 vssd1 vssd1 vccd1 vccd1 sky130_fd_sc_hd__fill_1
X_07232_ _01600_ _01601_ vssd1 vssd1 vccd1 vccd1 _01602_ sky130_fd_sc_hd__and2b_1
XFILLER_0_6_523 vssd1 vssd1 vccd1 vccd1 sky130_fd_sc_hd__decap_8
X_07163_ _01531_ _01532_ vssd1 vssd1 vccd1 vccd1 _01533_ sky130_fd_sc_hd__or2_1
X_06114_ _00489_ _00490_ _00420_ vssd1 vssd1 vccd1 vccd1 _00492_ sky130_fd_sc_hd__a21o_1
XFILLER_0_26_194 vssd1 vssd1 vccd1 vccd1 sky130_fd_sc_hd__fill_2
X_07094_ _01462_ _01463_ _01464_ vssd1 vssd1 vccd1 vccd1 _01465_ sky130_fd_sc_hd__and3_2
XFILLER_0_67_3 vssd1 vssd1 vccd1 vccd1 sky130_fd_sc_hd__decap_3
X_06045_ _00421_ _00422_ vssd1 vssd1 vccd1 vccd1 _00424_ sky130_fd_sc_hd__xnor2_1
XFILLER_0_41_197 vssd1 vssd1 vccd1 vccd1 sky130_fd_sc_hd__decap_8
Xfanout214 mul.a\[21\] vssd1 vssd1 vccd1 vccd1 net214 sky130_fd_sc_hd__clkbuf_4
Xfanout203 net204 vssd1 vssd1 vccd1 vccd1 net203 sky130_fd_sc_hd__clkbuf_4
Xfanout225 mul.a\[19\] vssd1 vssd1 vccd1 vccd1 net225 sky130_fd_sc_hd__clkbuf_4
Xfanout247 mul.a\[17\] vssd1 vssd1 vccd1 vccd1 net247 sky130_fd_sc_hd__clkbuf_4
Xfanout236 net238 vssd1 vssd1 vccd1 vccd1 net236 sky130_fd_sc_hd__clkbuf_2
X_09804_ _04322_ vssd1 vssd1 vccd1 vccd1 _04323_ sky130_fd_sc_hd__inv_2
Xfanout258 net261 vssd1 vssd1 vccd1 vccd1 net258 sky130_fd_sc_hd__dlymetal6s2s_1
X_07996_ _02219_ _02223_ _02366_ _02368_ vssd1 vssd1 vccd1 vccd1 _02369_ sky130_fd_sc_hd__o211ai_2
Xfanout269 net270 vssd1 vssd1 vccd1 vccd1 net269 sky130_fd_sc_hd__clkbuf_4
X_06947_ net259 net690 net546 net250 vssd1 vssd1 vccd1 vccd1 _01319_ sky130_fd_sc_hd__a22o_1
X_09735_ _04246_ _04247_ vssd1 vssd1 vccd1 vccd1 _04248_ sky130_fd_sc_hd__or2_1
X_09666_ _04010_ _04016_ _04009_ vssd1 vssd1 vccd1 vccd1 _04172_ sky130_fd_sc_hd__o21ai_1
XTAP_1205 vssd1 vccd1 sky130_fd_sc_hd__tapvpwrvgnd_1
X_08617_ _03023_ _03024_ _03020_ vssd1 vssd1 vccd1 vccd1 _03026_ sky130_fd_sc_hd__a21o_1
X_06878_ _01247_ _01248_ _01141_ vssd1 vssd1 vccd1 vccd1 _01250_ sky130_fd_sc_hd__a21o_1
XTAP_1238 vssd1 vccd1 sky130_fd_sc_hd__tapvpwrvgnd_1
XTAP_1227 vssd1 vccd1 sky130_fd_sc_hd__tapvpwrvgnd_1
XTAP_1216 vssd1 vccd1 sky130_fd_sc_hd__tapvpwrvgnd_1
X_09597_ _04096_ _04090_ vssd1 vssd1 vccd1 vccd1 _04097_ sky130_fd_sc_hd__nand2b_1
X_05829_ _00207_ _00208_ vssd1 vssd1 vccd1 vccd1 _00210_ sky130_fd_sc_hd__xor2_1
XTAP_1249 vssd1 vccd1 sky130_fd_sc_hd__tapvpwrvgnd_1
X_08548_ _02948_ _02949_ vssd1 vssd1 vccd1 vccd1 _02950_ sky130_fd_sc_hd__xor2_1
X_08479_ _02872_ _02873_ _02664_ net727 vssd1 vssd1 vccd1 vccd1 _02876_ sky130_fd_sc_hd__a211oi_2
XFILLER_0_37_426 vssd1 vssd1 vccd1 vccd1 sky130_fd_sc_hd__fill_2
XFILLER_0_64_267 vssd1 vssd1 vccd1 vccd1 sky130_fd_sc_hd__decap_4
XFILLER_0_45_492 vssd1 vssd1 vccd1 vccd1 sky130_ef_sc_hd__decap_12
XFILLER_0_60_473 vssd1 vssd1 vccd1 vccd1 sky130_fd_sc_hd__decap_3
XFILLER_0_60_462 vssd1 vssd1 vccd1 vccd1 sky130_fd_sc_hd__fill_1
XFILLER_0_20_348 vssd1 vssd1 vccd1 vccd1 sky130_fd_sc_hd__fill_1
XFILLER_0_32_197 vssd1 vssd1 vccd1 vccd1 sky130_fd_sc_hd__decap_4
XFILLER_0_46_29 vssd1 vssd1 vccd1 vccd1 sky130_fd_sc_hd__fill_1
XFILLER_0_99_164 vssd1 vssd1 vccd1 vccd1 sky130_fd_sc_hd__decap_4
XFILLER_0_70_215 vssd1 vssd1 vccd1 vccd1 sky130_fd_sc_hd__decap_6
XFILLER_0_55_278 vssd1 vssd1 vccd1 vccd1 sky130_fd_sc_hd__fill_2
XFILLER_0_11_10 vssd1 vssd1 vccd1 vccd1 sky130_ef_sc_hd__decap_12
XFILLER_0_11_54 vssd1 vssd1 vccd1 vccd1 sky130_fd_sc_hd__fill_2
XFILLER_0_87_25 vssd1 vssd1 vccd1 vccd1 sky130_fd_sc_hd__decap_6
XFILLER_0_87_47 vssd1 vssd1 vccd1 vccd1 sky130_fd_sc_hd__decap_4
XFILLER_0_11_337 vssd1 vssd1 vccd1 vccd1 sky130_fd_sc_hd__decap_4
X_07850_ net220 net528 _02218_ _02220_ vssd1 vssd1 vccd1 vccd1 _02223_ sky130_fd_sc_hd__and4_1
X_07781_ _02151_ _02150_ vssd1 vssd1 vccd1 vccd1 _02152_ sky130_fd_sc_hd__nand2b_1
X_06801_ _01169_ _01172_ _01173_ vssd1 vssd1 vccd1 vccd1 _01174_ sky130_fd_sc_hd__and3_1
Xinput3 wbs_adr_i[3] vssd1 vssd1 vccd1 vccd1 net3 sky130_fd_sc_hd__buf_1
X_06732_ _01103_ _01104_ vssd1 vssd1 vccd1 vccd1 _01105_ sky130_fd_sc_hd__and2b_1
X_09520_ net146 net151 net505 net514 vssd1 vssd1 vccd1 vccd1 _04013_ sky130_fd_sc_hd__and4_1
X_09451_ _03936_ _03937_ vssd1 vssd1 vccd1 vccd1 _03938_ sky130_fd_sc_hd__or2_1
X_06663_ _01034_ _01035_ _01016_ vssd1 vssd1 vccd1 vccd1 _01037_ sky130_fd_sc_hd__a21oi_2
X_08402_ _02627_ _02629_ vssd1 vssd1 vccd1 vccd1 _02791_ sky130_fd_sc_hd__nand2_1
X_09382_ net162 net497 _03857_ _03860_ vssd1 vssd1 vccd1 vccd1 _03862_ sky130_fd_sc_hd__and4_1
X_05614_ _04882_ _04883_ vssd1 vssd1 vccd1 vccd1 _04884_ sky130_fd_sc_hd__xnor2_2
X_06594_ net210 net218 net603 net613 vssd1 vssd1 vccd1 vccd1 _00968_ sky130_fd_sc_hd__and4_1
X_08333_ _02714_ _02715_ vssd1 vssd1 vccd1 vccd1 _02716_ sky130_fd_sc_hd__or2_1
X_05545_ _04744_ _04745_ _04746_ _04813_ _04814_ vssd1 vssd1 vccd1 vccd1 _04815_ sky130_fd_sc_hd__o32a_1
X_08264_ _02503_ _02510_ _02509_ vssd1 vssd1 vccd1 vccd1 _02640_ sky130_fd_sc_hd__a21o_1
XFILLER_0_46_245 vssd1 vssd1 vccd1 vccd1 sky130_fd_sc_hd__decap_6
X_05476_ _02973_ _04555_ _04553_ vssd1 vssd1 vccd1 vccd1 _04746_ sky130_fd_sc_hd__o21a_1
XFILLER_0_27_481 vssd1 vssd1 vccd1 vccd1 sky130_ef_sc_hd__decap_12
X_08195_ _02565_ _02566_ _02558_ vssd1 vssd1 vccd1 vccd1 _02568_ sky130_fd_sc_hd__a21o_1
X_07215_ _01445_ _01447_ _01584_ vssd1 vssd1 vccd1 vccd1 _01585_ sky130_fd_sc_hd__o21a_1
XFILLER_0_42_440 vssd1 vssd1 vccd1 vccd1 sky130_fd_sc_hd__fill_1
X_07146_ _01511_ _01514_ vssd1 vssd1 vccd1 vccd1 _01516_ sky130_fd_sc_hd__xnor2_1
X_07077_ _01438_ _01446_ vssd1 vssd1 vccd1 vccd1 _01448_ sky130_fd_sc_hd__xnor2_1
X_06028_ net235 net625 net634 net226 vssd1 vssd1 vccd1 vccd1 _00407_ sky130_fd_sc_hd__a22oi_1
X_07979_ _02349_ _02350_ _02343_ vssd1 vssd1 vccd1 vccd1 _02352_ sky130_fd_sc_hd__a21o_1
X_09718_ net239 net249 net400 net407 vssd1 vssd1 vccd1 vccd1 _04229_ sky130_fd_sc_hd__nand4_1
XFILLER_0_69_304 vssd1 vssd1 vccd1 vccd1 sky130_fd_sc_hd__fill_1
X_09649_ _04151_ _04152_ vssd1 vssd1 vccd1 vccd1 _04155_ sky130_fd_sc_hd__xnor2_1
XTAP_1013 vssd1 vccd1 sky130_fd_sc_hd__tapvpwrvgnd_1
XTAP_1002 vssd1 vccd1 sky130_fd_sc_hd__tapvpwrvgnd_1
XFILLER_0_69_337 vssd1 vssd1 vccd1 vccd1 sky130_fd_sc_hd__decap_6
XFILLER_0_96_189 vssd1 vssd1 vccd1 vccd1 sky130_fd_sc_hd__decap_3
XFILLER_0_96_156 vssd1 vssd1 vccd1 vccd1 sky130_fd_sc_hd__decap_3
XTAP_1046 vssd1 vccd1 sky130_fd_sc_hd__tapvpwrvgnd_1
XTAP_1035 vssd1 vccd1 sky130_fd_sc_hd__tapvpwrvgnd_1
XTAP_1024 vssd1 vccd1 sky130_fd_sc_hd__tapvpwrvgnd_1
XTAP_1079 vssd1 vccd1 sky130_fd_sc_hd__tapvpwrvgnd_1
XTAP_1068 vssd1 vccd1 sky130_fd_sc_hd__tapvpwrvgnd_1
XTAP_1057 vssd1 vccd1 sky130_fd_sc_hd__tapvpwrvgnd_1
XFILLER_0_37_267 vssd1 vssd1 vccd1 vccd1 sky130_fd_sc_hd__fill_1
XFILLER_0_92_384 vssd1 vssd1 vccd1 vccd1 sky130_fd_sc_hd__decap_8
XFILLER_0_65_587 vssd1 vssd1 vccd1 vccd1 sky130_fd_sc_hd__decap_3
XFILLER_0_18_470 vssd1 vssd1 vccd1 vccd1 sky130_fd_sc_hd__decap_6
XFILLER_0_25_429 vssd1 vssd1 vccd1 vccd1 sky130_fd_sc_hd__decap_4
XFILLER_0_80_579 vssd1 vssd1 vccd1 vccd1 sky130_fd_sc_hd__decap_6
XFILLER_0_33_484 vssd1 vssd1 vccd1 vccd1 sky130_ef_sc_hd__decap_12
XTAP_808 vssd1 vccd1 sky130_fd_sc_hd__tapvpwrvgnd_1
XTAP_819 vssd1 vccd1 sky130_fd_sc_hd__tapvpwrvgnd_1
XFILLER_0_87_167 vssd1 vssd1 vccd1 vccd1 sky130_fd_sc_hd__fill_1
XFILLER_0_7_139 vssd1 vssd1 vccd1 vccd1 sky130_fd_sc_hd__decap_8
X_05330_ _04562_ _04564_ _04563_ vssd1 vssd1 vccd1 vccd1 _04600_ sky130_fd_sc_hd__a21o_1
XFILLER_0_56_587 vssd1 vssd1 vccd1 vccd1 sky130_fd_sc_hd__fill_1
XFILLER_0_16_418 vssd1 vssd1 vccd1 vccd1 sky130_fd_sc_hd__fill_2
XFILLER_0_22_64 vssd1 vssd1 vccd1 vccd1 sky130_fd_sc_hd__decap_6
X_05261_ net335 net586 _04372_ _04383_ vssd1 vssd1 vccd1 vccd1 _04405_ sky130_fd_sc_hd__a22o_1
X_05192_ net362 net369 net559 net568 vssd1 vssd1 vccd1 vccd1 _03651_ sky130_fd_sc_hd__and4_1
X_07000_ _01369_ _01370_ vssd1 vssd1 vccd1 vccd1 _01371_ sky130_fd_sc_hd__and2b_1
XFILLER_0_101_309 vssd1 vssd1 vccd1 vccd1 sky130_ef_sc_hd__decap_12
XFILLER_0_3_378 vssd1 vssd1 vccd1 vccd1 sky130_fd_sc_hd__decap_3
XFILLER_0_11_156 vssd1 vssd1 vccd1 vccd1 sky130_ef_sc_hd__decap_12
X_08951_ _03390_ _03391_ vssd1 vssd1 vccd1 vccd1 _03392_ sky130_fd_sc_hd__and2_1
X_08882_ net303 net399 net406 net294 vssd1 vssd1 vccd1 vccd1 _03316_ sky130_fd_sc_hd__a22o_1
X_07902_ _01647_ _01790_ _01949_ _02109_ vssd1 vssd1 vccd1 vccd1 _02276_ sky130_fd_sc_hd__nor4_2
X_07833_ net299 net452 _02202_ _02203_ vssd1 vssd1 vccd1 vccd1 _02204_ sky130_fd_sc_hd__a22oi_2
XFILLER_0_47_61 vssd1 vssd1 vccd1 vccd1 sky130_fd_sc_hd__decap_8
X_07764_ _02116_ _02133_ vssd1 vssd1 vccd1 vccd1 _02135_ sky130_fd_sc_hd__xnor2_1
XFILLER_0_2_41 vssd1 vssd1 vccd1 vccd1 sky130_ef_sc_hd__decap_12
X_09503_ _03992_ _03993_ vssd1 vssd1 vccd1 vccd1 _03995_ sky130_fd_sc_hd__xnor2_4
X_07695_ net212 net393 net550 vssd1 vssd1 vccd1 vccd1 _02067_ sky130_fd_sc_hd__and3_1
XFILLER_0_2_85 vssd1 vssd1 vccd1 vccd1 sky130_ef_sc_hd__decap_12
X_06715_ _01085_ _01086_ _00947_ _00949_ vssd1 vssd1 vccd1 vccd1 _01089_ sky130_fd_sc_hd__a211oi_1
X_09434_ _03916_ _03917_ vssd1 vssd1 vccd1 vccd1 _03919_ sky130_fd_sc_hd__xnor2_4
XFILLER_0_78_167 vssd1 vssd1 vccd1 vccd1 sky130_fd_sc_hd__fill_1
XPHY_107 vssd1 vssd1 vccd1 vccd1 sky130_fd_sc_hd__decap_3
X_06646_ _01018_ _01019_ vssd1 vssd1 vccd1 vccd1 _01020_ sky130_fd_sc_hd__nor2_1
XPHY_129 vssd1 vssd1 vccd1 vccd1 sky130_fd_sc_hd__decap_3
XPHY_118 vssd1 vssd1 vccd1 vccd1 sky130_fd_sc_hd__decap_3
XFILLER_0_19_223 vssd1 vssd1 vccd1 vccd1 sky130_fd_sc_hd__fill_1
XFILLER_0_47_532 vssd1 vssd1 vccd1 vccd1 sky130_fd_sc_hd__decap_8
X_09365_ net120 _03843_ vssd1 vssd1 vccd1 vccd1 _03844_ sky130_fd_sc_hd__nand2_1
X_06577_ _00949_ _00950_ _00824_ _00827_ vssd1 vssd1 vccd1 vccd1 _00952_ sky130_fd_sc_hd__o211a_1
X_08316_ _02694_ _02695_ _02696_ vssd1 vssd1 vccd1 vccd1 _02697_ sky130_fd_sc_hd__and3_1
X_09296_ _03745_ _03746_ _03766_ _03767_ vssd1 vssd1 vccd1 vccd1 _03768_ sky130_fd_sc_hd__nor4_1
XFILLER_0_74_373 vssd1 vssd1 vccd1 vccd1 sky130_fd_sc_hd__fill_2
X_05528_ _04796_ _04797_ _04697_ vssd1 vssd1 vccd1 vccd1 _04798_ sky130_fd_sc_hd__nor3b_1
X_08247_ _02618_ _02619_ _02620_ vssd1 vssd1 vccd1 vccd1 _02621_ sky130_fd_sc_hd__and3_2
X_05459_ _04077_ _04727_ vssd1 vssd1 vccd1 vccd1 _04729_ sky130_fd_sc_hd__xnor2_1
XFILLER_0_34_226 vssd1 vssd1 vccd1 vccd1 sky130_fd_sc_hd__decap_3
XFILLER_0_15_440 vssd1 vssd1 vccd1 vccd1 sky130_fd_sc_hd__decap_8
X_08178_ net360 net398 vssd1 vssd1 vccd1 vccd1 _02550_ sky130_fd_sc_hd__and2_1
XFILLER_0_15_495 vssd1 vssd1 vccd1 vccd1 sky130_fd_sc_hd__fill_2
X_07129_ _01095_ _01220_ _01357_ _01493_ vssd1 vssd1 vccd1 vccd1 _01499_ sky130_fd_sc_hd__and4_1
XFILLER_0_100_320 vssd1 vssd1 vccd1 vccd1 sky130_fd_sc_hd__fill_2
X_10071_ clknet_3_2_0_wb_clk_i _00067_ _00003_ vssd1 vssd1 vccd1 vccd1 mul.b\[0\]
+ sky130_fd_sc_hd__dfrtp_4
Xmax_cap87 _00267_ vssd1 vssd1 vccd1 vccd1 net87 sky130_fd_sc_hd__buf_1
XPHY_9 vssd1 vssd1 vccd1 vccd1 sky130_fd_sc_hd__decap_3
Xmax_cap76 net77 vssd1 vssd1 vccd1 vccd1 net76 sky130_fd_sc_hd__clkbuf_1
Xmax_cap98 net99 vssd1 vssd1 vccd1 vccd1 net98 sky130_fd_sc_hd__clkbuf_1
XFILLER_0_57_329 vssd1 vssd1 vccd1 vccd1 sky130_fd_sc_hd__decap_6
XFILLER_0_65_351 vssd1 vssd1 vccd1 vccd1 sky130_fd_sc_hd__decap_4
XFILLER_0_92_170 vssd1 vssd1 vccd1 vccd1 sky130_fd_sc_hd__fill_2
XFILLER_0_38_576 vssd1 vssd1 vccd1 vccd1 sky130_ef_sc_hd__decap_12
XFILLER_0_80_365 vssd1 vssd1 vccd1 vccd1 sky130_fd_sc_hd__decap_8
XFILLER_0_80_398 vssd1 vssd1 vccd1 vccd1 sky130_fd_sc_hd__fill_1
XFILLER_0_61_590 vssd1 vssd1 vccd1 vccd1 sky130_fd_sc_hd__decap_4
XFILLER_0_21_410 vssd1 vssd1 vccd1 vccd1 sky130_ef_sc_hd__decap_12
XFILLER_0_33_281 vssd1 vssd1 vccd1 vccd1 sky130_fd_sc_hd__decap_4
XFILLER_0_68_27 vssd1 vssd1 vccd1 vccd1 sky130_fd_sc_hd__fill_1
XFILLER_0_0_304 vssd1 vssd1 vccd1 vccd1 sky130_fd_sc_hd__decap_4
XTAP_605 vssd1 vccd1 sky130_fd_sc_hd__tapvpwrvgnd_1
XTAP_616 vssd1 vccd1 sky130_fd_sc_hd__tapvpwrvgnd_1
XTAP_627 vssd1 vccd1 sky130_fd_sc_hd__tapvpwrvgnd_1
XTAP_638 vssd1 vccd1 sky130_fd_sc_hd__tapvpwrvgnd_1
XTAP_649 vssd1 vccd1 sky130_fd_sc_hd__tapvpwrvgnd_1
XFILLER_0_84_15 vssd1 vssd1 vccd1 vccd1 sky130_ef_sc_hd__decap_12
X_07480_ net359 net368 net420 net427 _01701_ vssd1 vssd1 vccd1 vccd1 _01851_ sky130_fd_sc_hd__a41o_1
X_06500_ _00859_ _00874_ vssd1 vssd1 vccd1 vccd1 _00875_ sky130_fd_sc_hd__or2_1
XFILLER_0_29_510 vssd1 vssd1 vccd1 vccd1 sky130_ef_sc_hd__decap_12
X_06431_ _00804_ _00805_ _00806_ vssd1 vssd1 vccd1 vccd1 _00807_ sky130_fd_sc_hd__nand3_2
XFILLER_0_90_107 vssd1 vssd1 vccd1 vccd1 sky130_fd_sc_hd__decap_3
X_09150_ net216 net449 _03606_ _03608_ vssd1 vssd1 vccd1 vccd1 _03609_ sky130_fd_sc_hd__o2bb2a_1
X_06362_ net243 net590 _00736_ _00737_ vssd1 vssd1 vccd1 vccd1 _00738_ sky130_fd_sc_hd__nand4_2
XFILLER_0_44_524 vssd1 vssd1 vccd1 vccd1 sky130_fd_sc_hd__decap_8
X_09081_ _03502_ _03503_ _03533_ vssd1 vssd1 vccd1 vccd1 _03534_ sky130_fd_sc_hd__nor3_2
X_08101_ _02463_ _02472_ vssd1 vssd1 vccd1 vccd1 _02473_ sky130_fd_sc_hd__xnor2_2
XFILLER_0_71_332 vssd1 vssd1 vccd1 vccd1 sky130_fd_sc_hd__decap_4
X_05313_ _03957_ _04581_ _04580_ vssd1 vssd1 vccd1 vccd1 _04583_ sky130_fd_sc_hd__a21bo_1
X_06293_ net328 net503 net511 net320 vssd1 vssd1 vccd1 vccd1 _00670_ sky130_fd_sc_hd__a22oi_2
X_08032_ net290 net452 _02402_ _02404_ vssd1 vssd1 vccd1 vccd1 _02405_ sky130_fd_sc_hd__a22oi_2
X_05244_ _04186_ _04197_ _04208_ vssd1 vssd1 vccd1 vccd1 _04219_ sky130_fd_sc_hd__nand3_1
XFILLER_0_3_142 vssd1 vssd1 vccd1 vccd1 sky130_fd_sc_hd__fill_1
XFILLER_0_12_410 vssd1 vssd1 vccd1 vccd1 sky130_fd_sc_hd__decap_8
XFILLER_0_12_421 vssd1 vssd1 vccd1 vccd1 sky130_ef_sc_hd__decap_12
XFILLER_0_3_175 vssd1 vssd1 vccd1 vccd1 sky130_ef_sc_hd__decap_12
X_05175_ net361 net595 net605 net352 vssd1 vssd1 vccd1 vccd1 _03465_ sky130_fd_sc_hd__a22o_1
XFILLER_0_3_197 vssd1 vssd1 vccd1 vccd1 sky130_fd_sc_hd__decap_6
X_09983_ net199 net422 vssd1 vssd1 vccd1 vccd1 _04519_ sky130_fd_sc_hd__nand2_1
X_08934_ net119 _03372_ vssd1 vssd1 vccd1 vccd1 _03373_ sky130_fd_sc_hd__xor2_1
XFILLER_0_58_60 vssd1 vssd1 vccd1 vccd1 sky130_fd_sc_hd__fill_2
X_08865_ _03287_ _03296_ vssd1 vssd1 vccd1 vccd1 _03297_ sky130_fd_sc_hd__or2_2
X_08796_ _03202_ _03221_ vssd1 vssd1 vccd1 vccd1 _03222_ sky130_fd_sc_hd__and2b_1
X_07816_ _02186_ vssd1 vssd1 vccd1 vccd1 _02187_ sky130_fd_sc_hd__inv_2
X_07747_ net149 net628 net636 vssd1 vssd1 vccd1 vccd1 _02118_ sky130_fd_sc_hd__and3_1
X_07678_ _02047_ _02048_ _02041_ vssd1 vssd1 vccd1 vccd1 _02050_ sky130_fd_sc_hd__a21o_1
XFILLER_0_66_137 vssd1 vssd1 vccd1 vccd1 sky130_fd_sc_hd__decap_3
X_06629_ _01002_ vssd1 vssd1 vccd1 vccd1 _01003_ sky130_fd_sc_hd__inv_2
X_09417_ net187 net191 net455 net462 vssd1 vssd1 vccd1 vccd1 _03900_ sky130_fd_sc_hd__and4_1
X_09348_ _03822_ _03823_ vssd1 vssd1 vccd1 vccd1 _03825_ sky130_fd_sc_hd__xor2_1
XFILLER_0_74_170 vssd1 vssd1 vccd1 vccd1 sky130_fd_sc_hd__decap_4
X_09279_ net233 net430 _03747_ _03748_ vssd1 vssd1 vccd1 vccd1 _03750_ sky130_fd_sc_hd__a22o_1
XFILLER_0_35_579 vssd1 vssd1 vccd1 vccd1 sky130_fd_sc_hd__decap_3
XFILLER_0_15_292 vssd1 vssd1 vccd1 vccd1 sky130_fd_sc_hd__decap_3
XFILLER_0_30_262 vssd1 vssd1 vccd1 vccd1 sky130_fd_sc_hd__fill_1
X_10123_ clknet_3_6_0_wb_clk_i _00117_ _00053_ vssd1 vssd1 vccd1 vccd1 mul.a\[18\]
+ sky130_fd_sc_hd__dfrtp_1
X_10054_ net642 vssd1 vssd1 vccd1 vccd1 _00050_ sky130_fd_sc_hd__inv_2
XFILLER_0_54_29 vssd1 vssd1 vccd1 vccd1 sky130_fd_sc_hd__decap_8
XFILLER_0_85_435 vssd1 vssd1 vccd1 vccd1 sky130_fd_sc_hd__fill_1
XFILLER_0_65_181 vssd1 vssd1 vccd1 vccd1 sky130_fd_sc_hd__decap_3
XFILLER_0_53_321 vssd1 vssd1 vccd1 vccd1 sky130_fd_sc_hd__fill_2
XFILLER_0_79_15 vssd1 vssd1 vccd1 vccd1 sky130_ef_sc_hd__decap_12
XFILLER_0_53_365 vssd1 vssd1 vccd1 vccd1 sky130_fd_sc_hd__decap_6
XFILLER_0_79_37 vssd1 vssd1 vccd1 vccd1 sky130_fd_sc_hd__decap_4
XFILLER_0_0_156 vssd1 vssd1 vccd1 vccd1 sky130_fd_sc_hd__fill_2
XTAP_402 vssd1 vccd1 sky130_fd_sc_hd__tapvpwrvgnd_1
XTAP_413 vssd1 vccd1 sky130_fd_sc_hd__tapvpwrvgnd_1
XTAP_424 vssd1 vccd1 sky130_fd_sc_hd__tapvpwrvgnd_1
XFILLER_0_21_295 vssd1 vssd1 vccd1 vccd1 sky130_fd_sc_hd__fill_2
XFILLER_0_0_189 vssd1 vssd1 vccd1 vccd1 sky130_fd_sc_hd__decap_6
XTAP_435 vssd1 vccd1 sky130_fd_sc_hd__tapvpwrvgnd_1
XTAP_446 vssd1 vccd1 sky130_fd_sc_hd__tapvpwrvgnd_1
XTAP_457 vssd1 vccd1 sky130_fd_sc_hd__tapvpwrvgnd_1
XFILLER_0_28_41 vssd1 vssd1 vccd1 vccd1 sky130_fd_sc_hd__decap_4
X_06980_ _01348_ _01349_ net688 _01212_ vssd1 vssd1 vccd1 vccd1 _01352_ sky130_fd_sc_hd__a211oi_2
X_05931_ _00309_ _00310_ vssd1 vssd1 vccd1 vccd1 _00311_ sky130_fd_sc_hd__nor2_1
XTAP_468 vssd1 vccd1 sky130_fd_sc_hd__tapvpwrvgnd_1
XTAP_479 vssd1 vccd1 sky130_fd_sc_hd__tapvpwrvgnd_1
X_08650_ _02879_ _02895_ _02894_ vssd1 vssd1 vccd1 vccd1 _03063_ sky130_fd_sc_hd__a21oi_1
X_05862_ _00240_ _00241_ _00239_ vssd1 vssd1 vccd1 vccd1 _00243_ sky130_fd_sc_hd__a21o_1
X_07601_ _01971_ _01972_ vssd1 vssd1 vccd1 vccd1 _01973_ sky130_fd_sc_hd__and2b_1
X_08581_ _02983_ _02985_ _02815_ _02817_ vssd1 vssd1 vccd1 vccd1 _02987_ sky130_fd_sc_hd__o211ai_4
X_05793_ _04976_ _00174_ vssd1 vssd1 vccd1 vccd1 _00175_ sky130_fd_sc_hd__nand2b_1
XFILLER_0_44_62 vssd1 vssd1 vccd1 vccd1 sky130_fd_sc_hd__fill_2
X_07532_ _01901_ _01903_ _01904_ vssd1 vssd1 vccd1 vccd1 _01905_ sky130_fd_sc_hd__a21oi_1
XFILLER_0_48_104 vssd1 vssd1 vccd1 vccd1 sky130_fd_sc_hd__decap_8
XFILLER_0_48_126 vssd1 vssd1 vccd1 vccd1 sky130_fd_sc_hd__fill_2
XFILLER_0_76_457 vssd1 vssd1 vccd1 vccd1 sky130_fd_sc_hd__fill_1
XFILLER_0_29_340 vssd1 vssd1 vccd1 vccd1 sky130_ef_sc_hd__decap_12
X_07463_ _01711_ _01713_ _01830_ _01831_ vssd1 vssd1 vccd1 vccd1 _01832_ sky130_fd_sc_hd__o211a_1
X_09202_ _03665_ vssd1 vssd1 vccd1 vccd1 _03666_ sky130_fd_sc_hd__inv_2
X_06414_ _00780_ _00788_ vssd1 vssd1 vccd1 vccd1 _00790_ sky130_fd_sc_hd__xnor2_2
XFILLER_0_29_362 vssd1 vssd1 vccd1 vccd1 sky130_fd_sc_hd__decap_4
XFILLER_0_91_449 vssd1 vssd1 vccd1 vccd1 sky130_ef_sc_hd__decap_12
X_09133_ _03588_ _03589_ vssd1 vssd1 vccd1 vccd1 _03590_ sky130_fd_sc_hd__or2_1
X_07394_ _01759_ _01760_ _01761_ vssd1 vssd1 vccd1 vccd1 _01763_ sky130_fd_sc_hd__a21oi_1
XFILLER_0_56_170 vssd1 vssd1 vccd1 vccd1 sky130_fd_sc_hd__decap_8
XFILLER_0_97_3 vssd1 vssd1 vccd1 vccd1 sky130_ef_sc_hd__decap_12
X_06345_ net219 net617 vssd1 vssd1 vccd1 vccd1 _00721_ sky130_fd_sc_hd__nand2_1
XFILLER_0_44_365 vssd1 vssd1 vccd1 vccd1 sky130_fd_sc_hd__fill_2
X_09064_ _03508_ net123 vssd1 vssd1 vccd1 vccd1 _03515_ sky130_fd_sc_hd__or2_1
X_06276_ _00651_ _00652_ vssd1 vssd1 vccd1 vccd1 _00653_ sky130_fd_sc_hd__nor2_1
XFILLER_0_44_376 vssd1 vssd1 vccd1 vccd1 sky130_fd_sc_hd__fill_1
X_08015_ _02385_ _02386_ _02382_ vssd1 vssd1 vccd1 vccd1 _02388_ sky130_fd_sc_hd__a21o_1
X_05227_ _03979_ _04022_ _03716_ _03738_ vssd1 vssd1 vccd1 vccd1 _04033_ sky130_fd_sc_hd__a211o_1
XFILLER_0_4_484 vssd1 vssd1 vccd1 vccd1 sky130_fd_sc_hd__decap_6
X_05158_ _03203_ _03214_ _03257_ vssd1 vssd1 vccd1 vccd1 _03279_ sky130_fd_sc_hd__o21bai_1
X_09966_ net208 net416 vssd1 vssd1 vccd1 vccd1 _04500_ sky130_fd_sc_hd__nand2_1
X_05089_ net27 net616 net124 vssd1 vssd1 vccd1 vccd1 _00069_ sky130_fd_sc_hd__mux2_1
X_08917_ _03191_ _03194_ vssd1 vssd1 vccd1 vccd1 _03354_ sky130_fd_sc_hd__nor2_1
XTAP_980 vssd1 vccd1 sky130_fd_sc_hd__tapvpwrvgnd_1
X_09897_ _04401_ _04423_ vssd1 vssd1 vccd1 vccd1 _04425_ sky130_fd_sc_hd__nand2_1
XFILLER_0_99_505 vssd1 vssd1 vccd1 vccd1 sky130_fd_sc_hd__decap_4
X_08848_ _03263_ _03264_ _03276_ vssd1 vssd1 vccd1 vccd1 _03278_ sky130_fd_sc_hd__or3_4
XTAP_991 vssd1 vccd1 sky130_fd_sc_hd__tapvpwrvgnd_1
X_08779_ _03007_ _03015_ _03014_ vssd1 vssd1 vccd1 vccd1 _03204_ sky130_fd_sc_hd__a21o_1
XFILLER_0_94_210 vssd1 vssd1 vccd1 vccd1 sky130_fd_sc_hd__fill_1
XFILLER_0_39_104 vssd1 vssd1 vccd1 vccd1 sky130_fd_sc_hd__fill_1
XFILLER_0_54_129 vssd1 vssd1 vccd1 vccd1 sky130_fd_sc_hd__decap_8
XFILLER_0_90_460 vssd1 vssd1 vccd1 vccd1 sky130_fd_sc_hd__fill_1
XFILLER_0_23_505 vssd1 vssd1 vccd1 vccd1 sky130_fd_sc_hd__fill_1
XFILLER_0_35_354 vssd1 vssd1 vccd1 vccd1 sky130_fd_sc_hd__decap_8
XFILLER_0_62_173 vssd1 vssd1 vccd1 vccd1 sky130_fd_sc_hd__decap_6
XFILLER_0_50_335 vssd1 vssd1 vccd1 vccd1 sky130_fd_sc_hd__fill_1
XFILLER_0_65_39 vssd1 vssd1 vccd1 vccd1 sky130_ef_sc_hd__decap_12
X_10106_ clknet_3_2_0_wb_clk_i _00100_ _00036_ vssd1 vssd1 vccd1 vccd1 mul.a\[1\]
+ sky130_fd_sc_hd__dfrtp_1
X_10037_ net643 vssd1 vssd1 vccd1 vccd1 _00033_ sky130_fd_sc_hd__inv_2
XFILLER_0_81_49 vssd1 vssd1 vccd1 vccd1 sky130_fd_sc_hd__decap_3
XFILLER_0_81_27 vssd1 vssd1 vccd1 vccd1 sky130_fd_sc_hd__fill_2
XFILLER_0_58_424 vssd1 vssd1 vccd1 vccd1 sky130_fd_sc_hd__fill_1
XFILLER_0_58_435 vssd1 vssd1 vccd1 vccd1 sky130_fd_sc_hd__fill_2
XFILLER_0_14_21 vssd1 vssd1 vccd1 vccd1 sky130_fd_sc_hd__decap_6
XFILLER_0_73_449 vssd1 vssd1 vccd1 vccd1 sky130_fd_sc_hd__decap_4
XFILLER_0_26_332 vssd1 vssd1 vccd1 vccd1 sky130_fd_sc_hd__decap_4
XFILLER_0_45_129 vssd1 vssd1 vccd1 vccd1 sky130_fd_sc_hd__decap_8
X_06130_ net244 net617 _00399_ _00398_ vssd1 vssd1 vccd1 vccd1 _00508_ sky130_fd_sc_hd__a31o_1
X_06061_ _00436_ _00439_ vssd1 vssd1 vccd1 vccd1 _00440_ sky130_fd_sc_hd__xnor2_2
XFILLER_0_1_432 vssd1 vssd1 vccd1 vccd1 sky130_fd_sc_hd__decap_3
XFILLER_0_41_379 vssd1 vssd1 vccd1 vccd1 sky130_fd_sc_hd__fill_1
XFILLER_0_39_51 vssd1 vssd1 vccd1 vccd1 sky130_fd_sc_hd__decap_4
Xfanout407 net408 vssd1 vssd1 vccd1 vccd1 net407 sky130_fd_sc_hd__buf_2
Xfanout418 net419 vssd1 vssd1 vccd1 vccd1 net418 sky130_fd_sc_hd__clkbuf_4
Xfanout429 net431 vssd1 vssd1 vccd1 vccd1 net429 sky130_fd_sc_hd__buf_2
XTAP_210 vssd1 vccd1 sky130_fd_sc_hd__tapvpwrvgnd_1
XTAP_232 vssd1 vccd1 sky130_fd_sc_hd__tapvpwrvgnd_1
XTAP_221 vssd1 vccd1 sky130_fd_sc_hd__tapvpwrvgnd_1
XFILLER_0_39_84 vssd1 vssd1 vccd1 vccd1 sky130_fd_sc_hd__decap_4
X_09820_ net172 net455 net462 net166 vssd1 vssd1 vccd1 vccd1 _04341_ sky130_fd_sc_hd__a22oi_1
X_09751_ _04068_ _04113_ _04265_ vssd1 vssd1 vccd1 vccd1 _04266_ sky130_fd_sc_hd__o21ai_1
XTAP_265 vssd1 vccd1 sky130_fd_sc_hd__tapvpwrvgnd_1
XTAP_254 vssd1 vccd1 sky130_fd_sc_hd__tapvpwrvgnd_1
XTAP_243 vssd1 vccd1 sky130_fd_sc_hd__tapvpwrvgnd_1
X_06963_ _01333_ _01334_ _01301_ vssd1 vssd1 vccd1 vccd1 _01335_ sky130_fd_sc_hd__nor3b_2
X_08702_ net215 net471 _03116_ _03117_ vssd1 vssd1 vccd1 vccd1 _03119_ sky130_fd_sc_hd__and4_1
XTAP_298 vssd1 vccd1 sky130_fd_sc_hd__tapvpwrvgnd_1
XTAP_287 vssd1 vccd1 sky130_fd_sc_hd__tapvpwrvgnd_1
XTAP_276 vssd1 vccd1 sky130_fd_sc_hd__tapvpwrvgnd_1
X_05914_ _00291_ _00292_ vssd1 vssd1 vccd1 vccd1 _00294_ sky130_fd_sc_hd__xor2_1
X_06894_ net225 net234 net561 net569 vssd1 vssd1 vccd1 vccd1 _01266_ sky130_fd_sc_hd__and4_1
X_09682_ _04176_ _04188_ vssd1 vssd1 vccd1 vccd1 _04190_ sky130_fd_sc_hd__nor2_1
X_08633_ _03041_ _03042_ _02832_ _02871_ vssd1 vssd1 vccd1 vccd1 _03044_ sky130_fd_sc_hd__a211oi_2
X_05845_ net381 net496 _00136_ _00137_ net513 vssd1 vssd1 vccd1 vccd1 _00226_ sky130_fd_sc_hd__a32o_1
XFILLER_0_89_571 vssd1 vssd1 vccd1 vccd1 sky130_fd_sc_hd__fill_1
X_08564_ _02957_ _02966_ vssd1 vssd1 vccd1 vccd1 _02968_ sky130_fd_sc_hd__xnor2_2
XFILLER_0_12_3 vssd1 vssd1 vccd1 vccd1 sky130_ef_sc_hd__decap_12
X_05776_ _04833_ _04834_ _04956_ vssd1 vssd1 vccd1 vccd1 _00158_ sky130_fd_sc_hd__or3_2
X_07515_ _01885_ _01886_ _01871_ vssd1 vssd1 vccd1 vccd1 _01888_ sky130_fd_sc_hd__a21oi_1
XFILLER_0_49_446 vssd1 vssd1 vccd1 vccd1 sky130_fd_sc_hd__fill_2
XFILLER_0_49_457 vssd1 vssd1 vccd1 vccd1 sky130_fd_sc_hd__fill_1
X_08495_ _02881_ _02892_ vssd1 vssd1 vccd1 vccd1 _02893_ sky130_fd_sc_hd__xnor2_1
XFILLER_0_9_521 vssd1 vssd1 vccd1 vccd1 sky130_fd_sc_hd__fill_1
XFILLER_0_49_468 vssd1 vssd1 vccd1 vccd1 sky130_ef_sc_hd__decap_12
X_07446_ net210 net555 net582 net189 vssd1 vssd1 vccd1 vccd1 _01814_ sky130_fd_sc_hd__a22o_1
XFILLER_0_91_257 vssd1 vssd1 vccd1 vccd1 sky130_fd_sc_hd__fill_1
X_07377_ net259 net508 net518 net250 vssd1 vssd1 vccd1 vccd1 _01746_ sky130_fd_sc_hd__a22o_1
XFILLER_0_72_493 vssd1 vssd1 vccd1 vccd1 sky130_fd_sc_hd__fill_1
X_09116_ _03567_ _03568_ _03569_ vssd1 vssd1 vccd1 vccd1 _03571_ sky130_fd_sc_hd__a21o_1
X_06328_ _00525_ _00703_ _00704_ vssd1 vssd1 vccd1 vccd1 _00705_ sky130_fd_sc_hd__and3_1
XFILLER_0_44_184 vssd1 vssd1 vccd1 vccd1 sky130_fd_sc_hd__fill_1
X_09047_ _03339_ _03341_ _03494_ _03495_ vssd1 vssd1 vccd1 vccd1 _03496_ sky130_fd_sc_hd__a211oi_2
XFILLER_0_32_346 vssd1 vssd1 vccd1 vccd1 sky130_fd_sc_hd__decap_8
XFILLER_0_44_195 vssd1 vssd1 vccd1 vccd1 sky130_fd_sc_hd__fill_1
X_06259_ _00497_ _00634_ vssd1 vssd1 vccd1 vccd1 _00636_ sky130_fd_sc_hd__xnor2_1
X_09949_ _04475_ _04480_ vssd1 vssd1 vccd1 vccd1 _04482_ sky130_fd_sc_hd__xnor2_1
XFILLER_0_67_232 vssd1 vssd1 vccd1 vccd1 sky130_fd_sc_hd__fill_2
XFILLER_0_48_490 vssd1 vssd1 vccd1 vccd1 sky130_fd_sc_hd__decap_4
XFILLER_0_90_290 vssd1 vssd1 vccd1 vccd1 sky130_fd_sc_hd__fill_1
XFILLER_0_50_165 vssd1 vssd1 vccd1 vccd1 sky130_fd_sc_hd__fill_2
XFILLER_0_92_37 vssd1 vssd1 vccd1 vccd1 sky130_fd_sc_hd__decap_8
X_05630_ _04898_ _04899_ vssd1 vssd1 vccd1 vccd1 _04900_ sky130_fd_sc_hd__nor2_1
XFILLER_0_86_530 vssd1 vssd1 vccd1 vccd1 sky130_fd_sc_hd__fill_2
XFILLER_0_25_75 vssd1 vssd1 vccd1 vccd1 sky130_ef_sc_hd__decap_12
XFILLER_0_86_574 vssd1 vssd1 vccd1 vccd1 sky130_fd_sc_hd__decap_8
X_05561_ _04828_ _04829_ _04824_ vssd1 vssd1 vccd1 vccd1 _04831_ sky130_fd_sc_hd__a21o_1
X_07300_ _01523_ _01525_ vssd1 vssd1 vccd1 vccd1 _01669_ sky130_fd_sc_hd__nand2_1
X_08280_ _02654_ _02655_ _02640_ vssd1 vssd1 vccd1 vccd1 _02658_ sky130_fd_sc_hd__a21oi_2
X_05492_ _04760_ _04761_ vssd1 vssd1 vccd1 vccd1 _04762_ sky130_fd_sc_hd__and2b_1
XFILLER_0_18_118 vssd1 vssd1 vccd1 vccd1 sky130_fd_sc_hd__decap_3
XFILLER_0_73_257 vssd1 vssd1 vccd1 vccd1 sky130_fd_sc_hd__decap_3
X_07231_ net269 net506 net515 net259 vssd1 vssd1 vccd1 vccd1 _01601_ sky130_fd_sc_hd__a22o_1
XFILLER_0_14_302 vssd1 vssd1 vccd1 vccd1 sky130_fd_sc_hd__fill_1
X_07162_ _01386_ _01390_ _01530_ vssd1 vssd1 vccd1 vccd1 _01532_ sky130_fd_sc_hd__and3_1
XFILLER_0_14_346 vssd1 vssd1 vccd1 vccd1 sky130_fd_sc_hd__decap_8
X_06113_ _00420_ _00489_ _00490_ vssd1 vssd1 vccd1 vccd1 _00491_ sky130_fd_sc_hd__nand3_1
XFILLER_0_41_165 vssd1 vssd1 vccd1 vccd1 sky130_fd_sc_hd__decap_3
XFILLER_0_41_176 vssd1 vssd1 vccd1 vccd1 sky130_ef_sc_hd__decap_12
X_07093_ _01316_ _01324_ _01323_ vssd1 vssd1 vccd1 vccd1 _01464_ sky130_fd_sc_hd__a21bo_1
X_06044_ net390 net463 _00421_ vssd1 vssd1 vccd1 vccd1 _00423_ sky130_fd_sc_hd__and3_1
Xfanout204 net206 vssd1 vssd1 vccd1 vccd1 net204 sky130_fd_sc_hd__buf_4
XFILLER_0_10_541 vssd1 vssd1 vccd1 vccd1 sky130_fd_sc_hd__decap_8
Xfanout215 net217 vssd1 vssd1 vccd1 vccd1 net215 sky130_fd_sc_hd__clkbuf_4
Xfanout237 net238 vssd1 vssd1 vccd1 vccd1 net237 sky130_fd_sc_hd__clkbuf_4
XFILLER_0_10_574 vssd1 vssd1 vccd1 vccd1 sky130_fd_sc_hd__fill_1
Xfanout226 net229 vssd1 vssd1 vccd1 vccd1 net226 sky130_fd_sc_hd__clkbuf_4
X_09803_ _04319_ _04320_ net162 net468 vssd1 vssd1 vccd1 vccd1 _04322_ sky130_fd_sc_hd__and4bb_1
X_07995_ net212 net528 _02363_ _02365_ vssd1 vssd1 vccd1 vccd1 _02368_ sky130_fd_sc_hd__nand4_1
Xfanout248 net249 vssd1 vssd1 vccd1 vccd1 net248 sky130_fd_sc_hd__clkbuf_4
Xfanout259 net261 vssd1 vssd1 vccd1 vccd1 net259 sky130_fd_sc_hd__clkbuf_4
X_06946_ net250 net259 net690 net546 vssd1 vssd1 vccd1 vccd1 _01318_ sky130_fd_sc_hd__nand4_1
X_09734_ net234 net411 _04243_ _04245_ vssd1 vssd1 vccd1 vccd1 _04247_ sky130_fd_sc_hd__and4_1
X_06877_ _01141_ _01247_ _01248_ vssd1 vssd1 vccd1 vccd1 _01249_ sky130_fd_sc_hd__nand3_1
X_09665_ _04010_ _04170_ vssd1 vssd1 vccd1 vccd1 _04171_ sky130_fd_sc_hd__xor2_1
X_08616_ _03020_ _03023_ _03024_ vssd1 vssd1 vccd1 vccd1 _03025_ sky130_fd_sc_hd__nand3_1
X_05828_ _00207_ _00208_ vssd1 vssd1 vccd1 vccd1 _00209_ sky130_fd_sc_hd__and2b_1
XTAP_1239 vssd1 vccd1 sky130_fd_sc_hd__tapvpwrvgnd_1
XTAP_1228 vssd1 vccd1 sky130_fd_sc_hd__tapvpwrvgnd_1
XTAP_1217 vssd1 vccd1 sky130_fd_sc_hd__tapvpwrvgnd_1
XTAP_1206 vssd1 vccd1 sky130_fd_sc_hd__tapvpwrvgnd_1
XFILLER_0_89_390 vssd1 vssd1 vccd1 vccd1 sky130_fd_sc_hd__fill_2
XFILLER_0_77_541 vssd1 vssd1 vccd1 vccd1 sky130_ef_sc_hd__decap_12
X_09596_ _04094_ _04095_ vssd1 vssd1 vccd1 vccd1 _04096_ sky130_fd_sc_hd__or2_1
X_08547_ net201 net500 vssd1 vssd1 vccd1 vccd1 _02949_ sky130_fd_sc_hd__nand2_1
X_05759_ net337 net347 net531 net541 vssd1 vssd1 vccd1 vccd1 _00141_ sky130_fd_sc_hd__nand4_1
X_08478_ _02664_ _02707_ _02872_ _02873_ vssd1 vssd1 vccd1 vccd1 _02874_ sky130_fd_sc_hd__o211a_4
XFILLER_0_9_373 vssd1 vssd1 vccd1 vccd1 sky130_ef_sc_hd__decap_12
X_07429_ net165 net618 vssd1 vssd1 vccd1 vccd1 _01797_ sky130_fd_sc_hd__nand2_1
XFILLER_0_17_151 vssd1 vssd1 vccd1 vccd1 sky130_fd_sc_hd__fill_1
XFILLER_0_17_184 vssd1 vssd1 vccd1 vccd1 sky130_fd_sc_hd__fill_2
XFILLER_0_32_132 vssd1 vssd1 vccd1 vccd1 sky130_fd_sc_hd__decap_8
XFILLER_0_1_3 vssd1 vssd1 vccd1 vccd1 sky130_ef_sc_hd__decap_12
XFILLER_0_99_121 vssd1 vssd1 vccd1 vccd1 sky130_fd_sc_hd__decap_3
XFILLER_0_99_187 vssd1 vssd1 vccd1 vccd1 sky130_fd_sc_hd__decap_4
XFILLER_0_87_305 vssd1 vssd1 vccd1 vccd1 sky130_fd_sc_hd__fill_1
XFILLER_0_28_427 vssd1 vssd1 vccd1 vccd1 sky130_fd_sc_hd__decap_4
XFILLER_0_11_22 vssd1 vssd1 vccd1 vccd1 sky130_fd_sc_hd__decap_8
XFILLER_0_3_505 vssd1 vssd1 vccd1 vccd1 sky130_fd_sc_hd__decap_4
XFILLER_0_36_493 vssd1 vssd1 vccd1 vccd1 sky130_fd_sc_hd__decap_4
XFILLER_0_11_99 vssd1 vssd1 vccd1 vccd1 sky130_ef_sc_hd__decap_12
X_06800_ net330 net468 _01170_ _01171_ vssd1 vssd1 vccd1 vccd1 _01173_ sky130_fd_sc_hd__a22o_1
X_07780_ _01976_ _01988_ _01987_ vssd1 vssd1 vccd1 vccd1 _02151_ sky130_fd_sc_hd__a21boi_1
Xinput4 wbs_cyc_i vssd1 vssd1 vccd1 vccd1 net4 sky130_fd_sc_hd__buf_1
X_06731_ net203 net620 _00969_ _00968_ vssd1 vssd1 vccd1 vccd1 _01104_ sky130_fd_sc_hd__a31o_1
X_09450_ _03925_ _03934_ vssd1 vssd1 vccd1 vccd1 _03937_ sky130_fd_sc_hd__and2_1
XFILLER_0_78_305 vssd1 vssd1 vccd1 vccd1 sky130_fd_sc_hd__decap_3
XFILLER_0_36_85 vssd1 vssd1 vccd1 vccd1 sky130_ef_sc_hd__decap_12
X_08401_ _02785_ _02786_ _02788_ vssd1 vssd1 vccd1 vccd1 _02790_ sky130_fd_sc_hd__a21oi_2
X_06662_ _01016_ _01034_ _01035_ vssd1 vssd1 vccd1 vccd1 _01036_ sky130_fd_sc_hd__and3_2
X_09381_ net162 net497 _03857_ _03860_ vssd1 vssd1 vccd1 vccd1 _03861_ sky130_fd_sc_hd__a22oi_1
X_05613_ _04730_ _04767_ _04804_ vssd1 vssd1 vccd1 vccd1 _04883_ sky130_fd_sc_hd__o21bai_2
X_06593_ _00726_ _00857_ _00856_ vssd1 vssd1 vccd1 vccd1 _00967_ sky130_fd_sc_hd__a21oi_1
XFILLER_0_86_371 vssd1 vssd1 vccd1 vccd1 sky130_fd_sc_hd__fill_1
X_08332_ net150 net601 net610 vssd1 vssd1 vccd1 vccd1 _02715_ sky130_fd_sc_hd__and3_1
XFILLER_0_52_62 vssd1 vssd1 vccd1 vccd1 sky130_fd_sc_hd__fill_1
X_05544_ _04680_ _04743_ _04742_ vssd1 vssd1 vccd1 vccd1 _04814_ sky130_fd_sc_hd__a21boi_1
XFILLER_0_46_202 vssd1 vssd1 vccd1 vccd1 sky130_fd_sc_hd__decap_3
X_08263_ _02636_ _02637_ _02501_ _02513_ vssd1 vssd1 vccd1 vccd1 _02639_ sky130_fd_sc_hd__a211o_1
XFILLER_0_34_408 vssd1 vssd1 vccd1 vccd1 sky130_ef_sc_hd__decap_12
X_07214_ _01574_ _01582_ vssd1 vssd1 vccd1 vccd1 _01584_ sky130_fd_sc_hd__xor2_1
X_05475_ _04742_ _04743_ _04680_ vssd1 vssd1 vccd1 vccd1 _04745_ sky130_fd_sc_hd__a21oi_1
XFILLER_0_15_611 vssd1 vssd1 vccd1 vccd1 sky130_fd_sc_hd__fill_1
X_08194_ _02558_ _02565_ _02566_ vssd1 vssd1 vccd1 vccd1 _02567_ sky130_fd_sc_hd__nand3_1
XFILLER_0_27_493 vssd1 vssd1 vccd1 vccd1 sky130_fd_sc_hd__decap_6
XFILLER_0_14_154 vssd1 vssd1 vccd1 vccd1 sky130_fd_sc_hd__decap_4
X_07145_ _01511_ _01514_ vssd1 vssd1 vccd1 vccd1 _01515_ sky130_fd_sc_hd__and2b_1
X_07076_ _01438_ _01446_ vssd1 vssd1 vccd1 vccd1 _01447_ sky130_fd_sc_hd__and2_1
X_06027_ net226 net235 net625 net633 vssd1 vssd1 vccd1 vccd1 _00406_ sky130_fd_sc_hd__and4_1
X_07978_ _02343_ _02349_ _02350_ vssd1 vssd1 vccd1 vccd1 _02351_ sky130_fd_sc_hd__nand3_1
X_09717_ net248 net400 net407 net239 vssd1 vssd1 vccd1 vccd1 _04228_ sky130_fd_sc_hd__a22o_1
X_06929_ _01299_ _01300_ vssd1 vssd1 vccd1 vccd1 _01301_ sky130_fd_sc_hd__and2_1
X_09648_ _04151_ _04152_ vssd1 vssd1 vccd1 vccd1 _04153_ sky130_fd_sc_hd__nand2b_1
XFILLER_0_96_124 vssd1 vssd1 vccd1 vccd1 sky130_fd_sc_hd__decap_3
XTAP_1003 vssd1 vccd1 sky130_fd_sc_hd__tapvpwrvgnd_1
XFILLER_0_77_360 vssd1 vssd1 vccd1 vccd1 sky130_fd_sc_hd__decap_8
XTAP_1047 vssd1 vccd1 sky130_fd_sc_hd__tapvpwrvgnd_1
XTAP_1036 vssd1 vccd1 sky130_fd_sc_hd__tapvpwrvgnd_1
XTAP_1025 vssd1 vccd1 sky130_fd_sc_hd__tapvpwrvgnd_1
XTAP_1014 vssd1 vccd1 sky130_fd_sc_hd__tapvpwrvgnd_1
X_09579_ net248 net257 net400 net405 vssd1 vssd1 vccd1 vccd1 _04078_ sky130_fd_sc_hd__nand4_1
XTAP_1069 vssd1 vccd1 sky130_fd_sc_hd__tapvpwrvgnd_1
XFILLER_0_77_393 vssd1 vssd1 vccd1 vccd1 sky130_fd_sc_hd__decap_3
XFILLER_0_77_382 vssd1 vssd1 vccd1 vccd1 sky130_fd_sc_hd__decap_4
XTAP_1058 vssd1 vccd1 sky130_fd_sc_hd__tapvpwrvgnd_1
XFILLER_0_92_363 vssd1 vssd1 vccd1 vccd1 sky130_fd_sc_hd__fill_1
XFILLER_0_37_279 vssd1 vssd1 vccd1 vccd1 sky130_fd_sc_hd__fill_1
XFILLER_0_18_493 vssd1 vssd1 vccd1 vccd1 sky130_fd_sc_hd__decap_4
XFILLER_0_33_496 vssd1 vssd1 vccd1 vccd1 sky130_fd_sc_hd__decap_8
XFILLER_0_57_29 vssd1 vssd1 vccd1 vccd1 sky130_fd_sc_hd__decap_4
XTAP_809 vssd1 vccd1 sky130_fd_sc_hd__tapvpwrvgnd_1
XFILLER_0_73_17 vssd1 vssd1 vccd1 vccd1 sky130_ef_sc_hd__decap_12
Xfanout590 net591 vssd1 vssd1 vccd1 vccd1 net590 sky130_fd_sc_hd__clkbuf_4
XFILLER_0_56_533 vssd1 vssd1 vccd1 vccd1 sky130_fd_sc_hd__decap_8
XFILLER_0_56_544 vssd1 vssd1 vccd1 vccd1 sky130_fd_sc_hd__fill_1
XFILLER_0_7_118 vssd1 vssd1 vccd1 vccd1 sky130_ef_sc_hd__decap_12
XFILLER_0_28_235 vssd1 vssd1 vccd1 vccd1 sky130_fd_sc_hd__decap_3
XFILLER_0_71_503 vssd1 vssd1 vccd1 vccd1 sky130_fd_sc_hd__fill_1
X_05260_ net335 net586 _04372_ _04383_ vssd1 vssd1 vccd1 vccd1 _04394_ sky130_fd_sc_hd__nand4_2
XFILLER_0_3_302 vssd1 vssd1 vccd1 vccd1 sky130_fd_sc_hd__fill_1
X_05191_ _03290_ _03301_ _03399_ _03618_ vssd1 vssd1 vccd1 vccd1 _03640_ sky130_fd_sc_hd__a211o_1
XFILLER_0_3_335 vssd1 vssd1 vccd1 vccd1 sky130_fd_sc_hd__fill_1
XFILLER_0_11_113 vssd1 vssd1 vccd1 vccd1 sky130_fd_sc_hd__decap_4
X_08950_ net120 _03235_ _03234_ vssd1 vssd1 vccd1 vccd1 _03391_ sky130_fd_sc_hd__a21oi_1
X_08881_ _03164_ _03314_ vssd1 vssd1 vccd1 vccd1 _03315_ sky130_fd_sc_hd__xnor2_1
X_07901_ _02273_ _02274_ vssd1 vssd1 vccd1 vccd1 _02275_ sky130_fd_sc_hd__nand2_2
X_07832_ net282 net290 net459 net466 vssd1 vssd1 vccd1 vccd1 _02203_ sky130_fd_sc_hd__nand4_4
X_09502_ _03993_ _03992_ vssd1 vssd1 vccd1 vccd1 _03994_ sky130_fd_sc_hd__and2b_1
X_07763_ _02116_ _02133_ vssd1 vssd1 vccd1 vccd1 _02134_ sky130_fd_sc_hd__nand2_1
X_07694_ net212 net548 net393 vssd1 vssd1 vccd1 vccd1 _02066_ sky130_fd_sc_hd__a21o_1
XFILLER_0_2_53 vssd1 vssd1 vccd1 vccd1 sky130_fd_sc_hd__decap_6
X_06714_ net673 _00949_ _01085_ _01086_ vssd1 vssd1 vccd1 vccd1 _01088_ sky130_fd_sc_hd__o211ai_2
X_09433_ _03917_ _03916_ vssd1 vssd1 vccd1 vccd1 _03918_ sky130_fd_sc_hd__nand2b_1
XFILLER_0_2_97 vssd1 vssd1 vccd1 vccd1 sky130_fd_sc_hd__decap_6
X_06645_ net382 net434 net440 net373 vssd1 vssd1 vccd1 vccd1 _01019_ sky130_fd_sc_hd__a22oi_1
X_09364_ _03840_ _03841_ vssd1 vssd1 vccd1 vccd1 _03843_ sky130_fd_sc_hd__xor2_1
XFILLER_0_93_138 vssd1 vssd1 vccd1 vccd1 sky130_fd_sc_hd__fill_2
XPHY_119 vssd1 vssd1 vccd1 vccd1 sky130_fd_sc_hd__decap_3
XPHY_108 vssd1 vssd1 vccd1 vccd1 sky130_fd_sc_hd__decap_3
X_08315_ _02558_ _02566_ _02565_ vssd1 vssd1 vccd1 vccd1 _02696_ sky130_fd_sc_hd__a21bo_1
XFILLER_0_59_393 vssd1 vssd1 vccd1 vccd1 sky130_ef_sc_hd__decap_12
X_06576_ _00824_ _00827_ _00949_ _00950_ vssd1 vssd1 vccd1 vccd1 _00951_ sky130_fd_sc_hd__a211oi_4
X_09295_ _03764_ _03765_ _03613_ _03615_ vssd1 vssd1 vccd1 vccd1 _03767_ sky130_fd_sc_hd__o211a_1
X_05527_ _04793_ _04794_ _04795_ vssd1 vssd1 vccd1 vccd1 _04797_ sky130_fd_sc_hd__a21oi_1
X_08246_ _02492_ _02497_ _02491_ vssd1 vssd1 vccd1 vccd1 _02620_ sky130_fd_sc_hd__a21bo_1
X_05458_ _04077_ _04727_ vssd1 vssd1 vccd1 vccd1 _04728_ sky130_fd_sc_hd__and2_1
X_08177_ net341 net351 net403 mul.b\[28\] vssd1 vssd1 vccd1 vccd1 _02549_ sky130_fd_sc_hd__nand4_1
XFILLER_0_15_485 vssd1 vssd1 vccd1 vccd1 sky130_fd_sc_hd__decap_3
X_05389_ _04641_ _04658_ vssd1 vssd1 vccd1 vccd1 _04659_ sky130_fd_sc_hd__nand2_1
X_07128_ _01357_ _01358_ _01493_ _01497_ _01492_ vssd1 vssd1 vccd1 vccd1 _01498_ sky130_fd_sc_hd__a32o_1
XFILLER_0_42_282 vssd1 vssd1 vccd1 vccd1 sky130_ef_sc_hd__decap_12
X_07059_ _01289_ _01291_ _01428_ _01429_ vssd1 vssd1 vccd1 vccd1 _01430_ sky130_fd_sc_hd__a211o_1
X_10070_ net645 vssd1 vssd1 vccd1 vccd1 _00066_ sky130_fd_sc_hd__inv_2
XFILLER_0_69_113 vssd1 vssd1 vccd1 vccd1 sky130_ef_sc_hd__decap_12
Xmax_cap88 net716 vssd1 vssd1 vccd1 vccd1 net88 sky130_fd_sc_hd__buf_1
XFILLER_0_97_488 vssd1 vssd1 vccd1 vccd1 sky130_fd_sc_hd__decap_4
Xmax_cap99 net718 vssd1 vssd1 vccd1 vccd1 net99 sky130_fd_sc_hd__buf_1
XFILLER_0_38_511 vssd1 vssd1 vccd1 vccd1 sky130_ef_sc_hd__decap_12
XFILLER_0_38_533 vssd1 vssd1 vccd1 vccd1 sky130_fd_sc_hd__decap_4
XFILLER_0_38_544 vssd1 vssd1 vccd1 vccd1 sky130_fd_sc_hd__fill_1
XFILLER_0_38_555 vssd1 vssd1 vccd1 vccd1 sky130_fd_sc_hd__decap_4
XFILLER_0_80_333 vssd1 vssd1 vccd1 vccd1 sky130_fd_sc_hd__decap_3
XFILLER_0_53_558 vssd1 vssd1 vccd1 vccd1 sky130_fd_sc_hd__fill_2
XFILLER_0_21_422 vssd1 vssd1 vccd1 vccd1 sky130_ef_sc_hd__decap_12
XFILLER_0_0_316 vssd1 vssd1 vccd1 vccd1 sky130_fd_sc_hd__decap_6
XTAP_606 vssd1 vccd1 sky130_fd_sc_hd__tapvpwrvgnd_1
XTAP_617 vssd1 vccd1 sky130_fd_sc_hd__tapvpwrvgnd_1
XTAP_628 vssd1 vccd1 sky130_fd_sc_hd__tapvpwrvgnd_1
XTAP_639 vssd1 vccd1 sky130_fd_sc_hd__tapvpwrvgnd_1
XFILLER_0_84_27 vssd1 vssd1 vccd1 vccd1 sky130_fd_sc_hd__fill_1
XFILLER_0_88_477 vssd1 vssd1 vccd1 vccd1 sky130_fd_sc_hd__decap_8
XFILLER_0_75_116 vssd1 vssd1 vccd1 vccd1 sky130_ef_sc_hd__decap_12
X_06430_ _00673_ _00681_ _00680_ vssd1 vssd1 vccd1 vccd1 _00806_ sky130_fd_sc_hd__a21bo_1
XFILLER_0_29_522 vssd1 vssd1 vccd1 vccd1 sky130_ef_sc_hd__decap_12
XFILLER_0_91_609 vssd1 vssd1 vccd1 vccd1 sky130_fd_sc_hd__fill_1
XFILLER_0_33_53 vssd1 vssd1 vccd1 vccd1 sky130_fd_sc_hd__decap_3
XFILLER_0_8_438 vssd1 vssd1 vccd1 vccd1 sky130_fd_sc_hd__fill_1
X_06361_ net281 net554 net581 net252 vssd1 vssd1 vccd1 vccd1 _00737_ sky130_fd_sc_hd__a22o_1
X_09080_ _03504_ _03532_ vssd1 vssd1 vccd1 vccd1 _03533_ sky130_fd_sc_hd__xnor2_1
X_08100_ _02464_ _02471_ vssd1 vssd1 vccd1 vccd1 _02472_ sky130_fd_sc_hd__xnor2_2
X_05312_ _04580_ _04581_ _03957_ vssd1 vssd1 vccd1 vccd1 _04582_ sky130_fd_sc_hd__nand3b_1
X_06292_ net336 net495 vssd1 vssd1 vccd1 vccd1 _00669_ sky130_fd_sc_hd__nand2_1
X_08031_ net275 net283 net460 net467 vssd1 vssd1 vccd1 vccd1 _02404_ sky130_fd_sc_hd__nand4_1
X_05243_ net327 net594 net604 net319 vssd1 vssd1 vccd1 vccd1 _04208_ sky130_fd_sc_hd__a22o_1
XFILLER_0_3_187 vssd1 vssd1 vccd1 vccd1 sky130_fd_sc_hd__fill_2
XFILLER_0_12_433 vssd1 vssd1 vccd1 vccd1 sky130_fd_sc_hd__decap_6
XFILLER_0_12_455 vssd1 vssd1 vccd1 vccd1 sky130_ef_sc_hd__decap_12
X_05174_ net343 net614 vssd1 vssd1 vccd1 vccd1 _03454_ sky130_fd_sc_hd__and2_1
X_09982_ _04335_ _04338_ _04336_ vssd1 vssd1 vccd1 vccd1 _04518_ sky130_fd_sc_hd__o21bai_1
X_08933_ _03369_ _03370_ vssd1 vssd1 vccd1 vccd1 _03372_ sky130_fd_sc_hd__xnor2_1
XFILLER_0_58_83 vssd1 vssd1 vccd1 vccd1 sky130_fd_sc_hd__fill_1
XFILLER_0_42_3 vssd1 vssd1 vccd1 vccd1 sky130_fd_sc_hd__decap_8
X_08864_ _03293_ _03294_ vssd1 vssd1 vccd1 vccd1 _03296_ sky130_fd_sc_hd__xnor2_1
X_08795_ net119 _03220_ vssd1 vssd1 vccd1 vccd1 _03221_ sky130_fd_sc_hd__xor2_1
X_07815_ _02183_ _02184_ _02185_ vssd1 vssd1 vccd1 vccd1 _02186_ sky130_fd_sc_hd__and3_1
XFILLER_0_74_93 vssd1 vssd1 vccd1 vccd1 sky130_fd_sc_hd__fill_2
X_07746_ net628 net636 net149 vssd1 vssd1 vccd1 vccd1 _02117_ sky130_fd_sc_hd__o21a_1
XFILLER_0_67_617 vssd1 vssd1 vccd1 vccd1 sky130_fd_sc_hd__fill_2
XFILLER_0_66_105 vssd1 vssd1 vccd1 vccd1 sky130_fd_sc_hd__decap_8
X_07677_ _02041_ _02047_ _02048_ vssd1 vssd1 vccd1 vccd1 _02049_ sky130_fd_sc_hd__nand3_2
X_09416_ net191 net455 net462 net187 vssd1 vssd1 vccd1 vccd1 _03899_ sky130_fd_sc_hd__a22o_1
X_06628_ _00884_ _01000_ _01001_ vssd1 vssd1 vccd1 vccd1 _01002_ sky130_fd_sc_hd__nor3_2
X_09347_ _03822_ _03823_ vssd1 vssd1 vccd1 vccd1 _03824_ sky130_fd_sc_hd__and2b_1
XFILLER_0_74_160 vssd1 vssd1 vccd1 vccd1 sky130_fd_sc_hd__decap_6
X_06559_ _00807_ _00810_ _00931_ _00933_ vssd1 vssd1 vccd1 vccd1 _00934_ sky130_fd_sc_hd__a211oi_1
XFILLER_0_35_503 vssd1 vssd1 vccd1 vccd1 sky130_fd_sc_hd__fill_1
X_09278_ net216 net224 net436 net442 vssd1 vssd1 vccd1 vccd1 _03748_ sky130_fd_sc_hd__nand4_2
XFILLER_0_35_536 vssd1 vssd1 vccd1 vccd1 sky130_fd_sc_hd__fill_1
X_08229_ net476 net144 net130 net238 vssd1 vssd1 vccd1 vccd1 _02603_ sky130_fd_sc_hd__a22o_1
XFILLER_0_7_482 vssd1 vssd1 vccd1 vccd1 sky130_fd_sc_hd__decap_8
XFILLER_0_62_388 vssd1 vssd1 vccd1 vccd1 sky130_fd_sc_hd__fill_2
X_10122_ clknet_3_6_0_wb_clk_i _00116_ _00052_ vssd1 vssd1 vccd1 vccd1 mul.a\[17\]
+ sky130_fd_sc_hd__dfrtp_2
XFILLER_0_100_195 vssd1 vssd1 vccd1 vccd1 sky130_fd_sc_hd__fill_1
X_10053_ net640 vssd1 vssd1 vccd1 vccd1 _00049_ sky130_fd_sc_hd__inv_2
XFILLER_0_89_219 vssd1 vssd1 vccd1 vccd1 sky130_fd_sc_hd__fill_1
XFILLER_0_89_208 vssd1 vssd1 vccd1 vccd1 sky130_fd_sc_hd__fill_2
XFILLER_0_85_447 vssd1 vssd1 vccd1 vccd1 sky130_fd_sc_hd__fill_1
XFILLER_0_38_363 vssd1 vssd1 vccd1 vccd1 sky130_fd_sc_hd__fill_1
XFILLER_0_26_547 vssd1 vssd1 vccd1 vccd1 sky130_fd_sc_hd__decap_8
XFILLER_0_0_113 vssd1 vssd1 vccd1 vccd1 sky130_ef_sc_hd__decap_12
XFILLER_0_95_15 vssd1 vssd1 vccd1 vccd1 sky130_fd_sc_hd__decap_4
XTAP_403 vssd1 vccd1 sky130_fd_sc_hd__tapvpwrvgnd_1
XTAP_414 vssd1 vccd1 sky130_fd_sc_hd__tapvpwrvgnd_1
XTAP_436 vssd1 vccd1 sky130_fd_sc_hd__tapvpwrvgnd_1
XTAP_425 vssd1 vccd1 sky130_fd_sc_hd__tapvpwrvgnd_1
XTAP_447 vssd1 vccd1 sky130_fd_sc_hd__tapvpwrvgnd_1
XTAP_458 vssd1 vccd1 sky130_fd_sc_hd__tapvpwrvgnd_1
X_05930_ net235 net244 net625 net633 vssd1 vssd1 vccd1 vccd1 _00310_ sky130_fd_sc_hd__and4_1
XTAP_469 vssd1 vccd1 sky130_fd_sc_hd__tapvpwrvgnd_1
XFILLER_0_28_53 vssd1 vssd1 vccd1 vccd1 sky130_ef_sc_hd__decap_12
X_05861_ _00239_ _00240_ _00241_ vssd1 vssd1 vccd1 vccd1 _00242_ sky130_fd_sc_hd__nand3_1
X_08580_ _02815_ _02817_ _02983_ _02985_ vssd1 vssd1 vccd1 vccd1 _02986_ sky130_fd_sc_hd__a211o_2
X_07600_ _01800_ _01805_ vssd1 vssd1 vccd1 vccd1 _01972_ sky130_fd_sc_hd__nand2_1
X_07531_ net265 net500 vssd1 vssd1 vccd1 vccd1 _01904_ sky130_fd_sc_hd__and2_1
X_05792_ _00171_ _00172_ vssd1 vssd1 vccd1 vccd1 _00174_ sky130_fd_sc_hd__xor2_1
XFILLER_0_14_7 vssd1 vssd1 vccd1 vccd1 sky130_fd_sc_hd__fill_1
XFILLER_0_88_274 vssd1 vssd1 vccd1 vccd1 sky130_fd_sc_hd__decap_3
XFILLER_0_44_85 vssd1 vssd1 vccd1 vccd1 sky130_ef_sc_hd__decap_12
XFILLER_0_48_138 vssd1 vssd1 vccd1 vccd1 sky130_fd_sc_hd__fill_2
X_07462_ _01826_ _01829_ _01811_ vssd1 vssd1 vccd1 vccd1 _01831_ sky130_fd_sc_hd__o21ai_1
X_09201_ _03461_ net90 _03663_ _03664_ vssd1 vssd1 vccd1 vccd1 _03665_ sky130_fd_sc_hd__o211a_1
X_07393_ _01759_ _01760_ _01761_ vssd1 vssd1 vccd1 vccd1 _01762_ sky130_fd_sc_hd__and3_1
XFILLER_0_17_503 vssd1 vssd1 vccd1 vccd1 sky130_fd_sc_hd__fill_1
X_06413_ _00780_ _00788_ vssd1 vssd1 vccd1 vccd1 _00789_ sky130_fd_sc_hd__nand2b_1
XFILLER_0_29_352 vssd1 vssd1 vccd1 vccd1 sky130_fd_sc_hd__decap_3
XFILLER_0_84_491 vssd1 vssd1 vccd1 vccd1 sky130_ef_sc_hd__decap_12
X_09132_ net192 net472 _03586_ _03587_ vssd1 vssd1 vccd1 vccd1 _03589_ sky130_fd_sc_hd__and4_1
XFILLER_0_56_160 vssd1 vssd1 vccd1 vccd1 sky130_fd_sc_hd__fill_2
X_06344_ _00718_ _00719_ vssd1 vssd1 vccd1 vccd1 _00720_ sky130_fd_sc_hd__nand2b_1
X_09063_ _03508_ net123 vssd1 vssd1 vccd1 vccd1 _03514_ sky130_fd_sc_hd__nand2_1
XFILLER_0_8_41 vssd1 vssd1 vccd1 vccd1 sky130_fd_sc_hd__decap_6
X_06275_ net387 net447 _00649_ _00650_ vssd1 vssd1 vccd1 vccd1 _00652_ sky130_fd_sc_hd__a22oi_1
X_08014_ _02382_ _02385_ _02386_ vssd1 vssd1 vccd1 vccd1 _02387_ sky130_fd_sc_hd__and3_1
XFILLER_0_71_196 vssd1 vssd1 vccd1 vccd1 sky130_fd_sc_hd__fill_1
X_05226_ _03979_ _03990_ _04011_ vssd1 vssd1 vccd1 vccd1 _04022_ sky130_fd_sc_hd__nand3_1
XFILLER_0_12_241 vssd1 vssd1 vccd1 vccd1 sky130_fd_sc_hd__fill_1
X_05157_ _03203_ _03214_ _03257_ vssd1 vssd1 vccd1 vccd1 _03268_ sky130_fd_sc_hd__or3b_4
XFILLER_0_8_85 vssd1 vssd1 vccd1 vccd1 sky130_fd_sc_hd__decap_4
X_09965_ _03310_ _04498_ vssd1 vssd1 vccd1 vccd1 _04499_ sky130_fd_sc_hd__xor2_1
X_05088_ net30 net608 net124 vssd1 vssd1 vccd1 vccd1 _00070_ sky130_fd_sc_hd__mux2_1
X_08916_ net119 _03220_ _03219_ vssd1 vssd1 vccd1 vccd1 _03353_ sky130_fd_sc_hd__o21ai_1
XTAP_970 vssd1 vccd1 sky130_fd_sc_hd__tapvpwrvgnd_1
X_09896_ _04401_ _04423_ vssd1 vssd1 vccd1 vccd1 _04424_ sky130_fd_sc_hd__or2_1
X_08847_ _03263_ _03264_ _03276_ vssd1 vssd1 vccd1 vccd1 _03277_ sky130_fd_sc_hd__nor3_1
XTAP_992 vssd1 vccd1 sky130_fd_sc_hd__tapvpwrvgnd_1
XTAP_981 vssd1 vccd1 sky130_fd_sc_hd__tapvpwrvgnd_1
X_08778_ _03035_ _03037_ vssd1 vssd1 vccd1 vccd1 _03202_ sky130_fd_sc_hd__nor2_1
X_07729_ _01833_ _01835_ _02099_ _02100_ vssd1 vssd1 vccd1 vccd1 _02101_ sky130_fd_sc_hd__a211oi_4
Xclkbuf_3_3_0_wb_clk_i clknet_0_wb_clk_i vssd1 vssd1 vccd1 vccd1 clknet_3_3_0_wb_clk_i
+ sky130_fd_sc_hd__clkbuf_8
XFILLER_0_82_417 vssd1 vssd1 vccd1 vccd1 sky130_fd_sc_hd__decap_3
XFILLER_0_62_141 vssd1 vssd1 vccd1 vccd1 sky130_fd_sc_hd__fill_2
XFILLER_0_101_482 vssd1 vssd1 vccd1 vccd1 sky130_ef_sc_hd__decap_12
X_10105_ clknet_3_2_0_wb_clk_i _00099_ _00035_ vssd1 vssd1 vccd1 vccd1 mul.a\[0\]
+ sky130_fd_sc_hd__dfrtp_4
X_10036_ net643 vssd1 vssd1 vccd1 vccd1 _00032_ sky130_fd_sc_hd__inv_2
XFILLER_0_58_447 vssd1 vssd1 vccd1 vccd1 sky130_fd_sc_hd__fill_1
XFILLER_0_73_428 vssd1 vssd1 vccd1 vccd1 sky130_fd_sc_hd__decap_4
XFILLER_0_38_193 vssd1 vssd1 vccd1 vccd1 sky130_fd_sc_hd__decap_3
XFILLER_0_81_461 vssd1 vssd1 vccd1 vccd1 sky130_ef_sc_hd__decap_12
XFILLER_0_100_3 vssd1 vssd1 vccd1 vccd1 sky130_ef_sc_hd__decap_12
X_06060_ _00437_ _00438_ vssd1 vssd1 vccd1 vccd1 _00439_ sky130_fd_sc_hd__nor2_1
XFILLER_0_30_98 vssd1 vssd1 vccd1 vccd1 sky130_fd_sc_hd__decap_4
XFILLER_0_22_550 vssd1 vssd1 vccd1 vccd1 sky130_ef_sc_hd__decap_12
Xfanout408 mul.b\[28\] vssd1 vssd1 vccd1 vccd1 net408 sky130_fd_sc_hd__clkbuf_2
Xfanout419 mul.b\[26\] vssd1 vssd1 vccd1 vccd1 net419 sky130_fd_sc_hd__clkbuf_2
XTAP_211 vssd1 vccd1 sky130_fd_sc_hd__tapvpwrvgnd_1
XTAP_233 vssd1 vccd1 sky130_fd_sc_hd__tapvpwrvgnd_1
XTAP_222 vssd1 vccd1 sky130_fd_sc_hd__tapvpwrvgnd_1
X_09750_ _04221_ _04264_ vssd1 vssd1 vccd1 vccd1 _04265_ sky130_fd_sc_hd__xor2_1
XTAP_266 vssd1 vccd1 sky130_fd_sc_hd__tapvpwrvgnd_1
XTAP_255 vssd1 vccd1 sky130_fd_sc_hd__tapvpwrvgnd_1
XTAP_244 vssd1 vccd1 sky130_fd_sc_hd__tapvpwrvgnd_1
X_06962_ _01331_ _01332_ _01194_ net668 vssd1 vssd1 vccd1 vccd1 _01334_ sky130_fd_sc_hd__a211oi_2
X_08701_ net215 net471 _03116_ _03117_ vssd1 vssd1 vccd1 vccd1 _03118_ sky130_fd_sc_hd__a22oi_1
XTAP_299 vssd1 vccd1 sky130_fd_sc_hd__tapvpwrvgnd_1
XTAP_288 vssd1 vccd1 sky130_fd_sc_hd__tapvpwrvgnd_1
XTAP_277 vssd1 vccd1 sky130_fd_sc_hd__tapvpwrvgnd_1
X_05913_ _00291_ _00292_ vssd1 vssd1 vccd1 vccd1 _00293_ sky130_fd_sc_hd__nand2b_1
X_09681_ _04176_ _04188_ vssd1 vssd1 vccd1 vccd1 _04189_ sky130_fd_sc_hd__and2_1
X_08632_ _02832_ _02871_ _03041_ _03042_ vssd1 vssd1 vccd1 vccd1 _03043_ sky130_fd_sc_hd__o211a_1
X_06893_ net234 net561 net567 net225 vssd1 vssd1 vccd1 vccd1 _01265_ sky130_fd_sc_hd__a22o_1
X_05844_ net305 net312 net562 net571 vssd1 vssd1 vccd1 vccd1 _00225_ sky130_fd_sc_hd__and4_2
X_08563_ _02957_ _02966_ vssd1 vssd1 vccd1 vccd1 _02967_ sky130_fd_sc_hd__and2_1
X_05775_ _00155_ _00156_ vssd1 vssd1 vccd1 vccd1 _00157_ sky130_fd_sc_hd__or2_1
XFILLER_0_49_403 vssd1 vssd1 vccd1 vccd1 sky130_fd_sc_hd__fill_2
X_08494_ _02882_ _02891_ vssd1 vssd1 vccd1 vccd1 _02892_ sky130_fd_sc_hd__xnor2_1
X_07514_ _01871_ _01885_ _01886_ vssd1 vssd1 vccd1 vccd1 _01887_ sky130_fd_sc_hd__and3_1
XFILLER_0_64_417 vssd1 vssd1 vccd1 vccd1 sky130_fd_sc_hd__decap_3
X_07445_ _01671_ _01673_ vssd1 vssd1 vccd1 vccd1 _01813_ sky130_fd_sc_hd__nand2_1
XFILLER_0_91_225 vssd1 vssd1 vccd1 vccd1 sky130_ef_sc_hd__decap_12
X_07376_ net250 net259 net508 net518 vssd1 vssd1 vccd1 vccd1 _01745_ sky130_fd_sc_hd__and4_1
XFILLER_0_17_333 vssd1 vssd1 vccd1 vccd1 sky130_fd_sc_hd__decap_3
XFILLER_0_44_141 vssd1 vssd1 vccd1 vccd1 sky130_fd_sc_hd__fill_2
X_09115_ _03567_ _03568_ _03569_ vssd1 vssd1 vccd1 vccd1 _03570_ sky130_fd_sc_hd__nand3_1
X_06327_ net84 _00702_ _00581_ _00583_ vssd1 vssd1 vccd1 vccd1 _00704_ sky130_fd_sc_hd__o211ai_2
X_09046_ _03492_ _03493_ _03299_ _03302_ vssd1 vssd1 vccd1 vccd1 _03495_ sky130_fd_sc_hd__a211oi_2
X_06258_ _00497_ _00634_ vssd1 vssd1 vccd1 vccd1 _00635_ sky130_fd_sc_hd__or2_1
X_05209_ _03476_ _03771_ _03826_ vssd1 vssd1 vccd1 vccd1 _03837_ sky130_fd_sc_hd__nand3_1
XFILLER_0_13_572 vssd1 vssd1 vccd1 vccd1 sky130_fd_sc_hd__decap_4
X_06189_ _00563_ _00564_ _00565_ vssd1 vssd1 vccd1 vccd1 _00567_ sky130_fd_sc_hd__a21o_1
XFILLER_0_40_380 vssd1 vssd1 vccd1 vccd1 sky130_ef_sc_hd__decap_12
X_09948_ _04476_ _04479_ vssd1 vssd1 vccd1 vccd1 _04480_ sky130_fd_sc_hd__xnor2_1
X_09879_ net138 _03510_ _02885_ vssd1 vssd1 vccd1 vccd1 _04406_ sky130_fd_sc_hd__mux2_1
XFILLER_0_95_531 vssd1 vssd1 vccd1 vccd1 sky130_fd_sc_hd__decap_8
XFILLER_0_95_564 vssd1 vssd1 vccd1 vccd1 sky130_ef_sc_hd__decap_12
XFILLER_0_55_406 vssd1 vssd1 vccd1 vccd1 sky130_fd_sc_hd__fill_1
XFILLER_0_67_288 vssd1 vssd1 vccd1 vccd1 sky130_fd_sc_hd__decap_3
XFILLER_0_82_269 vssd1 vssd1 vccd1 vccd1 sky130_fd_sc_hd__decap_4
XFILLER_0_51_623 vssd1 vssd1 vccd1 vccd1 sky130_fd_sc_hd__fill_2
XFILLER_0_35_163 vssd1 vssd1 vccd1 vccd1 sky130_fd_sc_hd__decap_4
XFILLER_0_23_347 vssd1 vssd1 vccd1 vccd1 sky130_fd_sc_hd__fill_1
XFILLER_0_35_185 vssd1 vssd1 vccd1 vccd1 sky130_fd_sc_hd__decap_6
XFILLER_0_31_380 vssd1 vssd1 vccd1 vccd1 sky130_ef_sc_hd__decap_12
X_10019_ net640 vssd1 vssd1 vccd1 vccd1 _00015_ sky130_fd_sc_hd__inv_2
X_05560_ _04824_ _04828_ _04829_ vssd1 vssd1 vccd1 vccd1 _04830_ sky130_fd_sc_hd__nand3_1
XFILLER_0_25_65 vssd1 vssd1 vccd1 vccd1 sky130_fd_sc_hd__decap_3
XFILLER_0_25_87 vssd1 vssd1 vccd1 vccd1 sky130_ef_sc_hd__decap_12
X_05491_ _04757_ _04758_ _04759_ vssd1 vssd1 vccd1 vccd1 _04761_ sky130_fd_sc_hd__a21o_1
X_07230_ net259 net269 net506 net515 vssd1 vssd1 vccd1 vccd1 _01600_ sky130_fd_sc_hd__and4_1
XFILLER_0_6_536 vssd1 vssd1 vccd1 vccd1 sky130_ef_sc_hd__decap_12
XFILLER_0_54_450 vssd1 vssd1 vccd1 vccd1 sky130_fd_sc_hd__decap_4
XFILLER_0_26_141 vssd1 vssd1 vccd1 vccd1 sky130_fd_sc_hd__fill_1
X_07161_ _01386_ _01390_ _01530_ vssd1 vssd1 vccd1 vccd1 _01531_ sky130_fd_sc_hd__a21oi_2
XFILLER_0_54_494 vssd1 vssd1 vccd1 vccd1 sky130_ef_sc_hd__decap_12
XFILLER_0_14_336 vssd1 vssd1 vccd1 vccd1 sky130_fd_sc_hd__fill_1
X_06112_ net262 net589 _00487_ _00488_ vssd1 vssd1 vccd1 vccd1 _00490_ sky130_fd_sc_hd__a22o_1
XFILLER_0_41_100 vssd1 vssd1 vccd1 vccd1 sky130_fd_sc_hd__decap_4
X_07092_ _01460_ _01461_ _01453_ vssd1 vssd1 vccd1 vccd1 _01463_ sky130_fd_sc_hd__a21o_1
XFILLER_0_1_241 vssd1 vssd1 vccd1 vccd1 sky130_fd_sc_hd__fill_2
X_06043_ net388 net463 vssd1 vssd1 vccd1 vccd1 _00422_ sky130_fd_sc_hd__nand2_1
XFILLER_0_41_188 vssd1 vssd1 vccd1 vccd1 sky130_fd_sc_hd__decap_3
Xfanout205 net206 vssd1 vssd1 vccd1 vccd1 net205 sky130_fd_sc_hd__buf_2
XFILLER_0_10_531 vssd1 vssd1 vccd1 vccd1 sky130_fd_sc_hd__fill_1
XFILLER_0_1_285 vssd1 vssd1 vccd1 vccd1 sky130_fd_sc_hd__fill_1
Xfanout216 net217 vssd1 vssd1 vccd1 vccd1 net216 sky130_fd_sc_hd__clkbuf_4
Xfanout238 mul.a\[18\] vssd1 vssd1 vccd1 vccd1 net238 sky130_fd_sc_hd__clkbuf_4
Xfanout227 net229 vssd1 vssd1 vccd1 vccd1 net227 sky130_fd_sc_hd__clkbuf_2
X_09802_ _04319_ _04320_ net162 net468 vssd1 vssd1 vccd1 vccd1 _04321_ sky130_fd_sc_hd__a2bb2o_1
X_07994_ net212 net528 _02363_ _02365_ vssd1 vssd1 vccd1 vccd1 _02367_ sky130_fd_sc_hd__and4_1
Xfanout249 net251 vssd1 vssd1 vccd1 vccd1 net249 sky130_fd_sc_hd__buf_2
X_09733_ net234 net411 _04243_ _04245_ vssd1 vssd1 vccd1 vccd1 _04246_ sky130_fd_sc_hd__a22oi_1
X_06945_ net269 net526 vssd1 vssd1 vccd1 vccd1 _01317_ sky130_fd_sc_hd__and2_1
X_06876_ net209 net591 _01245_ _01246_ vssd1 vssd1 vccd1 vccd1 _01248_ sky130_fd_sc_hd__a22o_1
X_09664_ _04168_ _04169_ vssd1 vssd1 vccd1 vccd1 _04170_ sky130_fd_sc_hd__xor2_1
X_08615_ net304 net415 _03021_ _03022_ vssd1 vssd1 vccd1 vccd1 _03024_ sky130_fd_sc_hd__nand4_2
X_09595_ _04093_ net411 net239 _04091_ vssd1 vssd1 vccd1 vccd1 _04095_ sky130_fd_sc_hd__and4b_1
X_05827_ _04993_ _04996_ vssd1 vssd1 vccd1 vccd1 _00208_ sky130_fd_sc_hd__or2_1
XTAP_1229 vssd1 vccd1 sky130_fd_sc_hd__tapvpwrvgnd_1
XTAP_1218 vssd1 vccd1 sky130_fd_sc_hd__tapvpwrvgnd_1
XTAP_1207 vssd1 vccd1 sky130_fd_sc_hd__tapvpwrvgnd_1
XFILLER_0_82_82 vssd1 vssd1 vccd1 vccd1 sky130_fd_sc_hd__fill_2
XFILLER_0_82_60 vssd1 vssd1 vccd1 vccd1 sky130_fd_sc_hd__decap_8
XFILLER_0_77_553 vssd1 vssd1 vccd1 vccd1 sky130_fd_sc_hd__decap_6
X_08546_ net515 _02947_ _02946_ vssd1 vssd1 vccd1 vccd1 _02948_ sky130_fd_sc_hd__a21bo_1
X_05758_ net356 net522 vssd1 vssd1 vccd1 vccd1 _00140_ sky130_fd_sc_hd__and2_1
X_08477_ _02832_ _02833_ _02869_ _02870_ vssd1 vssd1 vccd1 vccd1 _02873_ sky130_fd_sc_hd__a2bb2o_1
XFILLER_0_9_352 vssd1 vssd1 vccd1 vccd1 sky130_fd_sc_hd__fill_2
X_05689_ _04935_ _04958_ vssd1 vssd1 vccd1 vccd1 _04959_ sky130_fd_sc_hd__xnor2_1
XFILLER_0_9_385 vssd1 vssd1 vccd1 vccd1 sky130_fd_sc_hd__decap_6
X_07428_ net611 _01795_ _01794_ vssd1 vssd1 vccd1 vccd1 _01796_ sky130_fd_sc_hd__a21bo_1
X_07359_ _01725_ _01726_ vssd1 vssd1 vccd1 vccd1 _01728_ sky130_fd_sc_hd__xor2_1
XFILLER_0_60_442 vssd1 vssd1 vccd1 vccd1 sky130_ef_sc_hd__decap_12
XFILLER_0_17_196 vssd1 vssd1 vccd1 vccd1 sky130_fd_sc_hd__fill_2
X_09029_ _03466_ _03475_ vssd1 vssd1 vccd1 vccd1 _03477_ sky130_fd_sc_hd__xnor2_1
XFILLER_0_99_111 vssd1 vssd1 vccd1 vccd1 sky130_fd_sc_hd__fill_1
XFILLER_0_68_531 vssd1 vssd1 vccd1 vccd1 sky130_fd_sc_hd__fill_1
XFILLER_0_51_486 vssd1 vssd1 vccd1 vccd1 sky130_fd_sc_hd__fill_2
Xinput5 wbs_dat_i[0] vssd1 vssd1 vccd1 vccd1 net5 sky130_fd_sc_hd__clkbuf_1
X_06730_ _01101_ _01102_ vssd1 vssd1 vccd1 vccd1 _01103_ sky130_fd_sc_hd__xnor2_1
XFILLER_0_36_64 vssd1 vssd1 vccd1 vccd1 sky130_fd_sc_hd__fill_1
XFILLER_0_78_328 vssd1 vssd1 vccd1 vccd1 sky130_fd_sc_hd__fill_1
X_06661_ _01031_ _01032_ _01017_ vssd1 vssd1 vccd1 vccd1 _01035_ sky130_fd_sc_hd__a21o_1
XFILLER_0_36_97 vssd1 vssd1 vccd1 vccd1 sky130_fd_sc_hd__decap_8
XFILLER_0_78_339 vssd1 vssd1 vccd1 vccd1 sky130_fd_sc_hd__decap_8
X_08400_ _02785_ _02786_ _02788_ vssd1 vssd1 vccd1 vccd1 _02789_ sky130_fd_sc_hd__and3_2
X_05612_ _04842_ _04880_ vssd1 vssd1 vccd1 vccd1 _04882_ sky130_fd_sc_hd__xnor2_2
X_09380_ _03859_ vssd1 vssd1 vccd1 vccd1 _03860_ sky130_fd_sc_hd__inv_2
X_06592_ net73 _00962_ _00965_ vssd1 vssd1 vccd1 vccd1 _00966_ sky130_fd_sc_hd__a21o_1
X_08331_ net601 net610 net150 vssd1 vssd1 vccd1 vccd1 _02714_ sky130_fd_sc_hd__o21ai_1
X_05543_ _04749_ _04811_ vssd1 vssd1 vccd1 vccd1 _04813_ sky130_fd_sc_hd__xnor2_2
X_08262_ _02501_ net112 _02636_ _02637_ vssd1 vssd1 vccd1 vccd1 _02638_ sky130_fd_sc_hd__o211ai_4
XFILLER_0_52_85 vssd1 vssd1 vccd1 vccd1 sky130_fd_sc_hd__fill_1
X_05474_ _04680_ _04742_ _04743_ vssd1 vssd1 vccd1 vccd1 _04744_ sky130_fd_sc_hd__and3_1
X_07213_ _01574_ _01582_ vssd1 vssd1 vccd1 vccd1 _01583_ sky130_fd_sc_hd__or2_1
XFILLER_0_6_322 vssd1 vssd1 vccd1 vccd1 sky130_ef_sc_hd__decap_12
X_08193_ _02563_ _02564_ _02559_ vssd1 vssd1 vccd1 vccd1 _02566_ sky130_fd_sc_hd__a21o_1
XFILLER_0_14_133 vssd1 vssd1 vccd1 vccd1 sky130_fd_sc_hd__decap_6
X_07144_ _01512_ _01513_ vssd1 vssd1 vccd1 vccd1 _01514_ sky130_fd_sc_hd__nor2_1
XFILLER_0_72_3 vssd1 vssd1 vccd1 vccd1 sky130_ef_sc_hd__decap_12
X_07075_ _01439_ _01444_ vssd1 vssd1 vccd1 vccd1 _01446_ sky130_fd_sc_hd__xnor2_1
XFILLER_0_2_550 vssd1 vssd1 vccd1 vccd1 sky130_fd_sc_hd__fill_1
XFILLER_0_42_486 vssd1 vssd1 vccd1 vccd1 sky130_fd_sc_hd__fill_1
X_06026_ _00402_ _00403_ vssd1 vssd1 vccd1 vccd1 _00405_ sky130_fd_sc_hd__xor2_1
XFILLER_0_77_60 vssd1 vssd1 vccd1 vccd1 sky130_fd_sc_hd__decap_8
X_07977_ _02347_ _02348_ _02198_ _02200_ vssd1 vssd1 vccd1 vccd1 _02350_ sky130_fd_sc_hd__o211ai_2
X_09716_ _04226_ vssd1 vssd1 vccd1 vccd1 _04227_ sky130_fd_sc_hd__inv_2
X_06928_ _01297_ _01298_ _01282_ vssd1 vssd1 vccd1 vccd1 _01300_ sky130_fd_sc_hd__a21o_1
XFILLER_0_97_615 vssd1 vssd1 vccd1 vccd1 sky130_fd_sc_hd__fill_1
X_09647_ net121 _04000_ _03999_ vssd1 vssd1 vccd1 vccd1 _04152_ sky130_fd_sc_hd__a21o_1
XTAP_1004 vssd1 vccd1 sky130_fd_sc_hd__tapvpwrvgnd_1
X_06859_ _01229_ _01230_ vssd1 vssd1 vccd1 vccd1 _01231_ sky130_fd_sc_hd__xnor2_1
XTAP_1037 vssd1 vccd1 sky130_fd_sc_hd__tapvpwrvgnd_1
XTAP_1026 vssd1 vccd1 sky130_fd_sc_hd__tapvpwrvgnd_1
XTAP_1015 vssd1 vccd1 sky130_fd_sc_hd__tapvpwrvgnd_1
X_09578_ net248 net257 net400 net407 vssd1 vssd1 vccd1 vccd1 _04076_ sky130_fd_sc_hd__and4_1
XTAP_1059 vssd1 vccd1 sky130_fd_sc_hd__tapvpwrvgnd_1
XTAP_1048 vssd1 vccd1 sky130_fd_sc_hd__tapvpwrvgnd_1
X_08529_ _02282_ _02929_ _02928_ vssd1 vssd1 vccd1 vccd1 _02931_ sky130_fd_sc_hd__o21ba_1
XFILLER_0_65_512 vssd1 vssd1 vccd1 vccd1 sky130_fd_sc_hd__decap_4
XFILLER_0_37_247 vssd1 vssd1 vccd1 vccd1 sky130_fd_sc_hd__decap_8
XFILLER_0_52_239 vssd1 vssd1 vccd1 vccd1 sky130_fd_sc_hd__decap_3
XFILLER_0_33_464 vssd1 vssd1 vccd1 vccd1 sky130_fd_sc_hd__fill_2
XFILLER_0_60_272 vssd1 vssd1 vccd1 vccd1 sky130_fd_sc_hd__fill_2
Xfanout591 net592 vssd1 vssd1 vccd1 vccd1 net591 sky130_fd_sc_hd__clkbuf_4
Xfanout580 net581 vssd1 vssd1 vccd1 vccd1 net580 sky130_fd_sc_hd__clkbuf_4
XFILLER_0_73_29 vssd1 vssd1 vccd1 vccd1 sky130_fd_sc_hd__fill_2
XFILLER_0_87_169 vssd1 vssd1 vccd1 vccd1 sky130_fd_sc_hd__decap_3
XFILLER_0_22_11 vssd1 vssd1 vccd1 vccd1 sky130_fd_sc_hd__fill_1
XFILLER_0_22_22 vssd1 vssd1 vccd1 vccd1 sky130_fd_sc_hd__fill_2
XFILLER_0_28_258 vssd1 vssd1 vccd1 vccd1 sky130_fd_sc_hd__decap_4
XFILLER_0_56_589 vssd1 vssd1 vccd1 vccd1 sky130_fd_sc_hd__decap_4
XFILLER_0_98_15 vssd1 vssd1 vccd1 vccd1 sky130_ef_sc_hd__decap_12
XFILLER_0_71_559 vssd1 vssd1 vccd1 vccd1 sky130_fd_sc_hd__fill_1
XFILLER_0_98_37 vssd1 vssd1 vccd1 vccd1 sky130_fd_sc_hd__decap_3
X_05190_ _03399_ _03618_ _03290_ _03301_ vssd1 vssd1 vccd1 vccd1 _03629_ sky130_fd_sc_hd__o211ai_4
XFILLER_0_3_347 vssd1 vssd1 vccd1 vccd1 sky130_ef_sc_hd__decap_12
XFILLER_0_11_169 vssd1 vssd1 vccd1 vccd1 sky130_fd_sc_hd__decap_8
X_08880_ _03310_ _03311_ net136 net326 vssd1 vssd1 vccd1 vccd1 _03314_ sky130_fd_sc_hd__o22a_1
X_07900_ _02271_ _02272_ _02103_ _02105_ vssd1 vssd1 vccd1 vccd1 _02274_ sky130_fd_sc_hd__a211o_1
X_07831_ net290 net459 net466 net282 vssd1 vssd1 vccd1 vccd1 _02202_ sky130_fd_sc_hd__a22o_1
X_09501_ _03810_ net711 vssd1 vssd1 vccd1 vccd1 _03993_ sky130_fd_sc_hd__nor2_2
X_07762_ _02131_ _02132_ vssd1 vssd1 vccd1 vccd1 _02133_ sky130_fd_sc_hd__and2_1
X_07693_ _02057_ _02064_ vssd1 vssd1 vccd1 vccd1 _02065_ sky130_fd_sc_hd__xnor2_2
X_06713_ net672 _00949_ _01085_ _01086_ vssd1 vssd1 vccd1 vccd1 _01087_ sky130_fd_sc_hd__o211a_1
X_09432_ _03745_ net718 vssd1 vssd1 vccd1 vccd1 _03917_ sky130_fd_sc_hd__nor2_2
X_06644_ net373 net382 net434 net440 vssd1 vssd1 vccd1 vccd1 _01018_ sky130_fd_sc_hd__and4_1
X_09363_ _03840_ _03841_ vssd1 vssd1 vccd1 vccd1 _03842_ sky130_fd_sc_hd__nand2_1
XFILLER_0_93_106 vssd1 vssd1 vccd1 vccd1 sky130_fd_sc_hd__decap_6
XPHY_109 vssd1 vssd1 vccd1 vccd1 sky130_fd_sc_hd__decap_3
X_06575_ _00947_ _00948_ _00753_ _00756_ vssd1 vssd1 vccd1 vccd1 _00950_ sky130_fd_sc_hd__o211a_1
X_08314_ _02692_ _02693_ _02685_ vssd1 vssd1 vccd1 vccd1 _02695_ sky130_fd_sc_hd__a21o_1
XFILLER_0_74_342 vssd1 vssd1 vccd1 vccd1 sky130_fd_sc_hd__fill_1
X_05526_ _04793_ _04794_ _04795_ vssd1 vssd1 vccd1 vccd1 _04796_ sky130_fd_sc_hd__and3_1
XANTENNA_10 net326 vssd1 vssd1 vccd1 vccd1 sky130_fd_sc_hd__diode_2
X_09294_ _03613_ _03615_ _03764_ _03765_ vssd1 vssd1 vccd1 vccd1 _03766_ sky130_fd_sc_hd__a211oi_2
XFILLER_0_62_504 vssd1 vssd1 vccd1 vccd1 sky130_fd_sc_hd__fill_2
X_08245_ _02610_ _02611_ _02617_ vssd1 vssd1 vccd1 vccd1 _02619_ sky130_fd_sc_hd__a21o_1
X_05457_ _04723_ _04726_ vssd1 vssd1 vccd1 vccd1 _04727_ sky130_fd_sc_hd__xor2_1
X_08176_ net351 net403 mul.b\[28\] net341 vssd1 vssd1 vccd1 vccd1 _02548_ sky130_fd_sc_hd__a22o_1
X_05388_ net385 net606 net615 net378 vssd1 vssd1 vccd1 vccd1 _04658_ sky130_fd_sc_hd__a22o_1
X_07127_ _01355_ _01491_ vssd1 vssd1 vccd1 vccd1 _01497_ sky130_fd_sc_hd__nand2_1
XFILLER_0_100_333 vssd1 vssd1 vccd1 vccd1 sky130_fd_sc_hd__decap_3
X_07058_ _01426_ _01427_ net342 net451 vssd1 vssd1 vccd1 vccd1 _01429_ sky130_fd_sc_hd__and4bb_1
XFILLER_0_30_467 vssd1 vssd1 vccd1 vccd1 sky130_fd_sc_hd__decap_8
X_06009_ _00324_ _00386_ _00387_ vssd1 vssd1 vccd1 vccd1 _00388_ sky130_fd_sc_hd__nand3_1
XFILLER_0_69_125 vssd1 vssd1 vccd1 vccd1 sky130_fd_sc_hd__decap_6
Xmax_cap78 net79 vssd1 vssd1 vccd1 vccd1 net78 sky130_fd_sc_hd__clkbuf_1
XFILLER_0_69_169 vssd1 vssd1 vccd1 vccd1 sky130_fd_sc_hd__decap_8
XFILLER_0_84_128 vssd1 vssd1 vccd1 vccd1 sky130_fd_sc_hd__decap_4
XFILLER_0_84_106 vssd1 vssd1 vccd1 vccd1 sky130_fd_sc_hd__decap_8
Xmax_cap89 _01134_ vssd1 vssd1 vccd1 vccd1 net89 sky130_fd_sc_hd__clkbuf_2
XFILLER_0_38_523 vssd1 vssd1 vccd1 vccd1 sky130_fd_sc_hd__decap_4
XFILLER_0_65_342 vssd1 vssd1 vccd1 vccd1 sky130_fd_sc_hd__fill_1
XFILLER_0_38_567 vssd1 vssd1 vccd1 vccd1 sky130_fd_sc_hd__decap_4
XFILLER_0_61_581 vssd1 vssd1 vccd1 vccd1 sky130_fd_sc_hd__fill_2
XFILLER_0_21_434 vssd1 vssd1 vccd1 vccd1 sky130_ef_sc_hd__decap_12
XTAP_607 vssd1 vccd1 sky130_fd_sc_hd__tapvpwrvgnd_1
XTAP_618 vssd1 vccd1 sky130_fd_sc_hd__tapvpwrvgnd_1
XTAP_629 vssd1 vccd1 sky130_fd_sc_hd__tapvpwrvgnd_1
XFILLER_0_17_44 vssd1 vssd1 vccd1 vccd1 sky130_fd_sc_hd__fill_1
XFILLER_0_48_309 vssd1 vssd1 vccd1 vccd1 sky130_fd_sc_hd__decap_3
XFILLER_0_75_128 vssd1 vssd1 vccd1 vccd1 sky130_ef_sc_hd__decap_12
XFILLER_0_29_534 vssd1 vssd1 vccd1 vccd1 sky130_fd_sc_hd__fill_1
XFILLER_0_29_556 vssd1 vssd1 vccd1 vccd1 sky130_fd_sc_hd__decap_4
X_06360_ net252 net280 net554 net580 vssd1 vssd1 vccd1 vccd1 _00736_ sky130_fd_sc_hd__nand4_2
XFILLER_0_33_87 vssd1 vssd1 vccd1 vccd1 sky130_fd_sc_hd__decap_4
XFILLER_0_33_98 vssd1 vssd1 vccd1 vccd1 sky130_fd_sc_hd__decap_4
X_05311_ _03924_ _03935_ _03946_ vssd1 vssd1 vccd1 vccd1 _04581_ sky130_fd_sc_hd__a21o_1
X_06291_ _00659_ _00667_ vssd1 vssd1 vccd1 vccd1 _00668_ sky130_fd_sc_hd__xor2_2
X_08030_ net274 net282 net459 net466 vssd1 vssd1 vccd1 vccd1 _02403_ sky130_fd_sc_hd__and4_1
XFILLER_0_3_111 vssd1 vssd1 vccd1 vccd1 sky130_fd_sc_hd__fill_1
X_05242_ net319 net327 net594 net604 vssd1 vssd1 vccd1 vccd1 _04197_ sky130_fd_sc_hd__nand4_1
Xinput30 wbs_dat_i[3] vssd1 vssd1 vccd1 vccd1 net30 sky130_fd_sc_hd__clkbuf_1
XFILLER_0_3_122 vssd1 vssd1 vccd1 vccd1 sky130_fd_sc_hd__fill_1
XFILLER_0_24_261 vssd1 vssd1 vccd1 vccd1 sky130_fd_sc_hd__fill_2
X_05173_ net352 net361 net595 net605 vssd1 vssd1 vccd1 vccd1 _03443_ sky130_fd_sc_hd__nand4_1
XFILLER_0_12_467 vssd1 vssd1 vccd1 vccd1 sky130_fd_sc_hd__fill_1
X_09981_ net242 net397 vssd1 vssd1 vccd1 vccd1 _04517_ sky130_fd_sc_hd__nand2_1
X_08932_ _03369_ _03370_ vssd1 vssd1 vccd1 vccd1 _03371_ sky130_fd_sc_hd__or2_1
X_08863_ _03293_ _03294_ vssd1 vssd1 vccd1 vccd1 _03295_ sky130_fd_sc_hd__nand2_2
XFILLER_0_35_3 vssd1 vssd1 vccd1 vccd1 sky130_ef_sc_hd__decap_12
X_08794_ _03217_ _03218_ vssd1 vssd1 vccd1 vccd1 _03220_ sky130_fd_sc_hd__xnor2_1
X_07814_ _02016_ _02023_ _02022_ vssd1 vssd1 vccd1 vccd1 _02185_ sky130_fd_sc_hd__a21bo_1
X_07745_ _01964_ _01967_ vssd1 vssd1 vccd1 vccd1 _02116_ sky130_fd_sc_hd__or2_1
X_07676_ _02044_ _02045_ _02046_ vssd1 vssd1 vccd1 vccd1 _02048_ sky130_fd_sc_hd__a21o_1
X_09415_ _03896_ _03897_ vssd1 vssd1 vccd1 vccd1 _03898_ sky130_fd_sc_hd__nand2_1
XFILLER_0_66_128 vssd1 vssd1 vccd1 vccd1 sky130_fd_sc_hd__fill_1
XFILLER_0_59_180 vssd1 vssd1 vccd1 vccd1 sky130_ef_sc_hd__decap_12
X_06627_ _00985_ _00999_ vssd1 vssd1 vccd1 vccd1 _01001_ sky130_fd_sc_hd__and2_1
XFILLER_0_47_331 vssd1 vssd1 vccd1 vccd1 sky130_fd_sc_hd__fill_1
X_09346_ _03677_ _03679_ _03676_ vssd1 vssd1 vccd1 vccd1 _03823_ sky130_fd_sc_hd__a21o_1
X_06558_ _00929_ _00930_ _00912_ vssd1 vssd1 vccd1 vccd1 _00933_ sky130_fd_sc_hd__a21oi_1
X_09277_ net222 net436 net442 net216 vssd1 vssd1 vccd1 vccd1 _03747_ sky130_fd_sc_hd__a22o_1
X_05509_ _04769_ _04777_ _04778_ vssd1 vssd1 vccd1 vccd1 _04779_ sky130_fd_sc_hd__or3_2
X_06489_ _00759_ _00862_ _00863_ vssd1 vssd1 vccd1 vccd1 _00864_ sky130_fd_sc_hd__nand3_1
X_08228_ _02597_ _02600_ vssd1 vssd1 vccd1 vccd1 _02602_ sky130_fd_sc_hd__nand2b_1
XFILLER_0_50_529 vssd1 vssd1 vccd1 vccd1 sky130_fd_sc_hd__decap_3
X_08159_ _02528_ _02529_ _02523_ vssd1 vssd1 vccd1 vccd1 _02531_ sky130_fd_sc_hd__a21o_1
XFILLER_0_30_231 vssd1 vssd1 vccd1 vccd1 sky130_fd_sc_hd__decap_4
XFILLER_0_100_141 vssd1 vssd1 vccd1 vccd1 sky130_fd_sc_hd__decap_3
X_10121_ clknet_3_6_0_wb_clk_i _00115_ _00051_ vssd1 vssd1 vccd1 vccd1 mul.a\[16\]
+ sky130_fd_sc_hd__dfrtp_4
X_10052_ net640 vssd1 vssd1 vccd1 vccd1 _00048_ sky130_fd_sc_hd__inv_2
XFILLER_0_97_231 vssd1 vssd1 vccd1 vccd1 sky130_fd_sc_hd__decap_8
XFILLER_0_53_389 vssd1 vssd1 vccd1 vccd1 sky130_fd_sc_hd__decap_3
XFILLER_0_80_197 vssd1 vssd1 vccd1 vccd1 sky130_fd_sc_hd__decap_6
XFILLER_0_0_125 vssd1 vssd1 vccd1 vccd1 sky130_fd_sc_hd__decap_8
XTAP_404 vssd1 vccd1 sky130_fd_sc_hd__tapvpwrvgnd_1
XTAP_415 vssd1 vccd1 sky130_fd_sc_hd__tapvpwrvgnd_1
XFILLER_0_21_275 vssd1 vssd1 vccd1 vccd1 sky130_fd_sc_hd__decap_4
XTAP_437 vssd1 vccd1 sky130_fd_sc_hd__tapvpwrvgnd_1
XTAP_426 vssd1 vccd1 sky130_fd_sc_hd__tapvpwrvgnd_1
XTAP_448 vssd1 vccd1 sky130_fd_sc_hd__tapvpwrvgnd_1
XTAP_459 vssd1 vccd1 sky130_fd_sc_hd__tapvpwrvgnd_1
X_05860_ net337 net531 net541 net329 vssd1 vssd1 vccd1 vccd1 _00241_ sky130_fd_sc_hd__a22o_1
X_05791_ _00171_ _00172_ vssd1 vssd1 vccd1 vccd1 _00173_ sky130_fd_sc_hd__nand2_1
X_07530_ net246 net255 net508 net518 vssd1 vssd1 vccd1 vccd1 _01903_ sky130_fd_sc_hd__nand4_1
XFILLER_0_44_97 vssd1 vssd1 vccd1 vccd1 sky130_ef_sc_hd__decap_12
X_07461_ _01811_ _01826_ _01829_ vssd1 vssd1 vccd1 vccd1 _01830_ sky130_fd_sc_hd__or3_4
X_09200_ _03626_ _03627_ _03659_ _03660_ vssd1 vssd1 vccd1 vccd1 _03664_ sky130_fd_sc_hd__o22ai_2
XFILLER_0_91_407 vssd1 vssd1 vccd1 vccd1 sky130_fd_sc_hd__decap_4
X_07392_ _01604_ _01612_ _01611_ vssd1 vssd1 vccd1 vccd1 _01761_ sky130_fd_sc_hd__a21bo_1
X_06412_ _00781_ _00786_ vssd1 vssd1 vccd1 vccd1 _00788_ sky130_fd_sc_hd__xnor2_2
X_09131_ net192 net472 _03586_ _03587_ vssd1 vssd1 vccd1 vccd1 _03588_ sky130_fd_sc_hd__a22oi_1
X_06343_ net236 net597 net608 net227 vssd1 vssd1 vccd1 vccd1 _00719_ sky130_fd_sc_hd__a22o_1
X_09062_ _03511_ _03512_ vssd1 vssd1 vccd1 vccd1 _03513_ sky130_fd_sc_hd__and2_1
XFILLER_0_60_85 vssd1 vssd1 vccd1 vccd1 sky130_fd_sc_hd__fill_2
X_06274_ _00648_ _00650_ net387 net447 vssd1 vssd1 vccd1 vccd1 _00651_ sky130_fd_sc_hd__and4b_1
XFILLER_0_32_529 vssd1 vssd1 vccd1 vccd1 sky130_fd_sc_hd__decap_3
X_08013_ net264 net476 _02383_ _02384_ vssd1 vssd1 vccd1 vccd1 _02386_ sky130_fd_sc_hd__nand4_1
XFILLER_0_8_75 vssd1 vssd1 vccd1 vccd1 sky130_fd_sc_hd__decap_8
X_05225_ _03083_ _04001_ vssd1 vssd1 vccd1 vccd1 _04011_ sky130_fd_sc_hd__nor2_1
X_05156_ _03225_ _03246_ vssd1 vssd1 vccd1 vccd1 _03257_ sky130_fd_sc_hd__and2_1
XFILLER_0_40_584 vssd1 vssd1 vccd1 vccd1 sky130_fd_sc_hd__fill_1
X_05087_ net31 net597 net124 vssd1 vssd1 vccd1 vccd1 _00071_ sky130_fd_sc_hd__mux2_1
X_09964_ net225 net411 _04380_ _04379_ vssd1 vssd1 vccd1 vccd1 _04498_ sky130_fd_sc_hd__a31o_1
X_08915_ _03349_ _03350_ _03156_ _03196_ vssd1 vssd1 vccd1 vccd1 _03352_ sky130_fd_sc_hd__a211oi_1
XTAP_971 vssd1 vccd1 sky130_fd_sc_hd__tapvpwrvgnd_1
XTAP_960 vssd1 vccd1 sky130_fd_sc_hd__tapvpwrvgnd_1
X_09895_ _04402_ _04422_ vssd1 vssd1 vccd1 vccd1 _04423_ sky130_fd_sc_hd__xnor2_1
X_08846_ _03265_ _03274_ vssd1 vssd1 vccd1 vccd1 _03276_ sky130_fd_sc_hd__xnor2_1
XTAP_993 vssd1 vccd1 sky130_fd_sc_hd__tapvpwrvgnd_1
XTAP_982 vssd1 vccd1 sky130_fd_sc_hd__tapvpwrvgnd_1
XFILLER_0_99_529 vssd1 vssd1 vccd1 vccd1 sky130_fd_sc_hd__fill_1
X_08777_ _03065_ net119 _03064_ vssd1 vssd1 vccd1 vccd1 _03201_ sky130_fd_sc_hd__o21ai_1
X_05989_ _00222_ _00367_ _00368_ vssd1 vssd1 vccd1 vccd1 _00369_ sky130_fd_sc_hd__and3_1
X_07728_ _02097_ _02098_ _01933_ _01935_ vssd1 vssd1 vccd1 vccd1 _02100_ sky130_fd_sc_hd__a211oi_2
XFILLER_0_94_234 vssd1 vssd1 vccd1 vccd1 sky130_fd_sc_hd__fill_2
X_07659_ _02027_ _02029_ _02015_ vssd1 vssd1 vccd1 vccd1 _02031_ sky130_fd_sc_hd__o21ai_2
X_09329_ _03801_ _03802_ _03617_ _03620_ vssd1 vssd1 vccd1 vccd1 _03805_ sky130_fd_sc_hd__a211oi_2
XFILLER_0_82_429 vssd1 vssd1 vccd1 vccd1 sky130_ef_sc_hd__decap_12
XFILLER_0_75_481 vssd1 vssd1 vccd1 vccd1 sky130_fd_sc_hd__fill_1
XFILLER_0_62_131 vssd1 vssd1 vccd1 vccd1 sky130_fd_sc_hd__fill_1
XFILLER_0_35_334 vssd1 vssd1 vccd1 vccd1 sky130_fd_sc_hd__fill_2
XFILLER_0_62_197 vssd1 vssd1 vccd1 vccd1 sky130_fd_sc_hd__fill_1
XFILLER_0_101_461 vssd1 vssd1 vccd1 vccd1 sky130_ef_sc_hd__decap_12
XFILLER_0_101_494 vssd1 vssd1 vccd1 vccd1 sky130_fd_sc_hd__decap_6
X_10104_ clknet_3_2_0_wb_clk_i _00001_ vssd1 vssd1 vccd1 vccd1 val_b_reg.wb_helper.wbs_ack_o
+ sky130_fd_sc_hd__dfxtp_1
X_10035_ net643 vssd1 vssd1 vccd1 vccd1 _00031_ sky130_fd_sc_hd__inv_2
XFILLER_0_98_562 vssd1 vssd1 vccd1 vccd1 sky130_fd_sc_hd__decap_3
XFILLER_0_30_11 vssd1 vssd1 vccd1 vccd1 sky130_fd_sc_hd__fill_2
XFILLER_0_81_473 vssd1 vssd1 vccd1 vccd1 sky130_fd_sc_hd__decap_8
XFILLER_0_30_55 vssd1 vssd1 vccd1 vccd1 sky130_fd_sc_hd__decap_6
XFILLER_0_81_495 vssd1 vssd1 vccd1 vccd1 sky130_fd_sc_hd__fill_2
XFILLER_0_1_456 vssd1 vssd1 vccd1 vccd1 sky130_fd_sc_hd__fill_1
XFILLER_0_1_467 vssd1 vssd1 vccd1 vccd1 sky130_fd_sc_hd__decap_3
Xfanout409 net410 vssd1 vssd1 vccd1 vccd1 net409 sky130_fd_sc_hd__buf_4
XTAP_212 vssd1 vccd1 sky130_fd_sc_hd__tapvpwrvgnd_1
XTAP_223 vssd1 vccd1 sky130_fd_sc_hd__tapvpwrvgnd_1
XFILLER_0_39_75 vssd1 vssd1 vccd1 vccd1 sky130_fd_sc_hd__decap_3
XTAP_256 vssd1 vccd1 sky130_fd_sc_hd__tapvpwrvgnd_1
XTAP_234 vssd1 vccd1 sky130_fd_sc_hd__tapvpwrvgnd_1
XTAP_245 vssd1 vccd1 sky130_fd_sc_hd__tapvpwrvgnd_1
X_06961_ _01194_ _01196_ _01331_ _01332_ vssd1 vssd1 vccd1 vccd1 _01333_ sky130_fd_sc_hd__o211a_1
X_08700_ net201 net207 net480 net489 vssd1 vssd1 vccd1 vccd1 _03117_ sky130_fd_sc_hd__nand4_1
XTAP_289 vssd1 vccd1 sky130_fd_sc_hd__tapvpwrvgnd_1
XTAP_278 vssd1 vccd1 sky130_fd_sc_hd__tapvpwrvgnd_1
XTAP_267 vssd1 vccd1 sky130_fd_sc_hd__tapvpwrvgnd_1
X_05912_ _00186_ _00188_ vssd1 vssd1 vccd1 vccd1 _00292_ sky130_fd_sc_hd__nand2_1
X_09680_ _04177_ _04185_ vssd1 vssd1 vccd1 vccd1 _04188_ sky130_fd_sc_hd__xnor2_1
X_08631_ _02999_ _03000_ _03037_ _03038_ vssd1 vssd1 vccd1 vccd1 _03042_ sky130_fd_sc_hd__o22ai_2
X_06892_ _01225_ _01262_ vssd1 vssd1 vccd1 vccd1 _01264_ sky130_fd_sc_hd__xor2_1
X_05843_ net312 net562 net570 net305 vssd1 vssd1 vccd1 vccd1 _00224_ sky130_fd_sc_hd__a22oi_2
X_08562_ _02958_ _02964_ vssd1 vssd1 vccd1 vccd1 _02966_ sky130_fd_sc_hd__xnor2_1
X_05774_ _00153_ _00154_ _00131_ vssd1 vssd1 vccd1 vccd1 _00156_ sky130_fd_sc_hd__a21oi_1
X_08493_ _02887_ _02889_ vssd1 vssd1 vccd1 vccd1 _02891_ sky130_fd_sc_hd__or2_1
X_07513_ _01883_ _01884_ _01876_ vssd1 vssd1 vccd1 vccd1 _01886_ sky130_fd_sc_hd__a21o_1
X_07444_ _01545_ _01674_ _01676_ vssd1 vssd1 vccd1 vccd1 _01812_ sky130_fd_sc_hd__o21ai_2
XFILLER_0_91_237 vssd1 vssd1 vccd1 vccd1 sky130_fd_sc_hd__decap_4
XFILLER_0_71_84 vssd1 vssd1 vccd1 vccd1 sky130_fd_sc_hd__fill_1
XFILLER_0_9_556 vssd1 vssd1 vccd1 vccd1 sky130_fd_sc_hd__decap_4
X_07375_ _01735_ _01743_ vssd1 vssd1 vccd1 vccd1 _01744_ sky130_fd_sc_hd__xnor2_1
X_09114_ _03400_ _03402_ _03401_ vssd1 vssd1 vccd1 vccd1 _03569_ sky130_fd_sc_hd__a21bo_1
X_06326_ _00581_ _00583_ net84 _00702_ vssd1 vssd1 vccd1 vccd1 _00703_ sky130_fd_sc_hd__a211o_1
X_09045_ _03299_ _03302_ _03492_ _03493_ vssd1 vssd1 vccd1 vccd1 _03494_ sky130_fd_sc_hd__o211a_1
X_06257_ _00632_ _00633_ vssd1 vssd1 vccd1 vccd1 _00634_ sky130_fd_sc_hd__nand2_1
XFILLER_0_44_197 vssd1 vssd1 vccd1 vccd1 sky130_fd_sc_hd__fill_1
XFILLER_0_4_283 vssd1 vssd1 vccd1 vccd1 sky130_fd_sc_hd__fill_1
X_05208_ _03793_ _03804_ _03782_ vssd1 vssd1 vccd1 vccd1 _03826_ sky130_fd_sc_hd__a21bo_1
X_06188_ _00563_ _00564_ _00565_ vssd1 vssd1 vccd1 vccd1 _00566_ sky130_fd_sc_hd__nand3_4
X_05139_ net344 net585 _03039_ _03050_ vssd1 vssd1 vccd1 vccd1 _03072_ sky130_fd_sc_hd__a22o_1
XFILLER_0_40_392 vssd1 vssd1 vccd1 vccd1 sky130_fd_sc_hd__fill_1
X_09947_ _04477_ _04478_ vssd1 vssd1 vccd1 vccd1 _04479_ sky130_fd_sc_hd__xnor2_1
XFILLER_0_99_337 vssd1 vssd1 vccd1 vccd1 sky130_fd_sc_hd__decap_8
XFILLER_0_99_326 vssd1 vssd1 vccd1 vccd1 sky130_fd_sc_hd__fill_2
X_09878_ _02885_ _03510_ vssd1 vssd1 vccd1 vccd1 _04404_ sky130_fd_sc_hd__nand2_1
XTAP_790 vssd1 vccd1 sky130_fd_sc_hd__tapvpwrvgnd_1
X_08829_ net184 net499 vssd1 vssd1 vccd1 vccd1 _03258_ sky130_fd_sc_hd__nand2_1
XFILLER_0_95_576 vssd1 vssd1 vccd1 vccd1 sky130_fd_sc_hd__fill_2
XFILLER_0_2_209 vssd1 vssd1 vccd1 vccd1 sky130_ef_sc_hd__decap_12
XFILLER_0_50_189 vssd1 vssd1 vccd1 vccd1 sky130_fd_sc_hd__decap_3
XFILLER_0_31_370 vssd1 vssd1 vccd1 vccd1 sky130_fd_sc_hd__decap_3
XFILLER_0_76_18 vssd1 vssd1 vccd1 vccd1 sky130_fd_sc_hd__decap_6
X_10018_ net639 vssd1 vssd1 vccd1 vccd1 _00014_ sky130_fd_sc_hd__inv_2
XFILLER_0_86_510 vssd1 vssd1 vccd1 vccd1 sky130_ef_sc_hd__decap_12
XFILLER_0_25_55 vssd1 vssd1 vccd1 vccd1 sky130_fd_sc_hd__fill_1
XFILLER_0_25_99 vssd1 vssd1 vccd1 vccd1 sky130_ef_sc_hd__decap_12
X_05490_ _04757_ _04758_ _04759_ vssd1 vssd1 vccd1 vccd1 _04760_ sky130_fd_sc_hd__and3_1
XFILLER_0_46_418 vssd1 vssd1 vccd1 vccd1 sky130_fd_sc_hd__fill_2
XFILLER_0_41_54 vssd1 vssd1 vccd1 vccd1 sky130_fd_sc_hd__fill_2
XFILLER_0_6_548 vssd1 vssd1 vccd1 vccd1 sky130_fd_sc_hd__decap_6
X_07160_ _01527_ _01528_ vssd1 vssd1 vccd1 vccd1 _01530_ sky130_fd_sc_hd__xor2_1
X_07091_ _01453_ _01460_ _01461_ vssd1 vssd1 vccd1 vccd1 _01462_ sky130_fd_sc_hd__nand3_1
X_06111_ net262 net589 _00487_ _00488_ vssd1 vssd1 vccd1 vccd1 _00489_ sky130_fd_sc_hd__nand4_2
XFILLER_0_26_197 vssd1 vssd1 vccd1 vccd1 sky130_fd_sc_hd__decap_4
X_06042_ _00229_ _00332_ _00331_ vssd1 vssd1 vccd1 vccd1 _00421_ sky130_fd_sc_hd__o21ai_1
XFILLER_0_10_554 vssd1 vssd1 vccd1 vccd1 sky130_ef_sc_hd__decap_12
Xfanout217 mul.a\[20\] vssd1 vssd1 vccd1 vccd1 net217 sky130_fd_sc_hd__clkbuf_4
Xfanout206 mul.a\[22\] vssd1 vssd1 vccd1 vccd1 net206 sky130_fd_sc_hd__buf_2
Xfanout228 net229 vssd1 vssd1 vccd1 vccd1 net228 sky130_fd_sc_hd__buf_2
X_09801_ net151 net156 net479 net488 vssd1 vssd1 vccd1 vccd1 _04320_ sky130_fd_sc_hd__and4_1
X_07993_ net212 net528 _02363_ _02365_ vssd1 vssd1 vccd1 vccd1 _02366_ sky130_fd_sc_hd__a22o_1
XFILLER_0_66_51 vssd1 vssd1 vccd1 vccd1 sky130_fd_sc_hd__decap_6
XFILLER_0_66_40 vssd1 vssd1 vccd1 vccd1 sky130_fd_sc_hd__decap_4
Xfanout239 net241 vssd1 vssd1 vccd1 vccd1 net239 sky130_fd_sc_hd__clkbuf_4
XFILLER_0_5_65 vssd1 vssd1 vccd1 vccd1 sky130_fd_sc_hd__decap_6
X_09732_ _04244_ vssd1 vssd1 vccd1 vccd1 _04245_ sky130_fd_sc_hd__inv_2
X_06944_ _01314_ _01315_ vssd1 vssd1 vccd1 vccd1 _01316_ sky130_fd_sc_hd__xnor2_2
X_06875_ net209 net591 _01245_ _01246_ vssd1 vssd1 vccd1 vccd1 _01247_ sky130_fd_sc_hd__nand4_1
X_09663_ net151 net497 vssd1 vssd1 vccd1 vccd1 _04169_ sky130_fd_sc_hd__nand2_1
X_08614_ net304 net415 _03021_ _03022_ vssd1 vssd1 vccd1 vccd1 _03023_ sky130_fd_sc_hd__a22o_1
X_09594_ net239 net411 _04092_ _04093_ vssd1 vssd1 vccd1 vccd1 _04094_ sky130_fd_sc_hd__o2bb2a_1
X_05826_ _00205_ _00206_ vssd1 vssd1 vccd1 vccd1 _00207_ sky130_fd_sc_hd__or2_1
XTAP_1219 vssd1 vccd1 sky130_fd_sc_hd__tapvpwrvgnd_1
XTAP_1208 vssd1 vccd1 sky130_fd_sc_hd__tapvpwrvgnd_1
XFILLER_0_89_370 vssd1 vssd1 vccd1 vccd1 sky130_ef_sc_hd__decap_12
X_08545_ net186 net193 net506 vssd1 vssd1 vccd1 vccd1 _02947_ sky130_fd_sc_hd__and3_1
XFILLER_0_82_94 vssd1 vssd1 vccd1 vccd1 sky130_fd_sc_hd__fill_1
XFILLER_0_77_576 vssd1 vssd1 vccd1 vccd1 sky130_fd_sc_hd__decap_8
X_05757_ _00135_ _00138_ vssd1 vssd1 vccd1 vccd1 _00139_ sky130_fd_sc_hd__xor2_1
XFILLER_0_49_267 vssd1 vssd1 vccd1 vccd1 sky130_fd_sc_hd__decap_4
X_08476_ _02832_ _02833_ _02869_ _02870_ vssd1 vssd1 vccd1 vccd1 _02872_ sky130_fd_sc_hd__or4bb_4
X_05688_ _04956_ _04957_ vssd1 vssd1 vccd1 vccd1 _04958_ sky130_fd_sc_hd__xnor2_1
XFILLER_0_49_278 vssd1 vssd1 vccd1 vccd1 sky130_fd_sc_hd__fill_2
X_07427_ net170 net175 net600 vssd1 vssd1 vccd1 vccd1 _01795_ sky130_fd_sc_hd__and3_1
X_07358_ _01725_ _01726_ vssd1 vssd1 vccd1 vccd1 _01727_ sky130_fd_sc_hd__nand2b_1
XFILLER_0_60_421 vssd1 vssd1 vccd1 vccd1 sky130_ef_sc_hd__decap_12
X_06309_ _00682_ _00683_ _00684_ vssd1 vssd1 vccd1 vccd1 _00686_ sky130_fd_sc_hd__a21o_1
XFILLER_0_33_624 vssd1 vssd1 vccd1 vccd1 sky130_fd_sc_hd__fill_1
XFILLER_0_60_454 vssd1 vssd1 vccd1 vccd1 sky130_fd_sc_hd__decap_8
X_07289_ net165 net628 net636 net159 vssd1 vssd1 vccd1 vccd1 _01658_ sky130_fd_sc_hd__a22o_1
X_09028_ _03473_ _03474_ vssd1 vssd1 vccd1 vccd1 _03475_ sky130_fd_sc_hd__and2b_1
XFILLER_0_95_351 vssd1 vssd1 vccd1 vccd1 sky130_fd_sc_hd__decap_4
XFILLER_0_83_502 vssd1 vssd1 vccd1 vccd1 sky130_fd_sc_hd__fill_2
XFILLER_0_68_598 vssd1 vssd1 vccd1 vccd1 sky130_fd_sc_hd__fill_1
XFILLER_0_55_248 vssd1 vssd1 vccd1 vccd1 sky130_fd_sc_hd__fill_1
XFILLER_0_63_281 vssd1 vssd1 vccd1 vccd1 sky130_fd_sc_hd__decap_4
XFILLER_0_11_35 vssd1 vssd1 vccd1 vccd1 sky130_fd_sc_hd__fill_2
XFILLER_0_23_123 vssd1 vssd1 vccd1 vccd1 sky130_fd_sc_hd__fill_2
XFILLER_0_23_134 vssd1 vssd1 vccd1 vccd1 sky130_fd_sc_hd__fill_1
Xinput6 wbs_dat_i[10] vssd1 vssd1 vccd1 vccd1 net6 sky130_fd_sc_hd__clkbuf_1
X_06660_ _01033_ vssd1 vssd1 vccd1 vccd1 _01034_ sky130_fd_sc_hd__inv_2
X_05611_ _04842_ _04878_ _04879_ vssd1 vssd1 vccd1 vccd1 _04881_ sky130_fd_sc_hd__or3_1
X_06591_ _00598_ _00962_ _00963_ _00964_ vssd1 vssd1 vccd1 vccd1 _00965_ sky130_fd_sc_hd__a211o_1
X_08330_ _02574_ _02576_ vssd1 vssd1 vccd1 vccd1 _02713_ sky130_fd_sc_hd__nor2_1
XFILLER_0_74_513 vssd1 vssd1 vccd1 vccd1 sky130_fd_sc_hd__decap_6
X_05542_ _04749_ _04811_ vssd1 vssd1 vccd1 vccd1 _04812_ sky130_fd_sc_hd__nand2_1
XFILLER_0_19_418 vssd1 vssd1 vccd1 vccd1 sky130_fd_sc_hd__fill_1
X_08261_ _02621_ _02622_ _02633_ vssd1 vssd1 vccd1 vccd1 _02637_ sky130_fd_sc_hd__o21ai_2
X_05473_ _04740_ _04741_ _04548_ _04549_ vssd1 vssd1 vccd1 vccd1 _04743_ sky130_fd_sc_hd__a211o_1
XFILLER_0_46_237 vssd1 vssd1 vccd1 vccd1 sky130_fd_sc_hd__fill_1
X_07212_ _01579_ _01580_ vssd1 vssd1 vccd1 vccd1 _01582_ sky130_fd_sc_hd__xnor2_1
XFILLER_0_6_334 vssd1 vssd1 vccd1 vccd1 sky130_ef_sc_hd__decap_12
X_08192_ _02559_ _02563_ _02564_ vssd1 vssd1 vccd1 vccd1 _02565_ sky130_fd_sc_hd__nand3_1
XFILLER_0_15_624 vssd1 vssd1 vccd1 vccd1 sky130_fd_sc_hd__fill_1
XFILLER_0_42_421 vssd1 vssd1 vccd1 vccd1 sky130_fd_sc_hd__decap_6
X_07143_ net165 net170 net628 net636 vssd1 vssd1 vccd1 vccd1 _01513_ sky130_fd_sc_hd__and4_1
X_07074_ _01444_ _01439_ vssd1 vssd1 vccd1 vccd1 _01445_ sky130_fd_sc_hd__and2b_1
XFILLER_0_2_562 vssd1 vssd1 vccd1 vccd1 sky130_fd_sc_hd__decap_4
X_06025_ _00402_ _00403_ vssd1 vssd1 vccd1 vccd1 _00404_ sky130_fd_sc_hd__and2b_1
XFILLER_0_10_373 vssd1 vssd1 vccd1 vccd1 sky130_fd_sc_hd__decap_3
X_07976_ _02198_ _02200_ _02347_ _02348_ vssd1 vssd1 vccd1 vccd1 _02349_ sky130_fd_sc_hd__a211o_1
X_09715_ _03164_ _04225_ vssd1 vssd1 vccd1 vccd1 _04226_ sky130_fd_sc_hd__xnor2_1
X_06927_ _01282_ _01297_ _01298_ vssd1 vssd1 vccd1 vccd1 _01299_ sky130_fd_sc_hd__nand3_1
X_09646_ _04149_ _04150_ vssd1 vssd1 vccd1 vccd1 _04151_ sky130_fd_sc_hd__nand2_2
XFILLER_0_96_104 vssd1 vssd1 vccd1 vccd1 sky130_ef_sc_hd__decap_12
X_06858_ net188 net619 vssd1 vssd1 vccd1 vccd1 _01230_ sky130_fd_sc_hd__nand2_1
XTAP_1038 vssd1 vccd1 sky130_fd_sc_hd__tapvpwrvgnd_1
XTAP_1027 vssd1 vccd1 sky130_fd_sc_hd__tapvpwrvgnd_1
XTAP_1016 vssd1 vccd1 sky130_fd_sc_hd__tapvpwrvgnd_1
X_09577_ net257 net400 net405 net248 vssd1 vssd1 vccd1 vccd1 _04075_ sky130_fd_sc_hd__a22o_1
XTAP_1005 vssd1 vccd1 sky130_fd_sc_hd__tapvpwrvgnd_1
X_05809_ _05017_ _00188_ _00189_ vssd1 vssd1 vccd1 vccd1 _00190_ sky130_fd_sc_hd__nand3_1
X_06789_ _01154_ _01160_ _01161_ vssd1 vssd1 vccd1 vccd1 _01162_ sky130_fd_sc_hd__nand3_2
XTAP_1049 vssd1 vccd1 sky130_fd_sc_hd__tapvpwrvgnd_1
X_08528_ _02599_ _02765_ _02595_ _02596_ vssd1 vssd1 vccd1 vccd1 _02929_ sky130_fd_sc_hd__or4bb_4
XFILLER_0_37_215 vssd1 vssd1 vccd1 vccd1 sky130_fd_sc_hd__decap_3
X_08459_ net299 net308 net420 net426 vssd1 vssd1 vccd1 vccd1 _02854_ sky130_fd_sc_hd__nand4_2
XFILLER_0_80_549 vssd1 vssd1 vccd1 vccd1 sky130_fd_sc_hd__decap_3
XFILLER_0_52_229 vssd1 vssd1 vccd1 vccd1 sky130_fd_sc_hd__fill_1
XFILLER_0_20_115 vssd1 vssd1 vccd1 vccd1 sky130_fd_sc_hd__fill_2
XFILLER_0_20_159 vssd1 vssd1 vccd1 vccd1 sky130_ef_sc_hd__decap_12
Xfanout581 net582 vssd1 vssd1 vccd1 vccd1 net581 sky130_fd_sc_hd__clkbuf_4
Xfanout570 net571 vssd1 vssd1 vccd1 vccd1 net570 sky130_fd_sc_hd__clkbuf_4
Xfanout592 mul.b\[5\] vssd1 vssd1 vccd1 vccd1 net592 sky130_fd_sc_hd__clkbuf_4
XFILLER_0_68_362 vssd1 vssd1 vccd1 vccd1 sky130_fd_sc_hd__fill_2
XPHY_90 vssd1 vssd1 vccd1 vccd1 sky130_fd_sc_hd__decap_3
XFILLER_0_83_354 vssd1 vssd1 vccd1 vccd1 sky130_fd_sc_hd__decap_8
XFILLER_0_71_505 vssd1 vssd1 vccd1 vccd1 sky130_fd_sc_hd__fill_1
XFILLER_0_24_421 vssd1 vssd1 vccd1 vccd1 sky130_fd_sc_hd__fill_2
XFILLER_0_98_27 vssd1 vssd1 vccd1 vccd1 sky130_fd_sc_hd__fill_1
XFILLER_0_3_359 vssd1 vssd1 vccd1 vccd1 sky130_fd_sc_hd__decap_4
XFILLER_0_3_337 vssd1 vssd1 vccd1 vccd1 sky130_fd_sc_hd__decap_6
XFILLER_0_24_465 vssd1 vssd1 vccd1 vccd1 sky130_fd_sc_hd__decap_3
X_07830_ _02199_ _02200_ vssd1 vssd1 vccd1 vccd1 _02201_ sky130_fd_sc_hd__and2_1
X_07761_ _01961_ _01969_ _02130_ vssd1 vssd1 vccd1 vccd1 _02132_ sky130_fd_sc_hd__or3_1
X_09500_ _03965_ _03989_ vssd1 vssd1 vccd1 vccd1 _03992_ sky130_fd_sc_hd__xor2_4
X_06712_ _01083_ _01084_ _00877_ _00879_ vssd1 vssd1 vccd1 vccd1 _01086_ sky130_fd_sc_hd__a211o_1
X_07692_ _02062_ _02063_ vssd1 vssd1 vccd1 vccd1 _02064_ sky130_fd_sc_hd__nand2b_1
X_09431_ _03892_ _03915_ vssd1 vssd1 vccd1 vccd1 _03916_ sky130_fd_sc_hd__xnor2_4
X_06643_ _00903_ _00910_ _00909_ vssd1 vssd1 vccd1 vccd1 _01017_ sky130_fd_sc_hd__a21o_1
X_09362_ _03696_ _03698_ _03694_ vssd1 vssd1 vccd1 vccd1 _03841_ sky130_fd_sc_hd__o21bai_2
XFILLER_0_59_351 vssd1 vssd1 vccd1 vccd1 sky130_fd_sc_hd__decap_3
X_06574_ _00753_ _00756_ _00947_ _00948_ vssd1 vssd1 vccd1 vccd1 _00949_ sky130_fd_sc_hd__a211oi_4
X_08313_ _02685_ _02692_ _02693_ vssd1 vssd1 vccd1 vccd1 _02694_ sky130_fd_sc_hd__nand3_1
X_05525_ _04699_ _04707_ _04706_ vssd1 vssd1 vccd1 vccd1 _04795_ sky130_fd_sc_hd__a21bo_1
XFILLER_0_19_248 vssd1 vssd1 vccd1 vccd1 sky130_fd_sc_hd__decap_3
XFILLER_0_74_365 vssd1 vssd1 vccd1 vccd1 sky130_fd_sc_hd__decap_8
X_09293_ _03591_ _03593_ _03763_ vssd1 vssd1 vccd1 vccd1 _03765_ sky130_fd_sc_hd__nor3_1
XANTENNA_11 net397 vssd1 vssd1 vccd1 vccd1 sky130_fd_sc_hd__diode_2
X_08244_ _02610_ _02611_ _02617_ vssd1 vssd1 vccd1 vccd1 _02618_ sky130_fd_sc_hd__nand3_1
X_05456_ net530 _04724_ _04725_ vssd1 vssd1 vccd1 vccd1 _04726_ sky130_fd_sc_hd__a21bo_1
X_08175_ _02545_ _02546_ vssd1 vssd1 vccd1 vccd1 _02547_ sky130_fd_sc_hd__xor2_2
X_05387_ _04655_ _04656_ vssd1 vssd1 vccd1 vccd1 _04657_ sky130_fd_sc_hd__nand2_1
XFILLER_0_6_197 vssd1 vssd1 vccd1 vccd1 sky130_fd_sc_hd__decap_4
XFILLER_0_15_476 vssd1 vssd1 vccd1 vccd1 sky130_fd_sc_hd__decap_6
X_07126_ mul.b\[11\] net143 net129 net298 _01496_ vssd1 vssd1 vccd1 vccd1 net42 sky130_fd_sc_hd__a221o_1
XFILLER_0_42_251 vssd1 vssd1 vccd1 vccd1 sky130_fd_sc_hd__fill_1
XFILLER_0_100_301 vssd1 vssd1 vccd1 vccd1 sky130_fd_sc_hd__decap_6
XFILLER_0_88_71 vssd1 vssd1 vccd1 vccd1 sky130_ef_sc_hd__decap_12
X_07057_ net342 net451 _01426_ _01427_ vssd1 vssd1 vccd1 vccd1 _01428_ sky130_fd_sc_hd__o2bb2a_1
XFILLER_0_2_370 vssd1 vssd1 vccd1 vccd1 sky130_ef_sc_hd__decap_12
X_06008_ net272 net589 _00384_ _00385_ vssd1 vssd1 vccd1 vccd1 _00387_ sky130_fd_sc_hd__a22o_1
X_07959_ _02330_ _02331_ vssd1 vssd1 vccd1 vccd1 _02332_ sky130_fd_sc_hd__xor2_2
XFILLER_0_69_104 vssd1 vssd1 vccd1 vccd1 sky130_fd_sc_hd__fill_1
Xmax_cap79 _03832_ vssd1 vssd1 vccd1 vccd1 net79 sky130_fd_sc_hd__buf_1
X_09629_ _04129_ _04130_ vssd1 vssd1 vccd1 vccd1 _04133_ sky130_fd_sc_hd__xor2_1
XFILLER_0_69_137 vssd1 vssd1 vccd1 vccd1 sky130_ef_sc_hd__decap_12
XFILLER_0_77_192 vssd1 vssd1 vccd1 vccd1 sky130_fd_sc_hd__decap_4
XFILLER_0_65_321 vssd1 vssd1 vccd1 vccd1 sky130_fd_sc_hd__decap_4
XFILLER_0_53_505 vssd1 vssd1 vccd1 vccd1 sky130_ef_sc_hd__decap_12
XFILLER_0_92_162 vssd1 vssd1 vccd1 vccd1 sky130_fd_sc_hd__fill_1
XFILLER_0_33_262 vssd1 vssd1 vccd1 vccd1 sky130_ef_sc_hd__decap_12
XFILLER_0_68_19 vssd1 vssd1 vccd1 vccd1 sky130_fd_sc_hd__decap_8
XFILLER_0_21_446 vssd1 vssd1 vccd1 vccd1 sky130_fd_sc_hd__fill_2
XTAP_608 vssd1 vccd1 sky130_fd_sc_hd__tapvpwrvgnd_1
XTAP_619 vssd1 vccd1 sky130_fd_sc_hd__tapvpwrvgnd_1
XFILLER_0_88_446 vssd1 vssd1 vccd1 vccd1 sky130_fd_sc_hd__fill_1
XFILLER_0_56_365 vssd1 vssd1 vccd1 vccd1 sky130_fd_sc_hd__fill_2
XFILLER_0_44_505 vssd1 vssd1 vccd1 vccd1 sky130_fd_sc_hd__decap_4
XFILLER_0_83_184 vssd1 vssd1 vccd1 vccd1 sky130_fd_sc_hd__fill_2
XFILLER_0_71_324 vssd1 vssd1 vccd1 vccd1 sky130_fd_sc_hd__fill_2
XFILLER_0_56_398 vssd1 vssd1 vccd1 vccd1 sky130_fd_sc_hd__fill_1
X_06290_ _00665_ _00666_ vssd1 vssd1 vccd1 vccd1 _00667_ sky130_fd_sc_hd__nor2_1
X_05310_ _04575_ _04576_ _04579_ vssd1 vssd1 vccd1 vccd1 _04580_ sky130_fd_sc_hd__nand3_1
Xinput20 wbs_dat_i[23] vssd1 vssd1 vccd1 vccd1 net20 sky130_fd_sc_hd__clkbuf_1
XFILLER_0_71_357 vssd1 vssd1 vccd1 vccd1 sky130_ef_sc_hd__decap_12
X_05241_ net310 net614 vssd1 vssd1 vccd1 vccd1 _04186_ sky130_fd_sc_hd__and2_1
Xinput31 wbs_dat_i[4] vssd1 vssd1 vccd1 vccd1 net31 sky130_fd_sc_hd__clkbuf_1
X_05172_ _02809_ _02831_ _02820_ vssd1 vssd1 vccd1 vccd1 _03432_ sky130_fd_sc_hd__a21o_1
X_09980_ _04453_ _04515_ vssd1 vssd1 vccd1 vccd1 _04516_ sky130_fd_sc_hd__xnor2_4
X_08931_ _03215_ _03216_ _03213_ vssd1 vssd1 vccd1 vccd1 _03370_ sky130_fd_sc_hd__a21oi_1
X_08862_ _03138_ _03140_ vssd1 vssd1 vccd1 vccd1 _03294_ sky130_fd_sc_hd__or2_1
XFILLER_0_58_96 vssd1 vssd1 vccd1 vccd1 sky130_fd_sc_hd__decap_4
XFILLER_0_58_85 vssd1 vssd1 vccd1 vccd1 sky130_fd_sc_hd__decap_4
X_07813_ _02181_ _02182_ _02175_ vssd1 vssd1 vccd1 vccd1 _02184_ sky130_fd_sc_hd__a21o_1
X_08793_ _03217_ _03218_ vssd1 vssd1 vccd1 vccd1 _03219_ sky130_fd_sc_hd__or2_1
X_07744_ _02032_ _02034_ vssd1 vssd1 vccd1 vccd1 _02115_ sky130_fd_sc_hd__or2_1
XFILLER_0_28_3 vssd1 vssd1 vccd1 vccd1 sky130_fd_sc_hd__fill_1
X_07675_ _02044_ _02045_ _02046_ vssd1 vssd1 vccd1 vccd1 _02047_ sky130_fd_sc_hd__nand3_2
X_09414_ net222 net428 _03894_ _03895_ vssd1 vssd1 vccd1 vccd1 _03897_ sky130_fd_sc_hd__nand4_1
X_06626_ _00985_ _00999_ vssd1 vssd1 vccd1 vccd1 _01000_ sky130_fd_sc_hd__nor2_1
XFILLER_0_59_192 vssd1 vssd1 vccd1 vccd1 sky130_ef_sc_hd__decap_12
X_09345_ _03819_ _03820_ vssd1 vssd1 vccd1 vccd1 _03822_ sky130_fd_sc_hd__xor2_1
X_06557_ _00912_ _00929_ _00930_ vssd1 vssd1 vccd1 vccd1 _00932_ sky130_fd_sc_hd__nand3_2
XFILLER_0_35_505 vssd1 vssd1 vccd1 vccd1 sky130_fd_sc_hd__decap_6
X_09276_ _03743_ _03744_ _03581_ _03595_ vssd1 vssd1 vccd1 vccd1 _03746_ sky130_fd_sc_hd__a211oi_1
X_05508_ _04775_ _04776_ _04770_ vssd1 vssd1 vccd1 vccd1 _04778_ sky130_fd_sc_hd__a21oi_1
X_06488_ net235 net590 _00860_ _00861_ vssd1 vssd1 vccd1 vccd1 _00863_ sky130_fd_sc_hd__a22o_1
XFILLER_0_47_376 vssd1 vssd1 vccd1 vccd1 sky130_fd_sc_hd__fill_2
XFILLER_0_47_398 vssd1 vssd1 vccd1 vccd1 sky130_ef_sc_hd__decap_12
X_08227_ _02600_ _02597_ vssd1 vssd1 vccd1 vccd1 _02601_ sky130_fd_sc_hd__nand2b_4
XFILLER_0_7_473 vssd1 vssd1 vccd1 vccd1 sky130_fd_sc_hd__fill_2
X_05439_ _04706_ _04707_ _04699_ vssd1 vssd1 vccd1 vccd1 _04709_ sky130_fd_sc_hd__a21o_1
X_08158_ _02523_ _02528_ _02529_ vssd1 vssd1 vccd1 vccd1 _02530_ sky130_fd_sc_hd__nand3_2
XFILLER_0_30_210 vssd1 vssd1 vccd1 vccd1 sky130_fd_sc_hd__decap_4
X_08089_ _02306_ _02310_ _02312_ _02314_ _02305_ vssd1 vssd1 vccd1 vccd1 _02461_ sky130_fd_sc_hd__a32o_1
X_07109_ _01476_ _01477_ _01337_ _01339_ vssd1 vssd1 vccd1 vccd1 _01480_ sky130_fd_sc_hd__o211a_1
X_10120_ clknet_3_6_0_wb_clk_i _00114_ _00050_ vssd1 vssd1 vccd1 vccd1 mul.a\[15\]
+ sky130_fd_sc_hd__dfrtp_1
XFILLER_0_30_287 vssd1 vssd1 vccd1 vccd1 sky130_fd_sc_hd__fill_2
X_10051_ net640 vssd1 vssd1 vccd1 vccd1 _00047_ sky130_fd_sc_hd__inv_2
XFILLER_0_100_197 vssd1 vssd1 vccd1 vccd1 sky130_fd_sc_hd__decap_6
XFILLER_0_85_427 vssd1 vssd1 vccd1 vccd1 sky130_fd_sc_hd__decap_8
XFILLER_0_26_505 vssd1 vssd1 vccd1 vccd1 sky130_fd_sc_hd__decap_8
XFILLER_0_38_332 vssd1 vssd1 vccd1 vccd1 sky130_fd_sc_hd__fill_1
XFILLER_0_38_365 vssd1 vssd1 vccd1 vccd1 sky130_fd_sc_hd__decap_8
XFILLER_0_65_173 vssd1 vssd1 vccd1 vccd1 sky130_fd_sc_hd__decap_8
XFILLER_0_53_313 vssd1 vssd1 vccd1 vccd1 sky130_fd_sc_hd__decap_8
XFILLER_0_53_302 vssd1 vssd1 vccd1 vccd1 sky130_fd_sc_hd__decap_6
XFILLER_0_65_195 vssd1 vssd1 vccd1 vccd1 sky130_fd_sc_hd__fill_1
XFILLER_0_80_176 vssd1 vssd1 vccd1 vccd1 sky130_fd_sc_hd__decap_3
XFILLER_0_21_232 vssd1 vssd1 vccd1 vccd1 sky130_fd_sc_hd__decap_4
XFILLER_0_21_243 vssd1 vssd1 vccd1 vccd1 sky130_fd_sc_hd__fill_2
XFILLER_0_0_148 vssd1 vssd1 vccd1 vccd1 sky130_fd_sc_hd__decap_8
XTAP_405 vssd1 vccd1 sky130_fd_sc_hd__tapvpwrvgnd_1
XTAP_416 vssd1 vccd1 sky130_fd_sc_hd__tapvpwrvgnd_1
XTAP_438 vssd1 vccd1 sky130_fd_sc_hd__tapvpwrvgnd_1
XTAP_427 vssd1 vccd1 sky130_fd_sc_hd__tapvpwrvgnd_1
XTAP_449 vssd1 vccd1 sky130_fd_sc_hd__tapvpwrvgnd_1
XFILLER_0_28_11 vssd1 vssd1 vccd1 vccd1 sky130_ef_sc_hd__decap_12
X_05790_ _04963_ _04965_ vssd1 vssd1 vccd1 vccd1 _00172_ sky130_fd_sc_hd__nand2_1
XFILLER_0_44_10 vssd1 vssd1 vccd1 vccd1 sky130_fd_sc_hd__decap_4
XFILLER_0_48_118 vssd1 vssd1 vccd1 vccd1 sky130_fd_sc_hd__decap_8
X_07460_ _01678_ _01681_ _01825_ vssd1 vssd1 vccd1 vccd1 _01829_ sky130_fd_sc_hd__nor3_1
X_07391_ _01757_ _01758_ _01749_ vssd1 vssd1 vccd1 vccd1 _01760_ sky130_fd_sc_hd__a21o_1
XFILLER_0_8_226 vssd1 vssd1 vccd1 vccd1 sky130_fd_sc_hd__decap_3
XFILLER_0_17_505 vssd1 vssd1 vccd1 vccd1 sky130_fd_sc_hd__fill_2
X_06411_ _00781_ _00786_ vssd1 vssd1 vccd1 vccd1 _00787_ sky130_fd_sc_hd__nand2b_1
X_09130_ net178 net185 net480 net489 vssd1 vssd1 vccd1 vccd1 _03587_ sky130_fd_sc_hd__nand4_1
X_06342_ net227 net236 net597 net608 vssd1 vssd1 vccd1 vccd1 _00718_ sky130_fd_sc_hd__and4_1
X_09061_ _02885_ net138 _03510_ vssd1 vssd1 vccd1 vccd1 _03512_ sky130_fd_sc_hd__or3_1
XFILLER_0_56_195 vssd1 vssd1 vccd1 vccd1 sky130_fd_sc_hd__fill_1
X_08012_ net264 net476 _02383_ _02384_ vssd1 vssd1 vccd1 vccd1 _02385_ sky130_fd_sc_hd__a22o_1
XFILLER_0_4_421 vssd1 vssd1 vccd1 vccd1 sky130_ef_sc_hd__decap_12
X_06273_ net379 net454 net461 net371 vssd1 vssd1 vccd1 vccd1 _00650_ sky130_fd_sc_hd__a22o_1
X_05224_ net377 net559 net568 net369 vssd1 vssd1 vccd1 vccd1 _04001_ sky130_fd_sc_hd__a22oi_1
XFILLER_0_12_232 vssd1 vssd1 vccd1 vccd1 sky130_fd_sc_hd__fill_1
X_05155_ _03181_ _03236_ vssd1 vssd1 vccd1 vccd1 _03246_ sky130_fd_sc_hd__nor2_1
X_05086_ net32 net592 net124 vssd1 vssd1 vccd1 vccd1 _00072_ sky130_fd_sc_hd__mux2_1
X_09963_ _04493_ _04496_ vssd1 vssd1 vccd1 vccd1 _04497_ sky130_fd_sc_hd__xnor2_1
X_08914_ _03156_ _03196_ _03349_ _03350_ vssd1 vssd1 vccd1 vccd1 _03351_ sky130_fd_sc_hd__o211a_1
XTAP_961 vssd1 vccd1 sky130_fd_sc_hd__tapvpwrvgnd_1
XTAP_950 vssd1 vccd1 sky130_fd_sc_hd__tapvpwrvgnd_1
X_09894_ _04420_ _04421_ vssd1 vssd1 vccd1 vccd1 _04422_ sky130_fd_sc_hd__nor2_1
XFILLER_0_85_83 vssd1 vssd1 vccd1 vccd1 sky130_fd_sc_hd__fill_1
X_08845_ _03265_ _03274_ vssd1 vssd1 vccd1 vccd1 _03275_ sky130_fd_sc_hd__and2_1
XTAP_994 vssd1 vccd1 sky130_fd_sc_hd__tapvpwrvgnd_1
XTAP_983 vssd1 vccd1 sky130_fd_sc_hd__tapvpwrvgnd_1
XTAP_972 vssd1 vccd1 sky130_fd_sc_hd__tapvpwrvgnd_1
X_08776_ _03197_ _03198_ _02999_ net91 vssd1 vssd1 vccd1 vccd1 _03200_ sky130_fd_sc_hd__a211oi_2
X_07727_ _01933_ _01935_ _02097_ _02098_ vssd1 vssd1 vccd1 vccd1 _02099_ sky130_fd_sc_hd__o211a_2
X_05988_ net703 _00366_ _00265_ net716 vssd1 vssd1 vccd1 vccd1 _00368_ sky130_fd_sc_hd__a211o_1
XFILLER_0_94_202 vssd1 vssd1 vccd1 vccd1 sky130_fd_sc_hd__decap_8
XFILLER_0_79_265 vssd1 vssd1 vccd1 vccd1 sky130_fd_sc_hd__decap_3
XFILLER_0_67_438 vssd1 vssd1 vccd1 vccd1 sky130_fd_sc_hd__decap_6
X_07658_ _02015_ _02027_ _02029_ vssd1 vssd1 vccd1 vccd1 _02030_ sky130_fd_sc_hd__or3_2
XFILLER_0_82_408 vssd1 vssd1 vccd1 vccd1 sky130_fd_sc_hd__fill_1
X_06609_ _00981_ _00982_ vssd1 vssd1 vccd1 vccd1 _00983_ sky130_fd_sc_hd__and2_1
X_07589_ _01959_ _01960_ vssd1 vssd1 vccd1 vccd1 _01961_ sky130_fd_sc_hd__and2_1
XFILLER_0_94_279 vssd1 vssd1 vccd1 vccd1 sky130_fd_sc_hd__fill_2
X_09328_ _03617_ _03620_ _03801_ _03802_ vssd1 vssd1 vccd1 vccd1 _03803_ sky130_fd_sc_hd__o211a_1
XFILLER_0_63_611 vssd1 vssd1 vccd1 vccd1 sky130_fd_sc_hd__fill_2
XFILLER_0_90_474 vssd1 vssd1 vccd1 vccd1 sky130_fd_sc_hd__fill_2
X_09259_ _03571_ _03577_ _03570_ vssd1 vssd1 vccd1 vccd1 _03728_ sky130_fd_sc_hd__a21bo_1
XFILLER_0_50_316 vssd1 vssd1 vccd1 vccd1 sky130_fd_sc_hd__decap_6
XFILLER_0_7_281 vssd1 vssd1 vccd1 vccd1 sky130_fd_sc_hd__decap_8
XFILLER_0_23_519 vssd1 vssd1 vccd1 vccd1 sky130_ef_sc_hd__decap_12
XFILLER_0_101_473 vssd1 vssd1 vccd1 vccd1 sky130_fd_sc_hd__decap_3
X_10103_ clknet_3_2_0_wb_clk_i _00000_ vssd1 vssd1 vccd1 vccd1 val_a_reg.wb_helper.wbs_ack_o
+ sky130_fd_sc_hd__dfxtp_1
X_10034_ net643 vssd1 vssd1 vccd1 vccd1 _00030_ sky130_fd_sc_hd__inv_2
XFILLER_0_66_460 vssd1 vssd1 vccd1 vccd1 sky130_fd_sc_hd__decap_3
XFILLER_0_38_162 vssd1 vssd1 vccd1 vccd1 sky130_fd_sc_hd__fill_1
XFILLER_0_53_198 vssd1 vssd1 vccd1 vccd1 sky130_fd_sc_hd__fill_2
XFILLER_0_22_596 vssd1 vssd1 vccd1 vccd1 sky130_fd_sc_hd__fill_2
XTAP_213 vssd1 vccd1 sky130_fd_sc_hd__tapvpwrvgnd_1
XTAP_224 vssd1 vccd1 sky130_fd_sc_hd__tapvpwrvgnd_1
XTAP_257 vssd1 vccd1 sky130_fd_sc_hd__tapvpwrvgnd_1
XTAP_235 vssd1 vccd1 sky130_fd_sc_hd__tapvpwrvgnd_1
XTAP_246 vssd1 vccd1 sky130_fd_sc_hd__tapvpwrvgnd_1
XFILLER_0_39_98 vssd1 vssd1 vccd1 vccd1 sky130_fd_sc_hd__decap_6
X_06960_ _01328_ _01329_ _01311_ vssd1 vssd1 vccd1 vccd1 _01332_ sky130_fd_sc_hd__o21ai_1
XTAP_279 vssd1 vccd1 sky130_fd_sc_hd__tapvpwrvgnd_1
XTAP_268 vssd1 vccd1 sky130_fd_sc_hd__tapvpwrvgnd_1
X_05911_ _00289_ _00290_ vssd1 vssd1 vccd1 vccd1 _00291_ sky130_fd_sc_hd__nand2_1
X_06891_ _01262_ _01225_ vssd1 vssd1 vccd1 vccd1 _01263_ sky130_fd_sc_hd__nand2b_2
X_08630_ _02999_ _03000_ _03037_ _03038_ vssd1 vssd1 vccd1 vccd1 _03041_ sky130_fd_sc_hd__or4_4
X_05842_ _00220_ _00221_ _04990_ _05011_ vssd1 vssd1 vccd1 vccd1 _00223_ sky130_fd_sc_hd__a211oi_1
X_08561_ _02964_ _02958_ vssd1 vssd1 vccd1 vccd1 _02965_ sky130_fd_sc_hd__and2b_1
X_05773_ _00131_ _00153_ _00154_ vssd1 vssd1 vccd1 vccd1 _00155_ sky130_fd_sc_hd__and3_1
X_08492_ _02889_ vssd1 vssd1 vccd1 vccd1 _02890_ sky130_fd_sc_hd__inv_2
X_07512_ _01876_ _01883_ _01884_ vssd1 vssd1 vccd1 vccd1 _01885_ sky130_fd_sc_hd__nand3_2
XFILLER_0_49_427 vssd1 vssd1 vccd1 vccd1 sky130_ef_sc_hd__decap_12
XFILLER_0_76_268 vssd1 vssd1 vccd1 vccd1 sky130_fd_sc_hd__fill_1
XFILLER_0_71_52 vssd1 vssd1 vccd1 vccd1 sky130_fd_sc_hd__fill_1
XFILLER_0_9_502 vssd1 vssd1 vccd1 vccd1 sky130_fd_sc_hd__fill_2
X_07443_ _01660_ _01809_ vssd1 vssd1 vccd1 vccd1 _01811_ sky130_fd_sc_hd__xnor2_1
XFILLER_0_57_482 vssd1 vssd1 vccd1 vccd1 sky130_ef_sc_hd__decap_12
X_07374_ _01741_ _01742_ vssd1 vssd1 vccd1 vccd1 _01743_ sky130_fd_sc_hd__and2b_1
X_09113_ _03564_ _03565_ _03566_ vssd1 vssd1 vccd1 vccd1 _03568_ sky130_fd_sc_hd__nand3_1
XFILLER_0_44_121 vssd1 vssd1 vccd1 vccd1 sky130_ef_sc_hd__decap_12
XFILLER_0_95_3 vssd1 vssd1 vccd1 vccd1 sky130_ef_sc_hd__decap_12
X_06325_ _00641_ _00642_ _00699_ _00700_ vssd1 vssd1 vccd1 vccd1 _00702_ sky130_fd_sc_hd__o22a_1
X_09044_ _03489_ _03491_ _03477_ vssd1 vssd1 vccd1 vccd1 _03493_ sky130_fd_sc_hd__o21ai_1
X_06256_ _00491_ _00495_ _00631_ vssd1 vssd1 vccd1 vccd1 _00633_ sky130_fd_sc_hd__nand3_1
XFILLER_0_4_262 vssd1 vssd1 vccd1 vccd1 sky130_fd_sc_hd__decap_4
X_05207_ _03782_ _03793_ _03804_ vssd1 vssd1 vccd1 vccd1 _03815_ sky130_fd_sc_hd__nand3_1
X_06187_ _00440_ _00448_ _00447_ vssd1 vssd1 vccd1 vccd1 _00565_ sky130_fd_sc_hd__a21bo_1
X_05138_ net344 net585 _03039_ _03050_ vssd1 vssd1 vccd1 vccd1 _03061_ sky130_fd_sc_hd__nand4_2
X_05069_ net19 net446 net127 vssd1 vssd1 vccd1 vccd1 _00089_ sky130_fd_sc_hd__mux2_1
X_09946_ _04345_ _04346_ _04348_ vssd1 vssd1 vccd1 vccd1 _04478_ sky130_fd_sc_hd__a21oi_1
X_09877_ _03163_ _04224_ net137 net268 vssd1 vssd1 vccd1 vccd1 _04403_ sky130_fd_sc_hd__o2bb2a_1
XTAP_791 vssd1 vccd1 sky130_fd_sc_hd__tapvpwrvgnd_1
XTAP_780 vssd1 vccd1 sky130_fd_sc_hd__tapvpwrvgnd_1
X_08828_ net515 _03255_ _03254_ vssd1 vssd1 vccd1 vccd1 _03256_ sky130_fd_sc_hd__a21bo_1
X_08759_ _03176_ _03179_ _03180_ vssd1 vssd1 vccd1 vccd1 _03182_ sky130_fd_sc_hd__or3_2
XFILLER_0_95_511 vssd1 vssd1 vccd1 vccd1 sky130_fd_sc_hd__decap_4
XFILLER_0_82_227 vssd1 vssd1 vccd1 vccd1 sky130_fd_sc_hd__fill_1
XFILLER_0_82_205 vssd1 vssd1 vccd1 vccd1 sky130_fd_sc_hd__decap_6
XFILLER_0_35_121 vssd1 vssd1 vccd1 vccd1 sky130_fd_sc_hd__fill_1
XFILLER_0_101_281 vssd1 vssd1 vccd1 vccd1 sky130_ef_sc_hd__decap_12
X_10017_ net639 vssd1 vssd1 vccd1 vccd1 _00013_ sky130_fd_sc_hd__inv_2
XFILLER_0_86_533 vssd1 vssd1 vccd1 vccd1 sky130_fd_sc_hd__decap_8
XFILLER_0_86_544 vssd1 vssd1 vccd1 vccd1 sky130_ef_sc_hd__decap_12
XFILLER_0_39_460 vssd1 vssd1 vccd1 vccd1 sky130_fd_sc_hd__fill_1
X_07090_ _01457_ _01458_ _01459_ vssd1 vssd1 vccd1 vccd1 _01461_ sky130_fd_sc_hd__a21o_1
X_06110_ net297 net553 net580 net272 vssd1 vssd1 vccd1 vccd1 _00488_ sky130_fd_sc_hd__a22o_1
X_06041_ net288 net297 net562 net570 vssd1 vssd1 vccd1 vccd1 _00420_ sky130_fd_sc_hd__and4_1
XFILLER_0_1_265 vssd1 vssd1 vccd1 vccd1 sky130_fd_sc_hd__decap_4
XFILLER_0_22_393 vssd1 vssd1 vccd1 vccd1 sky130_fd_sc_hd__fill_1
Xfanout207 net214 vssd1 vssd1 vccd1 vccd1 net207 sky130_fd_sc_hd__buf_2
Xfanout229 mul.a\[19\] vssd1 vssd1 vccd1 vccd1 net229 sky130_fd_sc_hd__buf_2
X_07992_ net197 net204 net539 net549 vssd1 vssd1 vccd1 vccd1 _02365_ sky130_fd_sc_hd__nand4_1
XFILLER_0_10_566 vssd1 vssd1 vccd1 vccd1 sky130_fd_sc_hd__decap_8
XFILLER_0_5_33 vssd1 vssd1 vccd1 vccd1 sky130_fd_sc_hd__fill_1
X_09800_ net156 net479 net488 net151 vssd1 vssd1 vccd1 vccd1 _04319_ sky130_fd_sc_hd__a22oi_1
Xfanout218 net219 vssd1 vssd1 vccd1 vccd1 net218 sky130_fd_sc_hd__buf_4
X_06943_ net295 net498 vssd1 vssd1 vccd1 vccd1 _01315_ sky130_fd_sc_hd__nand2_1
X_09731_ net217 net225 net416 net422 vssd1 vssd1 vccd1 vccd1 _04244_ sky130_fd_sc_hd__and4_1
X_06874_ net243 net552 net577 net218 vssd1 vssd1 vccd1 vccd1 _01246_ sky130_fd_sc_hd__a22o_1
X_09662_ _04166_ _04167_ vssd1 vssd1 vccd1 vccd1 _04168_ sky130_fd_sc_hd__nor2_2
X_08613_ net286 net296 net418 net424 vssd1 vssd1 vccd1 vccd1 _03022_ sky130_fd_sc_hd__nand4_2
X_09593_ net222 net230 net416 net422 vssd1 vssd1 vccd1 vccd1 _04093_ sky130_fd_sc_hd__and4_1
X_05825_ _00203_ net616 net263 _00202_ vssd1 vssd1 vccd1 vccd1 _00206_ sky130_fd_sc_hd__and4b_1
XTAP_1209 vssd1 vccd1 sky130_fd_sc_hd__tapvpwrvgnd_1
XFILLER_0_89_393 vssd1 vssd1 vccd1 vccd1 sky130_fd_sc_hd__decap_4
XFILLER_0_89_382 vssd1 vssd1 vccd1 vccd1 sky130_fd_sc_hd__decap_8
X_08544_ net193 net506 net515 net184 vssd1 vssd1 vccd1 vccd1 _02946_ sky130_fd_sc_hd__a22o_1
XFILLER_0_10_3 vssd1 vssd1 vccd1 vccd1 sky130_fd_sc_hd__fill_1
X_05756_ net513 _00137_ _00136_ vssd1 vssd1 vccd1 vccd1 _00138_ sky130_fd_sc_hd__a21bo_1
X_08475_ _02832_ _02833_ _02869_ _02870_ vssd1 vssd1 vccd1 vccd1 _02871_ sky130_fd_sc_hd__and4bb_1
X_05687_ _04764_ _04836_ _04835_ vssd1 vssd1 vccd1 vccd1 _04957_ sky130_fd_sc_hd__a21oi_1
XFILLER_0_92_558 vssd1 vssd1 vccd1 vccd1 sky130_fd_sc_hd__decap_4
XFILLER_0_64_249 vssd1 vssd1 vccd1 vccd1 sky130_fd_sc_hd__decap_3
X_07426_ net175 net600 net611 net170 vssd1 vssd1 vccd1 vccd1 _01794_ sky130_fd_sc_hd__a22o_1
X_07357_ _01576_ _01578_ vssd1 vssd1 vccd1 vccd1 _01726_ sky130_fd_sc_hd__or2_1
XFILLER_0_60_411 vssd1 vssd1 vccd1 vccd1 sky130_fd_sc_hd__decap_8
XFILLER_0_17_176 vssd1 vssd1 vccd1 vccd1 sky130_fd_sc_hd__decap_8
X_06308_ _00682_ _00683_ _00684_ vssd1 vssd1 vccd1 vccd1 _00685_ sky130_fd_sc_hd__nand3_4
XFILLER_0_32_113 vssd1 vssd1 vccd1 vccd1 sky130_fd_sc_hd__decap_6
X_09027_ _03470_ _03472_ _03317_ _03320_ vssd1 vssd1 vccd1 vccd1 _03474_ sky130_fd_sc_hd__a211o_1
XFILLER_0_60_433 vssd1 vssd1 vccd1 vccd1 sky130_fd_sc_hd__fill_1
X_07288_ _01654_ _01655_ vssd1 vssd1 vccd1 vccd1 _01657_ sky130_fd_sc_hd__xnor2_1
X_06239_ _00611_ _00614_ vssd1 vssd1 vccd1 vccd1 _00616_ sky130_fd_sc_hd__xnor2_1
X_09929_ _04455_ _04458_ vssd1 vssd1 vccd1 vccd1 _04460_ sky130_fd_sc_hd__xnor2_1
XFILLER_0_99_113 vssd1 vssd1 vccd1 vccd1 sky130_fd_sc_hd__decap_8
XFILLER_0_99_146 vssd1 vssd1 vccd1 vccd1 sky130_fd_sc_hd__fill_2
XFILLER_0_83_569 vssd1 vssd1 vccd1 vccd1 sky130_fd_sc_hd__decap_3
XFILLER_0_36_441 vssd1 vssd1 vccd1 vccd1 sky130_fd_sc_hd__decap_4
XFILLER_0_51_400 vssd1 vssd1 vccd1 vccd1 sky130_fd_sc_hd__fill_1
XFILLER_0_36_474 vssd1 vssd1 vccd1 vccd1 sky130_fd_sc_hd__fill_2
Xinput7 wbs_dat_i[11] vssd1 vssd1 vccd1 vccd1 net7 sky130_fd_sc_hd__clkbuf_1
X_05610_ _04878_ _04879_ vssd1 vssd1 vccd1 vccd1 _04880_ sky130_fd_sc_hd__nor2_1
XFILLER_0_86_341 vssd1 vssd1 vccd1 vccd1 sky130_fd_sc_hd__decap_8
XFILLER_0_52_21 vssd1 vssd1 vccd1 vccd1 sky130_fd_sc_hd__fill_1
X_06590_ _00957_ _00837_ _00836_ _00956_ vssd1 vssd1 vccd1 vccd1 _00964_ sky130_fd_sc_hd__and4bb_1
X_05541_ _04809_ _04810_ vssd1 vssd1 vccd1 vccd1 _04811_ sky130_fd_sc_hd__xor2_2
X_08260_ _02621_ _02622_ _02633_ vssd1 vssd1 vccd1 vccd1 _02636_ sky130_fd_sc_hd__or3_2
XFILLER_0_74_558 vssd1 vssd1 vccd1 vccd1 sky130_fd_sc_hd__decap_3
X_05472_ _04548_ _04549_ _04740_ _04741_ vssd1 vssd1 vccd1 vccd1 _04742_ sky130_fd_sc_hd__o211ai_2
X_08191_ net333 net414 _02560_ _02562_ vssd1 vssd1 vccd1 vccd1 _02564_ sky130_fd_sc_hd__nand4_2
X_07211_ _01579_ _01580_ vssd1 vssd1 vccd1 vccd1 _01581_ sky130_fd_sc_hd__or2_1
XFILLER_0_6_357 vssd1 vssd1 vccd1 vccd1 sky130_fd_sc_hd__fill_2
XFILLER_0_6_346 vssd1 vssd1 vccd1 vccd1 sky130_fd_sc_hd__fill_2
XFILLER_0_14_102 vssd1 vssd1 vccd1 vccd1 sky130_fd_sc_hd__fill_1
X_07142_ net170 net628 net636 net165 vssd1 vssd1 vccd1 vccd1 _01512_ sky130_fd_sc_hd__a22oi_1
X_07073_ _01442_ _01443_ vssd1 vssd1 vccd1 vccd1 _01444_ sky130_fd_sc_hd__or2_1
XFILLER_0_42_466 vssd1 vssd1 vccd1 vccd1 sky130_fd_sc_hd__decap_4
X_06024_ net253 net616 _00302_ _00301_ vssd1 vssd1 vccd1 vccd1 _00403_ sky130_fd_sc_hd__a31o_1
XFILLER_0_77_73 vssd1 vssd1 vccd1 vccd1 sky130_fd_sc_hd__decap_4
XFILLER_0_58_3 vssd1 vssd1 vccd1 vccd1 sky130_fd_sc_hd__decap_4
XFILLER_0_77_95 vssd1 vssd1 vccd1 vccd1 sky130_fd_sc_hd__decap_8
X_07975_ net340 net414 _02344_ _02345_ vssd1 vssd1 vccd1 vccd1 _02348_ sky130_fd_sc_hd__and4_1
X_09714_ net267 net137 _04224_ vssd1 vssd1 vccd1 vccd1 _04225_ sky130_fd_sc_hd__o21a_1
X_06926_ _01295_ _01296_ _01283_ vssd1 vssd1 vccd1 vccd1 _01298_ sky130_fd_sc_hd__a21o_1
X_09645_ net122 _04148_ vssd1 vssd1 vccd1 vccd1 _04150_ sky130_fd_sc_hd__or2_1
XFILLER_0_93_72 vssd1 vssd1 vccd1 vccd1 sky130_fd_sc_hd__fill_2
X_06857_ _01227_ _01228_ vssd1 vssd1 vccd1 vccd1 _01229_ sky130_fd_sc_hd__nand2b_1
XFILLER_0_96_116 vssd1 vssd1 vccd1 vccd1 sky130_fd_sc_hd__decap_8
X_05808_ net288 net589 _00186_ _00187_ vssd1 vssd1 vccd1 vccd1 _00189_ sky130_fd_sc_hd__a22o_1
X_09576_ _04073_ vssd1 vssd1 vccd1 vccd1 _04074_ sky130_fd_sc_hd__inv_2
XTAP_1028 vssd1 vccd1 sky130_fd_sc_hd__tapvpwrvgnd_1
XTAP_1017 vssd1 vccd1 sky130_fd_sc_hd__tapvpwrvgnd_1
XTAP_1006 vssd1 vccd1 sky130_fd_sc_hd__tapvpwrvgnd_1
X_06788_ _01158_ _01159_ _01024_ _01026_ vssd1 vssd1 vccd1 vccd1 _01161_ sky130_fd_sc_hd__o211ai_2
XTAP_1039 vssd1 vccd1 sky130_fd_sc_hd__tapvpwrvgnd_1
X_08527_ _02597_ _02598_ _02764_ _02927_ _02762_ vssd1 vssd1 vccd1 vccd1 _02928_ sky130_fd_sc_hd__a311o_1
XFILLER_0_65_503 vssd1 vssd1 vccd1 vccd1 sky130_fd_sc_hd__fill_1
X_05739_ _04899_ _05008_ vssd1 vssd1 vccd1 vccd1 _05009_ sky130_fd_sc_hd__nand2_1
X_08458_ net308 net420 net426 net299 vssd1 vssd1 vccd1 vccd1 _02852_ sky130_fd_sc_hd__a22o_1
XFILLER_0_80_517 vssd1 vssd1 vccd1 vccd1 sky130_fd_sc_hd__fill_1
X_07409_ _01689_ _01690_ _01775_ _01776_ vssd1 vssd1 vccd1 vccd1 _01778_ sky130_fd_sc_hd__or4_4
XFILLER_0_73_580 vssd1 vssd1 vccd1 vccd1 sky130_fd_sc_hd__decap_4
X_08389_ net184 net527 _02771_ _02773_ vssd1 vssd1 vccd1 vccd1 _02777_ sky130_fd_sc_hd__nand4_2
XFILLER_0_9_195 vssd1 vssd1 vccd1 vccd1 sky130_fd_sc_hd__decap_3
XFILLER_0_18_485 vssd1 vssd1 vccd1 vccd1 sky130_fd_sc_hd__fill_1
XFILLER_0_60_241 vssd1 vssd1 vccd1 vccd1 sky130_fd_sc_hd__decap_6
XFILLER_0_20_127 vssd1 vssd1 vccd1 vccd1 sky130_ef_sc_hd__decap_12
Xfanout560 net561 vssd1 vssd1 vccd1 vccd1 net560 sky130_fd_sc_hd__clkbuf_2
Xfanout593 mul.b\[5\] vssd1 vssd1 vccd1 vccd1 net593 sky130_fd_sc_hd__clkbuf_4
Xfanout571 net572 vssd1 vssd1 vccd1 vccd1 net571 sky130_fd_sc_hd__buf_2
Xfanout582 net583 vssd1 vssd1 vccd1 vccd1 net582 sky130_fd_sc_hd__clkbuf_2
XFILLER_0_95_182 vssd1 vssd1 vccd1 vccd1 sky130_fd_sc_hd__decap_6
XPHY_80 vssd1 vssd1 vccd1 vccd1 sky130_fd_sc_hd__decap_3
XPHY_91 vssd1 vssd1 vccd1 vccd1 sky130_fd_sc_hd__decap_3
XFILLER_0_83_344 vssd1 vssd1 vccd1 vccd1 sky130_fd_sc_hd__fill_2
XFILLER_0_22_79 vssd1 vssd1 vccd1 vccd1 sky130_fd_sc_hd__decap_4
X_07760_ _01961_ _01969_ _02130_ vssd1 vssd1 vccd1 vccd1 _02131_ sky130_fd_sc_hd__o21ai_2
XFILLER_0_79_617 vssd1 vssd1 vccd1 vccd1 sky130_fd_sc_hd__fill_2
X_06711_ _00877_ _00879_ _01083_ _01084_ vssd1 vssd1 vccd1 vccd1 _01085_ sky130_fd_sc_hd__o211ai_4
X_09430_ _03912_ _03914_ vssd1 vssd1 vccd1 vccd1 _03915_ sky130_fd_sc_hd__and2_2
X_07691_ _02060_ _02061_ _01902_ _01906_ vssd1 vssd1 vccd1 vccd1 _02063_ sky130_fd_sc_hd__a211o_1
XFILLER_0_63_53 vssd1 vssd1 vccd1 vccd1 sky130_fd_sc_hd__decap_3
XFILLER_0_59_330 vssd1 vssd1 vccd1 vccd1 sky130_fd_sc_hd__fill_1
X_06642_ _00893_ _00894_ _00896_ _00897_ _00889_ vssd1 vssd1 vccd1 vccd1 _01016_ sky130_fd_sc_hd__a32o_1
X_09361_ _03838_ _03839_ vssd1 vssd1 vccd1 vccd1 _03840_ sky130_fd_sc_hd__nor2_2
X_06573_ net82 _00946_ _00820_ _00822_ vssd1 vssd1 vccd1 vccd1 _00948_ sky130_fd_sc_hd__o211a_1
X_08312_ _02690_ _02691_ _02520_ _02522_ vssd1 vssd1 vccd1 vccd1 _02693_ sky130_fd_sc_hd__o211ai_2
X_09292_ _03591_ _03593_ _03763_ vssd1 vssd1 vccd1 vccd1 _03764_ sky130_fd_sc_hd__o21a_1
X_05524_ _04791_ _04792_ _04785_ vssd1 vssd1 vccd1 vccd1 _04794_ sky130_fd_sc_hd__a21o_1
XFILLER_0_47_525 vssd1 vssd1 vccd1 vccd1 sky130_fd_sc_hd__fill_1
X_08243_ _02615_ _02616_ vssd1 vssd1 vccd1 vccd1 _02617_ sky130_fd_sc_hd__xor2_1
XANTENNA_12 net397 vssd1 vssd1 vccd1 vccd1 sky130_fd_sc_hd__diode_2
XFILLER_0_74_388 vssd1 vssd1 vccd1 vccd1 sky130_fd_sc_hd__fill_1
X_05455_ net381 net530 net540 net371 vssd1 vssd1 vccd1 vccd1 _04725_ sky130_fd_sc_hd__a22o_1
XFILLER_0_27_271 vssd1 vssd1 vccd1 vccd1 sky130_fd_sc_hd__decap_8
XFILLER_0_34_208 vssd1 vssd1 vccd1 vccd1 sky130_fd_sc_hd__decap_8
X_08174_ net169 net574 vssd1 vssd1 vccd1 vccd1 _02546_ sky130_fd_sc_hd__nand2_1
X_05386_ net374 net624 net632 net362 vssd1 vssd1 vccd1 vccd1 _04656_ sky130_fd_sc_hd__a22o_1
X_07125_ _00182_ _01495_ vssd1 vssd1 vccd1 vccd1 _01496_ sky130_fd_sc_hd__nor2_1
XFILLER_0_42_263 vssd1 vssd1 vccd1 vccd1 sky130_fd_sc_hd__fill_1
XFILLER_0_70_583 vssd1 vssd1 vccd1 vccd1 sky130_fd_sc_hd__fill_2
X_07056_ net323 net334 net457 net464 vssd1 vssd1 vccd1 vccd1 _01427_ sky130_fd_sc_hd__and4_1
XFILLER_0_42_274 vssd1 vssd1 vccd1 vccd1 sky130_fd_sc_hd__fill_1
XFILLER_0_88_83 vssd1 vssd1 vccd1 vccd1 sky130_fd_sc_hd__fill_1
XFILLER_0_2_382 vssd1 vssd1 vccd1 vccd1 sky130_fd_sc_hd__decap_4
X_06007_ net272 net589 _00384_ _00385_ vssd1 vssd1 vccd1 vccd1 _00386_ sky130_fd_sc_hd__nand4_2
XFILLER_0_100_379 vssd1 vssd1 vccd1 vccd1 sky130_fd_sc_hd__decap_4
X_07958_ net176 net574 vssd1 vssd1 vccd1 vccd1 _02331_ sky130_fd_sc_hd__nand2_1
X_07889_ _02159_ _02261_ _02262_ vssd1 vssd1 vccd1 vccd1 _02263_ sky130_fd_sc_hd__nor3_2
X_06909_ _01142_ _01280_ vssd1 vssd1 vccd1 vccd1 _01281_ sky130_fd_sc_hd__xor2_1
XFILLER_0_97_469 vssd1 vssd1 vccd1 vccd1 sky130_fd_sc_hd__decap_6
X_09628_ _04129_ _04130_ vssd1 vssd1 vccd1 vccd1 _04131_ sky130_fd_sc_hd__nand2b_1
X_09559_ _03900_ _03904_ vssd1 vssd1 vccd1 vccd1 _04056_ sky130_fd_sc_hd__or2_1
XFILLER_0_92_152 vssd1 vssd1 vccd1 vccd1 sky130_fd_sc_hd__decap_3
XFILLER_0_53_517 vssd1 vssd1 vccd1 vccd1 sky130_fd_sc_hd__decap_6
XFILLER_0_61_561 vssd1 vssd1 vccd1 vccd1 sky130_ef_sc_hd__decap_12
XFILLER_0_33_274 vssd1 vssd1 vccd1 vccd1 sky130_fd_sc_hd__decap_6
XTAP_609 vssd1 vccd1 sky130_fd_sc_hd__tapvpwrvgnd_1
Xfanout390 net391 vssd1 vssd1 vccd1 vccd1 net390 sky130_fd_sc_hd__clkbuf_4
XFILLER_0_29_503 vssd1 vssd1 vccd1 vccd1 sky130_fd_sc_hd__fill_1
XFILLER_0_8_419 vssd1 vssd1 vccd1 vccd1 sky130_fd_sc_hd__fill_1
XFILLER_0_33_45 vssd1 vssd1 vccd1 vccd1 sky130_fd_sc_hd__fill_1
XFILLER_0_33_78 vssd1 vssd1 vccd1 vccd1 sky130_fd_sc_hd__fill_2
XFILLER_0_83_163 vssd1 vssd1 vccd1 vccd1 sky130_fd_sc_hd__decap_4
Xinput21 wbs_dat_i[24] vssd1 vssd1 vccd1 vccd1 net21 sky130_fd_sc_hd__clkbuf_1
X_05240_ _04154_ _04165_ vssd1 vssd1 vccd1 vccd1 _04175_ sky130_fd_sc_hd__nor2_1
Xinput10 wbs_dat_i[14] vssd1 vssd1 vccd1 vccd1 net10 sky130_fd_sc_hd__clkbuf_1
XFILLER_0_71_369 vssd1 vssd1 vccd1 vccd1 sky130_fd_sc_hd__decap_3
XFILLER_0_52_550 vssd1 vssd1 vccd1 vccd1 sky130_fd_sc_hd__fill_2
XFILLER_0_3_113 vssd1 vssd1 vccd1 vccd1 sky130_fd_sc_hd__fill_2
X_05171_ _02864_ _02908_ _02897_ vssd1 vssd1 vccd1 vccd1 _03421_ sky130_fd_sc_hd__a21o_1
Xinput32 wbs_dat_i[5] vssd1 vssd1 vccd1 vccd1 net32 sky130_fd_sc_hd__clkbuf_1
XFILLER_0_3_146 vssd1 vssd1 vccd1 vccd1 sky130_ef_sc_hd__decap_12
X_08930_ _03366_ _03368_ vssd1 vssd1 vccd1 vccd1 _03369_ sky130_fd_sc_hd__xnor2_1
X_08861_ _03291_ _03292_ vssd1 vssd1 vccd1 vccd1 _03293_ sky130_fd_sc_hd__nor2_1
X_07812_ _02175_ _02181_ _02182_ vssd1 vssd1 vccd1 vccd1 _02183_ sky130_fd_sc_hd__nand3_1
X_08792_ _03047_ _03060_ _03059_ vssd1 vssd1 vccd1 vccd1 _03218_ sky130_fd_sc_hd__a21oi_1
XFILLER_0_74_85 vssd1 vssd1 vccd1 vccd1 sky130_fd_sc_hd__decap_8
X_07743_ _01991_ _01993_ vssd1 vssd1 vccd1 vccd1 _02114_ sky130_fd_sc_hd__nand2b_1
X_07674_ _01877_ _01879_ _01878_ vssd1 vssd1 vccd1 vccd1 _02046_ sky130_fd_sc_hd__a21bo_1
X_09413_ net222 net428 _03894_ _03895_ vssd1 vssd1 vccd1 vccd1 _03896_ sky130_fd_sc_hd__a22o_1
X_06625_ _00870_ _00998_ vssd1 vssd1 vccd1 vccd1 _00999_ sky130_fd_sc_hd__xnor2_1
XFILLER_0_47_311 vssd1 vssd1 vccd1 vccd1 sky130_fd_sc_hd__decap_4
X_09344_ _03820_ _03819_ vssd1 vssd1 vccd1 vccd1 _03821_ sky130_fd_sc_hd__nand2b_1
X_06556_ _00912_ _00929_ _00930_ vssd1 vssd1 vccd1 vccd1 _00931_ sky130_fd_sc_hd__and3_1
XFILLER_0_47_344 vssd1 vssd1 vccd1 vccd1 sky130_fd_sc_hd__decap_6
XFILLER_0_90_623 vssd1 vssd1 vccd1 vccd1 sky130_fd_sc_hd__fill_2
X_09275_ _03581_ _03595_ _03743_ _03744_ vssd1 vssd1 vccd1 vccd1 _03745_ sky130_fd_sc_hd__o211a_1
X_05507_ _04770_ _04775_ _04776_ vssd1 vssd1 vccd1 vccd1 _04777_ sky130_fd_sc_hd__and3_1
X_06487_ net235 net590 _00860_ _00861_ vssd1 vssd1 vccd1 vccd1 _00862_ sky130_fd_sc_hd__nand4_2
X_08226_ net682 _02599_ _02598_ vssd1 vssd1 vccd1 vccd1 _02600_ sky130_fd_sc_hd__o21ba_1
X_05438_ _04699_ _04706_ _04707_ vssd1 vssd1 vccd1 vccd1 _04708_ sky130_fd_sc_hd__nand3_1
X_08157_ _02526_ _02527_ _02403_ _02406_ vssd1 vssd1 vccd1 vccd1 _02529_ sky130_fd_sc_hd__a211o_1
XFILLER_0_15_241 vssd1 vssd1 vccd1 vccd1 sky130_fd_sc_hd__fill_1
XFILLER_0_43_561 vssd1 vssd1 vccd1 vccd1 sky130_fd_sc_hd__decap_3
XFILLER_0_15_274 vssd1 vssd1 vccd1 vccd1 sky130_fd_sc_hd__decap_6
X_05369_ _04611_ _04638_ vssd1 vssd1 vccd1 vccd1 _04639_ sky130_fd_sc_hd__or2_1
X_07108_ _01478_ vssd1 vssd1 vccd1 vccd1 _01479_ sky130_fd_sc_hd__inv_2
X_08088_ _02119_ _02458_ vssd1 vssd1 vccd1 vccd1 _02460_ sky130_fd_sc_hd__xnor2_2
XFILLER_0_30_244 vssd1 vssd1 vccd1 vccd1 sky130_fd_sc_hd__fill_2
X_07039_ _01408_ _01409_ _01285_ _01287_ vssd1 vssd1 vccd1 vccd1 _01410_ sky130_fd_sc_hd__o211ai_2
XFILLER_0_11_480 vssd1 vssd1 vccd1 vccd1 sky130_fd_sc_hd__fill_1
X_10050_ net640 vssd1 vssd1 vccd1 vccd1 _00046_ sky130_fd_sc_hd__inv_2
XFILLER_0_97_222 vssd1 vssd1 vccd1 vccd1 sky130_fd_sc_hd__fill_2
XFILLER_0_65_130 vssd1 vssd1 vccd1 vccd1 sky130_fd_sc_hd__fill_1
XFILLER_0_81_623 vssd1 vssd1 vccd1 vccd1 sky130_fd_sc_hd__fill_2
XFILLER_0_26_528 vssd1 vssd1 vccd1 vccd1 sky130_fd_sc_hd__decap_4
XFILLER_0_21_200 vssd1 vssd1 vccd1 vccd1 sky130_fd_sc_hd__decap_3
XTAP_406 vssd1 vccd1 sky130_fd_sc_hd__tapvpwrvgnd_1
XTAP_417 vssd1 vccd1 sky130_fd_sc_hd__tapvpwrvgnd_1
XTAP_439 vssd1 vccd1 sky130_fd_sc_hd__tapvpwrvgnd_1
XTAP_428 vssd1 vccd1 sky130_fd_sc_hd__tapvpwrvgnd_1
XFILLER_0_28_23 vssd1 vssd1 vccd1 vccd1 sky130_fd_sc_hd__decap_4
XFILLER_0_28_45 vssd1 vssd1 vccd1 vccd1 sky130_fd_sc_hd__fill_1
XFILLER_0_44_33 vssd1 vssd1 vccd1 vccd1 sky130_fd_sc_hd__decap_3
XFILLER_0_76_439 vssd1 vssd1 vccd1 vccd1 sky130_fd_sc_hd__decap_4
XFILLER_0_69_480 vssd1 vssd1 vccd1 vccd1 sky130_fd_sc_hd__fill_2
X_06410_ _00782_ _00785_ vssd1 vssd1 vccd1 vccd1 _00786_ sky130_fd_sc_hd__xnor2_2
XFILLER_0_29_300 vssd1 vssd1 vccd1 vccd1 sky130_fd_sc_hd__decap_4
X_07390_ _01749_ _01757_ _01758_ vssd1 vssd1 vccd1 vccd1 _01759_ sky130_fd_sc_hd__nand3_1
XFILLER_0_60_21 vssd1 vssd1 vccd1 vccd1 sky130_fd_sc_hd__decap_6
XFILLER_0_17_528 vssd1 vssd1 vccd1 vccd1 sky130_ef_sc_hd__decap_12
X_06341_ net139 _00716_ _00717_ vssd1 vssd1 vccd1 vccd1 net67 sky130_fd_sc_hd__a21o_1
XFILLER_0_29_366 vssd1 vssd1 vccd1 vccd1 sky130_fd_sc_hd__fill_1
X_09060_ net138 _03510_ _02885_ vssd1 vssd1 vccd1 vccd1 _03511_ sky130_fd_sc_hd__o21ai_1
X_06272_ _00648_ vssd1 vssd1 vccd1 vccd1 _00649_ sky130_fd_sc_hd__inv_2
X_08011_ net245 net254 net485 net494 vssd1 vssd1 vccd1 vccd1 _02384_ sky130_fd_sc_hd__nand4_1
XFILLER_0_8_22 vssd1 vssd1 vccd1 vccd1 sky130_fd_sc_hd__decap_6
XFILLER_0_8_11 vssd1 vssd1 vccd1 vccd1 sky130_fd_sc_hd__decap_3
XFILLER_0_4_433 vssd1 vssd1 vccd1 vccd1 sky130_fd_sc_hd__decap_8
XFILLER_0_4_411 vssd1 vssd1 vccd1 vccd1 sky130_fd_sc_hd__fill_2
X_05223_ _03618_ _03968_ _03957_ vssd1 vssd1 vccd1 vccd1 _03990_ sky130_fd_sc_hd__o21ai_1
XFILLER_0_25_561 vssd1 vssd1 vccd1 vccd1 sky130_fd_sc_hd__fill_1
XFILLER_0_25_572 vssd1 vssd1 vccd1 vccd1 sky130_fd_sc_hd__fill_1
XFILLER_0_4_477 vssd1 vssd1 vccd1 vccd1 sky130_fd_sc_hd__decap_4
X_05154_ net369 net377 net575 net585 vssd1 vssd1 vccd1 vccd1 _03236_ sky130_fd_sc_hd__nand4_2
X_05085_ net33 net583 net125 vssd1 vssd1 vccd1 vccd1 _00073_ sky130_fd_sc_hd__mux2_1
X_09962_ _04494_ _04495_ vssd1 vssd1 vccd1 vccd1 _04496_ sky130_fd_sc_hd__xor2_1
X_08913_ _03308_ _03309_ _03346_ _03347_ vssd1 vssd1 vccd1 vccd1 _03350_ sky130_fd_sc_hd__o22ai_2
XFILLER_0_85_51 vssd1 vssd1 vccd1 vccd1 sky130_fd_sc_hd__decap_4
XTAP_962 vssd1 vccd1 sky130_fd_sc_hd__tapvpwrvgnd_1
XTAP_951 vssd1 vccd1 sky130_fd_sc_hd__tapvpwrvgnd_1
XTAP_940 vssd1 vccd1 sky130_fd_sc_hd__tapvpwrvgnd_1
X_09893_ _04259_ _04261_ _04419_ vssd1 vssd1 vccd1 vccd1 _04421_ sky130_fd_sc_hd__nor3_1
XFILLER_0_40_3 vssd1 vssd1 vccd1 vccd1 sky130_fd_sc_hd__decap_3
XFILLER_0_99_509 vssd1 vssd1 vccd1 vccd1 sky130_fd_sc_hd__fill_1
X_08844_ _03266_ _03272_ vssd1 vssd1 vccd1 vccd1 _03274_ sky130_fd_sc_hd__xnor2_1
XTAP_995 vssd1 vccd1 sky130_fd_sc_hd__tapvpwrvgnd_1
XTAP_984 vssd1 vccd1 sky130_fd_sc_hd__tapvpwrvgnd_1
XTAP_973 vssd1 vccd1 sky130_fd_sc_hd__tapvpwrvgnd_1
X_08775_ _02999_ _03040_ _03197_ _03198_ vssd1 vssd1 vccd1 vccd1 _03199_ sky130_fd_sc_hd__o211a_1
X_05987_ _00265_ net87 net703 _00366_ vssd1 vssd1 vccd1 vccd1 _00367_ sky130_fd_sc_hd__o211ai_4
X_07726_ _01997_ _01998_ _02095_ _02096_ vssd1 vssd1 vccd1 vccd1 _02098_ sky130_fd_sc_hd__a2bb2o_1
XFILLER_0_79_244 vssd1 vssd1 vccd1 vccd1 sky130_fd_sc_hd__decap_8
XFILLER_0_67_417 vssd1 vssd1 vccd1 vccd1 sky130_ef_sc_hd__decap_12
XFILLER_0_79_288 vssd1 vssd1 vccd1 vccd1 sky130_fd_sc_hd__fill_1
XFILLER_0_79_277 vssd1 vssd1 vccd1 vccd1 sky130_fd_sc_hd__decap_3
X_07657_ _02024_ _02025_ _02026_ vssd1 vssd1 vccd1 vccd1 _02029_ sky130_fd_sc_hd__a21oi_1
X_06608_ _00849_ _00854_ _00980_ vssd1 vssd1 vccd1 vccd1 _00982_ sky130_fd_sc_hd__or3_1
X_07588_ net165 net618 _01794_ _01795_ net611 vssd1 vssd1 vccd1 vccd1 _01960_ sky130_fd_sc_hd__a32o_1
X_09327_ _03799_ _03800_ _03787_ vssd1 vssd1 vccd1 vccd1 _03802_ sky130_fd_sc_hd__o21ai_1
XFILLER_0_75_461 vssd1 vssd1 vccd1 vccd1 sky130_fd_sc_hd__decap_6
XFILLER_0_63_623 vssd1 vssd1 vccd1 vccd1 sky130_fd_sc_hd__fill_2
X_06539_ net311 net504 net512 net302 vssd1 vssd1 vccd1 vccd1 _00914_ sky130_fd_sc_hd__a22o_1
X_09258_ _03718_ _03719_ _03724_ vssd1 vssd1 vccd1 vccd1 _03726_ sky130_fd_sc_hd__a21o_1
XFILLER_0_90_486 vssd1 vssd1 vccd1 vccd1 sky130_fd_sc_hd__fill_2
X_09189_ _03483_ _03486_ _03650_ vssd1 vssd1 vccd1 vccd1 _03652_ sky130_fd_sc_hd__a21oi_1
X_08209_ _02484_ _02580_ _02581_ vssd1 vssd1 vccd1 vccd1 _02582_ sky130_fd_sc_hd__nor3_1
X_10102_ clknet_3_4_0_wb_clk_i _00098_ _00034_ vssd1 vssd1 vccd1 vccd1 mul.b\[31\]
+ sky130_fd_sc_hd__dfrtp_1
X_10033_ net643 vssd1 vssd1 vccd1 vccd1 _00029_ sky130_fd_sc_hd__inv_2
XFILLER_0_58_406 vssd1 vssd1 vccd1 vccd1 sky130_fd_sc_hd__fill_2
XFILLER_0_85_225 vssd1 vssd1 vccd1 vccd1 sky130_fd_sc_hd__decap_6
XFILLER_0_26_325 vssd1 vssd1 vccd1 vccd1 sky130_fd_sc_hd__fill_1
XFILLER_0_26_336 vssd1 vssd1 vccd1 vccd1 sky130_fd_sc_hd__fill_1
XFILLER_0_26_347 vssd1 vssd1 vccd1 vccd1 sky130_fd_sc_hd__decap_3
XFILLER_0_1_447 vssd1 vssd1 vccd1 vccd1 sky130_fd_sc_hd__fill_1
XTAP_214 vssd1 vccd1 sky130_fd_sc_hd__tapvpwrvgnd_1
XFILLER_0_39_55 vssd1 vssd1 vccd1 vccd1 sky130_fd_sc_hd__fill_1
XTAP_225 vssd1 vccd1 sky130_fd_sc_hd__tapvpwrvgnd_1
XTAP_236 vssd1 vccd1 sky130_fd_sc_hd__tapvpwrvgnd_1
XTAP_247 vssd1 vccd1 sky130_fd_sc_hd__tapvpwrvgnd_1
XTAP_269 vssd1 vccd1 sky130_fd_sc_hd__tapvpwrvgnd_1
XTAP_258 vssd1 vccd1 sky130_fd_sc_hd__tapvpwrvgnd_1
X_05910_ _00287_ _00288_ _00225_ vssd1 vssd1 vccd1 vccd1 _00290_ sky130_fd_sc_hd__a21o_1
X_06890_ _01226_ _01260_ vssd1 vssd1 vccd1 vccd1 _01262_ sky130_fd_sc_hd__xor2_1
XFILLER_0_55_21 vssd1 vssd1 vccd1 vccd1 sky130_fd_sc_hd__fill_1
X_05841_ _04990_ _05011_ _00220_ _00221_ vssd1 vssd1 vccd1 vccd1 _00222_ sky130_fd_sc_hd__o211a_1
X_08560_ _02961_ _02963_ vssd1 vssd1 vccd1 vccd1 _02964_ sky130_fd_sc_hd__or2_1
X_05772_ _00151_ _00152_ _00134_ vssd1 vssd1 vccd1 vccd1 _00154_ sky130_fd_sc_hd__a21o_1
X_08491_ _02885_ _02884_ _02883_ vssd1 vssd1 vccd1 vccd1 _02889_ sky130_fd_sc_hd__and3b_1
X_07511_ _01880_ _01882_ _01722_ _01724_ vssd1 vssd1 vccd1 vccd1 _01884_ sky130_fd_sc_hd__o211ai_2
XFILLER_0_49_439 vssd1 vssd1 vccd1 vccd1 sky130_fd_sc_hd__fill_1
XFILLER_0_71_64 vssd1 vssd1 vccd1 vccd1 sky130_fd_sc_hd__fill_1
X_07442_ _01660_ _01809_ vssd1 vssd1 vccd1 vccd1 _01810_ sky130_fd_sc_hd__nand2_1
X_07373_ _01739_ _01740_ _01736_ vssd1 vssd1 vccd1 vccd1 _01742_ sky130_fd_sc_hd__a21o_1
XFILLER_0_84_291 vssd1 vssd1 vccd1 vccd1 sky130_fd_sc_hd__fill_1
X_09112_ _03564_ _03565_ _03566_ vssd1 vssd1 vccd1 vccd1 _03567_ sky130_fd_sc_hd__a21o_1
XFILLER_0_57_494 vssd1 vssd1 vccd1 vccd1 sky130_fd_sc_hd__decap_8
X_06324_ _00641_ _00642_ _00699_ _00700_ vssd1 vssd1 vccd1 vccd1 _00701_ sky130_fd_sc_hd__nor4_1
XFILLER_0_29_196 vssd1 vssd1 vccd1 vccd1 sky130_fd_sc_hd__decap_4
XFILLER_0_72_475 vssd1 vssd1 vccd1 vccd1 sky130_fd_sc_hd__fill_1
XFILLER_0_72_453 vssd1 vssd1 vccd1 vccd1 sky130_fd_sc_hd__fill_2
XFILLER_0_44_133 vssd1 vssd1 vccd1 vccd1 sky130_fd_sc_hd__decap_6
X_09043_ _03477_ _03489_ _03491_ vssd1 vssd1 vccd1 vccd1 _03492_ sky130_fd_sc_hd__or3_4
XFILLER_0_88_3 vssd1 vssd1 vccd1 vccd1 sky130_fd_sc_hd__decap_8
X_06255_ _00491_ _00495_ _00631_ vssd1 vssd1 vccd1 vccd1 _00632_ sky130_fd_sc_hd__a21o_1
X_06186_ _00561_ _00562_ _00554_ vssd1 vssd1 vccd1 vccd1 _00564_ sky130_fd_sc_hd__a21o_1
XFILLER_0_25_391 vssd1 vssd1 vccd1 vccd1 sky130_fd_sc_hd__fill_1
X_05206_ net370 net595 net605 net361 vssd1 vssd1 vccd1 vccd1 _03804_ sky130_fd_sc_hd__a22o_1
X_05137_ net377 net551 net575 net353 vssd1 vssd1 vccd1 vccd1 _03050_ sky130_fd_sc_hd__a22o_1
X_05068_ net20 net438 net127 vssd1 vssd1 vccd1 vccd1 _00090_ sky130_fd_sc_hd__mux2_1
X_09945_ _04333_ _04355_ _04331_ vssd1 vssd1 vccd1 vccd1 _04477_ sky130_fd_sc_hd__a21oi_1
X_09876_ net117 _04283_ _04281_ vssd1 vssd1 vccd1 vccd1 _04402_ sky130_fd_sc_hd__o21ai_2
XTAP_770 vssd1 vccd1 sky130_fd_sc_hd__tapvpwrvgnd_1
X_08827_ net174 net178 net507 vssd1 vssd1 vccd1 vccd1 _03255_ sky130_fd_sc_hd__and3_1
XTAP_792 vssd1 vccd1 sky130_fd_sc_hd__tapvpwrvgnd_1
XTAP_781 vssd1 vccd1 sky130_fd_sc_hd__tapvpwrvgnd_1
X_08758_ _03177_ _03178_ net296 net412 vssd1 vssd1 vccd1 vccd1 _03180_ sky130_fd_sc_hd__and4bb_1
XFILLER_0_95_523 vssd1 vssd1 vccd1 vccd1 sky130_fd_sc_hd__fill_2
X_08689_ net515 _03103_ _03102_ vssd1 vssd1 vccd1 vccd1 _03105_ sky130_fd_sc_hd__a21bo_1
X_07709_ _02073_ _02074_ _02079_ vssd1 vssd1 vccd1 vccd1 _02081_ sky130_fd_sc_hd__a21o_1
XFILLER_0_48_461 vssd1 vssd1 vccd1 vccd1 sky130_fd_sc_hd__decap_3
XFILLER_0_35_100 vssd1 vssd1 vccd1 vccd1 sky130_fd_sc_hd__decap_4
XFILLER_0_35_111 vssd1 vssd1 vccd1 vccd1 sky130_fd_sc_hd__fill_1
XFILLER_0_23_306 vssd1 vssd1 vccd1 vccd1 sky130_ef_sc_hd__decap_12
XFILLER_0_90_261 vssd1 vssd1 vccd1 vccd1 sky130_fd_sc_hd__decap_8
XFILLER_0_50_103 vssd1 vssd1 vccd1 vccd1 sky130_ef_sc_hd__decap_12
XFILLER_0_23_328 vssd1 vssd1 vccd1 vccd1 sky130_fd_sc_hd__decap_8
XFILLER_0_101_293 vssd1 vssd1 vccd1 vccd1 sky130_ef_sc_hd__decap_12
X_10016_ net639 vssd1 vssd1 vccd1 vccd1 _00012_ sky130_fd_sc_hd__inv_2
XFILLER_0_58_214 vssd1 vssd1 vccd1 vccd1 sky130_fd_sc_hd__fill_2
XFILLER_0_25_57 vssd1 vssd1 vccd1 vccd1 sky130_fd_sc_hd__decap_8
XFILLER_0_86_556 vssd1 vssd1 vccd1 vccd1 sky130_fd_sc_hd__decap_4
XFILLER_0_58_269 vssd1 vssd1 vccd1 vccd1 sky130_fd_sc_hd__fill_1
XFILLER_0_39_483 vssd1 vssd1 vccd1 vccd1 sky130_ef_sc_hd__decap_12
XFILLER_0_81_272 vssd1 vssd1 vccd1 vccd1 sky130_fd_sc_hd__fill_1
XFILLER_0_54_475 vssd1 vssd1 vccd1 vccd1 sky130_fd_sc_hd__fill_1
X_06040_ net297 net562 net570 net288 vssd1 vssd1 vccd1 vccd1 _00419_ sky130_fd_sc_hd__a22oi_1
XFILLER_0_41_136 vssd1 vssd1 vccd1 vccd1 sky130_fd_sc_hd__fill_2
XFILLER_0_1_222 vssd1 vssd1 vccd1 vccd1 sky130_fd_sc_hd__fill_2
Xclkbuf_3_2_0_wb_clk_i clknet_0_wb_clk_i vssd1 vssd1 vccd1 vccd1 clknet_3_2_0_wb_clk_i
+ sky130_fd_sc_hd__clkbuf_8
Xfanout208 net214 vssd1 vssd1 vccd1 vccd1 net208 sky130_fd_sc_hd__clkbuf_4
X_07991_ net197 net204 net538 net549 vssd1 vssd1 vccd1 vccd1 _02364_ sky130_fd_sc_hd__and4_1
XFILLER_0_1_299 vssd1 vssd1 vccd1 vccd1 sky130_fd_sc_hd__decap_6
Xfanout219 net221 vssd1 vssd1 vccd1 vccd1 net219 sky130_fd_sc_hd__clkbuf_4
X_06942_ _01312_ _01313_ vssd1 vssd1 vccd1 vccd1 _01314_ sky130_fd_sc_hd__and2b_1
X_09730_ net225 net416 net422 net217 vssd1 vssd1 vccd1 vccd1 _04243_ sky130_fd_sc_hd__a22o_1
X_06873_ net218 net243 net552 net577 vssd1 vssd1 vccd1 vccd1 _01245_ sky130_fd_sc_hd__nand4_2
X_09661_ net505 net514 net146 vssd1 vssd1 vccd1 vccd1 _04167_ sky130_fd_sc_hd__o21ai_1
XFILLER_0_96_309 vssd1 vssd1 vccd1 vccd1 sky130_fd_sc_hd__decap_3
X_08612_ net296 net418 net424 net286 vssd1 vssd1 vccd1 vccd1 _03021_ sky130_fd_sc_hd__a22o_1
X_09592_ _04091_ vssd1 vssd1 vccd1 vccd1 _04092_ sky130_fd_sc_hd__inv_2
X_05824_ net263 net616 _00202_ _00204_ vssd1 vssd1 vccd1 vccd1 _00205_ sky130_fd_sc_hd__a22oi_1
XFILLER_0_82_74 vssd1 vssd1 vccd1 vccd1 sky130_fd_sc_hd__decap_4
XFILLER_0_77_501 vssd1 vssd1 vccd1 vccd1 sky130_fd_sc_hd__decap_3
X_08543_ _02941_ _02943_ _02772_ _02775_ vssd1 vssd1 vccd1 vccd1 _02945_ sky130_fd_sc_hd__a211o_1
X_05755_ net366 net372 net509 vssd1 vssd1 vccd1 vccd1 _00137_ sky130_fd_sc_hd__and3_1
XFILLER_0_77_567 vssd1 vssd1 vccd1 vccd1 sky130_fd_sc_hd__decap_4
XFILLER_0_49_225 vssd1 vssd1 vccd1 vccd1 sky130_fd_sc_hd__fill_1
X_08474_ _02867_ _02868_ _02697_ _02701_ vssd1 vssd1 vccd1 vccd1 _02870_ sky130_fd_sc_hd__a211o_1
X_05686_ _04822_ _04955_ vssd1 vssd1 vccd1 vccd1 _04956_ sky130_fd_sc_hd__xnor2_1
XFILLER_0_9_333 vssd1 vssd1 vccd1 vccd1 sky130_fd_sc_hd__decap_3
XFILLER_0_64_239 vssd1 vssd1 vccd1 vccd1 sky130_fd_sc_hd__fill_1
X_07425_ net521 net143 net129 net281 _01793_ vssd1 vssd1 vccd1 vccd1 net44 sky130_fd_sc_hd__a221o_1
X_07356_ _01723_ _01724_ vssd1 vssd1 vccd1 vccd1 _01725_ sky130_fd_sc_hd__nand2_1
XFILLER_0_17_133 vssd1 vssd1 vccd1 vccd1 sky130_ef_sc_hd__decap_12
X_06307_ _00554_ _00562_ _00561_ vssd1 vssd1 vccd1 vccd1 _00684_ sky130_fd_sc_hd__a21bo_1
X_07287_ _01654_ _01655_ vssd1 vssd1 vccd1 vccd1 _01656_ sky130_fd_sc_hd__nand2_1
X_09026_ _03317_ _03320_ _03470_ _03472_ vssd1 vssd1 vccd1 vccd1 _03473_ sky130_fd_sc_hd__o211a_1
XFILLER_0_5_572 vssd1 vssd1 vccd1 vccd1 sky130_fd_sc_hd__fill_2
X_06238_ _00611_ _00614_ vssd1 vssd1 vccd1 vccd1 _00615_ sky130_fd_sc_hd__and2b_1
XFILLER_0_32_125 vssd1 vssd1 vccd1 vccd1 sky130_fd_sc_hd__decap_4
XFILLER_0_32_147 vssd1 vssd1 vccd1 vccd1 sky130_fd_sc_hd__fill_1
XFILLER_0_20_309 vssd1 vssd1 vccd1 vccd1 sky130_fd_sc_hd__decap_4
X_06169_ _00540_ _00545_ vssd1 vssd1 vccd1 vccd1 _00547_ sky130_fd_sc_hd__xnor2_1
X_09928_ _04456_ _04457_ vssd1 vssd1 vccd1 vccd1 _04458_ sky130_fd_sc_hd__xnor2_1
X_09859_ _04377_ _04382_ vssd1 vssd1 vccd1 vccd1 _04384_ sky130_fd_sc_hd__nor2_1
XFILLER_0_23_169 vssd1 vssd1 vccd1 vccd1 sky130_fd_sc_hd__decap_3
Xinput8 wbs_dat_i[12] vssd1 vssd1 vccd1 vccd1 net8 sky130_fd_sc_hd__clkbuf_1
XFILLER_0_78_309 vssd1 vssd1 vccd1 vccd1 sky130_fd_sc_hd__decap_4
X_05540_ _04738_ _04740_ vssd1 vssd1 vccd1 vccd1 _04810_ sky130_fd_sc_hd__and2b_1
XFILLER_0_19_409 vssd1 vssd1 vccd1 vccd1 sky130_fd_sc_hd__decap_4
X_05471_ _04738_ _04739_ _04536_ vssd1 vssd1 vccd1 vccd1 _04741_ sky130_fd_sc_hd__o21bai_1
XFILLER_0_46_217 vssd1 vssd1 vccd1 vccd1 sky130_ef_sc_hd__decap_12
X_08190_ net333 net414 _02560_ _02562_ vssd1 vssd1 vccd1 vccd1 _02563_ sky130_fd_sc_hd__a22o_1
X_07210_ _01427_ _01429_ vssd1 vssd1 vccd1 vccd1 _01580_ sky130_fd_sc_hd__nor2_1
XFILLER_0_6_314 vssd1 vssd1 vccd1 vccd1 sky130_fd_sc_hd__decap_4
XFILLER_0_27_475 vssd1 vssd1 vccd1 vccd1 sky130_fd_sc_hd__decap_3
X_07141_ _01508_ _01509_ vssd1 vssd1 vccd1 vccd1 _01511_ sky130_fd_sc_hd__xor2_1
XFILLER_0_54_283 vssd1 vssd1 vccd1 vccd1 sky130_fd_sc_hd__decap_4
XFILLER_0_14_147 vssd1 vssd1 vccd1 vccd1 sky130_fd_sc_hd__fill_1
XFILLER_0_42_434 vssd1 vssd1 vccd1 vccd1 sky130_fd_sc_hd__decap_6
X_07072_ net314 net471 _01440_ _01441_ vssd1 vssd1 vccd1 vccd1 _01443_ sky130_fd_sc_hd__and4_1
XFILLER_0_2_531 vssd1 vssd1 vccd1 vccd1 sky130_fd_sc_hd__fill_1
X_06023_ _00400_ _00401_ vssd1 vssd1 vccd1 vccd1 _00402_ sky130_fd_sc_hd__xnor2_1
XFILLER_0_22_180 vssd1 vssd1 vccd1 vccd1 sky130_fd_sc_hd__decap_4
XFILLER_0_100_528 vssd1 vssd1 vccd1 vccd1 sky130_fd_sc_hd__decap_4
XFILLER_0_10_331 vssd1 vssd1 vccd1 vccd1 sky130_fd_sc_hd__decap_6
XFILLER_0_2_586 vssd1 vssd1 vccd1 vccd1 sky130_fd_sc_hd__fill_2
XFILLER_0_10_386 vssd1 vssd1 vccd1 vccd1 sky130_ef_sc_hd__decap_12
X_07974_ net340 net414 _02344_ _02345_ vssd1 vssd1 vccd1 vccd1 _02347_ sky130_fd_sc_hd__a22oi_2
X_09713_ _01838_ net392 _03310_ vssd1 vssd1 vccd1 vccd1 _04224_ sky130_fd_sc_hd__a21o_1
X_06925_ _01283_ _01295_ _01296_ vssd1 vssd1 vccd1 vccd1 _01297_ sky130_fd_sc_hd__nand3_2
X_09644_ net122 _04148_ vssd1 vssd1 vccd1 vccd1 _04149_ sky130_fd_sc_hd__nand2_1
X_06856_ net203 net602 net613 net197 vssd1 vssd1 vccd1 vccd1 _01228_ sky130_fd_sc_hd__a22o_1
XFILLER_0_93_95 vssd1 vssd1 vccd1 vccd1 sky130_fd_sc_hd__fill_2
X_05807_ net288 net589 _00186_ _00187_ vssd1 vssd1 vccd1 vccd1 _00188_ sky130_fd_sc_hd__nand4_2
XFILLER_0_89_180 vssd1 vssd1 vccd1 vccd1 sky130_ef_sc_hd__decap_12
X_09575_ _03164_ _04072_ vssd1 vssd1 vccd1 vccd1 _04073_ sky130_fd_sc_hd__xnor2_1
XTAP_1029 vssd1 vccd1 sky130_fd_sc_hd__tapvpwrvgnd_1
XTAP_1018 vssd1 vccd1 sky130_fd_sc_hd__tapvpwrvgnd_1
XTAP_1007 vssd1 vccd1 sky130_fd_sc_hd__tapvpwrvgnd_1
X_06787_ _01024_ _01026_ _01158_ _01159_ vssd1 vssd1 vccd1 vccd1 _01160_ sky130_fd_sc_hd__a211o_1
XFILLER_0_77_375 vssd1 vssd1 vccd1 vccd1 sky130_fd_sc_hd__fill_2
X_08526_ _02595_ _02763_ vssd1 vssd1 vccd1 vccd1 _02927_ sky130_fd_sc_hd__and2b_1
X_05738_ _05005_ _05006_ vssd1 vssd1 vccd1 vccd1 _05008_ sky130_fd_sc_hd__xnor2_1
XFILLER_0_92_334 vssd1 vssd1 vccd1 vccd1 sky130_fd_sc_hd__decap_4
X_08457_ net299 net432 _02641_ _02642_ net446 vssd1 vssd1 vccd1 vccd1 _02851_ sky130_fd_sc_hd__a32o_1
XFILLER_0_77_386 vssd1 vssd1 vccd1 vccd1 sky130_fd_sc_hd__fill_1
XFILLER_0_65_526 vssd1 vssd1 vccd1 vccd1 sky130_fd_sc_hd__fill_2
X_05669_ net356 net533 net543 net347 vssd1 vssd1 vccd1 vccd1 _04939_ sky130_fd_sc_hd__a22o_1
XFILLER_0_9_152 vssd1 vssd1 vccd1 vccd1 sky130_fd_sc_hd__fill_2
X_07408_ _01689_ _01690_ _01775_ _01776_ vssd1 vssd1 vccd1 vccd1 _01777_ sky130_fd_sc_hd__nor4_2
X_08388_ net184 net527 _02771_ _02773_ vssd1 vssd1 vccd1 vccd1 _02775_ sky130_fd_sc_hd__and4_1
X_07339_ _01556_ _01558_ _01706_ vssd1 vssd1 vccd1 vccd1 _01708_ sky130_fd_sc_hd__nand3_2
XFILLER_0_18_497 vssd1 vssd1 vccd1 vccd1 sky130_fd_sc_hd__fill_1
XFILLER_0_33_456 vssd1 vssd1 vccd1 vccd1 sky130_fd_sc_hd__fill_2
X_09009_ _03295_ _03297_ _03452_ _03453_ vssd1 vssd1 vccd1 vccd1 _03455_ sky130_fd_sc_hd__a211oi_2
XFILLER_0_20_139 vssd1 vssd1 vccd1 vccd1 sky130_fd_sc_hd__fill_1
Xfanout550 mul.b\[10\] vssd1 vssd1 vccd1 vccd1 net550 sky130_fd_sc_hd__buf_4
Xfanout583 mul.b\[6\] vssd1 vssd1 vccd1 vccd1 net583 sky130_fd_sc_hd__buf_2
Xfanout561 mul.b\[8\] vssd1 vssd1 vccd1 vccd1 net561 sky130_fd_sc_hd__buf_2
Xfanout572 net573 vssd1 vssd1 vccd1 vccd1 net572 sky130_fd_sc_hd__clkbuf_4
Xfanout594 net595 vssd1 vssd1 vccd1 vccd1 net594 sky130_fd_sc_hd__clkbuf_4
XFILLER_0_68_331 vssd1 vssd1 vccd1 vccd1 sky130_fd_sc_hd__decap_4
XFILLER_0_83_312 vssd1 vssd1 vccd1 vccd1 sky130_fd_sc_hd__fill_1
XFILLER_0_28_217 vssd1 vssd1 vccd1 vccd1 sky130_fd_sc_hd__fill_2
XPHY_70 vssd1 vssd1 vccd1 vccd1 sky130_fd_sc_hd__decap_3
XPHY_81 vssd1 vssd1 vccd1 vccd1 sky130_fd_sc_hd__decap_3
XPHY_92 vssd1 vssd1 vccd1 vccd1 sky130_fd_sc_hd__decap_3
XFILLER_0_36_250 vssd1 vssd1 vccd1 vccd1 sky130_fd_sc_hd__fill_2
XFILLER_0_36_272 vssd1 vssd1 vccd1 vccd1 sky130_ef_sc_hd__decap_12
XFILLER_0_98_29 vssd1 vssd1 vccd1 vccd1 sky130_fd_sc_hd__decap_8
XFILLER_0_11_117 vssd1 vssd1 vccd1 vccd1 sky130_fd_sc_hd__fill_1
X_06710_ net692 _01082_ _00943_ _00945_ vssd1 vssd1 vccd1 vccd1 _01084_ sky130_fd_sc_hd__a211o_1
X_07690_ _01902_ _01906_ _02060_ _02061_ vssd1 vssd1 vccd1 vccd1 _02062_ sky130_fd_sc_hd__o211a_1
XFILLER_0_78_139 vssd1 vssd1 vccd1 vccd1 sky130_fd_sc_hd__fill_1
X_06641_ _01007_ _01013_ vssd1 vssd1 vccd1 vccd1 _01015_ sky130_fd_sc_hd__xnor2_2
X_09360_ _03834_ _03835_ _03836_ vssd1 vssd1 vccd1 vccd1 _03839_ sky130_fd_sc_hd__o21a_1
XFILLER_0_63_98 vssd1 vssd1 vccd1 vccd1 sky130_fd_sc_hd__fill_1
X_06572_ _00820_ _00822_ net82 _00946_ vssd1 vssd1 vccd1 vccd1 _00947_ sky130_fd_sc_hd__a211oi_4
X_08311_ _02520_ _02522_ _02690_ _02691_ vssd1 vssd1 vccd1 vccd1 _02692_ sky130_fd_sc_hd__a211o_1
XFILLER_0_86_183 vssd1 vssd1 vccd1 vccd1 sky130_ef_sc_hd__decap_12
X_09291_ _03752_ _03761_ vssd1 vssd1 vccd1 vccd1 _03763_ sky130_fd_sc_hd__xor2_1
X_05523_ _04785_ _04791_ _04792_ vssd1 vssd1 vccd1 vccd1 _04793_ sky130_fd_sc_hd__nand3_1
X_08242_ net215 net500 vssd1 vssd1 vccd1 vccd1 _02616_ sky130_fd_sc_hd__nand2_1
XANTENNA_13 net397 vssd1 vssd1 vccd1 vccd1 sky130_fd_sc_hd__diode_2
X_05454_ net371 net381 net540 vssd1 vssd1 vccd1 vccd1 _04724_ sky130_fd_sc_hd__and3_1
XFILLER_0_7_623 vssd1 vssd1 vccd1 vccd1 sky130_fd_sc_hd__fill_2
XFILLER_0_6_144 vssd1 vssd1 vccd1 vccd1 sky130_ef_sc_hd__decap_12
XFILLER_0_6_133 vssd1 vssd1 vccd1 vccd1 sky130_fd_sc_hd__decap_6
X_08173_ _02542_ _02543_ vssd1 vssd1 vccd1 vccd1 _02545_ sky130_fd_sc_hd__xnor2_2
X_05385_ net361 net374 net624 net632 vssd1 vssd1 vccd1 vccd1 _04655_ sky130_fd_sc_hd__nand4_1
X_07124_ _01493_ _01494_ vssd1 vssd1 vccd1 vccd1 _01495_ sky130_fd_sc_hd__xnor2_1
XFILLER_0_70_3 vssd1 vssd1 vccd1 vccd1 sky130_fd_sc_hd__decap_3
X_07055_ net334 mul.b\[20\] net464 net323 vssd1 vssd1 vccd1 vccd1 _01426_ sky130_fd_sc_hd__a22oi_1
XFILLER_0_42_297 vssd1 vssd1 vccd1 vccd1 sky130_fd_sc_hd__decap_8
X_06006_ net306 net553 net580 net281 vssd1 vssd1 vccd1 vccd1 _00385_ sky130_fd_sc_hd__a22o_1
XFILLER_0_2_394 vssd1 vssd1 vccd1 vccd1 sky130_fd_sc_hd__decap_8
XFILLER_0_10_194 vssd1 vssd1 vccd1 vccd1 sky130_fd_sc_hd__fill_2
X_07957_ _02327_ _02328_ vssd1 vssd1 vccd1 vccd1 _02330_ sky130_fd_sc_hd__xnor2_2
X_06908_ _01278_ _01279_ vssd1 vssd1 vccd1 vccd1 _01280_ sky130_fd_sc_hd__nand2_1
X_07888_ _02258_ _02260_ _02091_ _02093_ vssd1 vssd1 vccd1 vccd1 _02262_ sky130_fd_sc_hd__o211a_1
X_09627_ _03975_ _03978_ vssd1 vssd1 vccd1 vccd1 _04130_ sky130_fd_sc_hd__nand2_1
X_06839_ _01003_ _01005_ _01210_ _01211_ vssd1 vssd1 vccd1 vccd1 _01212_ sky130_fd_sc_hd__a211oi_4
X_09558_ _04052_ _04053_ vssd1 vssd1 vccd1 vccd1 _04054_ sky130_fd_sc_hd__or2_1
X_08509_ _02874_ _02876_ _02907_ vssd1 vssd1 vccd1 vccd1 _02909_ sky130_fd_sc_hd__nor3_1
XFILLER_0_38_537 vssd1 vssd1 vccd1 vccd1 sky130_fd_sc_hd__fill_1
X_09489_ _03976_ _03977_ vssd1 vssd1 vccd1 vccd1 _03980_ sky130_fd_sc_hd__nand2b_1
XFILLER_0_38_559 vssd1 vssd1 vccd1 vccd1 sky130_fd_sc_hd__fill_1
XFILLER_0_92_186 vssd1 vssd1 vccd1 vccd1 sky130_fd_sc_hd__decap_4
XFILLER_0_18_272 vssd1 vssd1 vccd1 vccd1 sky130_fd_sc_hd__fill_1
XFILLER_0_46_581 vssd1 vssd1 vccd1 vccd1 sky130_fd_sc_hd__fill_1
XFILLER_0_46_592 vssd1 vssd1 vccd1 vccd1 sky130_fd_sc_hd__fill_1
XFILLER_0_61_573 vssd1 vssd1 vccd1 vccd1 sky130_fd_sc_hd__decap_4
XFILLER_0_33_242 vssd1 vssd1 vccd1 vccd1 sky130_ef_sc_hd__decap_12
XFILLER_0_0_309 vssd1 vssd1 vccd1 vccd1 sky130_fd_sc_hd__fill_2
Xfanout391 mul.a\[0\] vssd1 vssd1 vccd1 vccd1 net391 sky130_fd_sc_hd__buf_4
Xfanout380 net381 vssd1 vssd1 vccd1 vccd1 net380 sky130_fd_sc_hd__clkbuf_2
XFILLER_0_88_459 vssd1 vssd1 vccd1 vccd1 sky130_fd_sc_hd__fill_2
XFILLER_0_33_57 vssd1 vssd1 vccd1 vccd1 sky130_fd_sc_hd__decap_4
Xinput22 wbs_dat_i[25] vssd1 vssd1 vccd1 vccd1 net22 sky130_fd_sc_hd__clkbuf_1
XFILLER_0_71_337 vssd1 vssd1 vccd1 vccd1 sky130_fd_sc_hd__decap_6
Xinput11 wbs_dat_i[15] vssd1 vssd1 vccd1 vccd1 net11 sky130_fd_sc_hd__clkbuf_1
X_05170_ net320 net328 net622 net630 vssd1 vssd1 vccd1 vccd1 _03410_ sky130_fd_sc_hd__and4_1
XFILLER_0_24_253 vssd1 vssd1 vccd1 vccd1 sky130_fd_sc_hd__decap_8
Xinput33 wbs_dat_i[6] vssd1 vssd1 vccd1 vccd1 net33 sky130_fd_sc_hd__clkbuf_1
XFILLER_0_58_65 vssd1 vssd1 vccd1 vccd1 sky130_fd_sc_hd__decap_4
X_08860_ _03288_ _03289_ net232 net449 vssd1 vssd1 vccd1 vccd1 _03292_ sky130_fd_sc_hd__and4bb_1
X_07811_ _02179_ _02180_ _02176_ vssd1 vssd1 vccd1 vccd1 _02182_ sky130_fd_sc_hd__a21o_1
X_08791_ _03215_ _03216_ vssd1 vssd1 vccd1 vccd1 _03217_ sky130_fd_sc_hd__xnor2_1
X_07742_ _01803_ _01974_ _01973_ vssd1 vssd1 vccd1 vccd1 _02113_ sky130_fd_sc_hd__o21bai_2
X_07673_ net299 net459 _02042_ _02043_ vssd1 vssd1 vccd1 vccd1 _02045_ sky130_fd_sc_hd__nand4_4
XFILLER_0_94_418 vssd1 vssd1 vccd1 vccd1 sky130_fd_sc_hd__fill_2
XFILLER_0_94_407 vssd1 vssd1 vccd1 vccd1 sky130_fd_sc_hd__decap_4
X_09412_ net208 net216 net436 net442 vssd1 vssd1 vccd1 vccd1 _03895_ sky130_fd_sc_hd__nand4_2
X_06624_ _00996_ _00997_ vssd1 vssd1 vccd1 vccd1 _00998_ sky130_fd_sc_hd__nand2_1
X_09343_ _03670_ _03674_ _03672_ vssd1 vssd1 vccd1 vccd1 _03820_ sky130_fd_sc_hd__a21oi_1
XFILLER_0_90_41 vssd1 vssd1 vccd1 vccd1 sky130_fd_sc_hd__decap_8
XFILLER_0_90_85 vssd1 vssd1 vccd1 vccd1 sky130_fd_sc_hd__fill_1
X_06555_ _00926_ _00927_ _00928_ vssd1 vssd1 vccd1 vccd1 _00930_ sky130_fd_sc_hd__a21o_1
X_09274_ _03729_ _03730_ _03742_ vssd1 vssd1 vccd1 vccd1 _03744_ sky130_fd_sc_hd__o21ai_1
XFILLER_0_7_431 vssd1 vssd1 vccd1 vccd1 sky130_ef_sc_hd__decap_12
X_05506_ _04773_ _04774_ _04720_ vssd1 vssd1 vccd1 vccd1 _04776_ sky130_fd_sc_hd__a21o_1
X_06486_ net273 net552 net577 net243 vssd1 vssd1 vccd1 vccd1 _00861_ sky130_fd_sc_hd__a22o_1
XFILLER_0_35_518 vssd1 vssd1 vccd1 vccd1 sky130_fd_sc_hd__decap_4
XFILLER_0_47_367 vssd1 vssd1 vccd1 vccd1 sky130_fd_sc_hd__fill_2
X_08225_ _02275_ _02436_ _02437_ vssd1 vssd1 vccd1 vccd1 _02599_ sky130_fd_sc_hd__or3_4
XFILLER_0_7_464 vssd1 vssd1 vccd1 vccd1 sky130_fd_sc_hd__decap_3
X_05437_ _04703_ _04704_ _04705_ vssd1 vssd1 vccd1 vccd1 _04707_ sky130_fd_sc_hd__a21o_1
XFILLER_0_28_581 vssd1 vssd1 vccd1 vccd1 sky130_fd_sc_hd__decap_6
XFILLER_0_99_61 vssd1 vssd1 vccd1 vccd1 sky130_fd_sc_hd__fill_1
X_08156_ _02403_ _02406_ _02526_ _02527_ vssd1 vssd1 vccd1 vccd1 _02528_ sky130_fd_sc_hd__o211ai_4
XFILLER_0_62_359 vssd1 vssd1 vccd1 vccd1 sky130_fd_sc_hd__decap_4
X_05368_ _04607_ _04610_ _04609_ vssd1 vssd1 vccd1 vccd1 _04638_ sky130_fd_sc_hd__a21oi_1
XFILLER_0_30_201 vssd1 vssd1 vccd1 vccd1 sky130_fd_sc_hd__fill_1
X_07107_ _01337_ _01339_ _01476_ _01477_ vssd1 vssd1 vccd1 vccd1 _01478_ sky130_fd_sc_hd__a211oi_2
XFILLER_0_101_623 vssd1 vssd1 vccd1 vccd1 sky130_fd_sc_hd__fill_2
X_08087_ _02119_ _02458_ vssd1 vssd1 vccd1 vccd1 _02459_ sky130_fd_sc_hd__or2_1
X_05299_ _04559_ _04568_ vssd1 vssd1 vccd1 vccd1 _04569_ sky130_fd_sc_hd__nor2_1
XFILLER_0_30_256 vssd1 vssd1 vccd1 vccd1 sky130_fd_sc_hd__decap_6
XFILLER_0_30_267 vssd1 vssd1 vccd1 vccd1 sky130_ef_sc_hd__decap_12
X_07038_ net390 net413 _01406_ _01407_ vssd1 vssd1 vccd1 vccd1 _01409_ sky130_fd_sc_hd__o2bb2a_1
X_08989_ _03416_ _03417_ _03429_ vssd1 vssd1 vccd1 vccd1 _03433_ sky130_fd_sc_hd__o21ai_2
XFILLER_0_97_278 vssd1 vssd1 vccd1 vccd1 sky130_fd_sc_hd__fill_2
XFILLER_0_80_101 vssd1 vssd1 vccd1 vccd1 sky130_fd_sc_hd__decap_6
XFILLER_0_53_337 vssd1 vssd1 vccd1 vccd1 sky130_ef_sc_hd__decap_12
XFILLER_0_80_167 vssd1 vssd1 vccd1 vccd1 sky130_fd_sc_hd__fill_2
XTAP_407 vssd1 vccd1 sky130_fd_sc_hd__tapvpwrvgnd_1
XTAP_418 vssd1 vccd1 sky130_fd_sc_hd__tapvpwrvgnd_1
XTAP_429 vssd1 vccd1 sky130_fd_sc_hd__tapvpwrvgnd_1
XFILLER_0_88_234 vssd1 vssd1 vccd1 vccd1 sky130_fd_sc_hd__decap_8
XFILLER_0_88_223 vssd1 vssd1 vccd1 vccd1 sky130_fd_sc_hd__fill_1
XFILLER_0_76_407 vssd1 vssd1 vccd1 vccd1 sky130_ef_sc_hd__decap_12
XFILLER_0_60_11 vssd1 vssd1 vccd1 vccd1 sky130_fd_sc_hd__decap_3
XFILLER_0_8_206 vssd1 vssd1 vccd1 vccd1 sky130_fd_sc_hd__decap_8
XTAP_1190 vssd1 vccd1 sky130_fd_sc_hd__tapvpwrvgnd_1
XFILLER_0_84_473 vssd1 vssd1 vccd1 vccd1 sky130_fd_sc_hd__decap_3
XFILLER_0_56_153 vssd1 vssd1 vccd1 vccd1 sky130_fd_sc_hd__decap_3
X_06340_ net592 net142 net128 net351 vssd1 vssd1 vccd1 vccd1 _00717_ sky130_fd_sc_hd__a22o_1
XFILLER_0_29_389 vssd1 vssd1 vccd1 vccd1 sky130_fd_sc_hd__decap_3
XFILLER_0_56_197 vssd1 vssd1 vccd1 vccd1 sky130_fd_sc_hd__decap_8
X_06271_ net370 net379 net454 net461 vssd1 vssd1 vccd1 vccd1 _00648_ sky130_fd_sc_hd__and4_1
XFILLER_0_44_337 vssd1 vssd1 vccd1 vccd1 sky130_ef_sc_hd__decap_12
X_08010_ net255 net485 net494 net245 vssd1 vssd1 vccd1 vccd1 _02383_ sky130_fd_sc_hd__a22o_1
X_05222_ _03618_ _03957_ _03968_ vssd1 vssd1 vccd1 vccd1 _03979_ sky130_fd_sc_hd__or3_2
XFILLER_0_44_359 vssd1 vssd1 vccd1 vccd1 sky130_fd_sc_hd__decap_4
X_05153_ _03159_ _03170_ vssd1 vssd1 vccd1 vccd1 _03225_ sky130_fd_sc_hd__and2b_1
XFILLER_0_100_83 vssd1 vssd1 vccd1 vccd1 sky130_fd_sc_hd__fill_1
X_05084_ net34 net573 net125 vssd1 vssd1 vccd1 vccd1 _00074_ sky130_fd_sc_hd__mux2_1
XFILLER_0_40_576 vssd1 vssd1 vccd1 vccd1 sky130_fd_sc_hd__fill_1
X_09961_ _04376_ _04385_ _04384_ vssd1 vssd1 vccd1 vccd1 _04495_ sky130_fd_sc_hd__a21o_1
X_08912_ _03308_ _03309_ _03346_ _03347_ vssd1 vssd1 vccd1 vccd1 _03349_ sky130_fd_sc_hd__or4_4
XTAP_952 vssd1 vccd1 sky130_fd_sc_hd__tapvpwrvgnd_1
XTAP_941 vssd1 vccd1 sky130_fd_sc_hd__tapvpwrvgnd_1
XTAP_930 vssd1 vccd1 sky130_fd_sc_hd__tapvpwrvgnd_1
X_09892_ _04259_ _04261_ _04419_ vssd1 vssd1 vccd1 vccd1 _04420_ sky130_fd_sc_hd__o21a_1
X_08843_ _03272_ _03266_ vssd1 vssd1 vccd1 vccd1 _03273_ sky130_fd_sc_hd__and2b_1
XTAP_996 vssd1 vccd1 sky130_fd_sc_hd__tapvpwrvgnd_1
XTAP_985 vssd1 vccd1 sky130_fd_sc_hd__tapvpwrvgnd_1
XTAP_974 vssd1 vccd1 sky130_fd_sc_hd__tapvpwrvgnd_1
XTAP_963 vssd1 vccd1 sky130_fd_sc_hd__tapvpwrvgnd_1
X_08774_ _03156_ _03157_ _03194_ _03195_ vssd1 vssd1 vccd1 vccd1 _03198_ sky130_fd_sc_hd__o22ai_2
X_05986_ _00321_ _00322_ _00363_ _00364_ vssd1 vssd1 vccd1 vccd1 _00366_ sky130_fd_sc_hd__a2bb2o_1
XFILLER_0_33_3 vssd1 vssd1 vccd1 vccd1 sky130_ef_sc_hd__decap_12
X_07725_ _01997_ _01998_ _02095_ _02096_ vssd1 vssd1 vccd1 vccd1 _02097_ sky130_fd_sc_hd__or4bb_4
XFILLER_0_94_226 vssd1 vssd1 vccd1 vccd1 sky130_fd_sc_hd__fill_2
X_07656_ _02024_ _02025_ _02026_ vssd1 vssd1 vccd1 vccd1 _02028_ sky130_fd_sc_hd__nand3_1
X_06607_ _00849_ _00854_ _00980_ vssd1 vssd1 vccd1 vccd1 _00981_ sky130_fd_sc_hd__o21ai_2
XFILLER_0_47_131 vssd1 vssd1 vccd1 vccd1 sky130_fd_sc_hd__decap_8
X_07587_ _01957_ _01958_ vssd1 vssd1 vccd1 vccd1 _01959_ sky130_fd_sc_hd__nor2_1
X_09326_ _03787_ _03799_ _03800_ vssd1 vssd1 vccd1 vccd1 _03801_ sky130_fd_sc_hd__or3_2
X_06538_ net321 net495 vssd1 vssd1 vccd1 vccd1 _00913_ sky130_fd_sc_hd__nand2_1
XFILLER_0_47_142 vssd1 vssd1 vccd1 vccd1 sky130_fd_sc_hd__fill_1
X_09257_ _03718_ _03719_ _03724_ vssd1 vssd1 vccd1 vccd1 _03725_ sky130_fd_sc_hd__nand3_1
XFILLER_0_90_454 vssd1 vssd1 vccd1 vccd1 sky130_fd_sc_hd__decap_6
X_08208_ _02578_ _02579_ _02418_ _02420_ vssd1 vssd1 vccd1 vccd1 _02581_ sky130_fd_sc_hd__a211oi_2
X_06469_ net227 net597 net609 net219 vssd1 vssd1 vccd1 vccd1 _00844_ sky130_fd_sc_hd__a22o_1
X_09188_ _03641_ _03648_ vssd1 vssd1 vccd1 vccd1 _03650_ sky130_fd_sc_hd__xnor2_1
X_08139_ _02509_ _02510_ vssd1 vssd1 vccd1 vccd1 _02511_ sky130_fd_sc_hd__and2b_1
X_10101_ clknet_3_5_0_wb_clk_i _00097_ _00033_ vssd1 vssd1 vccd1 vccd1 mul.b\[30\]
+ sky130_fd_sc_hd__dfrtp_4
X_10032_ net644 vssd1 vssd1 vccd1 vccd1 _00028_ sky130_fd_sc_hd__inv_2
XFILLER_0_58_418 vssd1 vssd1 vccd1 vccd1 sky130_fd_sc_hd__fill_2
XFILLER_0_14_59 vssd1 vssd1 vccd1 vccd1 sky130_fd_sc_hd__fill_1
XFILLER_0_93_292 vssd1 vssd1 vccd1 vccd1 sky130_fd_sc_hd__fill_1
XFILLER_0_93_281 vssd1 vssd1 vccd1 vccd1 sky130_fd_sc_hd__fill_1
XFILLER_0_53_134 vssd1 vssd1 vccd1 vccd1 sky130_ef_sc_hd__decap_12
XFILLER_0_30_25 vssd1 vssd1 vccd1 vccd1 sky130_fd_sc_hd__decap_3
XFILLER_0_53_167 vssd1 vssd1 vccd1 vccd1 sky130_fd_sc_hd__fill_1
XFILLER_0_22_587 vssd1 vssd1 vccd1 vccd1 sky130_fd_sc_hd__fill_1
XTAP_204 vssd1 vccd1 sky130_fd_sc_hd__tapvpwrvgnd_1
XTAP_215 vssd1 vccd1 sky130_fd_sc_hd__tapvpwrvgnd_1
XTAP_248 vssd1 vccd1 sky130_fd_sc_hd__tapvpwrvgnd_1
XTAP_226 vssd1 vccd1 sky130_fd_sc_hd__tapvpwrvgnd_1
XTAP_237 vssd1 vccd1 sky130_fd_sc_hd__tapvpwrvgnd_1
XTAP_259 vssd1 vccd1 sky130_fd_sc_hd__tapvpwrvgnd_1
X_05840_ _00201_ _00219_ vssd1 vssd1 vccd1 vccd1 _00221_ sky130_fd_sc_hd__nand2_1
XFILLER_0_89_565 vssd1 vssd1 vccd1 vccd1 sky130_fd_sc_hd__decap_6
X_07510_ _01722_ _01724_ _01880_ _01882_ vssd1 vssd1 vccd1 vccd1 _01883_ sky130_fd_sc_hd__a211o_1
X_05771_ _00134_ _00151_ _00152_ vssd1 vssd1 vccd1 vccd1 _00153_ sky130_fd_sc_hd__nand3_2
X_08490_ _02883_ _02884_ _02885_ vssd1 vssd1 vccd1 vccd1 _02888_ sky130_fd_sc_hd__a21bo_1
XFILLER_0_76_248 vssd1 vssd1 vccd1 vccd1 sky130_fd_sc_hd__decap_4
X_07441_ _01807_ _01808_ vssd1 vssd1 vccd1 vccd1 _01809_ sky130_fd_sc_hd__and2_1
X_07372_ _01736_ _01739_ _01740_ vssd1 vssd1 vccd1 vccd1 _01741_ sky130_fd_sc_hd__and3_1
XFILLER_0_57_440 vssd1 vssd1 vccd1 vccd1 sky130_fd_sc_hd__decap_8
XFILLER_0_17_304 vssd1 vssd1 vccd1 vccd1 sky130_fd_sc_hd__fill_1
XFILLER_0_72_421 vssd1 vssd1 vccd1 vccd1 sky130_fd_sc_hd__decap_6
X_09111_ net157 net524 vssd1 vssd1 vccd1 vccd1 _03566_ sky130_fd_sc_hd__and2_1
X_06323_ _00697_ _00698_ _00576_ _00578_ vssd1 vssd1 vccd1 vccd1 _00700_ sky130_fd_sc_hd__a211oi_2
XFILLER_0_29_175 vssd1 vssd1 vccd1 vccd1 sky130_fd_sc_hd__fill_1
XFILLER_0_17_348 vssd1 vssd1 vccd1 vccd1 sky130_fd_sc_hd__fill_2
X_09042_ _03332_ _03336_ _03488_ vssd1 vssd1 vccd1 vccd1 _03491_ sky130_fd_sc_hd__and3_1
X_06254_ _00628_ _00629_ vssd1 vssd1 vccd1 vccd1 _00631_ sky130_fd_sc_hd__xor2_1
XFILLER_0_32_307 vssd1 vssd1 vccd1 vccd1 sky130_fd_sc_hd__fill_1
XFILLER_0_44_189 vssd1 vssd1 vccd1 vccd1 sky130_fd_sc_hd__decap_6
XFILLER_0_4_253 vssd1 vssd1 vccd1 vccd1 sky130_fd_sc_hd__decap_3
X_06185_ _00554_ _00561_ _00562_ vssd1 vssd1 vccd1 vccd1 _00563_ sky130_fd_sc_hd__nand3_2
XFILLER_0_25_381 vssd1 vssd1 vccd1 vccd1 sky130_fd_sc_hd__fill_1
X_05205_ net352 net614 vssd1 vssd1 vccd1 vccd1 _03793_ sky130_fd_sc_hd__and2_1
X_05136_ net353 net377 net551 net575 vssd1 vssd1 vccd1 vccd1 _03039_ sky130_fd_sc_hd__nand4_2
XFILLER_0_13_576 vssd1 vssd1 vccd1 vccd1 sky130_fd_sc_hd__fill_1
XFILLER_0_40_340 vssd1 vssd1 vccd1 vccd1 sky130_fd_sc_hd__decap_6
XFILLER_0_96_51 vssd1 vssd1 vccd1 vccd1 sky130_fd_sc_hd__decap_3
XFILLER_0_40_373 vssd1 vssd1 vccd1 vccd1 sky130_fd_sc_hd__fill_2
X_05067_ net21 net432 net127 vssd1 vssd1 vccd1 vccd1 _00091_ sky130_fd_sc_hd__mux2_1
X_09944_ _04410_ _04412_ _04408_ vssd1 vssd1 vccd1 vccd1 _04476_ sky130_fd_sc_hd__a21oi_2
X_09875_ _04399_ _04400_ vssd1 vssd1 vccd1 vccd1 _04401_ sky130_fd_sc_hd__xnor2_1
XTAP_760 vssd1 vccd1 sky130_fd_sc_hd__tapvpwrvgnd_1
XFILLER_0_99_307 vssd1 vssd1 vccd1 vccd1 sky130_fd_sc_hd__fill_2
X_08826_ net178 net507 net515 net174 vssd1 vssd1 vccd1 vccd1 _03254_ sky130_fd_sc_hd__a22o_1
XTAP_793 vssd1 vccd1 sky130_fd_sc_hd__tapvpwrvgnd_1
XTAP_782 vssd1 vccd1 sky130_fd_sc_hd__tapvpwrvgnd_1
XTAP_771 vssd1 vccd1 sky130_fd_sc_hd__tapvpwrvgnd_1
X_08757_ net296 net412 _03177_ _03178_ vssd1 vssd1 vccd1 vccd1 _03179_ sky130_fd_sc_hd__o2bb2a_1
X_05969_ _00238_ _00246_ _00245_ vssd1 vssd1 vccd1 vccd1 _00349_ sky130_fd_sc_hd__a21bo_1
X_08688_ net179 net186 net506 vssd1 vssd1 vccd1 vccd1 _03103_ sky130_fd_sc_hd__and3_1
X_07708_ _02073_ _02074_ _02079_ vssd1 vssd1 vccd1 vccd1 _02080_ sky130_fd_sc_hd__nand3_2
X_07639_ _01841_ _01843_ _01842_ vssd1 vssd1 vccd1 vccd1 _02011_ sky130_fd_sc_hd__a21bo_1
X_09309_ _03633_ _03635_ vssd1 vssd1 vccd1 vccd1 _03783_ sky130_fd_sc_hd__nand2_1
XFILLER_0_63_410 vssd1 vssd1 vccd1 vccd1 sky130_fd_sc_hd__fill_1
XFILLER_0_48_473 vssd1 vssd1 vccd1 vccd1 sky130_fd_sc_hd__decap_3
XFILLER_0_63_465 vssd1 vssd1 vccd1 vccd1 sky130_fd_sc_hd__fill_1
XFILLER_0_8_581 vssd1 vssd1 vccd1 vccd1 sky130_fd_sc_hd__decap_6
XFILLER_0_50_115 vssd1 vssd1 vccd1 vccd1 sky130_ef_sc_hd__decap_12
XFILLER_0_35_167 vssd1 vssd1 vccd1 vccd1 sky130_fd_sc_hd__fill_1
XFILLER_0_31_362 vssd1 vssd1 vccd1 vccd1 sky130_fd_sc_hd__decap_8
X_10015_ net639 vssd1 vssd1 vccd1 vccd1 _00011_ sky130_fd_sc_hd__inv_2
XFILLER_0_86_502 vssd1 vssd1 vccd1 vccd1 sky130_fd_sc_hd__fill_1
XFILLER_0_26_101 vssd1 vssd1 vccd1 vccd1 sky130_fd_sc_hd__fill_1
XFILLER_0_39_495 vssd1 vssd1 vccd1 vccd1 sky130_fd_sc_hd__decap_8
XFILLER_0_41_46 vssd1 vssd1 vccd1 vccd1 sky130_fd_sc_hd__decap_8
XFILLER_0_41_68 vssd1 vssd1 vccd1 vccd1 sky130_fd_sc_hd__fill_2
XFILLER_0_81_251 vssd1 vssd1 vccd1 vccd1 sky130_fd_sc_hd__fill_1
XFILLER_0_41_104 vssd1 vssd1 vccd1 vccd1 sky130_fd_sc_hd__fill_1
XFILLER_0_10_513 vssd1 vssd1 vccd1 vccd1 sky130_ef_sc_hd__decap_12
X_07990_ net204 net538 net548 net193 vssd1 vssd1 vccd1 vccd1 _02363_ sky130_fd_sc_hd__a22o_1
Xfanout209 net214 vssd1 vssd1 vccd1 vccd1 net209 sky130_fd_sc_hd__clkbuf_4
X_06941_ net285 net507 net514 net277 vssd1 vssd1 vccd1 vccd1 _01313_ sky130_fd_sc_hd__a22o_1
X_09660_ net146 net505 net514 vssd1 vssd1 vccd1 vccd1 _04166_ sky130_fd_sc_hd__and3_1
X_08611_ net290 net431 _02808_ _02810_ net443 vssd1 vssd1 vccd1 vccd1 _03020_ sky130_fd_sc_hd__a32o_1
X_06872_ _01107_ _01242_ vssd1 vssd1 vccd1 vccd1 _01244_ sky130_fd_sc_hd__xnor2_2
X_09591_ net230 net416 net422 net222 vssd1 vssd1 vccd1 vccd1 _04091_ sky130_fd_sc_hd__a22o_1
X_05823_ _00203_ vssd1 vssd1 vccd1 vccd1 _00204_ sky130_fd_sc_hd__inv_2
XFILLER_0_77_513 vssd1 vssd1 vccd1 vccd1 sky130_fd_sc_hd__fill_2
X_08542_ _02772_ _02775_ _02941_ _02943_ vssd1 vssd1 vccd1 vccd1 _02944_ sky130_fd_sc_hd__o211ai_2
X_05754_ net372 net504 net513 net366 vssd1 vssd1 vccd1 vccd1 _00136_ sky130_fd_sc_hd__a22o_1
X_08473_ _02697_ _02701_ _02867_ _02868_ vssd1 vssd1 vccd1 vccd1 _02869_ sky130_fd_sc_hd__o211ai_2
X_05685_ _04953_ _04954_ vssd1 vssd1 vccd1 vccd1 _04955_ sky130_fd_sc_hd__and2b_1
XFILLER_0_15_91 vssd1 vssd1 vccd1 vccd1 sky130_ef_sc_hd__decap_12
X_07424_ _00182_ _01792_ vssd1 vssd1 vccd1 vccd1 _01793_ sky130_fd_sc_hd__nor2_1
XFILLER_0_72_240 vssd1 vssd1 vccd1 vccd1 sky130_fd_sc_hd__decap_3
X_07355_ net324 net452 _01721_ _01722_ vssd1 vssd1 vccd1 vccd1 _01724_ sky130_fd_sc_hd__nand4_2
XFILLER_0_57_292 vssd1 vssd1 vccd1 vccd1 sky130_fd_sc_hd__decap_4
XFILLER_0_17_145 vssd1 vssd1 vccd1 vccd1 sky130_fd_sc_hd__decap_3
XFILLER_0_72_251 vssd1 vssd1 vccd1 vccd1 sky130_fd_sc_hd__fill_1
X_06306_ _00680_ _00681_ _00673_ vssd1 vssd1 vccd1 vccd1 _00683_ sky130_fd_sc_hd__a21o_1
X_07286_ net175 net619 _01505_ _01504_ vssd1 vssd1 vccd1 vccd1 _01655_ sky130_fd_sc_hd__a31o_1
X_09025_ net303 net396 _03467_ _03469_ vssd1 vssd1 vccd1 vccd1 _03472_ sky130_fd_sc_hd__nand4_1
X_06237_ _00612_ _00613_ vssd1 vssd1 vccd1 vccd1 _00614_ sky130_fd_sc_hd__nor2_1
X_06168_ _00540_ _00545_ vssd1 vssd1 vccd1 vccd1 _00546_ sky130_fd_sc_hd__nand2b_1
XFILLER_0_40_170 vssd1 vssd1 vccd1 vccd1 sky130_fd_sc_hd__decap_4
X_06099_ _00473_ _00475_ _00314_ _00317_ vssd1 vssd1 vccd1 vccd1 _00478_ sky130_fd_sc_hd__o211a_1
X_05119_ _02820_ _02831_ _02809_ vssd1 vssd1 vccd1 vccd1 _02853_ sky130_fd_sc_hd__a21bo_1
X_09927_ net249 net392 vssd1 vssd1 vccd1 vccd1 _04457_ sky130_fd_sc_hd__and2b_1
XTAP_590 vssd1 vccd1 sky130_fd_sc_hd__tapvpwrvgnd_1
X_09858_ _04380_ _04381_ vssd1 vssd1 vccd1 vccd1 _04382_ sky130_fd_sc_hd__xor2_1
X_09789_ _04305_ _04306_ vssd1 vssd1 vccd1 vccd1 _04308_ sky130_fd_sc_hd__nand2_1
X_08809_ _03234_ _03235_ vssd1 vssd1 vccd1 vccd1 _03237_ sky130_fd_sc_hd__and2b_1
XFILLER_0_95_376 vssd1 vssd1 vccd1 vccd1 sky130_fd_sc_hd__fill_1
XFILLER_0_83_505 vssd1 vssd1 vccd1 vccd1 sky130_fd_sc_hd__decap_3
XFILLER_0_95_398 vssd1 vssd1 vccd1 vccd1 sky130_fd_sc_hd__fill_2
XFILLER_0_36_410 vssd1 vssd1 vccd1 vccd1 sky130_fd_sc_hd__fill_1
XFILLER_0_23_148 vssd1 vssd1 vccd1 vccd1 sky130_fd_sc_hd__decap_6
XFILLER_0_36_46 vssd1 vssd1 vccd1 vccd1 sky130_ef_sc_hd__decap_12
Xinput9 wbs_dat_i[13] vssd1 vssd1 vccd1 vccd1 net9 sky130_fd_sc_hd__clkbuf_1
XFILLER_0_59_557 vssd1 vssd1 vccd1 vccd1 sky130_fd_sc_hd__decap_3
XFILLER_0_86_365 vssd1 vssd1 vccd1 vccd1 sky130_fd_sc_hd__decap_6
XFILLER_0_74_538 vssd1 vssd1 vccd1 vccd1 sky130_fd_sc_hd__decap_4
X_05470_ _04738_ _04739_ _04536_ vssd1 vssd1 vccd1 vccd1 _04740_ sky130_fd_sc_hd__or3b_4
XFILLER_0_46_229 vssd1 vssd1 vccd1 vccd1 sky130_fd_sc_hd__fill_1
XFILLER_0_54_240 vssd1 vssd1 vccd1 vccd1 sky130_fd_sc_hd__decap_3
XFILLER_0_39_281 vssd1 vssd1 vccd1 vccd1 sky130_ef_sc_hd__decap_12
XFILLER_0_82_571 vssd1 vssd1 vccd1 vccd1 sky130_ef_sc_hd__decap_12
X_07140_ _01508_ _01509_ vssd1 vssd1 vccd1 vccd1 _01510_ sky130_fd_sc_hd__and2b_1
X_07071_ net314 net473 _01440_ _01441_ vssd1 vssd1 vccd1 vccd1 _01442_ sky130_fd_sc_hd__a22oi_1
XFILLER_0_42_457 vssd1 vssd1 vccd1 vccd1 sky130_fd_sc_hd__fill_2
X_06022_ net244 net617 vssd1 vssd1 vccd1 vccd1 _00401_ sky130_fd_sc_hd__nand2_1
XFILLER_0_77_42 vssd1 vssd1 vccd1 vccd1 sky130_fd_sc_hd__decap_6
XFILLER_0_2_598 vssd1 vssd1 vccd1 vccd1 sky130_fd_sc_hd__fill_1
XFILLER_0_22_192 vssd1 vssd1 vccd1 vccd1 sky130_fd_sc_hd__decap_4
XFILLER_0_10_365 vssd1 vssd1 vccd1 vccd1 sky130_fd_sc_hd__decap_8
X_07973_ _02345_ vssd1 vssd1 vccd1 vccd1 _02346_ sky130_fd_sc_hd__inv_2
X_09712_ _04041_ _04063_ _04062_ vssd1 vssd1 vccd1 vccd1 _04223_ sky130_fd_sc_hd__o21ai_1
XFILLER_0_10_398 vssd1 vssd1 vccd1 vccd1 sky130_fd_sc_hd__decap_6
X_06924_ _01293_ _01294_ _01288_ vssd1 vssd1 vccd1 vccd1 _01296_ sky130_fd_sc_hd__a21o_1
X_09643_ _04145_ _04146_ vssd1 vssd1 vccd1 vccd1 _04148_ sky130_fd_sc_hd__xnor2_1
X_06855_ net197 net203 net602 net613 vssd1 vssd1 vccd1 vccd1 _01227_ sky130_fd_sc_hd__and4_1
X_09574_ net276 net136 _04071_ _03310_ vssd1 vssd1 vccd1 vccd1 _04072_ sky130_fd_sc_hd__o22a_1
X_05806_ mul.a\[8\] net554 net581 net298 vssd1 vssd1 vccd1 vccd1 _00187_ sky130_fd_sc_hd__a22o_1
XFILLER_0_89_192 vssd1 vssd1 vccd1 vccd1 sky130_fd_sc_hd__decap_8
X_08525_ _02924_ _02925_ vssd1 vssd1 vccd1 vccd1 _02926_ sky130_fd_sc_hd__or2_1
XTAP_1019 vssd1 vccd1 sky130_fd_sc_hd__tapvpwrvgnd_1
XTAP_1008 vssd1 vccd1 sky130_fd_sc_hd__tapvpwrvgnd_1
X_06786_ net357 net448 _01155_ _01157_ vssd1 vssd1 vccd1 vccd1 _01159_ sky130_fd_sc_hd__a22oi_2
X_05737_ _05006_ _05005_ vssd1 vssd1 vccd1 vccd1 _05007_ sky130_fd_sc_hd__nand2b_1
X_08456_ _02688_ _02691_ vssd1 vssd1 vccd1 vccd1 _02850_ sky130_fd_sc_hd__or2_1
X_05668_ net364 net523 vssd1 vssd1 vccd1 vccd1 _04938_ sky130_fd_sc_hd__and2_1
X_08387_ net184 net527 _02771_ _02773_ vssd1 vssd1 vccd1 vccd1 _02774_ sky130_fd_sc_hd__a22o_1
XFILLER_0_9_164 vssd1 vssd1 vccd1 vccd1 sky130_fd_sc_hd__fill_1
XFILLER_0_18_421 vssd1 vssd1 vccd1 vccd1 sky130_fd_sc_hd__decap_4
X_07407_ net655 _01774_ _01625_ _01628_ vssd1 vssd1 vccd1 vccd1 _01776_ sky130_fd_sc_hd__a211oi_2
XFILLER_0_73_571 vssd1 vssd1 vccd1 vccd1 sky130_fd_sc_hd__fill_1
X_07338_ _01556_ _01558_ _01706_ vssd1 vssd1 vccd1 vccd1 _01707_ sky130_fd_sc_hd__a21o_2
X_05599_ _04868_ _04861_ vssd1 vssd1 vccd1 vccd1 _04869_ sky130_fd_sc_hd__and2b_1
XFILLER_0_45_284 vssd1 vssd1 vccd1 vccd1 sky130_fd_sc_hd__decap_6
XFILLER_0_5_381 vssd1 vssd1 vccd1 vccd1 sky130_fd_sc_hd__decap_4
XFILLER_0_21_608 vssd1 vssd1 vccd1 vccd1 sky130_fd_sc_hd__fill_2
X_07269_ _01635_ _01637_ _01398_ _01400_ vssd1 vssd1 vccd1 vccd1 _01639_ sky130_fd_sc_hd__o211ai_2
X_09008_ _03273_ _03275_ _03451_ vssd1 vssd1 vccd1 vccd1 _03453_ sky130_fd_sc_hd__nor3_2
XFILLER_0_60_298 vssd1 vssd1 vccd1 vccd1 sky130_fd_sc_hd__decap_3
Xfanout540 net542 vssd1 vssd1 vccd1 vccd1 net540 sky130_fd_sc_hd__clkbuf_4
Xfanout551 net552 vssd1 vssd1 vccd1 vccd1 net551 sky130_fd_sc_hd__clkbuf_4
Xfanout584 mul.b\[6\] vssd1 vssd1 vccd1 vccd1 net584 sky130_fd_sc_hd__buf_4
Xfanout562 net563 vssd1 vssd1 vccd1 vccd1 net562 sky130_fd_sc_hd__clkbuf_4
Xfanout573 mul.b\[7\] vssd1 vssd1 vccd1 vccd1 net573 sky130_fd_sc_hd__buf_2
Xfanout595 net596 vssd1 vssd1 vccd1 vccd1 net595 sky130_fd_sc_hd__clkbuf_4
XFILLER_0_87_107 vssd1 vssd1 vccd1 vccd1 sky130_fd_sc_hd__fill_1
XFILLER_0_95_140 vssd1 vssd1 vccd1 vccd1 sky130_fd_sc_hd__decap_8
XPHY_60 vssd1 vssd1 vccd1 vccd1 sky130_fd_sc_hd__decap_3
XPHY_71 vssd1 vssd1 vccd1 vccd1 sky130_fd_sc_hd__decap_3
XPHY_82 vssd1 vssd1 vccd1 vccd1 sky130_fd_sc_hd__decap_3
XPHY_93 vssd1 vssd1 vccd1 vccd1 sky130_fd_sc_hd__decap_3
XFILLER_0_83_379 vssd1 vssd1 vccd1 vccd1 sky130_ef_sc_hd__decap_12
XFILLER_0_24_402 vssd1 vssd1 vccd1 vccd1 sky130_fd_sc_hd__decap_8
XFILLER_0_36_284 vssd1 vssd1 vccd1 vccd1 sky130_ef_sc_hd__decap_12
XFILLER_0_47_23 vssd1 vssd1 vccd1 vccd1 sky130_ef_sc_hd__decap_12
X_06640_ _01013_ _01007_ vssd1 vssd1 vccd1 vccd1 _01014_ sky130_fd_sc_hd__and2b_1
XFILLER_0_59_365 vssd1 vssd1 vccd1 vccd1 sky130_ef_sc_hd__decap_12
XFILLER_0_59_343 vssd1 vssd1 vccd1 vccd1 sky130_fd_sc_hd__decap_8
X_06571_ _00879_ _00880_ _00943_ _00944_ vssd1 vssd1 vccd1 vccd1 _00946_ sky130_fd_sc_hd__o22a_1
XFILLER_0_47_505 vssd1 vssd1 vccd1 vccd1 sky130_ef_sc_hd__decap_12
X_08310_ net325 net413 _02686_ _02687_ vssd1 vssd1 vccd1 vccd1 _02691_ sky130_fd_sc_hd__and4_1
X_09290_ _03752_ _03761_ vssd1 vssd1 vccd1 vccd1 _03762_ sky130_fd_sc_hd__nor2_1
XFILLER_0_59_387 vssd1 vssd1 vccd1 vccd1 sky130_fd_sc_hd__decap_4
X_05522_ _04788_ _04789_ _04790_ vssd1 vssd1 vccd1 vccd1 _04792_ sky130_fd_sc_hd__a21o_1
XFILLER_0_86_195 vssd1 vssd1 vccd1 vccd1 sky130_fd_sc_hd__fill_1
X_08241_ net519 _02614_ _02613_ vssd1 vssd1 vccd1 vccd1 _02615_ sky130_fd_sc_hd__a21bo_1
XANTENNA_14 net397 vssd1 vssd1 vccd1 vccd1 sky130_fd_sc_hd__diode_2
X_05453_ net387 net522 vssd1 vssd1 vccd1 vccd1 _04723_ sky130_fd_sc_hd__nand2_1
XFILLER_0_6_101 vssd1 vssd1 vccd1 vccd1 sky130_fd_sc_hd__fill_1
XFILLER_0_62_519 vssd1 vssd1 vccd1 vccd1 sky130_fd_sc_hd__fill_1
X_08172_ net176 net565 _02542_ vssd1 vssd1 vccd1 vccd1 _02544_ sky130_fd_sc_hd__and3_1
XFILLER_0_12_70 vssd1 vssd1 vccd1 vccd1 sky130_fd_sc_hd__fill_1
XFILLER_0_6_156 vssd1 vssd1 vccd1 vccd1 sky130_ef_sc_hd__decap_12
X_05384_ net386 net586 _04652_ vssd1 vssd1 vccd1 vccd1 _04654_ sky130_fd_sc_hd__a21o_1
X_07123_ _01355_ _01361_ vssd1 vssd1 vccd1 vccd1 _01494_ sky130_fd_sc_hd__nand2_1
XFILLER_0_70_596 vssd1 vssd1 vccd1 vccd1 sky130_fd_sc_hd__fill_2
X_07054_ _01423_ _01424_ vssd1 vssd1 vccd1 vccd1 _01425_ sky130_fd_sc_hd__xor2_1
XFILLER_0_88_85 vssd1 vssd1 vccd1 vccd1 sky130_fd_sc_hd__decap_3
XFILLER_0_63_3 vssd1 vssd1 vccd1 vccd1 sky130_ef_sc_hd__decap_12
XFILLER_0_2_362 vssd1 vssd1 vccd1 vccd1 sky130_fd_sc_hd__fill_2
X_06005_ net280 net306 net554 net581 vssd1 vssd1 vccd1 vccd1 _00384_ sky130_fd_sc_hd__nand4_2
XFILLER_0_100_359 vssd1 vssd1 vccd1 vccd1 sky130_fd_sc_hd__decap_4
X_07956_ net183 net565 _02327_ vssd1 vssd1 vccd1 vccd1 _02329_ sky130_fd_sc_hd__and3_1
X_06907_ _01164_ _01166_ _01277_ vssd1 vssd1 vccd1 vccd1 _01279_ sky130_fd_sc_hd__nand3_1
XFILLER_0_97_416 vssd1 vssd1 vccd1 vccd1 sky130_fd_sc_hd__decap_6
X_07887_ _02091_ _02093_ _02258_ _02260_ vssd1 vssd1 vccd1 vccd1 _02261_ sky130_fd_sc_hd__a211oi_4
XFILLER_0_97_449 vssd1 vssd1 vccd1 vccd1 sky130_ef_sc_hd__decap_12
X_09626_ _04126_ _04127_ vssd1 vssd1 vccd1 vccd1 _04129_ sky130_fd_sc_hd__xor2_1
X_06838_ net81 _01209_ _01079_ _01081_ vssd1 vssd1 vccd1 vccd1 _01211_ sky130_fd_sc_hd__o211a_1
XFILLER_0_77_140 vssd1 vssd1 vccd1 vccd1 sky130_fd_sc_hd__decap_8
X_06769_ _01139_ _01140_ _01141_ vssd1 vssd1 vccd1 vccd1 _01142_ sky130_fd_sc_hd__or3_1
X_09557_ net191 net447 _04049_ _04051_ vssd1 vssd1 vccd1 vccd1 _04053_ sky130_fd_sc_hd__and4_1
X_09488_ _03977_ _03976_ vssd1 vssd1 vccd1 vccd1 _03978_ sky130_fd_sc_hd__nand2b_1
X_08508_ _02877_ _02906_ vssd1 vssd1 vccd1 vccd1 _02907_ sky130_fd_sc_hd__xnor2_1
XFILLER_0_77_173 vssd1 vssd1 vccd1 vccd1 sky130_fd_sc_hd__fill_1
XFILLER_0_38_527 vssd1 vssd1 vccd1 vccd1 sky130_fd_sc_hd__fill_1
X_08439_ _02638_ _02662_ _02828_ _02830_ vssd1 vssd1 vccd1 vccd1 _02832_ sky130_fd_sc_hd__a211oi_2
XFILLER_0_65_335 vssd1 vssd1 vccd1 vccd1 sky130_fd_sc_hd__fill_1
XFILLER_0_46_560 vssd1 vssd1 vccd1 vccd1 sky130_fd_sc_hd__decap_4
XFILLER_0_33_232 vssd1 vssd1 vccd1 vccd1 sky130_fd_sc_hd__decap_3
XFILLER_0_33_254 vssd1 vssd1 vccd1 vccd1 sky130_fd_sc_hd__decap_4
XFILLER_0_21_449 vssd1 vssd1 vccd1 vccd1 sky130_fd_sc_hd__decap_3
Xfanout392 net394 vssd1 vssd1 vccd1 vccd1 net392 sky130_fd_sc_hd__clkbuf_4
Xfanout370 net374 vssd1 vssd1 vccd1 vccd1 net370 sky130_fd_sc_hd__clkbuf_4
Xfanout381 net382 vssd1 vssd1 vccd1 vccd1 net381 sky130_fd_sc_hd__clkbuf_4
XFILLER_0_17_15 vssd1 vssd1 vccd1 vccd1 sky130_fd_sc_hd__decap_8
XFILLER_0_88_416 vssd1 vssd1 vccd1 vccd1 sky130_fd_sc_hd__decap_4
XFILLER_0_29_505 vssd1 vssd1 vccd1 vccd1 sky130_fd_sc_hd__fill_2
XFILLER_0_68_195 vssd1 vssd1 vccd1 vccd1 sky130_fd_sc_hd__fill_1
XFILLER_0_56_335 vssd1 vssd1 vccd1 vccd1 sky130_fd_sc_hd__decap_6
XFILLER_0_29_549 vssd1 vssd1 vccd1 vccd1 sky130_fd_sc_hd__decap_3
XFILLER_0_71_316 vssd1 vssd1 vccd1 vccd1 sky130_fd_sc_hd__decap_8
XFILLER_0_56_379 vssd1 vssd1 vccd1 vccd1 sky130_ef_sc_hd__decap_12
Xinput12 wbs_dat_i[16] vssd1 vssd1 vccd1 vccd1 net12 sky130_fd_sc_hd__clkbuf_1
Xinput23 wbs_dat_i[26] vssd1 vssd1 vccd1 vccd1 net23 sky130_fd_sc_hd__clkbuf_1
Xinput34 wbs_dat_i[7] vssd1 vssd1 vccd1 vccd1 net34 sky130_fd_sc_hd__clkbuf_1
X_08790_ _03049_ _03057_ _03056_ vssd1 vssd1 vccd1 vccd1 _03216_ sky130_fd_sc_hd__a21o_1
X_07810_ _02176_ _02179_ _02180_ vssd1 vssd1 vccd1 vccd1 _02181_ sky130_fd_sc_hd__nand3_1
X_07741_ _02110_ _02111_ _02112_ vssd1 vssd1 vccd1 vccd1 net46 sky130_fd_sc_hd__o21ai_1
X_07672_ net299 net459 _02042_ _02043_ vssd1 vssd1 vccd1 vccd1 _02044_ sky130_fd_sc_hd__a22o_1
XFILLER_0_59_140 vssd1 vssd1 vccd1 vccd1 sky130_fd_sc_hd__decap_3
X_09411_ net216 net436 net442 net208 vssd1 vssd1 vccd1 vccd1 _03894_ sky130_fd_sc_hd__a22o_1
X_06623_ _00864_ _00868_ _00995_ vssd1 vssd1 vccd1 vccd1 _00997_ sky130_fd_sc_hd__nand3_1
X_09342_ _03812_ _03817_ vssd1 vssd1 vccd1 vccd1 _03819_ sky130_fd_sc_hd__xnor2_1
XFILLER_0_87_471 vssd1 vssd1 vccd1 vccd1 sky130_ef_sc_hd__decap_12
X_06554_ _00926_ _00927_ _00928_ vssd1 vssd1 vccd1 vccd1 _00929_ sky130_fd_sc_hd__nand3_4
XFILLER_0_74_132 vssd1 vssd1 vccd1 vccd1 sky130_fd_sc_hd__fill_1
X_05505_ _04720_ _04773_ _04774_ vssd1 vssd1 vccd1 vccd1 _04775_ sky130_fd_sc_hd__nand3_1
X_09273_ _03729_ _03730_ _03742_ vssd1 vssd1 vccd1 vccd1 _03743_ sky130_fd_sc_hd__or3_1
X_06485_ net243 net273 net552 net577 vssd1 vssd1 vccd1 vccd1 _00860_ sky130_fd_sc_hd__nand4_2
XFILLER_0_74_187 vssd1 vssd1 vccd1 vccd1 sky130_fd_sc_hd__fill_2
X_08224_ _02273_ _02435_ _02437_ vssd1 vssd1 vccd1 vccd1 _02598_ sky130_fd_sc_hd__a21oi_1
XFILLER_0_7_443 vssd1 vssd1 vccd1 vccd1 sky130_fd_sc_hd__decap_4
X_05436_ _04703_ _04704_ _04705_ vssd1 vssd1 vccd1 vccd1 _04706_ sky130_fd_sc_hd__nand3_1
XFILLER_0_28_571 vssd1 vssd1 vccd1 vccd1 sky130_fd_sc_hd__decap_3
X_08155_ net282 net453 _02524_ _02525_ vssd1 vssd1 vccd1 vccd1 _02527_ sky130_fd_sc_hd__nand4_4
X_05367_ _04616_ _04618_ vssd1 vssd1 vccd1 vccd1 _04637_ sky130_fd_sc_hd__xnor2_1
XFILLER_0_99_84 vssd1 vssd1 vccd1 vccd1 sky130_fd_sc_hd__fill_1
XFILLER_0_70_382 vssd1 vssd1 vccd1 vccd1 sky130_fd_sc_hd__fill_2
X_07106_ _01474_ _01475_ _01419_ vssd1 vssd1 vccd1 vccd1 _01477_ sky130_fd_sc_hd__o21a_1
X_08086_ _02455_ _02456_ vssd1 vssd1 vccd1 vccd1 _02458_ sky130_fd_sc_hd__xor2_2
X_05298_ net343 net624 net632 net336 vssd1 vssd1 vccd1 vccd1 _04568_ sky130_fd_sc_hd__a22oi_1
XFILLER_0_100_112 vssd1 vssd1 vccd1 vccd1 sky130_fd_sc_hd__decap_6
XFILLER_0_30_279 vssd1 vssd1 vccd1 vccd1 sky130_fd_sc_hd__decap_8
X_07037_ _01406_ _01407_ net390 net413 vssd1 vssd1 vccd1 vccd1 _01408_ sky130_fd_sc_hd__and4bb_1
X_08988_ _03416_ _03417_ _03429_ vssd1 vssd1 vccd1 vccd1 _03431_ sky130_fd_sc_hd__or3_2
X_07939_ _02311_ vssd1 vssd1 vccd1 vccd1 _02312_ sky130_fd_sc_hd__inv_2
XFILLER_0_97_213 vssd1 vssd1 vccd1 vccd1 sky130_fd_sc_hd__decap_3
X_09609_ _04070_ _04109_ vssd1 vssd1 vccd1 vccd1 _04111_ sky130_fd_sc_hd__and2b_1
XFILLER_0_65_165 vssd1 vssd1 vccd1 vccd1 sky130_fd_sc_hd__decap_3
XFILLER_0_53_349 vssd1 vssd1 vccd1 vccd1 sky130_fd_sc_hd__decap_6
XFILLER_0_19_571 vssd1 vssd1 vccd1 vccd1 sky130_ef_sc_hd__decap_12
XFILLER_0_80_146 vssd1 vssd1 vccd1 vccd1 sky130_fd_sc_hd__fill_2
XFILLER_0_34_541 vssd1 vssd1 vccd1 vccd1 sky130_fd_sc_hd__fill_1
XFILLER_0_34_552 vssd1 vssd1 vccd1 vccd1 sky130_fd_sc_hd__fill_1
XFILLER_0_61_371 vssd1 vssd1 vccd1 vccd1 sky130_fd_sc_hd__decap_3
XFILLER_0_61_393 vssd1 vssd1 vccd1 vccd1 sky130_fd_sc_hd__decap_3
XFILLER_0_0_107 vssd1 vssd1 vccd1 vccd1 sky130_fd_sc_hd__decap_4
XFILLER_0_21_279 vssd1 vssd1 vccd1 vccd1 sky130_fd_sc_hd__fill_1
XTAP_408 vssd1 vccd1 sky130_fd_sc_hd__tapvpwrvgnd_1
XTAP_419 vssd1 vccd1 sky130_fd_sc_hd__tapvpwrvgnd_1
XFILLER_0_76_419 vssd1 vssd1 vccd1 vccd1 sky130_fd_sc_hd__fill_1
XFILLER_0_56_121 vssd1 vssd1 vccd1 vccd1 sky130_fd_sc_hd__decap_3
XFILLER_0_8_218 vssd1 vssd1 vccd1 vccd1 sky130_fd_sc_hd__decap_8
XTAP_1191 vssd1 vccd1 sky130_fd_sc_hd__tapvpwrvgnd_1
XTAP_1180 vssd1 vccd1 sky130_fd_sc_hd__tapvpwrvgnd_1
XFILLER_0_71_124 vssd1 vssd1 vccd1 vccd1 sky130_fd_sc_hd__decap_4
XFILLER_0_71_102 vssd1 vssd1 vccd1 vccd1 sky130_fd_sc_hd__decap_3
XFILLER_0_56_187 vssd1 vssd1 vccd1 vccd1 sky130_fd_sc_hd__decap_8
X_06270_ _00536_ _00645_ vssd1 vssd1 vccd1 vccd1 _00647_ sky130_fd_sc_hd__xnor2_1
X_05221_ _03585_ _03596_ _03607_ vssd1 vssd1 vccd1 vccd1 _03968_ sky130_fd_sc_hd__a21oi_1
XFILLER_0_44_349 vssd1 vssd1 vccd1 vccd1 sky130_fd_sc_hd__fill_2
XFILLER_0_69_32 vssd1 vssd1 vccd1 vccd1 sky130_fd_sc_hd__decap_6
XFILLER_0_4_446 vssd1 vssd1 vccd1 vccd1 sky130_ef_sc_hd__decap_12
XFILLER_0_52_382 vssd1 vssd1 vccd1 vccd1 sky130_fd_sc_hd__fill_1
XFILLER_0_12_213 vssd1 vssd1 vccd1 vccd1 sky130_fd_sc_hd__decap_8
XFILLER_0_4_468 vssd1 vssd1 vccd1 vccd1 sky130_fd_sc_hd__decap_8
X_05152_ _03115_ _03126_ _03192_ vssd1 vssd1 vccd1 vccd1 _03214_ sky130_fd_sc_hd__a21oi_1
XFILLER_0_40_533 vssd1 vssd1 vccd1 vccd1 sky130_fd_sc_hd__fill_1
XFILLER_0_100_73 vssd1 vssd1 vccd1 vccd1 sky130_fd_sc_hd__fill_1
X_05083_ net35 net564 net125 vssd1 vssd1 vccd1 vccd1 _00075_ sky130_fd_sc_hd__mux2_1
X_09960_ _04356_ _04357_ _04397_ vssd1 vssd1 vccd1 vccd1 _04494_ sky130_fd_sc_hd__o21a_1
X_08911_ _03308_ _03309_ _03346_ _03347_ vssd1 vssd1 vccd1 vccd1 _03348_ sky130_fd_sc_hd__nor4_1
XFILLER_0_85_42 vssd1 vssd1 vccd1 vccd1 sky130_fd_sc_hd__fill_2
XTAP_953 vssd1 vccd1 sky130_fd_sc_hd__tapvpwrvgnd_1
XTAP_942 vssd1 vccd1 sky130_fd_sc_hd__tapvpwrvgnd_1
X_09891_ net117 _04418_ vssd1 vssd1 vccd1 vccd1 _04419_ sky130_fd_sc_hd__xnor2_1
XTAP_931 vssd1 vccd1 sky130_fd_sc_hd__tapvpwrvgnd_1
XTAP_920 vssd1 vccd1 sky130_fd_sc_hd__tapvpwrvgnd_1
XFILLER_0_20_290 vssd1 vssd1 vccd1 vccd1 sky130_fd_sc_hd__decap_8
X_08842_ _03270_ _03271_ vssd1 vssd1 vccd1 vccd1 _03272_ sky130_fd_sc_hd__or2_1
XTAP_986 vssd1 vccd1 sky130_fd_sc_hd__tapvpwrvgnd_1
XTAP_975 vssd1 vccd1 sky130_fd_sc_hd__tapvpwrvgnd_1
XTAP_964 vssd1 vccd1 sky130_fd_sc_hd__tapvpwrvgnd_1
X_08773_ _03156_ _03157_ _03194_ _03195_ vssd1 vssd1 vccd1 vccd1 _03197_ sky130_fd_sc_hd__or4_4
XTAP_997 vssd1 vccd1 sky130_fd_sc_hd__tapvpwrvgnd_1
X_05985_ _00321_ _00322_ _00363_ _00364_ vssd1 vssd1 vccd1 vccd1 _00365_ sky130_fd_sc_hd__or4bb_4
X_07724_ net652 _02094_ net650 net93 vssd1 vssd1 vccd1 vccd1 _02096_ sky130_fd_sc_hd__a211o_1
XFILLER_0_26_3 vssd1 vssd1 vccd1 vccd1 sky130_ef_sc_hd__decap_12
XFILLER_0_79_257 vssd1 vssd1 vccd1 vccd1 sky130_fd_sc_hd__decap_8
X_07655_ _02024_ _02025_ _02026_ vssd1 vssd1 vccd1 vccd1 _02027_ sky130_fd_sc_hd__and3_1
X_06606_ _00975_ _00978_ vssd1 vssd1 vccd1 vccd1 _00980_ sky130_fd_sc_hd__xnor2_1
XFILLER_0_75_430 vssd1 vssd1 vccd1 vccd1 sky130_fd_sc_hd__fill_1
X_07586_ _01955_ _01956_ net165 net610 vssd1 vssd1 vccd1 vccd1 _01958_ sky130_fd_sc_hd__and4bb_1
X_09325_ _03646_ _03649_ _03798_ vssd1 vssd1 vccd1 vccd1 _03800_ sky130_fd_sc_hd__and3_1
X_06537_ _00903_ _00911_ vssd1 vssd1 vccd1 vccd1 _00912_ sky130_fd_sc_hd__xor2_2
X_09256_ _03722_ _03723_ vssd1 vssd1 vccd1 vccd1 _03724_ sky130_fd_sc_hd__xor2_1
X_06468_ net219 net227 net597 net609 vssd1 vssd1 vccd1 vccd1 _00843_ sky130_fd_sc_hd__and4_1
X_08207_ _02418_ _02420_ _02578_ _02579_ vssd1 vssd1 vccd1 vccd1 _02580_ sky130_fd_sc_hd__o211a_2
X_05419_ _04682_ _04687_ _04688_ vssd1 vssd1 vccd1 vccd1 _04689_ sky130_fd_sc_hd__nand3_1
XFILLER_0_7_251 vssd1 vssd1 vccd1 vccd1 sky130_fd_sc_hd__decap_4
XFILLER_0_16_530 vssd1 vssd1 vccd1 vccd1 sky130_fd_sc_hd__fill_2
XFILLER_0_90_477 vssd1 vssd1 vccd1 vccd1 sky130_fd_sc_hd__decap_4
X_09187_ _03641_ _03648_ vssd1 vssd1 vccd1 vccd1 _03649_ sky130_fd_sc_hd__nand2_1
XFILLER_0_62_179 vssd1 vssd1 vccd1 vccd1 sky130_fd_sc_hd__fill_1
XFILLER_0_16_563 vssd1 vssd1 vccd1 vccd1 sky130_fd_sc_hd__decap_4
X_06399_ _00765_ _00773_ vssd1 vssd1 vccd1 vccd1 _00775_ sky130_fd_sc_hd__xnor2_2
XFILLER_0_43_360 vssd1 vssd1 vccd1 vccd1 sky130_fd_sc_hd__fill_1
XFILLER_0_43_371 vssd1 vssd1 vccd1 vccd1 sky130_fd_sc_hd__decap_6
X_08138_ _02507_ _02508_ _02504_ vssd1 vssd1 vccd1 vccd1 _02510_ sky130_fd_sc_hd__a21o_1
XFILLER_0_43_393 vssd1 vssd1 vccd1 vccd1 sky130_fd_sc_hd__decap_4
XFILLER_0_101_421 vssd1 vssd1 vccd1 vccd1 sky130_fd_sc_hd__decap_3
X_08069_ net140 _02439_ _02440_ _02441_ vssd1 vssd1 vccd1 vccd1 net48 sky130_fd_sc_hd__a31o_1
X_10100_ clknet_3_5_0_wb_clk_i _00096_ _00032_ vssd1 vssd1 vccd1 vccd1 mul.b\[29\]
+ sky130_fd_sc_hd__dfrtp_1
X_10031_ net644 vssd1 vssd1 vccd1 vccd1 _00027_ sky130_fd_sc_hd__inv_2
XFILLER_0_98_500 vssd1 vssd1 vccd1 vccd1 sky130_fd_sc_hd__decap_8
XFILLER_0_98_533 vssd1 vssd1 vccd1 vccd1 sky130_ef_sc_hd__decap_12
XFILLER_0_85_216 vssd1 vssd1 vccd1 vccd1 sky130_fd_sc_hd__decap_8
XFILLER_0_14_27 vssd1 vssd1 vccd1 vccd1 sky130_fd_sc_hd__fill_1
XFILLER_0_81_433 vssd1 vssd1 vccd1 vccd1 sky130_fd_sc_hd__decap_4
XFILLER_0_53_113 vssd1 vssd1 vccd1 vccd1 sky130_fd_sc_hd__decap_8
XFILLER_0_38_176 vssd1 vssd1 vccd1 vccd1 sky130_fd_sc_hd__fill_2
XFILLER_0_81_444 vssd1 vssd1 vccd1 vccd1 sky130_fd_sc_hd__decap_4
XFILLER_0_53_146 vssd1 vssd1 vccd1 vccd1 sky130_fd_sc_hd__decap_6
XFILLER_0_30_37 vssd1 vssd1 vccd1 vccd1 sky130_fd_sc_hd__decap_3
XTAP_205 vssd1 vccd1 sky130_fd_sc_hd__tapvpwrvgnd_1
XFILLER_0_39_57 vssd1 vssd1 vccd1 vccd1 sky130_fd_sc_hd__decap_8
XTAP_227 vssd1 vccd1 sky130_fd_sc_hd__tapvpwrvgnd_1
XTAP_216 vssd1 vccd1 sky130_fd_sc_hd__tapvpwrvgnd_1
XTAP_238 vssd1 vccd1 sky130_fd_sc_hd__tapvpwrvgnd_1
XTAP_249 vssd1 vccd1 sky130_fd_sc_hd__tapvpwrvgnd_1
X_05770_ _00148_ _00149_ _00150_ vssd1 vssd1 vccd1 vccd1 _00152_ sky130_fd_sc_hd__a21o_1
XFILLER_0_71_44 vssd1 vssd1 vccd1 vccd1 sky130_fd_sc_hd__fill_1
XFILLER_0_9_505 vssd1 vssd1 vccd1 vccd1 sky130_fd_sc_hd__fill_1
X_07440_ _01656_ _01662_ _01806_ vssd1 vssd1 vccd1 vccd1 _01808_ sky130_fd_sc_hd__nand3_1
X_07371_ net295 net473 _01737_ _01738_ vssd1 vssd1 vccd1 vccd1 _01740_ sky130_fd_sc_hd__nand4_1
XFILLER_0_84_260 vssd1 vssd1 vccd1 vccd1 sky130_fd_sc_hd__decap_3
X_09110_ net148 net152 net697 net545 vssd1 vssd1 vccd1 vccd1 _03565_ sky130_fd_sc_hd__nand4_1
X_06322_ _00576_ _00578_ _00697_ _00698_ vssd1 vssd1 vccd1 vccd1 _00699_ sky130_fd_sc_hd__o211a_2
X_09041_ _03332_ _03336_ _03488_ vssd1 vssd1 vccd1 vccd1 _03490_ sky130_fd_sc_hd__a21o_1
XFILLER_0_72_499 vssd1 vssd1 vccd1 vccd1 sky130_fd_sc_hd__decap_8
XFILLER_0_13_511 vssd1 vssd1 vccd1 vccd1 sky130_fd_sc_hd__decap_8
X_06253_ _00628_ _00629_ vssd1 vssd1 vccd1 vccd1 _00630_ sky130_fd_sc_hd__nand2b_1
XFILLER_0_44_168 vssd1 vssd1 vccd1 vccd1 sky130_ef_sc_hd__decap_12
X_06184_ _00558_ _00559_ _00560_ vssd1 vssd1 vccd1 vccd1 _00562_ sky130_fd_sc_hd__a21o_1
X_05204_ net361 net369 net595 net605 vssd1 vssd1 vccd1 vccd1 _03782_ sky130_fd_sc_hd__nand4_1
X_05135_ _02995_ _03017_ vssd1 vssd1 vccd1 vccd1 _03028_ sky130_fd_sc_hd__nand2_1
X_05066_ net22 net426 net127 vssd1 vssd1 vccd1 vccd1 _00092_ sky130_fd_sc_hd__mux2_1
X_09943_ _04364_ _04374_ _04371_ vssd1 vssd1 vccd1 vccd1 _04475_ sky130_fd_sc_hd__a21o_1
X_09874_ _04221_ _04264_ _04220_ vssd1 vssd1 vccd1 vccd1 _04400_ sky130_fd_sc_hd__o21a_1
XTAP_750 vssd1 vccd1 sky130_fd_sc_hd__tapvpwrvgnd_1
XTAP_761 vssd1 vccd1 sky130_fd_sc_hd__tapvpwrvgnd_1
X_08825_ _03249_ _03251_ _03095_ _03098_ vssd1 vssd1 vccd1 vccd1 _03253_ sky130_fd_sc_hd__a211o_1
XTAP_794 vssd1 vccd1 sky130_fd_sc_hd__tapvpwrvgnd_1
XTAP_783 vssd1 vccd1 sky130_fd_sc_hd__tapvpwrvgnd_1
XTAP_772 vssd1 vccd1 sky130_fd_sc_hd__tapvpwrvgnd_1
X_08756_ net278 net286 net419 net425 vssd1 vssd1 vccd1 vccd1 _03178_ sky130_fd_sc_hd__and4_1
X_05968_ _00345_ _00346_ _00338_ vssd1 vssd1 vccd1 vccd1 _00348_ sky130_fd_sc_hd__a21o_1
X_08687_ net186 net506 net515 net178 vssd1 vssd1 vccd1 vccd1 _03102_ sky130_fd_sc_hd__a22o_1
X_07707_ _02075_ _02078_ vssd1 vssd1 vccd1 vccd1 _02079_ sky130_fd_sc_hd__xor2_2
X_05899_ _00278_ _00279_ vssd1 vssd1 vccd1 vccd1 _00280_ sky130_fd_sc_hd__nand2b_1
XFILLER_0_95_547 vssd1 vssd1 vccd1 vccd1 sky130_ef_sc_hd__decap_12
X_07638_ net376 net402 _02005_ _02007_ vssd1 vssd1 vccd1 vccd1 _02010_ sky130_fd_sc_hd__nand4_1
X_07569_ _01780_ _01782_ _01940_ _01941_ vssd1 vssd1 vccd1 vccd1 _01942_ sky130_fd_sc_hd__o211ai_4
X_09308_ _03779_ _03780_ vssd1 vssd1 vccd1 vccd1 _03781_ sky130_fd_sc_hd__nor2_1
XFILLER_0_82_219 vssd1 vssd1 vccd1 vccd1 sky130_fd_sc_hd__decap_8
XFILLER_0_35_113 vssd1 vssd1 vccd1 vccd1 sky130_fd_sc_hd__decap_8
XFILLER_0_35_135 vssd1 vssd1 vccd1 vccd1 sky130_ef_sc_hd__decap_12
X_09239_ _03704_ _03705_ vssd1 vssd1 vccd1 vccd1 _03707_ sky130_fd_sc_hd__nor2_1
XFILLER_0_16_360 vssd1 vssd1 vccd1 vccd1 sky130_fd_sc_hd__decap_4
XFILLER_0_35_179 vssd1 vssd1 vccd1 vccd1 sky130_fd_sc_hd__fill_2
XFILLER_0_50_127 vssd1 vssd1 vccd1 vccd1 sky130_ef_sc_hd__decap_12
XFILLER_0_31_330 vssd1 vssd1 vccd1 vccd1 sky130_fd_sc_hd__fill_1
XFILLER_0_43_190 vssd1 vssd1 vccd1 vccd1 sky130_fd_sc_hd__fill_1
X_10014_ net639 vssd1 vssd1 vccd1 vccd1 _00010_ sky130_fd_sc_hd__inv_2
XFILLER_0_98_363 vssd1 vssd1 vccd1 vccd1 sky130_fd_sc_hd__fill_1
XFILLER_0_25_48 vssd1 vssd1 vccd1 vccd1 sky130_fd_sc_hd__fill_2
XFILLER_0_39_452 vssd1 vssd1 vccd1 vccd1 sky130_fd_sc_hd__decap_8
XFILLER_0_54_477 vssd1 vssd1 vccd1 vccd1 sky130_ef_sc_hd__decap_12
XFILLER_0_26_179 vssd1 vssd1 vccd1 vccd1 sky130_ef_sc_hd__decap_12
XFILLER_0_41_116 vssd1 vssd1 vccd1 vccd1 sky130_ef_sc_hd__decap_12
XFILLER_0_10_536 vssd1 vssd1 vccd1 vccd1 sky130_fd_sc_hd__fill_2
XFILLER_0_10_525 vssd1 vssd1 vccd1 vccd1 sky130_fd_sc_hd__decap_6
XFILLER_0_22_385 vssd1 vssd1 vccd1 vccd1 sky130_fd_sc_hd__decap_8
X_06940_ net277 net285 net507 net514 vssd1 vssd1 vccd1 vccd1 _01312_ sky130_fd_sc_hd__and4_1
XFILLER_0_5_47 vssd1 vssd1 vccd1 vccd1 sky130_fd_sc_hd__decap_3
X_06871_ _01107_ _01242_ vssd1 vssd1 vccd1 vccd1 _01243_ sky130_fd_sc_hd__nand2_1
X_08610_ _02854_ _02856_ vssd1 vssd1 vccd1 vccd1 _03019_ sky130_fd_sc_hd__nand2_1
X_05822_ net273 net281 net598 net607 vssd1 vssd1 vccd1 vccd1 _00203_ sky130_fd_sc_hd__and4_1
X_09590_ _03895_ _03897_ vssd1 vssd1 vccd1 vccd1 _04090_ sky130_fd_sc_hd__nand2_1
X_08541_ net179 net525 _02937_ _02939_ vssd1 vssd1 vccd1 vccd1 _02943_ sky130_fd_sc_hd__nand4_2
X_05753_ net381 net496 vssd1 vssd1 vccd1 vccd1 _00135_ sky130_fd_sc_hd__nand2_1
X_08472_ _02865_ _02866_ _02657_ _02659_ vssd1 vssd1 vccd1 vccd1 _02868_ sky130_fd_sc_hd__a211o_1
X_05684_ _04951_ _04952_ _04936_ vssd1 vssd1 vccd1 vccd1 _04954_ sky130_fd_sc_hd__a21o_1
XFILLER_0_9_313 vssd1 vssd1 vccd1 vccd1 sky130_ef_sc_hd__decap_12
X_07423_ _01790_ _01791_ vssd1 vssd1 vccd1 vccd1 _01792_ sky130_fd_sc_hd__xor2_1
X_07354_ net324 net452 _01721_ _01722_ vssd1 vssd1 vccd1 vccd1 _01723_ sky130_fd_sc_hd__a22o_1
XFILLER_0_93_3 vssd1 vssd1 vccd1 vccd1 sky130_ef_sc_hd__decap_12
X_06305_ _00673_ _00680_ _00681_ vssd1 vssd1 vccd1 vccd1 _00682_ sky130_fd_sc_hd__nand3_2
XFILLER_0_33_617 vssd1 vssd1 vccd1 vccd1 sky130_fd_sc_hd__fill_1
X_07285_ _01652_ _01653_ vssd1 vssd1 vccd1 vccd1 _01654_ sky130_fd_sc_hd__nor2_1
X_09024_ net303 net395 _03467_ _03469_ vssd1 vssd1 vccd1 vccd1 _03471_ sky130_fd_sc_hd__and4_1
XFILLER_0_72_285 vssd1 vssd1 vccd1 vccd1 sky130_fd_sc_hd__fill_1
X_06236_ net219 net627 net635 net211 vssd1 vssd1 vccd1 vccd1 _00613_ sky130_fd_sc_hd__a22oi_1
X_06167_ _00541_ _00544_ vssd1 vssd1 vccd1 vccd1 _00545_ sky130_fd_sc_hd__xor2_1
X_06098_ _00314_ _00317_ _00473_ _00475_ vssd1 vssd1 vccd1 vccd1 _00477_ sky130_fd_sc_hd__a211o_1
X_05118_ _02809_ _02820_ _02831_ vssd1 vssd1 vccd1 vccd1 _02842_ sky130_fd_sc_hd__nand3_1
X_09926_ net152 net481 vssd1 vssd1 vccd1 vccd1 _04456_ sky130_fd_sc_hd__nand2_1
X_05049_ net34 net331 net133 vssd1 vssd1 vccd1 vccd1 _00106_ sky130_fd_sc_hd__mux2_1
XTAP_591 vssd1 vccd1 sky130_fd_sc_hd__tapvpwrvgnd_1
XTAP_580 vssd1 vccd1 sky130_fd_sc_hd__tapvpwrvgnd_1
X_09857_ net225 net411 vssd1 vssd1 vccd1 vccd1 _04381_ sky130_fd_sc_hd__nand2_1
X_09788_ _04153_ _04162_ vssd1 vssd1 vccd1 vccd1 _04306_ sky130_fd_sc_hd__nand2_1
X_08808_ _03232_ _03233_ _03075_ _03078_ vssd1 vssd1 vccd1 vccd1 _03235_ sky130_fd_sc_hd__a211o_1
X_08739_ net153 net566 _03158_ vssd1 vssd1 vccd1 vccd1 _03160_ sky130_fd_sc_hd__a21oi_1
XFILLER_0_95_311 vssd1 vssd1 vccd1 vccd1 sky130_ef_sc_hd__decap_12
XFILLER_0_63_252 vssd1 vssd1 vccd1 vccd1 sky130_fd_sc_hd__fill_2
XFILLER_0_23_105 vssd1 vssd1 vccd1 vccd1 sky130_fd_sc_hd__decap_3
XFILLER_0_36_466 vssd1 vssd1 vccd1 vccd1 sky130_fd_sc_hd__decap_8
XFILLER_0_36_477 vssd1 vssd1 vccd1 vccd1 sky130_fd_sc_hd__decap_3
XFILLER_0_51_447 vssd1 vssd1 vccd1 vccd1 sky130_fd_sc_hd__fill_1
XFILLER_0_31_182 vssd1 vssd1 vccd1 vccd1 sky130_fd_sc_hd__decap_6
XFILLER_0_36_58 vssd1 vssd1 vccd1 vccd1 sky130_fd_sc_hd__decap_6
XFILLER_0_59_503 vssd1 vssd1 vccd1 vccd1 sky130_fd_sc_hd__fill_1
XFILLER_0_98_182 vssd1 vssd1 vccd1 vccd1 sky130_ef_sc_hd__decap_12
XFILLER_0_52_46 vssd1 vssd1 vccd1 vccd1 sky130_fd_sc_hd__decap_4
XFILLER_0_54_230 vssd1 vssd1 vccd1 vccd1 sky130_fd_sc_hd__fill_2
XFILLER_0_39_293 vssd1 vssd1 vccd1 vccd1 sky130_fd_sc_hd__decap_4
XFILLER_0_82_550 vssd1 vssd1 vccd1 vccd1 sky130_fd_sc_hd__decap_4
XFILLER_0_15_617 vssd1 vssd1 vccd1 vccd1 sky130_fd_sc_hd__fill_1
XFILLER_0_82_583 vssd1 vssd1 vccd1 vccd1 sky130_fd_sc_hd__decap_4
X_07070_ net295 net304 net481 net490 vssd1 vssd1 vccd1 vccd1 _01441_ sky130_fd_sc_hd__nand4_1
XFILLER_0_2_533 vssd1 vssd1 vccd1 vccd1 sky130_fd_sc_hd__fill_2
X_06021_ _00398_ _00399_ vssd1 vssd1 vccd1 vccd1 _00400_ sky130_fd_sc_hd__nand2b_1
XFILLER_0_100_508 vssd1 vssd1 vccd1 vccd1 sky130_fd_sc_hd__fill_1
XFILLER_0_2_566 vssd1 vssd1 vccd1 vccd1 sky130_fd_sc_hd__fill_1
X_07972_ net324 net332 net421 net426 vssd1 vssd1 vccd1 vccd1 _02345_ sky130_fd_sc_hd__nand4_2
X_09711_ _04087_ _04103_ _04102_ vssd1 vssd1 vccd1 vccd1 _04222_ sky130_fd_sc_hd__o21bai_1
X_06923_ _01288_ _01293_ _01294_ vssd1 vssd1 vccd1 vccd1 _01295_ sky130_fd_sc_hd__nand3_2
X_09642_ _04145_ _04146_ vssd1 vssd1 vccd1 vccd1 _04147_ sky130_fd_sc_hd__nand2b_1
X_06854_ _01011_ _01146_ _01145_ vssd1 vssd1 vccd1 vccd1 _01226_ sky130_fd_sc_hd__a21o_1
X_09573_ net276 net392 vssd1 vssd1 vccd1 vccd1 _04071_ sky130_fd_sc_hd__and2b_1
X_05805_ net298 net322 net553 net581 vssd1 vssd1 vccd1 vccd1 _00186_ sky130_fd_sc_hd__nand4_2
X_06785_ net357 net448 _01155_ _01157_ vssd1 vssd1 vccd1 vccd1 _01158_ sky130_fd_sc_hd__and4_2
XFILLER_0_77_322 vssd1 vssd1 vccd1 vccd1 sky130_fd_sc_hd__decap_4
X_08524_ _02922_ _02923_ vssd1 vssd1 vccd1 vccd1 _02925_ sky130_fd_sc_hd__and2_1
XTAP_1009 vssd1 vccd1 sky130_fd_sc_hd__tapvpwrvgnd_1
X_05736_ _04900_ _04908_ _04907_ vssd1 vssd1 vccd1 vccd1 _05006_ sky130_fd_sc_hd__a21oi_1
X_08455_ _02839_ _02848_ vssd1 vssd1 vccd1 vccd1 _02849_ sky130_fd_sc_hd__xor2_2
X_05667_ _04825_ _04826_ _04827_ vssd1 vssd1 vccd1 vccd1 _04937_ sky130_fd_sc_hd__a21bo_1
XFILLER_0_18_411 vssd1 vssd1 vccd1 vccd1 sky130_fd_sc_hd__fill_2
XFILLER_0_92_347 vssd1 vssd1 vccd1 vccd1 sky130_ef_sc_hd__decap_12
X_08386_ net173 net179 net537 net547 vssd1 vssd1 vccd1 vccd1 _02773_ sky130_fd_sc_hd__nand4_2
X_05598_ _04866_ _04867_ vssd1 vssd1 vccd1 vccd1 _04868_ sky130_fd_sc_hd__or2_1
X_07406_ _01625_ _01628_ net654 _01774_ vssd1 vssd1 vccd1 vccd1 _01775_ sky130_fd_sc_hd__o211a_2
X_07337_ _01697_ _01704_ vssd1 vssd1 vccd1 vccd1 _01706_ sky130_fd_sc_hd__xnor2_1
XFILLER_0_9_187 vssd1 vssd1 vccd1 vccd1 sky130_fd_sc_hd__decap_8
XFILLER_0_18_477 vssd1 vssd1 vccd1 vccd1 sky130_fd_sc_hd__decap_8
XFILLER_0_45_252 vssd1 vssd1 vccd1 vccd1 sky130_fd_sc_hd__decap_4
XFILLER_0_33_447 vssd1 vssd1 vccd1 vccd1 sky130_fd_sc_hd__fill_1
X_07268_ _01398_ _01400_ _01635_ _01637_ vssd1 vssd1 vccd1 vccd1 _01638_ sky130_fd_sc_hd__a211o_2
X_09007_ _03273_ _03275_ _03451_ vssd1 vssd1 vccd1 vccd1 _03452_ sky130_fd_sc_hd__o21a_2
XFILLER_0_60_288 vssd1 vssd1 vccd1 vccd1 sky130_fd_sc_hd__decap_3
X_06219_ _00383_ _00479_ _00375_ _00376_ vssd1 vssd1 vccd1 vccd1 _00597_ sky130_fd_sc_hd__o2bb2a_1
XFILLER_0_20_108 vssd1 vssd1 vccd1 vccd1 sky130_fd_sc_hd__fill_2
X_07199_ _01542_ _01567_ vssd1 vssd1 vccd1 vccd1 _01569_ sky130_fd_sc_hd__and2_1
Xfanout541 net542 vssd1 vssd1 vccd1 vccd1 net541 sky130_fd_sc_hd__clkbuf_2
Xfanout530 net532 vssd1 vssd1 vccd1 vccd1 net530 sky130_fd_sc_hd__buf_4
X_09909_ _04437_ _04436_ vssd1 vssd1 vccd1 vccd1 _04439_ sky130_fd_sc_hd__and2b_2
Xfanout574 mul.b\[7\] vssd1 vssd1 vccd1 vccd1 net574 sky130_fd_sc_hd__clkbuf_4
Xfanout563 net564 vssd1 vssd1 vccd1 vccd1 net563 sky130_fd_sc_hd__buf_2
Xfanout552 net556 vssd1 vssd1 vccd1 vccd1 net552 sky130_fd_sc_hd__clkbuf_4
Xfanout596 mul.b\[4\] vssd1 vssd1 vccd1 vccd1 net596 sky130_fd_sc_hd__buf_2
Xfanout585 net586 vssd1 vssd1 vccd1 vccd1 net585 sky130_fd_sc_hd__clkbuf_4
XFILLER_0_83_303 vssd1 vssd1 vccd1 vccd1 sky130_fd_sc_hd__fill_2
XPHY_50 vssd1 vssd1 vccd1 vccd1 sky130_fd_sc_hd__decap_3
XPHY_61 vssd1 vssd1 vccd1 vccd1 sky130_fd_sc_hd__decap_3
XPHY_72 vssd1 vssd1 vccd1 vccd1 sky130_fd_sc_hd__decap_3
XPHY_83 vssd1 vssd1 vccd1 vccd1 sky130_fd_sc_hd__decap_3
XPHY_94 vssd1 vssd1 vccd1 vccd1 sky130_fd_sc_hd__decap_3
XFILLER_0_36_230 vssd1 vssd1 vccd1 vccd1 sky130_ef_sc_hd__decap_12
XFILLER_0_36_296 vssd1 vssd1 vccd1 vccd1 sky130_ef_sc_hd__decap_12
XFILLER_0_47_13 vssd1 vssd1 vccd1 vccd1 sky130_fd_sc_hd__fill_2
XFILLER_0_47_35 vssd1 vssd1 vccd1 vccd1 sky130_ef_sc_hd__decap_12
XFILLER_0_2_15 vssd1 vssd1 vccd1 vccd1 sky130_ef_sc_hd__decap_12
XFILLER_0_2_59 vssd1 vssd1 vccd1 vccd1 sky130_fd_sc_hd__fill_1
X_06570_ _00879_ _00880_ _00943_ _00944_ vssd1 vssd1 vccd1 vccd1 _00945_ sky130_fd_sc_hd__nor4_2
XFILLER_0_59_377 vssd1 vssd1 vccd1 vccd1 sky130_fd_sc_hd__decap_3
X_05521_ _04788_ _04789_ _04790_ vssd1 vssd1 vccd1 vccd1 _04791_ sky130_fd_sc_hd__nand3_1
XFILLER_0_19_219 vssd1 vssd1 vccd1 vccd1 sky130_fd_sc_hd__decap_4
XFILLER_0_47_517 vssd1 vssd1 vccd1 vccd1 sky130_fd_sc_hd__decap_8
X_08240_ net202 net207 net509 vssd1 vssd1 vccd1 vccd1 _02614_ sky130_fd_sc_hd__and3_1
X_05452_ _04720_ _04721_ vssd1 vssd1 vccd1 vccd1 _04722_ sky130_fd_sc_hd__or2_1
X_08171_ net176 net565 vssd1 vssd1 vccd1 vccd1 _02543_ sky130_fd_sc_hd__nand2_1
XANTENNA_15 net397 vssd1 vssd1 vccd1 vccd1 sky130_fd_sc_hd__diode_2
XFILLER_0_27_263 vssd1 vssd1 vccd1 vccd1 sky130_fd_sc_hd__fill_1
XFILLER_0_55_583 vssd1 vssd1 vccd1 vccd1 sky130_fd_sc_hd__decap_4
XFILLER_0_6_168 vssd1 vssd1 vccd1 vccd1 sky130_fd_sc_hd__decap_4
X_05383_ net386 net586 _04652_ vssd1 vssd1 vccd1 vccd1 _04653_ sky130_fd_sc_hd__nand3_1
X_07122_ _01491_ _01492_ vssd1 vssd1 vccd1 vccd1 _01493_ sky130_fd_sc_hd__and2_1
XFILLER_0_70_575 vssd1 vssd1 vccd1 vccd1 sky130_fd_sc_hd__decap_8
X_07053_ net365 net429 vssd1 vssd1 vccd1 vccd1 _01424_ sky130_fd_sc_hd__nand2_1
XFILLER_0_2_341 vssd1 vssd1 vccd1 vccd1 sky130_fd_sc_hd__decap_8
X_06004_ _00284_ _00374_ _00372_ vssd1 vssd1 vccd1 vccd1 _00383_ sky130_fd_sc_hd__o21ai_2
XFILLER_0_100_349 vssd1 vssd1 vccd1 vccd1 sky130_fd_sc_hd__decap_3
XFILLER_0_10_141 vssd1 vssd1 vccd1 vccd1 sky130_fd_sc_hd__fill_2
X_07955_ net183 net565 vssd1 vssd1 vccd1 vccd1 _02328_ sky130_fd_sc_hd__nand2_1
X_06906_ _01164_ _01166_ _01277_ vssd1 vssd1 vccd1 vccd1 _01278_ sky130_fd_sc_hd__a21o_1
XFILLER_0_97_406 vssd1 vssd1 vccd1 vccd1 sky130_fd_sc_hd__decap_3
X_09625_ _04127_ _04126_ vssd1 vssd1 vccd1 vccd1 _04128_ sky130_fd_sc_hd__nand2b_1
X_07886_ _02194_ _02195_ _02256_ _02257_ vssd1 vssd1 vccd1 vccd1 _02260_ sky130_fd_sc_hd__a2bb2oi_2
X_06837_ _01079_ _01081_ net81 _01209_ vssd1 vssd1 vccd1 vccd1 _01210_ sky130_fd_sc_hd__a211oi_4
X_06768_ net234 net242 net561 net567 vssd1 vssd1 vccd1 vccd1 _01141_ sky130_fd_sc_hd__and4_1
X_09556_ net191 net447 _04049_ _04051_ vssd1 vssd1 vccd1 vccd1 _04052_ sky130_fd_sc_hd__a22oi_1
XFILLER_0_93_623 vssd1 vssd1 vccd1 vccd1 sky130_fd_sc_hd__fill_2
X_09487_ _03670_ _03816_ _03814_ vssd1 vssd1 vccd1 vccd1 _03977_ sky130_fd_sc_hd__a21oi_1
X_08507_ _02878_ _02904_ vssd1 vssd1 vccd1 vccd1 _02906_ sky130_fd_sc_hd__xnor2_1
X_05719_ _04987_ _04988_ vssd1 vssd1 vccd1 vccd1 _04989_ sky130_fd_sc_hd__nand2_1
X_06699_ _01036_ _01037_ _01069_ _01070_ vssd1 vssd1 vccd1 vccd1 _01073_ sky130_fd_sc_hd__o22ai_4
XFILLER_0_92_111 vssd1 vssd1 vccd1 vccd1 sky130_fd_sc_hd__decap_8
X_08438_ _02805_ _02806_ _02827_ vssd1 vssd1 vccd1 vccd1 _02830_ sky130_fd_sc_hd__a21oi_1
XFILLER_0_80_306 vssd1 vssd1 vccd1 vccd1 sky130_fd_sc_hd__fill_2
XFILLER_0_65_369 vssd1 vssd1 vccd1 vccd1 sky130_fd_sc_hd__fill_2
X_08369_ _02481_ _02483_ _02753_ _02754_ vssd1 vssd1 vccd1 vccd1 _02756_ sky130_fd_sc_hd__a211oi_4
XFILLER_0_61_531 vssd1 vssd1 vccd1 vccd1 sky130_fd_sc_hd__fill_2
XFILLER_0_33_222 vssd1 vssd1 vccd1 vccd1 sky130_fd_sc_hd__fill_2
Xfanout393 net394 vssd1 vssd1 vccd1 vccd1 net393 sky130_fd_sc_hd__buf_4
Xfanout371 net373 vssd1 vssd1 vccd1 vccd1 net371 sky130_fd_sc_hd__buf_4
Xfanout382 net384 vssd1 vssd1 vccd1 vccd1 net382 sky130_fd_sc_hd__buf_4
XFILLER_0_17_38 vssd1 vssd1 vccd1 vccd1 sky130_fd_sc_hd__decap_6
Xfanout360 mul.a\[4\] vssd1 vssd1 vccd1 vccd1 net360 sky130_fd_sc_hd__clkbuf_4
XFILLER_0_88_428 vssd1 vssd1 vccd1 vccd1 sky130_ef_sc_hd__decap_12
XFILLER_0_33_15 vssd1 vssd1 vccd1 vccd1 sky130_fd_sc_hd__fill_2
XTAP_1340 vssd1 vccd1 sky130_fd_sc_hd__tapvpwrvgnd_1
XFILLER_0_83_100 vssd1 vssd1 vccd1 vccd1 sky130_ef_sc_hd__decap_12
XFILLER_0_68_141 vssd1 vssd1 vccd1 vccd1 sky130_fd_sc_hd__decap_4
XFILLER_0_96_494 vssd1 vssd1 vccd1 vccd1 sky130_fd_sc_hd__decap_3
Xinput13 wbs_dat_i[17] vssd1 vssd1 vccd1 vccd1 net13 sky130_fd_sc_hd__clkbuf_1
Xinput24 wbs_dat_i[27] vssd1 vssd1 vccd1 vccd1 net24 sky130_fd_sc_hd__clkbuf_1
XFILLER_0_24_233 vssd1 vssd1 vccd1 vccd1 sky130_fd_sc_hd__decap_6
Xinput35 wbs_dat_i[8] vssd1 vssd1 vccd1 vccd1 net35 sky130_fd_sc_hd__clkbuf_1
XFILLER_0_52_586 vssd1 vssd1 vccd1 vccd1 sky130_fd_sc_hd__fill_2
XFILLER_0_52_564 vssd1 vssd1 vccd1 vccd1 sky130_fd_sc_hd__decap_8
XFILLER_0_12_439 vssd1 vssd1 vccd1 vccd1 sky130_fd_sc_hd__fill_1
XFILLER_0_20_494 vssd1 vssd1 vccd1 vccd1 sky130_ef_sc_hd__decap_12
X_07740_ net502 net143 net129 net266 vssd1 vssd1 vccd1 vccd1 _02112_ sky130_fd_sc_hd__a22oi_1
XFILLER_0_74_55 vssd1 vssd1 vccd1 vccd1 sky130_ef_sc_hd__decap_12
X_07671_ net282 net290 net466 net476 vssd1 vssd1 vccd1 vccd1 _02043_ sky130_fd_sc_hd__nand4_4
X_09410_ _03732_ _03736_ _03739_ _03741_ _03731_ vssd1 vssd1 vccd1 vccd1 _03893_ sky130_fd_sc_hd__a32o_1
X_06622_ _00864_ _00868_ _00995_ vssd1 vssd1 vccd1 vccd1 _00996_ sky130_fd_sc_hd__a21o_1
X_09341_ _03812_ _03817_ vssd1 vssd1 vccd1 vccd1 _03818_ sky130_fd_sc_hd__nand2b_1
XFILLER_0_87_483 vssd1 vssd1 vccd1 vccd1 sky130_fd_sc_hd__fill_1
XFILLER_0_87_461 vssd1 vssd1 vccd1 vccd1 sky130_fd_sc_hd__decap_6
X_06553_ _00795_ _00803_ _00802_ vssd1 vssd1 vccd1 vccd1 _00928_ sky130_fd_sc_hd__a21bo_1
X_05504_ net321 net587 _04771_ _04772_ vssd1 vssd1 vccd1 vccd1 _04774_ sky130_fd_sc_hd__a22o_1
XFILLER_0_90_98 vssd1 vssd1 vccd1 vccd1 sky130_fd_sc_hd__fill_2
XFILLER_0_74_166 vssd1 vssd1 vccd1 vccd1 sky130_fd_sc_hd__fill_1
X_09272_ _03731_ _03741_ vssd1 vssd1 vccd1 vccd1 _03742_ sky130_fd_sc_hd__xnor2_1
XFILLER_0_62_306 vssd1 vssd1 vccd1 vccd1 sky130_fd_sc_hd__fill_2
X_06484_ _00726_ _00858_ vssd1 vssd1 vccd1 vccd1 _00859_ sky130_fd_sc_hd__xnor2_2
X_08223_ _02595_ _02596_ vssd1 vssd1 vccd1 vccd1 _02597_ sky130_fd_sc_hd__and2_1
X_05435_ _04186_ _04208_ _04197_ vssd1 vssd1 vccd1 vccd1 _04705_ sky130_fd_sc_hd__a21bo_1
X_08154_ net282 net453 _02524_ _02525_ vssd1 vssd1 vccd1 vccd1 _02526_ sky130_fd_sc_hd__a22o_1
X_05366_ _04597_ _04624_ vssd1 vssd1 vccd1 vccd1 _04636_ sky130_fd_sc_hd__xnor2_1
X_08085_ _02455_ _02456_ vssd1 vssd1 vccd1 vccd1 _02457_ sky130_fd_sc_hd__nand2b_1
X_07105_ _01419_ _01474_ _01475_ vssd1 vssd1 vccd1 vccd1 _01476_ sky130_fd_sc_hd__nor3_4
X_05297_ _03815_ _04561_ _04566_ vssd1 vssd1 vccd1 vccd1 _04567_ sky130_fd_sc_hd__nand3_1
X_07036_ net383 net420 net427 net375 vssd1 vssd1 vccd1 vccd1 _01407_ sky130_fd_sc_hd__a22oi_1
XFILLER_0_2_171 vssd1 vssd1 vccd1 vccd1 sky130_ef_sc_hd__decap_12
X_08987_ _03416_ _03417_ _03429_ vssd1 vssd1 vccd1 vccd1 _03430_ sky130_fd_sc_hd__nor3_1
X_07938_ net164 net593 _02307_ _02308_ vssd1 vssd1 vccd1 vccd1 _02311_ sky130_fd_sc_hd__and4_1
XFILLER_0_97_225 vssd1 vssd1 vccd1 vccd1 sky130_fd_sc_hd__decap_3
X_07869_ net274 net476 _02240_ _02241_ vssd1 vssd1 vccd1 vccd1 _02243_ sky130_fd_sc_hd__nand4_1
XFILLER_0_85_409 vssd1 vssd1 vccd1 vccd1 sky130_fd_sc_hd__decap_3
X_09608_ _04107_ _04108_ vssd1 vssd1 vccd1 vccd1 _04109_ sky130_fd_sc_hd__nor2_1
XFILLER_0_78_472 vssd1 vssd1 vccd1 vccd1 sky130_fd_sc_hd__decap_4
X_09539_ _04021_ _04031_ vssd1 vssd1 vccd1 vccd1 _04034_ sky130_fd_sc_hd__xnor2_1
XFILLER_0_65_111 vssd1 vssd1 vccd1 vccd1 sky130_fd_sc_hd__fill_1
XFILLER_0_93_464 vssd1 vssd1 vccd1 vccd1 sky130_fd_sc_hd__decap_3
XFILLER_0_38_358 vssd1 vssd1 vccd1 vccd1 sky130_fd_sc_hd__fill_1
XFILLER_0_19_583 vssd1 vssd1 vccd1 vccd1 sky130_fd_sc_hd__decap_8
XFILLER_0_21_225 vssd1 vssd1 vccd1 vccd1 sky130_fd_sc_hd__fill_2
XTAP_409 vssd1 vccd1 sky130_fd_sc_hd__tapvpwrvgnd_1
Xfanout190 mul.a\[24\] vssd1 vssd1 vccd1 vccd1 net190 sky130_fd_sc_hd__buf_4
XFILLER_0_44_14 vssd1 vssd1 vccd1 vccd1 sky130_fd_sc_hd__fill_1
XFILLER_0_69_472 vssd1 vssd1 vccd1 vccd1 sky130_fd_sc_hd__decap_8
XFILLER_0_57_623 vssd1 vssd1 vccd1 vccd1 sky130_fd_sc_hd__fill_2
XFILLER_0_29_314 vssd1 vssd1 vccd1 vccd1 sky130_fd_sc_hd__decap_4
XTAP_1192 vssd1 vccd1 sky130_fd_sc_hd__tapvpwrvgnd_1
XTAP_1181 vssd1 vccd1 sky130_fd_sc_hd__tapvpwrvgnd_1
XTAP_1170 vssd1 vccd1 sky130_fd_sc_hd__tapvpwrvgnd_1
XFILLER_0_72_604 vssd1 vssd1 vccd1 vccd1 sky130_fd_sc_hd__fill_1
XFILLER_0_60_68 vssd1 vssd1 vccd1 vccd1 sky130_fd_sc_hd__decap_3
X_05220_ _03924_ _03935_ _03946_ vssd1 vssd1 vccd1 vccd1 _03957_ sky130_fd_sc_hd__nand3_2
XFILLER_0_71_169 vssd1 vssd1 vccd1 vccd1 sky130_fd_sc_hd__decap_6
XFILLER_0_69_22 vssd1 vssd1 vccd1 vccd1 sky130_fd_sc_hd__fill_2
XFILLER_0_69_11 vssd1 vssd1 vccd1 vccd1 sky130_fd_sc_hd__fill_1
XFILLER_0_8_47 vssd1 vssd1 vccd1 vccd1 sky130_fd_sc_hd__fill_1
XFILLER_0_4_458 vssd1 vssd1 vccd1 vccd1 sky130_fd_sc_hd__fill_1
X_05151_ _03115_ _03126_ _03192_ vssd1 vssd1 vccd1 vccd1 _03203_ sky130_fd_sc_hd__and3_1
XFILLER_0_69_55 vssd1 vssd1 vccd1 vccd1 sky130_fd_sc_hd__fill_1
XFILLER_0_100_41 vssd1 vssd1 vccd1 vccd1 sky130_ef_sc_hd__decap_12
X_05082_ net36 net555 net125 vssd1 vssd1 vccd1 vccd1 _00076_ sky130_fd_sc_hd__mux2_1
X_08910_ _03343_ _03344_ _03187_ _03189_ vssd1 vssd1 vccd1 vccd1 _03347_ sky130_fd_sc_hd__o211a_1
X_09890_ _04415_ _04417_ vssd1 vssd1 vccd1 vccd1 _04418_ sky130_fd_sc_hd__nor2_1
XTAP_910 vssd1 vccd1 sky130_fd_sc_hd__tapvpwrvgnd_1
X_08841_ net208 net471 _03267_ _03269_ vssd1 vssd1 vccd1 vccd1 _03271_ sky130_fd_sc_hd__and4_1
XTAP_943 vssd1 vccd1 sky130_fd_sc_hd__tapvpwrvgnd_1
XTAP_932 vssd1 vccd1 sky130_fd_sc_hd__tapvpwrvgnd_1
XTAP_921 vssd1 vccd1 sky130_fd_sc_hd__tapvpwrvgnd_1
XTAP_987 vssd1 vccd1 sky130_fd_sc_hd__tapvpwrvgnd_1
XTAP_976 vssd1 vccd1 sky130_fd_sc_hd__tapvpwrvgnd_1
XTAP_965 vssd1 vccd1 sky130_fd_sc_hd__tapvpwrvgnd_1
XTAP_954 vssd1 vccd1 sky130_fd_sc_hd__tapvpwrvgnd_1
X_08772_ _03156_ _03157_ _03194_ _03195_ vssd1 vssd1 vccd1 vccd1 _03196_ sky130_fd_sc_hd__nor4_1
XTAP_998 vssd1 vccd1 sky130_fd_sc_hd__tapvpwrvgnd_1
X_05984_ _00361_ _00362_ _00259_ _00261_ vssd1 vssd1 vccd1 vccd1 _00364_ sky130_fd_sc_hd__a211o_1
X_07723_ net649 net93 _02093_ _02094_ vssd1 vssd1 vccd1 vccd1 _02095_ sky130_fd_sc_hd__o211ai_2
X_07654_ _01851_ _01858_ _01857_ vssd1 vssd1 vccd1 vccd1 _02026_ sky130_fd_sc_hd__a21o_1
XFILLER_0_19_3 vssd1 vssd1 vccd1 vccd1 sky130_fd_sc_hd__decap_3
X_06605_ _00975_ _00978_ vssd1 vssd1 vccd1 vccd1 _00979_ sky130_fd_sc_hd__and2b_1
XFILLER_0_47_111 vssd1 vssd1 vccd1 vccd1 sky130_fd_sc_hd__fill_1
X_07585_ net165 net611 _01955_ _01956_ vssd1 vssd1 vccd1 vccd1 _01957_ sky130_fd_sc_hd__o2bb2a_1
X_09324_ _03646_ _03649_ _03798_ vssd1 vssd1 vccd1 vccd1 _03799_ sky130_fd_sc_hd__a21oi_1
X_06536_ _00909_ _00910_ vssd1 vssd1 vccd1 vccd1 _00911_ sky130_fd_sc_hd__and2b_1
XFILLER_0_75_497 vssd1 vssd1 vccd1 vccd1 sky130_fd_sc_hd__decap_6
X_09255_ net167 net497 vssd1 vssd1 vccd1 vccd1 _03723_ sky130_fd_sc_hd__nand2_1
X_06467_ _00829_ _00831_ vssd1 vssd1 vccd1 vccd1 _00842_ sky130_fd_sc_hd__nand2_1
X_08206_ _02539_ _02541_ _02576_ _02577_ vssd1 vssd1 vccd1 vccd1 _02579_ sky130_fd_sc_hd__o22ai_2
X_05418_ _04685_ _04686_ _04044_ vssd1 vssd1 vccd1 vccd1 _04688_ sky130_fd_sc_hd__a21o_1
X_09186_ _03646_ _03647_ vssd1 vssd1 vccd1 vccd1 _03648_ sky130_fd_sc_hd__and2_1
X_06398_ _00765_ _00773_ vssd1 vssd1 vccd1 vccd1 _00774_ sky130_fd_sc_hd__nand2b_1
XFILLER_0_31_512 vssd1 vssd1 vccd1 vccd1 sky130_fd_sc_hd__decap_4
X_08137_ _02504_ _02507_ _02508_ vssd1 vssd1 vccd1 vccd1 _02509_ sky130_fd_sc_hd__and3_1
X_05349_ _04575_ _04576_ _04579_ vssd1 vssd1 vccd1 vccd1 _04619_ sky130_fd_sc_hd__a21o_1
X_08068_ net485 net144 net130 net247 vssd1 vssd1 vccd1 vccd1 _02441_ sky130_fd_sc_hd__a22o_1
XFILLER_0_31_567 vssd1 vssd1 vccd1 vccd1 sky130_fd_sc_hd__fill_1
X_07019_ _01388_ _01389_ vssd1 vssd1 vccd1 vccd1 _01390_ sky130_fd_sc_hd__nand2b_1
XFILLER_0_101_477 vssd1 vssd1 vccd1 vccd1 sky130_fd_sc_hd__fill_1
X_10030_ net644 vssd1 vssd1 vccd1 vccd1 _00026_ sky130_fd_sc_hd__inv_2
XFILLER_0_98_545 vssd1 vssd1 vccd1 vccd1 sky130_ef_sc_hd__decap_12
XFILLER_0_66_453 vssd1 vssd1 vccd1 vccd1 sky130_fd_sc_hd__fill_2
XFILLER_0_54_604 vssd1 vssd1 vccd1 vccd1 sky130_fd_sc_hd__fill_1
XFILLER_0_93_272 vssd1 vssd1 vccd1 vccd1 sky130_fd_sc_hd__decap_8
XFILLER_0_81_423 vssd1 vssd1 vccd1 vccd1 sky130_fd_sc_hd__decap_6
XFILLER_0_66_497 vssd1 vssd1 vccd1 vccd1 sky130_ef_sc_hd__decap_12
XFILLER_0_66_475 vssd1 vssd1 vccd1 vccd1 sky130_fd_sc_hd__fill_1
XFILLER_0_53_103 vssd1 vssd1 vccd1 vccd1 sky130_fd_sc_hd__fill_2
XFILLER_0_26_306 vssd1 vssd1 vccd1 vccd1 sky130_fd_sc_hd__fill_2
XFILLER_0_53_169 vssd1 vssd1 vccd1 vccd1 sky130_fd_sc_hd__decap_8
XTAP_206 vssd1 vccd1 sky130_fd_sc_hd__tapvpwrvgnd_1
XTAP_228 vssd1 vccd1 sky130_fd_sc_hd__tapvpwrvgnd_1
XTAP_217 vssd1 vccd1 sky130_fd_sc_hd__tapvpwrvgnd_1
XTAP_239 vssd1 vccd1 sky130_fd_sc_hd__tapvpwrvgnd_1
XFILLER_0_55_57 vssd1 vssd1 vccd1 vccd1 sky130_ef_sc_hd__decap_12
XFILLER_0_76_217 vssd1 vssd1 vccd1 vccd1 sky130_fd_sc_hd__decap_3
XFILLER_0_71_78 vssd1 vssd1 vccd1 vccd1 sky130_fd_sc_hd__decap_6
X_07370_ net295 net473 _01737_ _01738_ vssd1 vssd1 vccd1 vccd1 _01739_ sky130_fd_sc_hd__a22o_1
XFILLER_0_29_144 vssd1 vssd1 vccd1 vccd1 sky130_ef_sc_hd__decap_12
X_06321_ _00695_ _00696_ _00647_ vssd1 vssd1 vccd1 vccd1 _00698_ sky130_fd_sc_hd__a21o_1
X_09040_ _03332_ _03336_ _03488_ vssd1 vssd1 vccd1 vccd1 _03489_ sky130_fd_sc_hd__a21oi_1
X_06252_ _00487_ _00489_ vssd1 vssd1 vccd1 vccd1 _00629_ sky130_fd_sc_hd__nand2_1
XFILLER_0_72_467 vssd1 vssd1 vccd1 vccd1 sky130_fd_sc_hd__decap_8
XFILLER_0_4_222 vssd1 vssd1 vccd1 vccd1 sky130_fd_sc_hd__fill_1
X_05203_ _03443_ _03465_ _03454_ vssd1 vssd1 vccd1 vccd1 _03771_ sky130_fd_sc_hd__a21o_1
XFILLER_0_32_309 vssd1 vssd1 vccd1 vccd1 sky130_fd_sc_hd__decap_4
Xmax_cap110 _02802_ vssd1 vssd1 vccd1 vccd1 net110 sky130_fd_sc_hd__buf_1
XFILLER_0_4_266 vssd1 vssd1 vccd1 vccd1 sky130_fd_sc_hd__fill_1
X_06183_ _00558_ _00559_ _00560_ vssd1 vssd1 vccd1 vccd1 _00561_ sky130_fd_sc_hd__nand3_1
X_05134_ net353 net585 _02995_ _03006_ vssd1 vssd1 vccd1 vccd1 _03017_ sky130_fd_sc_hd__nand4_1
X_05065_ net23 net420 net127 vssd1 vssd1 vccd1 vccd1 _00093_ sky130_fd_sc_hd__mux2_1
X_09942_ _04469_ _04473_ vssd1 vssd1 vccd1 vccd1 _04474_ sky130_fd_sc_hd__xnor2_1
X_09873_ _04397_ _04398_ vssd1 vssd1 vccd1 vccd1 _04399_ sky130_fd_sc_hd__nand2_1
XTAP_740 vssd1 vccd1 sky130_fd_sc_hd__tapvpwrvgnd_1
XTAP_751 vssd1 vccd1 sky130_fd_sc_hd__tapvpwrvgnd_1
X_08824_ _03095_ _03098_ _03249_ _03251_ vssd1 vssd1 vccd1 vccd1 _03252_ sky130_fd_sc_hd__o211ai_2
XTAP_795 vssd1 vccd1 sky130_fd_sc_hd__tapvpwrvgnd_1
XTAP_784 vssd1 vccd1 sky130_fd_sc_hd__tapvpwrvgnd_1
XTAP_773 vssd1 vccd1 sky130_fd_sc_hd__tapvpwrvgnd_1
XTAP_762 vssd1 vccd1 sky130_fd_sc_hd__tapvpwrvgnd_1
X_08755_ net286 net418 net424 net278 vssd1 vssd1 vccd1 vccd1 _03177_ sky130_fd_sc_hd__a22oi_1
X_07706_ net694 _02077_ _02076_ vssd1 vssd1 vccd1 vccd1 _02078_ sky130_fd_sc_hd__a21bo_1
X_05967_ _00338_ _00345_ _00346_ vssd1 vssd1 vccd1 vccd1 _00347_ sky130_fd_sc_hd__nand3_1
XFILLER_0_95_515 vssd1 vssd1 vccd1 vccd1 sky130_fd_sc_hd__fill_1
X_08686_ _03097_ _03099_ _02938_ _02942_ vssd1 vssd1 vccd1 vccd1 _03101_ sky130_fd_sc_hd__a211o_1
X_05898_ _00173_ _00175_ _00276_ _00277_ vssd1 vssd1 vccd1 vccd1 _00279_ sky130_fd_sc_hd__a211o_1
XFILLER_0_95_559 vssd1 vssd1 vccd1 vccd1 sky130_fd_sc_hd__fill_1
X_07637_ net376 net402 _02005_ _02007_ vssd1 vssd1 vccd1 vccd1 _02009_ sky130_fd_sc_hd__and4_1
X_07568_ _01938_ _01939_ _01687_ _01689_ vssd1 vssd1 vccd1 vccd1 _01941_ sky130_fd_sc_hd__a211o_1
XFILLER_0_48_453 vssd1 vssd1 vccd1 vccd1 sky130_fd_sc_hd__decap_3
X_09307_ net284 net395 _03776_ _03778_ vssd1 vssd1 vccd1 vccd1 _03780_ sky130_fd_sc_hd__and4_1
X_06519_ _00891_ _00892_ _00890_ vssd1 vssd1 vccd1 vccd1 _00894_ sky130_fd_sc_hd__a21o_1
X_07499_ _01735_ _01742_ _01741_ vssd1 vssd1 vccd1 vccd1 _01871_ sky130_fd_sc_hd__a21o_1
XFILLER_0_8_572 vssd1 vssd1 vccd1 vccd1 sky130_fd_sc_hd__fill_1
X_09238_ _03544_ _03547_ _03703_ vssd1 vssd1 vccd1 vccd1 _03705_ sky130_fd_sc_hd__and3_1
XFILLER_0_90_253 vssd1 vssd1 vccd1 vccd1 sky130_fd_sc_hd__decap_3
XFILLER_0_63_478 vssd1 vssd1 vccd1 vccd1 sky130_fd_sc_hd__decap_3
X_09169_ net303 net136 _03628_ _03310_ vssd1 vssd1 vccd1 vccd1 _03630_ sky130_fd_sc_hd__o22a_1
XFILLER_0_50_139 vssd1 vssd1 vccd1 vccd1 sky130_fd_sc_hd__fill_1
XFILLER_0_43_180 vssd1 vssd1 vccd1 vccd1 sky130_fd_sc_hd__decap_4
XFILLER_0_101_274 vssd1 vssd1 vccd1 vccd1 sky130_fd_sc_hd__decap_6
XFILLER_0_8_3 vssd1 vssd1 vccd1 vccd1 sky130_fd_sc_hd__decap_8
X_10013_ net639 vssd1 vssd1 vccd1 vccd1 _00009_ sky130_fd_sc_hd__inv_2
XFILLER_0_98_397 vssd1 vssd1 vccd1 vccd1 sky130_fd_sc_hd__decap_8
XFILLER_0_73_209 vssd1 vssd1 vccd1 vccd1 sky130_fd_sc_hd__decap_8
XFILLER_0_54_412 vssd1 vssd1 vccd1 vccd1 sky130_fd_sc_hd__fill_1
XFILLER_0_39_475 vssd1 vssd1 vccd1 vccd1 sky130_fd_sc_hd__fill_2
XFILLER_0_41_15 vssd1 vssd1 vccd1 vccd1 sky130_ef_sc_hd__decap_12
XFILLER_0_26_147 vssd1 vssd1 vccd1 vccd1 sky130_ef_sc_hd__decap_12
XFILLER_0_41_128 vssd1 vssd1 vccd1 vccd1 sky130_fd_sc_hd__decap_8
XFILLER_0_1_225 vssd1 vssd1 vccd1 vccd1 sky130_fd_sc_hd__fill_2
XFILLER_0_1_203 vssd1 vssd1 vccd1 vccd1 sky130_fd_sc_hd__decap_4
XFILLER_0_34_191 vssd1 vssd1 vccd1 vccd1 sky130_fd_sc_hd__decap_4
XFILLER_0_5_15 vssd1 vssd1 vccd1 vccd1 sky130_fd_sc_hd__fill_2
XFILLER_0_66_12 vssd1 vssd1 vccd1 vccd1 sky130_fd_sc_hd__decap_3
X_06870_ _01240_ _01241_ vssd1 vssd1 vccd1 vccd1 _01242_ sky130_fd_sc_hd__and2_1
X_05821_ net281 net598 net607 net273 vssd1 vssd1 vccd1 vccd1 _00202_ sky130_fd_sc_hd__a22o_1
XFILLER_0_89_331 vssd1 vssd1 vccd1 vccd1 sky130_fd_sc_hd__decap_4
X_08540_ net179 net525 _02937_ _02939_ vssd1 vssd1 vccd1 vccd1 _02942_ sky130_fd_sc_hd__and4_1
X_05752_ _00132_ _00133_ vssd1 vssd1 vccd1 vccd1 _00134_ sky130_fd_sc_hd__nor2_1
XFILLER_0_89_397 vssd1 vssd1 vccd1 vccd1 sky130_fd_sc_hd__fill_1
X_08471_ _02657_ _02659_ _02865_ _02866_ vssd1 vssd1 vccd1 vccd1 _02867_ sky130_fd_sc_hd__o211ai_4
XFILLER_0_82_88 vssd1 vssd1 vccd1 vccd1 sky130_fd_sc_hd__decap_6
X_05683_ _04936_ _04951_ _04952_ vssd1 vssd1 vccd1 vccd1 _04953_ sky130_fd_sc_hd__and3_1
XFILLER_0_77_559 vssd1 vssd1 vccd1 vccd1 sky130_fd_sc_hd__fill_1
XFILLER_0_9_325 vssd1 vssd1 vccd1 vccd1 sky130_fd_sc_hd__decap_8
X_07422_ _01500_ _01647_ _01645_ vssd1 vssd1 vccd1 vccd1 _01791_ sky130_fd_sc_hd__o21ai_1
XFILLER_0_85_581 vssd1 vssd1 vccd1 vccd1 sky130_fd_sc_hd__fill_2
XFILLER_0_57_261 vssd1 vssd1 vccd1 vccd1 sky130_fd_sc_hd__decap_6
X_07353_ net307 net316 net459 net466 vssd1 vssd1 vccd1 vccd1 _01722_ sky130_fd_sc_hd__nand4_4
XFILLER_0_17_125 vssd1 vssd1 vccd1 vccd1 sky130_fd_sc_hd__fill_1
X_06304_ _00677_ _00678_ _00679_ vssd1 vssd1 vccd1 vccd1 _00681_ sky130_fd_sc_hd__a21o_1
X_07284_ _01650_ _01651_ net170 net619 vssd1 vssd1 vccd1 vccd1 _01653_ sky130_fd_sc_hd__and4bb_1
X_09023_ net303 net395 _03467_ _03469_ vssd1 vssd1 vccd1 vccd1 _03470_ sky130_fd_sc_hd__a22o_1
XFILLER_0_86_3 vssd1 vssd1 vccd1 vccd1 sky130_fd_sc_hd__decap_3
X_06235_ net211 net219 net627 net635 vssd1 vssd1 vccd1 vccd1 _00612_ sky130_fd_sc_hd__and4_1
X_06166_ net487 _00542_ _00543_ vssd1 vssd1 vccd1 vccd1 _00544_ sky130_fd_sc_hd__a21bo_1
X_06097_ _00314_ _00317_ _00473_ _00475_ vssd1 vssd1 vccd1 vccd1 _00476_ sky130_fd_sc_hd__a211oi_1
X_05117_ net352 net594 net604 net343 vssd1 vssd1 vccd1 vccd1 _02831_ sky130_fd_sc_hd__a22o_1
X_05048_ net35 net322 net133 vssd1 vssd1 vccd1 vccd1 _00107_ sky130_fd_sc_hd__mux2_1
X_09925_ _04311_ _04314_ _04327_ vssd1 vssd1 vccd1 vccd1 _04455_ sky130_fd_sc_hd__a21bo_1
XTAP_570 vssd1 vccd1 sky130_fd_sc_hd__tapvpwrvgnd_1
X_09856_ _04378_ _04379_ vssd1 vssd1 vccd1 vccd1 _04380_ sky130_fd_sc_hd__nor2_1
X_08807_ _03075_ _03078_ _03232_ _03233_ vssd1 vssd1 vccd1 vccd1 _03234_ sky130_fd_sc_hd__o211a_1
XTAP_592 vssd1 vccd1 sky130_fd_sc_hd__tapvpwrvgnd_1
XTAP_581 vssd1 vccd1 sky130_fd_sc_hd__tapvpwrvgnd_1
X_09787_ _04303_ _04304_ vssd1 vssd1 vccd1 vccd1 _04305_ sky130_fd_sc_hd__nor2_1
X_06999_ net188 net619 _01228_ _01227_ vssd1 vssd1 vccd1 vccd1 _01370_ sky130_fd_sc_hd__a31o_1
X_08738_ net334 net394 vssd1 vssd1 vccd1 vccd1 _03158_ sky130_fd_sc_hd__and2b_1
XFILLER_0_95_334 vssd1 vssd1 vccd1 vccd1 sky130_fd_sc_hd__fill_2
XFILLER_0_95_323 vssd1 vssd1 vccd1 vccd1 sky130_fd_sc_hd__decap_4
X_08669_ _03081_ _03082_ vssd1 vssd1 vccd1 vccd1 _03084_ sky130_fd_sc_hd__nand2_1
XFILLER_0_91_540 vssd1 vssd1 vccd1 vccd1 sky130_fd_sc_hd__fill_2
XFILLER_0_63_220 vssd1 vssd1 vccd1 vccd1 sky130_fd_sc_hd__decap_4
XFILLER_0_36_445 vssd1 vssd1 vccd1 vccd1 sky130_fd_sc_hd__fill_1
XFILLER_0_48_294 vssd1 vssd1 vccd1 vccd1 sky130_ef_sc_hd__decap_12
XFILLER_0_23_128 vssd1 vssd1 vccd1 vccd1 sky130_fd_sc_hd__decap_6
XFILLER_0_36_15 vssd1 vssd1 vccd1 vccd1 sky130_ef_sc_hd__decap_12
XFILLER_0_86_301 vssd1 vssd1 vccd1 vccd1 sky130_fd_sc_hd__fill_1
XFILLER_0_98_194 vssd1 vssd1 vccd1 vccd1 sky130_fd_sc_hd__fill_2
XFILLER_0_52_58 vssd1 vssd1 vccd1 vccd1 sky130_fd_sc_hd__decap_4
XFILLER_0_27_401 vssd1 vssd1 vccd1 vccd1 sky130_fd_sc_hd__decap_3
XFILLER_0_39_261 vssd1 vssd1 vccd1 vccd1 sky130_fd_sc_hd__fill_1
XFILLER_0_54_253 vssd1 vssd1 vccd1 vccd1 sky130_fd_sc_hd__decap_4
XFILLER_0_27_467 vssd1 vssd1 vccd1 vccd1 sky130_fd_sc_hd__fill_1
XFILLER_0_42_404 vssd1 vssd1 vccd1 vccd1 sky130_fd_sc_hd__decap_6
XFILLER_0_2_501 vssd1 vssd1 vccd1 vccd1 sky130_fd_sc_hd__decap_8
XFILLER_0_14_139 vssd1 vssd1 vccd1 vccd1 sky130_fd_sc_hd__fill_1
X_06020_ net263 net597 net608 net253 vssd1 vssd1 vccd1 vccd1 _00399_ sky130_fd_sc_hd__a22o_1
XFILLER_0_77_55 vssd1 vssd1 vccd1 vccd1 sky130_fd_sc_hd__fill_1
X_07971_ net332 net421 net426 net324 vssd1 vssd1 vccd1 vccd1 _02344_ sky130_fd_sc_hd__a22o_1
XFILLER_0_58_7 vssd1 vssd1 vccd1 vccd1 sky130_fd_sc_hd__fill_1
XFILLER_0_10_356 vssd1 vssd1 vccd1 vccd1 sky130_fd_sc_hd__decap_8
X_09710_ _04217_ _04218_ vssd1 vssd1 vccd1 vccd1 _04221_ sky130_fd_sc_hd__xnor2_1
X_06922_ _01291_ _01292_ _01156_ _01158_ vssd1 vssd1 vccd1 vccd1 _01294_ sky130_fd_sc_hd__a211o_1
X_09641_ _03995_ _03996_ _03994_ vssd1 vssd1 vccd1 vccd1 _04146_ sky130_fd_sc_hd__a21o_1
XFILLER_0_93_65 vssd1 vssd1 vccd1 vccd1 sky130_fd_sc_hd__fill_1
X_06853_ _00996_ _01128_ _01130_ vssd1 vssd1 vccd1 vccd1 _01225_ sky130_fd_sc_hd__o21ai_2
X_09572_ _03952_ _03954_ vssd1 vssd1 vccd1 vccd1 _04070_ sky130_fd_sc_hd__and2b_1
X_05804_ _00180_ net139 _00183_ _00185_ vssd1 vssd1 vccd1 vccd1 net40 sky130_fd_sc_hd__a31o_1
X_06784_ net348 net456 net463 net338 vssd1 vssd1 vccd1 vccd1 _01157_ sky130_fd_sc_hd__a22o_1
XFILLER_0_77_301 vssd1 vssd1 vccd1 vccd1 sky130_fd_sc_hd__fill_2
X_08523_ _02922_ _02923_ vssd1 vssd1 vccd1 vccd1 _02924_ sky130_fd_sc_hd__nor2_2
X_05735_ _05000_ _05003_ vssd1 vssd1 vccd1 vccd1 _05005_ sky130_fd_sc_hd__xnor2_1
X_08454_ _02846_ _02847_ vssd1 vssd1 vccd1 vccd1 _02848_ sky130_fd_sc_hd__or2_1
XFILLER_0_92_315 vssd1 vssd1 vccd1 vccd1 sky130_fd_sc_hd__fill_1
X_05666_ _04823_ _04831_ _04830_ vssd1 vssd1 vccd1 vccd1 _04936_ sky130_fd_sc_hd__a21bo_1
XFILLER_0_92_359 vssd1 vssd1 vccd1 vccd1 sky130_fd_sc_hd__decap_4
X_08385_ net174 net179 net701 net547 vssd1 vssd1 vccd1 vccd1 _02772_ sky130_fd_sc_hd__and4_1
X_05597_ _04864_ _04865_ _04750_ vssd1 vssd1 vccd1 vccd1 _04867_ sky130_fd_sc_hd__a21oi_1
X_07405_ _01713_ _01714_ _01771_ _01772_ vssd1 vssd1 vccd1 vccd1 _01774_ sky130_fd_sc_hd__a2bb2o_1
XFILLER_0_73_551 vssd1 vssd1 vccd1 vccd1 sky130_fd_sc_hd__decap_4
X_07336_ _01697_ _01704_ vssd1 vssd1 vccd1 vccd1 _01705_ sky130_fd_sc_hd__nand2_1
XFILLER_0_45_264 vssd1 vssd1 vccd1 vccd1 sky130_fd_sc_hd__fill_2
XFILLER_0_73_584 vssd1 vssd1 vccd1 vccd1 sky130_fd_sc_hd__fill_1
XFILLER_0_60_201 vssd1 vssd1 vccd1 vccd1 sky130_fd_sc_hd__decap_8
XFILLER_0_45_297 vssd1 vssd1 vccd1 vccd1 sky130_ef_sc_hd__decap_12
X_09006_ _03440_ _03449_ vssd1 vssd1 vccd1 vccd1 _03451_ sky130_fd_sc_hd__xor2_2
X_07267_ _01633_ _01634_ _01479_ _01481_ vssd1 vssd1 vccd1 vccd1 _01637_ sky130_fd_sc_hd__o211a_1
X_06218_ _00594_ _00595_ vssd1 vssd1 vccd1 vccd1 _00596_ sky130_fd_sc_hd__and2_4
X_07198_ _01542_ _01567_ vssd1 vssd1 vccd1 vccd1 _01568_ sky130_fd_sc_hd__nor2_1
X_06149_ net288 net563 net570 net280 vssd1 vssd1 vccd1 vccd1 _00527_ sky130_fd_sc_hd__a22oi_1
Xfanout520 net521 vssd1 vssd1 vccd1 vccd1 net520 sky130_fd_sc_hd__buf_6
XFILLER_0_6_80 vssd1 vssd1 vccd1 vccd1 sky130_fd_sc_hd__decap_4
Xfanout531 net532 vssd1 vssd1 vccd1 vccd1 net531 sky130_fd_sc_hd__buf_2
Xfanout542 net543 vssd1 vssd1 vccd1 vccd1 net542 sky130_fd_sc_hd__clkbuf_4
X_09908_ _04297_ _04298_ _04300_ vssd1 vssd1 vccd1 vccd1 _04437_ sky130_fd_sc_hd__o21ba_1
Xfanout553 net554 vssd1 vssd1 vccd1 vccd1 net553 sky130_fd_sc_hd__clkbuf_4
Xfanout575 net576 vssd1 vssd1 vccd1 vccd1 net575 sky130_fd_sc_hd__clkbuf_4
Xfanout564 mul.b\[8\] vssd1 vssd1 vccd1 vccd1 net564 sky130_fd_sc_hd__buf_4
X_09839_ _01827_ net392 _03310_ vssd1 vssd1 vccd1 vccd1 _04362_ sky130_fd_sc_hd__a21o_1
Xfanout586 net587 vssd1 vssd1 vccd1 vccd1 net586 sky130_fd_sc_hd__buf_2
Xfanout597 net598 vssd1 vssd1 vccd1 vccd1 net597 sky130_fd_sc_hd__buf_2
XPHY_40 vssd1 vssd1 vccd1 vccd1 sky130_fd_sc_hd__decap_3
Xclkbuf_3_1_0_wb_clk_i clknet_0_wb_clk_i vssd1 vssd1 vccd1 vccd1 clknet_3_1_0_wb_clk_i
+ sky130_fd_sc_hd__clkbuf_8
XFILLER_0_56_507 vssd1 vssd1 vccd1 vccd1 sky130_fd_sc_hd__fill_1
XPHY_51 vssd1 vssd1 vccd1 vccd1 sky130_fd_sc_hd__decap_3
XFILLER_0_28_209 vssd1 vssd1 vccd1 vccd1 sky130_fd_sc_hd__decap_8
XPHY_62 vssd1 vssd1 vccd1 vccd1 sky130_fd_sc_hd__decap_3
XPHY_73 vssd1 vssd1 vccd1 vccd1 sky130_fd_sc_hd__decap_3
XFILLER_0_83_337 vssd1 vssd1 vccd1 vccd1 sky130_fd_sc_hd__fill_1
XFILLER_0_22_39 vssd1 vssd1 vccd1 vccd1 sky130_fd_sc_hd__decap_8
XPHY_84 vssd1 vssd1 vccd1 vccd1 sky130_fd_sc_hd__decap_3
XPHY_95 vssd1 vssd1 vccd1 vccd1 sky130_fd_sc_hd__decap_3
XFILLER_0_64_562 vssd1 vssd1 vccd1 vccd1 sky130_fd_sc_hd__fill_2
XFILLER_0_36_242 vssd1 vssd1 vccd1 vccd1 sky130_fd_sc_hd__decap_8
XFILLER_0_36_253 vssd1 vssd1 vccd1 vccd1 sky130_ef_sc_hd__decap_12
XFILLER_0_24_437 vssd1 vssd1 vccd1 vccd1 sky130_fd_sc_hd__decap_3
XFILLER_0_24_448 vssd1 vssd1 vccd1 vccd1 sky130_fd_sc_hd__fill_1
XFILLER_0_47_47 vssd1 vssd1 vccd1 vccd1 sky130_fd_sc_hd__fill_2
XFILLER_0_47_69 vssd1 vssd1 vccd1 vccd1 sky130_fd_sc_hd__fill_1
XFILLER_0_2_27 vssd1 vssd1 vccd1 vccd1 sky130_fd_sc_hd__fill_1
XFILLER_0_63_57 vssd1 vssd1 vccd1 vccd1 sky130_fd_sc_hd__decap_6
X_05520_ _04700_ _04702_ _04701_ vssd1 vssd1 vccd1 vccd1 _04790_ sky130_fd_sc_hd__a21bo_1
XFILLER_0_74_326 vssd1 vssd1 vccd1 vccd1 sky130_fd_sc_hd__decap_6
X_05451_ net356 net559 net567 net347 vssd1 vssd1 vccd1 vccd1 _04721_ sky130_fd_sc_hd__a22oi_1
X_08170_ net680 net393 vssd1 vssd1 vccd1 vccd1 _02542_ sky130_fd_sc_hd__and2b_1
XFILLER_0_27_286 vssd1 vssd1 vccd1 vccd1 sky130_fd_sc_hd__decap_6
X_05382_ _04642_ _04648_ vssd1 vssd1 vccd1 vccd1 _04652_ sky130_fd_sc_hd__xor2_1
X_07121_ _01489_ _01490_ _01351_ _01353_ vssd1 vssd1 vccd1 vccd1 _01492_ sky130_fd_sc_hd__o211ai_1
XFILLER_0_12_83 vssd1 vssd1 vccd1 vccd1 sky130_fd_sc_hd__fill_1
X_07052_ net444 _01422_ _01421_ vssd1 vssd1 vccd1 vccd1 _01423_ sky130_fd_sc_hd__a21bo_1
X_06003_ net139 _00380_ _00381_ _00382_ vssd1 vssd1 vccd1 vccd1 net62 sky130_fd_sc_hd__a31o_1
XFILLER_0_10_131 vssd1 vssd1 vccd1 vccd1 sky130_fd_sc_hd__fill_1
XFILLER_0_2_386 vssd1 vssd1 vccd1 vccd1 sky130_fd_sc_hd__fill_1
X_07954_ net707 net393 vssd1 vssd1 vccd1 vccd1 _02327_ sky130_fd_sc_hd__and2b_1
XFILLER_0_10_197 vssd1 vssd1 vccd1 vccd1 sky130_fd_sc_hd__decap_4
X_07885_ _02194_ _02195_ _02256_ _02257_ vssd1 vssd1 vccd1 vccd1 _02259_ sky130_fd_sc_hd__or4bb_2
X_06905_ _01268_ _01276_ vssd1 vssd1 vccd1 vccd1 _01277_ sky130_fd_sc_hd__xnor2_1
X_09624_ _03670_ _03973_ _03971_ vssd1 vssd1 vccd1 vccd1 _04127_ sky130_fd_sc_hd__a21oi_1
X_06836_ net89 _01135_ net726 _01207_ vssd1 vssd1 vccd1 vccd1 _01209_ sky130_fd_sc_hd__o22a_1
XFILLER_0_97_429 vssd1 vssd1 vccd1 vccd1 sky130_ef_sc_hd__decap_12
X_06767_ net242 net561 net567 net234 vssd1 vssd1 vccd1 vccd1 _01140_ sky130_fd_sc_hd__a22oi_1
X_09555_ _04050_ vssd1 vssd1 vccd1 vccd1 _04051_ sky130_fd_sc_hd__inv_2
XFILLER_0_93_602 vssd1 vssd1 vccd1 vccd1 sky130_fd_sc_hd__fill_2
X_09486_ _03969_ _03974_ vssd1 vssd1 vccd1 vccd1 _03976_ sky130_fd_sc_hd__xnor2_1
X_08506_ _02904_ _02878_ vssd1 vssd1 vccd1 vccd1 _02905_ sky130_fd_sc_hd__and2b_1
XFILLER_0_65_315 vssd1 vssd1 vccd1 vccd1 sky130_fd_sc_hd__fill_2
X_05718_ _04920_ _04922_ _04986_ vssd1 vssd1 vccd1 vccd1 _04988_ sky130_fd_sc_hd__nand3_1
X_06698_ _01036_ _01037_ _01069_ _01070_ vssd1 vssd1 vccd1 vccd1 _01072_ sky130_fd_sc_hd__or4_4
X_08437_ _02805_ _02806_ _02827_ vssd1 vssd1 vccd1 vccd1 _02829_ sky130_fd_sc_hd__nand3_2
X_05649_ _04917_ _04918_ vssd1 vssd1 vccd1 vccd1 _04919_ sky130_fd_sc_hd__and2_1
XFILLER_0_18_242 vssd1 vssd1 vccd1 vccd1 sky130_fd_sc_hd__decap_6
XFILLER_0_18_253 vssd1 vssd1 vccd1 vccd1 sky130_fd_sc_hd__fill_2
XFILLER_0_46_551 vssd1 vssd1 vccd1 vccd1 sky130_fd_sc_hd__fill_1
XFILLER_0_73_381 vssd1 vssd1 vccd1 vccd1 sky130_fd_sc_hd__decap_8
X_08368_ _02751_ _02752_ _02580_ _02582_ vssd1 vssd1 vccd1 vccd1 _02754_ sky130_fd_sc_hd__a211oi_2
XFILLER_0_18_286 vssd1 vssd1 vccd1 vccd1 sky130_fd_sc_hd__decap_4
X_08299_ _02674_ _02675_ _02676_ vssd1 vssd1 vccd1 vccd1 _02679_ sky130_fd_sc_hd__nand3_1
X_07319_ _01685_ _01686_ _01566_ _01568_ vssd1 vssd1 vccd1 vccd1 _01688_ sky130_fd_sc_hd__a211oi_2
XFILLER_0_33_289 vssd1 vssd1 vccd1 vccd1 sky130_ef_sc_hd__decap_12
Xfanout350 net351 vssd1 vssd1 vccd1 vccd1 net350 sky130_fd_sc_hd__buf_4
Xfanout383 net384 vssd1 vssd1 vccd1 vccd1 net383 sky130_fd_sc_hd__buf_4
Xfanout372 net373 vssd1 vssd1 vccd1 vccd1 net372 sky130_fd_sc_hd__clkbuf_2
Xfanout361 net362 vssd1 vssd1 vccd1 vccd1 net361 sky130_fd_sc_hd__clkbuf_4
Xfanout394 mul.b\[31\] vssd1 vssd1 vccd1 vccd1 net394 sky130_fd_sc_hd__clkbuf_4
XTAP_1341 vssd1 vccd1 sky130_fd_sc_hd__tapvpwrvgnd_1
XTAP_1330 vssd1 vccd1 sky130_fd_sc_hd__tapvpwrvgnd_1
XFILLER_0_96_462 vssd1 vssd1 vccd1 vccd1 sky130_fd_sc_hd__fill_1
XFILLER_0_83_123 vssd1 vssd1 vccd1 vccd1 sky130_fd_sc_hd__decap_8
XFILLER_0_68_197 vssd1 vssd1 vccd1 vccd1 sky130_fd_sc_hd__decap_6
XFILLER_0_83_167 vssd1 vssd1 vccd1 vccd1 sky130_fd_sc_hd__fill_1
XFILLER_0_71_307 vssd1 vssd1 vccd1 vccd1 sky130_fd_sc_hd__decap_3
XFILLER_0_24_212 vssd1 vssd1 vccd1 vccd1 sky130_fd_sc_hd__fill_1
Xinput25 wbs_dat_i[28] vssd1 vssd1 vccd1 vccd1 net25 sky130_fd_sc_hd__clkbuf_1
Xinput14 wbs_dat_i[18] vssd1 vssd1 vccd1 vccd1 net14 sky130_fd_sc_hd__clkbuf_1
XFILLER_0_52_543 vssd1 vssd1 vccd1 vccd1 sky130_fd_sc_hd__fill_2
Xinput36 wbs_dat_i[9] vssd1 vssd1 vccd1 vccd1 net36 sky130_fd_sc_hd__clkbuf_1
XFILLER_0_12_418 vssd1 vssd1 vccd1 vccd1 sky130_fd_sc_hd__fill_2
XFILLER_0_58_13 vssd1 vssd1 vccd1 vccd1 sky130_fd_sc_hd__fill_1
XFILLER_0_58_24 vssd1 vssd1 vccd1 vccd1 sky130_fd_sc_hd__decap_4
XFILLER_0_74_67 vssd1 vssd1 vccd1 vccd1 sky130_fd_sc_hd__decap_4
X_07670_ net290 net466 net476 net282 vssd1 vssd1 vccd1 vccd1 _02042_ sky130_fd_sc_hd__a22o_1
X_06621_ _00992_ _00993_ vssd1 vssd1 vccd1 vccd1 _00995_ sky130_fd_sc_hd__xor2_1
X_09340_ _03669_ _03816_ vssd1 vssd1 vccd1 vccd1 _03817_ sky130_fd_sc_hd__xnor2_1
XFILLER_0_59_164 vssd1 vssd1 vccd1 vccd1 sky130_fd_sc_hd__decap_4
XFILLER_0_59_153 vssd1 vssd1 vccd1 vccd1 sky130_fd_sc_hd__fill_1
X_06552_ _00924_ _00925_ _00917_ vssd1 vssd1 vccd1 vccd1 _00927_ sky130_fd_sc_hd__a21o_1
X_09271_ _03732_ _03740_ vssd1 vssd1 vccd1 vccd1 _03741_ sky130_fd_sc_hd__xnor2_1
X_05503_ net321 net587 _04771_ _04772_ vssd1 vssd1 vccd1 vccd1 _04773_ sky130_fd_sc_hd__nand4_1
XFILLER_0_90_616 vssd1 vssd1 vccd1 vccd1 sky130_fd_sc_hd__fill_1
XFILLER_0_90_605 vssd1 vssd1 vccd1 vccd1 sky130_fd_sc_hd__fill_2
X_08222_ _02593_ _02594_ _02431_ _02433_ vssd1 vssd1 vccd1 vccd1 _02596_ sky130_fd_sc_hd__a211o_1
X_06483_ _00856_ _00857_ vssd1 vssd1 vccd1 vccd1 _00858_ sky130_fd_sc_hd__and2b_1
XFILLER_0_47_359 vssd1 vssd1 vccd1 vccd1 sky130_fd_sc_hd__decap_8
XFILLER_0_74_178 vssd1 vssd1 vccd1 vccd1 sky130_fd_sc_hd__fill_2
XFILLER_0_62_329 vssd1 vssd1 vccd1 vccd1 sky130_fd_sc_hd__fill_2
XFILLER_0_7_456 vssd1 vssd1 vccd1 vccd1 sky130_fd_sc_hd__decap_8
X_05434_ _04701_ _04702_ _04700_ vssd1 vssd1 vccd1 vccd1 _04704_ sky130_fd_sc_hd__a21o_1
XFILLER_0_28_562 vssd1 vssd1 vccd1 vccd1 sky130_fd_sc_hd__fill_2
X_08153_ net264 net274 net460 net467 vssd1 vssd1 vccd1 vccd1 _02525_ sky130_fd_sc_hd__nand4_4
X_05365_ _04573_ _04575_ vssd1 vssd1 vccd1 vccd1 _04635_ sky130_fd_sc_hd__and2_1
XFILLER_0_70_340 vssd1 vssd1 vccd1 vccd1 sky130_fd_sc_hd__decap_3
X_08084_ _02293_ _02294_ _02296_ vssd1 vssd1 vccd1 vccd1 _02456_ sky130_fd_sc_hd__a21bo_1
X_07104_ net667 _01473_ _01333_ net653 vssd1 vssd1 vccd1 vccd1 _01475_ sky130_fd_sc_hd__a211oi_2
X_05296_ _04563_ _04564_ _04562_ vssd1 vssd1 vccd1 vccd1 _04566_ sky130_fd_sc_hd__a21bo_1
X_07035_ net375 net382 net418 net427 vssd1 vssd1 vccd1 vccd1 _01406_ sky130_fd_sc_hd__and4_1
X_08986_ _03418_ _03427_ vssd1 vssd1 vccd1 vccd1 _03429_ sky130_fd_sc_hd__xnor2_1
X_07937_ net164 net593 _02307_ _02308_ vssd1 vssd1 vccd1 vccd1 _02310_ sky130_fd_sc_hd__a22o_1
X_07868_ net274 net476 _02240_ _02241_ vssd1 vssd1 vccd1 vccd1 _02242_ sky130_fd_sc_hd__a22o_1
XFILLER_0_3_81 vssd1 vssd1 vccd1 vccd1 sky130_fd_sc_hd__decap_8
X_09607_ _03910_ _03912_ _04106_ vssd1 vssd1 vccd1 vccd1 _04108_ sky130_fd_sc_hd__and3_1
X_07799_ _02166_ _02167_ _02168_ vssd1 vssd1 vccd1 vccd1 _02170_ sky130_fd_sc_hd__nand3_1
X_06819_ _01189_ _01190_ _01182_ vssd1 vssd1 vccd1 vccd1 _01192_ sky130_fd_sc_hd__a21o_1
X_09538_ _04021_ _04031_ vssd1 vssd1 vccd1 vccd1 _04032_ sky130_fd_sc_hd__and2b_1
XFILLER_0_78_495 vssd1 vssd1 vccd1 vccd1 sky130_fd_sc_hd__fill_1
XFILLER_0_38_326 vssd1 vssd1 vccd1 vccd1 sky130_fd_sc_hd__decap_3
X_09469_ _03954_ _03955_ _03764_ _03766_ vssd1 vssd1 vccd1 vccd1 _03958_ sky130_fd_sc_hd__a211oi_1
XFILLER_0_34_576 vssd1 vssd1 vccd1 vccd1 sky130_fd_sc_hd__fill_1
XFILLER_0_61_384 vssd1 vssd1 vccd1 vccd1 sky130_fd_sc_hd__fill_1
XFILLER_0_28_27 vssd1 vssd1 vccd1 vccd1 sky130_fd_sc_hd__fill_1
Xfanout180 mul.a\[25\] vssd1 vssd1 vccd1 vccd1 net180 sky130_fd_sc_hd__clkbuf_4
Xfanout191 net198 vssd1 vssd1 vccd1 vccd1 net191 sky130_fd_sc_hd__buf_2
XFILLER_0_88_204 vssd1 vssd1 vccd1 vccd1 sky130_fd_sc_hd__decap_8
XFILLER_0_44_26 vssd1 vssd1 vccd1 vccd1 sky130_fd_sc_hd__fill_2
XFILLER_0_56_101 vssd1 vssd1 vccd1 vccd1 sky130_ef_sc_hd__decap_12
XTAP_1182 vssd1 vccd1 sky130_fd_sc_hd__tapvpwrvgnd_1
XTAP_1160 vssd1 vccd1 sky130_fd_sc_hd__tapvpwrvgnd_1
XTAP_1171 vssd1 vccd1 sky130_fd_sc_hd__tapvpwrvgnd_1
XFILLER_0_84_454 vssd1 vssd1 vccd1 vccd1 sky130_ef_sc_hd__decap_12
XFILLER_0_84_443 vssd1 vssd1 vccd1 vccd1 sky130_fd_sc_hd__decap_6
XFILLER_0_56_145 vssd1 vssd1 vccd1 vccd1 sky130_fd_sc_hd__decap_8
XTAP_1193 vssd1 vccd1 sky130_fd_sc_hd__tapvpwrvgnd_1
XFILLER_0_56_178 vssd1 vssd1 vccd1 vccd1 sky130_fd_sc_hd__decap_3
XFILLER_0_44_307 vssd1 vssd1 vccd1 vccd1 sky130_fd_sc_hd__fill_1
X_05150_ _03170_ _03181_ _03159_ vssd1 vssd1 vccd1 vccd1 _03192_ sky130_fd_sc_hd__a21o_1
XFILLER_0_52_373 vssd1 vssd1 vccd1 vccd1 sky130_fd_sc_hd__fill_2
XFILLER_0_12_237 vssd1 vssd1 vccd1 vccd1 sky130_fd_sc_hd__decap_4
XFILLER_0_25_587 vssd1 vssd1 vccd1 vccd1 sky130_fd_sc_hd__decap_6
XFILLER_0_100_53 vssd1 vssd1 vccd1 vccd1 sky130_ef_sc_hd__decap_12
XFILLER_0_12_259 vssd1 vssd1 vccd1 vccd1 sky130_fd_sc_hd__fill_1
X_05081_ net6 net550 net125 vssd1 vssd1 vccd1 vccd1 _00077_ sky130_fd_sc_hd__mux2_1
XTAP_900 vssd1 vccd1 sky130_fd_sc_hd__tapvpwrvgnd_1
X_08840_ net207 net471 _03267_ _03269_ vssd1 vssd1 vccd1 vccd1 _03270_ sky130_fd_sc_hd__a22oi_1
XTAP_944 vssd1 vccd1 sky130_fd_sc_hd__tapvpwrvgnd_1
XTAP_933 vssd1 vccd1 sky130_fd_sc_hd__tapvpwrvgnd_1
XTAP_922 vssd1 vccd1 sky130_fd_sc_hd__tapvpwrvgnd_1
XTAP_911 vssd1 vccd1 sky130_fd_sc_hd__tapvpwrvgnd_1
XFILLER_0_85_55 vssd1 vssd1 vccd1 vccd1 sky130_fd_sc_hd__fill_1
XTAP_977 vssd1 vccd1 sky130_fd_sc_hd__tapvpwrvgnd_1
XTAP_966 vssd1 vccd1 sky130_fd_sc_hd__tapvpwrvgnd_1
XTAP_955 vssd1 vccd1 sky130_fd_sc_hd__tapvpwrvgnd_1
X_08771_ _03191_ _03193_ _03031_ _03033_ vssd1 vssd1 vccd1 vccd1 _03195_ sky130_fd_sc_hd__o211a_1
XTAP_999 vssd1 vccd1 sky130_fd_sc_hd__tapvpwrvgnd_1
XTAP_988 vssd1 vccd1 sky130_fd_sc_hd__tapvpwrvgnd_1
X_05983_ _00259_ net96 _00361_ _00362_ vssd1 vssd1 vccd1 vccd1 _00363_ sky130_fd_sc_hd__o211ai_4
XFILLER_0_79_215 vssd1 vssd1 vccd1 vccd1 sky130_fd_sc_hd__decap_3
X_07722_ _02034_ _02035_ _02091_ _02092_ vssd1 vssd1 vccd1 vccd1 _02094_ sky130_fd_sc_hd__a2bb2o_2
XFILLER_0_18_82 vssd1 vssd1 vccd1 vccd1 sky130_fd_sc_hd__fill_2
X_07653_ _02022_ _02023_ _02016_ vssd1 vssd1 vccd1 vccd1 _02025_ sky130_fd_sc_hd__a21o_1
XFILLER_0_94_218 vssd1 vssd1 vccd1 vccd1 sky130_fd_sc_hd__decap_8
X_06604_ _00976_ _00977_ vssd1 vssd1 vccd1 vccd1 _00978_ sky130_fd_sc_hd__nor2_1
XFILLER_0_87_270 vssd1 vssd1 vccd1 vccd1 sky130_fd_sc_hd__decap_3
X_09323_ _03788_ _03796_ vssd1 vssd1 vccd1 vccd1 _03798_ sky130_fd_sc_hd__xnor2_1
X_07584_ net170 net177 net592 net600 vssd1 vssd1 vccd1 vccd1 _01956_ sky130_fd_sc_hd__and4_1
X_06535_ _00907_ _00908_ _00904_ vssd1 vssd1 vccd1 vccd1 _00910_ sky130_fd_sc_hd__a21o_1
X_09254_ net516 _03721_ _03720_ vssd1 vssd1 vccd1 vccd1 _03722_ sky130_fd_sc_hd__a21bo_1
XFILLER_0_16_510 vssd1 vssd1 vccd1 vccd1 sky130_fd_sc_hd__decap_6
X_06466_ net583 net142 net128 net339 _00841_ vssd1 vssd1 vccd1 vccd1 net68 sky130_fd_sc_hd__a221o_1
XFILLER_0_47_167 vssd1 vssd1 vccd1 vccd1 sky130_fd_sc_hd__fill_1
X_09185_ _03644_ _03645_ _03437_ _03439_ vssd1 vssd1 vccd1 vccd1 _03647_ sky130_fd_sc_hd__o211ai_1
X_08205_ _02539_ _02541_ _02576_ _02577_ vssd1 vssd1 vccd1 vccd1 _02578_ sky130_fd_sc_hd__or4_4
X_05417_ _04044_ _04685_ _04686_ vssd1 vssd1 vccd1 vccd1 _04687_ sky130_fd_sc_hd__nand3_1
X_08136_ net254 net473 _02505_ _02506_ vssd1 vssd1 vccd1 vccd1 _02508_ sky130_fd_sc_hd__nand4_2
X_06397_ _00770_ _00771_ vssd1 vssd1 vccd1 vccd1 _00773_ sky130_fd_sc_hd__xnor2_2
XFILLER_0_50_91 vssd1 vssd1 vccd1 vccd1 sky130_ef_sc_hd__decap_12
X_05348_ _03312_ _04617_ vssd1 vssd1 vccd1 vccd1 _04618_ sky130_fd_sc_hd__or2_1
X_08067_ _02286_ _02438_ vssd1 vssd1 vccd1 vccd1 _02440_ sky130_fd_sc_hd__nand2_1
X_05279_ _03727_ _04547_ vssd1 vssd1 vccd1 vccd1 _04549_ sky130_fd_sc_hd__nor2_1
XFILLER_0_101_434 vssd1 vssd1 vccd1 vccd1 sky130_ef_sc_hd__decap_12
X_07018_ _01245_ _01247_ vssd1 vssd1 vccd1 vccd1 _01389_ sky130_fd_sc_hd__nand2_1
XFILLER_0_11_281 vssd1 vssd1 vccd1 vccd1 sky130_fd_sc_hd__decap_3
X_08969_ net178 net499 vssd1 vssd1 vccd1 vccd1 _03411_ sky130_fd_sc_hd__nand2_1
XFILLER_0_98_557 vssd1 vssd1 vccd1 vccd1 sky130_fd_sc_hd__fill_2
XFILLER_0_98_568 vssd1 vssd1 vccd1 vccd1 sky130_fd_sc_hd__fill_1
XFILLER_0_66_421 vssd1 vssd1 vccd1 vccd1 sky130_fd_sc_hd__decap_8
XFILLER_0_14_29 vssd1 vssd1 vccd1 vccd1 sky130_ef_sc_hd__decap_12
XFILLER_0_38_123 vssd1 vssd1 vccd1 vccd1 sky130_ef_sc_hd__decap_12
XFILLER_0_53_159 vssd1 vssd1 vccd1 vccd1 sky130_fd_sc_hd__decap_8
XFILLER_0_22_502 vssd1 vssd1 vccd1 vccd1 sky130_ef_sc_hd__decap_12
XFILLER_0_34_384 vssd1 vssd1 vccd1 vccd1 sky130_fd_sc_hd__decap_4
XFILLER_0_39_15 vssd1 vssd1 vccd1 vccd1 sky130_ef_sc_hd__decap_12
XTAP_229 vssd1 vccd1 sky130_fd_sc_hd__tapvpwrvgnd_1
XTAP_207 vssd1 vccd1 sky130_fd_sc_hd__tapvpwrvgnd_1
XTAP_218 vssd1 vccd1 sky130_fd_sc_hd__tapvpwrvgnd_1
XFILLER_0_89_502 vssd1 vssd1 vccd1 vccd1 sky130_fd_sc_hd__fill_2
X_10089_ clknet_3_6_0_wb_clk_i _00085_ _00021_ vssd1 vssd1 vccd1 vccd1 mul.b\[18\]
+ sky130_fd_sc_hd__dfrtp_1
XFILLER_0_55_69 vssd1 vssd1 vccd1 vccd1 sky130_ef_sc_hd__decap_12
XFILLER_0_55_36 vssd1 vssd1 vccd1 vccd1 sky130_ef_sc_hd__decap_12
XFILLER_0_89_546 vssd1 vssd1 vccd1 vccd1 sky130_ef_sc_hd__decap_12
XFILLER_0_9_529 vssd1 vssd1 vccd1 vccd1 sky130_ef_sc_hd__decap_12
XFILLER_0_84_273 vssd1 vssd1 vccd1 vccd1 sky130_ef_sc_hd__decap_12
XFILLER_0_84_251 vssd1 vssd1 vccd1 vccd1 sky130_fd_sc_hd__fill_1
X_06320_ _00647_ _00695_ _00696_ vssd1 vssd1 vccd1 vccd1 _00697_ sky130_fd_sc_hd__nand3_2
XFILLER_0_29_156 vssd1 vssd1 vccd1 vccd1 sky130_ef_sc_hd__decap_12
XFILLER_0_45_605 vssd1 vssd1 vccd1 vccd1 sky130_fd_sc_hd__fill_2
X_06251_ _00626_ _00627_ vssd1 vssd1 vccd1 vccd1 _00628_ sky130_fd_sc_hd__nand2_1
X_05202_ _03498_ _03531_ _03520_ vssd1 vssd1 vccd1 vccd1 _03760_ sky130_fd_sc_hd__a21o_1
Xmax_cap100 _01623_ vssd1 vssd1 vccd1 vccd1 net100 sky130_fd_sc_hd__clkbuf_2
XFILLER_0_4_234 vssd1 vssd1 vccd1 vccd1 sky130_fd_sc_hd__decap_3
X_06182_ _00441_ _00443_ _00442_ vssd1 vssd1 vccd1 vccd1 _00560_ sky130_fd_sc_hd__a21bo_1
Xmax_cap111 _02635_ vssd1 vssd1 vccd1 vccd1 net111 sky130_fd_sc_hd__buf_1
XFILLER_0_4_289 vssd1 vssd1 vccd1 vccd1 sky130_ef_sc_hd__decap_12
X_05133_ net385 net551 net575 net361 vssd1 vssd1 vccd1 vccd1 _03006_ sky130_fd_sc_hd__a22o_1
X_05064_ net24 net414 net127 vssd1 vssd1 vccd1 vccd1 _00094_ sky130_fd_sc_hd__mux2_1
XFILLER_0_40_365 vssd1 vssd1 vccd1 vccd1 sky130_fd_sc_hd__decap_8
X_09941_ _04471_ _04472_ vssd1 vssd1 vccd1 vccd1 _04473_ sky130_fd_sc_hd__xnor2_1
XFILLER_0_96_76 vssd1 vssd1 vccd1 vccd1 sky130_fd_sc_hd__fill_2
XFILLER_0_0_473 vssd1 vssd1 vccd1 vccd1 sky130_fd_sc_hd__decap_3
XFILLER_0_96_98 vssd1 vssd1 vccd1 vccd1 sky130_fd_sc_hd__fill_1
X_09872_ _04358_ _04396_ vssd1 vssd1 vccd1 vccd1 _04398_ sky130_fd_sc_hd__or2_1
XFILLER_0_29_70 vssd1 vssd1 vccd1 vccd1 sky130_fd_sc_hd__decap_8
XTAP_730 vssd1 vccd1 sky130_fd_sc_hd__tapvpwrvgnd_1
XTAP_741 vssd1 vccd1 sky130_fd_sc_hd__tapvpwrvgnd_1
XTAP_752 vssd1 vccd1 sky130_fd_sc_hd__tapvpwrvgnd_1
X_08823_ net167 net525 _03245_ _03248_ vssd1 vssd1 vccd1 vccd1 _03251_ sky130_fd_sc_hd__nand4_1
XTAP_785 vssd1 vccd1 sky130_fd_sc_hd__tapvpwrvgnd_1
XTAP_774 vssd1 vccd1 sky130_fd_sc_hd__tapvpwrvgnd_1
XFILLER_0_29_92 vssd1 vssd1 vccd1 vccd1 sky130_ef_sc_hd__decap_12
XTAP_763 vssd1 vccd1 sky130_fd_sc_hd__tapvpwrvgnd_1
X_08754_ _02976_ _02979_ _02977_ vssd1 vssd1 vccd1 vccd1 _03176_ sky130_fd_sc_hd__a21boi_1
XTAP_796 vssd1 vccd1 sky130_fd_sc_hd__tapvpwrvgnd_1
X_05966_ _00342_ _00343_ _00344_ vssd1 vssd1 vccd1 vccd1 _00346_ sky130_fd_sc_hd__a21o_1
XFILLER_0_31_3 vssd1 vssd1 vccd1 vccd1 sky130_fd_sc_hd__decap_8
X_07705_ net228 net237 net529 vssd1 vssd1 vccd1 vccd1 _02077_ sky130_fd_sc_hd__and3_1
X_08685_ _02938_ _02942_ _03097_ _03099_ vssd1 vssd1 vccd1 vccd1 _03100_ sky130_fd_sc_hd__o211ai_2
X_05897_ _00276_ _00277_ _00173_ _00175_ vssd1 vssd1 vccd1 vccd1 _00278_ sky130_fd_sc_hd__o211a_1
X_07636_ net376 net402 _02005_ _02007_ vssd1 vssd1 vccd1 vccd1 _02008_ sky130_fd_sc_hd__a22o_1
X_07567_ _01687_ _01689_ _01938_ _01939_ vssd1 vssd1 vccd1 vccd1 _01940_ sky130_fd_sc_hd__o211ai_4
X_09306_ net284 net396 _03776_ _03778_ vssd1 vssd1 vccd1 vccd1 _03779_ sky130_fd_sc_hd__a22oi_1
XFILLER_0_75_251 vssd1 vssd1 vccd1 vccd1 sky130_fd_sc_hd__decap_3
XFILLER_0_63_402 vssd1 vssd1 vccd1 vccd1 sky130_fd_sc_hd__decap_8
X_06518_ _00890_ _00891_ _00892_ vssd1 vssd1 vccd1 vccd1 _00893_ sky130_fd_sc_hd__nand3_1
X_09237_ _03544_ _03547_ _03703_ vssd1 vssd1 vccd1 vccd1 _03704_ sky130_fd_sc_hd__a21oi_1
X_07498_ _01866_ _01867_ _01707_ _01709_ vssd1 vssd1 vccd1 vccd1 _01869_ sky130_fd_sc_hd__o211a_1
XFILLER_0_63_457 vssd1 vssd1 vccd1 vccd1 sky130_fd_sc_hd__decap_8
XFILLER_0_16_351 vssd1 vssd1 vccd1 vccd1 sky130_fd_sc_hd__fill_2
X_06449_ _00822_ _00823_ _00699_ net715 vssd1 vssd1 vccd1 vccd1 _00825_ sky130_fd_sc_hd__a211o_2
X_09168_ net303 net392 vssd1 vssd1 vccd1 vccd1 _03628_ sky130_fd_sc_hd__and2b_1
XFILLER_0_31_310 vssd1 vssd1 vccd1 vccd1 sky130_fd_sc_hd__fill_2
X_09099_ _02926_ _03089_ _03240_ _03394_ vssd1 vssd1 vccd1 vccd1 _03554_ sky130_fd_sc_hd__and4b_1
X_08119_ _02364_ _02367_ _02488_ _02490_ vssd1 vssd1 vccd1 vccd1 _02491_ sky130_fd_sc_hd__o211ai_2
XFILLER_0_9_91 vssd1 vssd1 vccd1 vccd1 sky130_fd_sc_hd__fill_1
XFILLER_0_101_253 vssd1 vssd1 vccd1 vccd1 sky130_fd_sc_hd__decap_6
X_10012_ net638 vssd1 vssd1 vccd1 vccd1 _00008_ sky130_fd_sc_hd__inv_2
XFILLER_0_98_365 vssd1 vssd1 vccd1 vccd1 sky130_fd_sc_hd__fill_1
XFILLER_0_25_28 vssd1 vssd1 vccd1 vccd1 sky130_ef_sc_hd__decap_12
XFILLER_0_66_251 vssd1 vssd1 vccd1 vccd1 sky130_fd_sc_hd__fill_1
XFILLER_0_81_221 vssd1 vssd1 vccd1 vccd1 sky130_fd_sc_hd__decap_3
XFILLER_0_66_295 vssd1 vssd1 vccd1 vccd1 sky130_fd_sc_hd__fill_2
XFILLER_0_26_126 vssd1 vssd1 vccd1 vccd1 sky130_ef_sc_hd__decap_12
XFILLER_0_54_457 vssd1 vssd1 vccd1 vccd1 sky130_ef_sc_hd__decap_12
XFILLER_0_26_159 vssd1 vssd1 vccd1 vccd1 sky130_fd_sc_hd__decap_8
XFILLER_0_22_365 vssd1 vssd1 vccd1 vccd1 sky130_ef_sc_hd__decap_12
XFILLER_0_5_27 vssd1 vssd1 vccd1 vccd1 sky130_fd_sc_hd__decap_6
XFILLER_0_66_57 vssd1 vssd1 vccd1 vccd1 sky130_fd_sc_hd__fill_1
X_05820_ _00199_ _00200_ vssd1 vssd1 vccd1 vccd1 _00201_ sky130_fd_sc_hd__nand2_1
X_05751_ net390 net488 _04946_ _04949_ vssd1 vssd1 vccd1 vccd1 _00133_ sky130_fd_sc_hd__a211oi_1
X_08470_ _02862_ _02863_ _02849_ vssd1 vssd1 vccd1 vccd1 _02866_ sky130_fd_sc_hd__a21o_1
X_05682_ _04943_ _04944_ _04950_ vssd1 vssd1 vccd1 vccd1 _04952_ sky130_fd_sc_hd__a21o_1
X_07421_ _01788_ _01789_ vssd1 vssd1 vccd1 vccd1 _01790_ sky130_fd_sc_hd__nand2b_1
X_07352_ net316 net459 net466 net307 vssd1 vssd1 vccd1 vccd1 _01721_ sky130_fd_sc_hd__a22o_1
XFILLER_0_9_337 vssd1 vssd1 vccd1 vccd1 sky130_ef_sc_hd__decap_12
XFILLER_0_45_413 vssd1 vssd1 vccd1 vccd1 sky130_fd_sc_hd__fill_1
X_06303_ _00677_ _00678_ _00679_ vssd1 vssd1 vccd1 vccd1 _00680_ sky130_fd_sc_hd__nand3_1
XFILLER_0_45_446 vssd1 vssd1 vccd1 vccd1 sky130_fd_sc_hd__fill_2
X_07283_ net170 net619 _01650_ _01651_ vssd1 vssd1 vccd1 vccd1 _01652_ sky130_fd_sc_hd__o2bb2a_1
X_09022_ net284 net294 net400 net406 vssd1 vssd1 vccd1 vccd1 _03469_ sky130_fd_sc_hd__nand4_1
X_06234_ _00608_ _00609_ vssd1 vssd1 vccd1 vccd1 _00611_ sky130_fd_sc_hd__xor2_1
XFILLER_0_31_93 vssd1 vssd1 vccd1 vccd1 sky130_fd_sc_hd__decap_6
XFILLER_0_53_490 vssd1 vssd1 vccd1 vccd1 sky130_fd_sc_hd__fill_2
X_06165_ net362 net478 net487 net354 vssd1 vssd1 vccd1 vccd1 _00543_ sky130_fd_sc_hd__a22o_1
X_05116_ net335 net614 vssd1 vssd1 vccd1 vccd1 _02820_ sky130_fd_sc_hd__and2_1
X_06096_ _00470_ _00472_ _00367_ _00370_ vssd1 vssd1 vccd1 vccd1 _00475_ sky130_fd_sc_hd__o211a_1
X_09924_ net230 net400 vssd1 vssd1 vccd1 vccd1 _04454_ sky130_fd_sc_hd__nand2_1
X_05047_ net36 net313 net133 vssd1 vssd1 vccd1 vccd1 _00108_ sky130_fd_sc_hd__mux2_1
XFILLER_0_0_292 vssd1 vssd1 vccd1 vccd1 sky130_ef_sc_hd__decap_12
XTAP_560 vssd1 vccd1 sky130_fd_sc_hd__tapvpwrvgnd_1
X_09855_ net209 net217 net416 net422 vssd1 vssd1 vccd1 vccd1 _04379_ sky130_fd_sc_hd__and4_1
XFILLER_0_99_107 vssd1 vssd1 vccd1 vccd1 sky130_fd_sc_hd__decap_4
X_08806_ _03229_ _03230_ _03231_ vssd1 vssd1 vccd1 vccd1 _03233_ sky130_fd_sc_hd__o21ai_1
XTAP_571 vssd1 vccd1 sky130_fd_sc_hd__tapvpwrvgnd_1
XTAP_593 vssd1 vccd1 sky130_fd_sc_hd__tapvpwrvgnd_1
XTAP_582 vssd1 vccd1 sky130_fd_sc_hd__tapvpwrvgnd_1
X_09786_ _04147_ _04149_ _04301_ vssd1 vssd1 vccd1 vccd1 _04304_ sky130_fd_sc_hd__and3_2
X_06998_ _01367_ _01368_ vssd1 vssd1 vccd1 vccd1 _01369_ sky130_fd_sc_hd__xnor2_1
X_08737_ _03153_ _03155_ _02972_ _02997_ vssd1 vssd1 vccd1 vccd1 _03157_ sky130_fd_sc_hd__o211a_1
X_05949_ _00327_ _00328_ vssd1 vssd1 vccd1 vccd1 _00329_ sky130_fd_sc_hd__and2b_1
X_08668_ _03079_ _03080_ _02912_ _02915_ vssd1 vssd1 vccd1 vccd1 _03082_ sky130_fd_sc_hd__a211o_1
X_07619_ _01822_ _01824_ _01989_ _01990_ vssd1 vssd1 vccd1 vccd1 _01991_ sky130_fd_sc_hd__a211oi_1
X_08599_ _03004_ _03005_ vssd1 vssd1 vccd1 vccd1 _03007_ sky130_fd_sc_hd__xnor2_1
XFILLER_0_95_368 vssd1 vssd1 vccd1 vccd1 sky130_fd_sc_hd__decap_8
XFILLER_0_83_519 vssd1 vssd1 vccd1 vccd1 sky130_fd_sc_hd__decap_8
XFILLER_0_76_571 vssd1 vssd1 vccd1 vccd1 sky130_fd_sc_hd__decap_8
XFILLER_0_48_251 vssd1 vssd1 vccd1 vccd1 sky130_fd_sc_hd__fill_1
XFILLER_0_16_170 vssd1 vssd1 vccd1 vccd1 sky130_fd_sc_hd__fill_1
XFILLER_0_31_173 vssd1 vssd1 vccd1 vccd1 sky130_fd_sc_hd__fill_1
XFILLER_0_31_195 vssd1 vssd1 vccd1 vccd1 sky130_fd_sc_hd__decap_8
XFILLER_0_36_27 vssd1 vssd1 vccd1 vccd1 sky130_fd_sc_hd__fill_1
XFILLER_0_59_505 vssd1 vssd1 vccd1 vccd1 sky130_ef_sc_hd__decap_12
XFILLER_0_86_379 vssd1 vssd1 vccd1 vccd1 sky130_fd_sc_hd__decap_4
XFILLER_0_39_240 vssd1 vssd1 vccd1 vccd1 sky130_fd_sc_hd__decap_8
XFILLER_0_27_446 vssd1 vssd1 vccd1 vccd1 sky130_fd_sc_hd__fill_2
XFILLER_0_54_287 vssd1 vssd1 vccd1 vccd1 sky130_fd_sc_hd__fill_1
XFILLER_0_54_276 vssd1 vssd1 vccd1 vccd1 sky130_fd_sc_hd__fill_2
XFILLER_0_54_265 vssd1 vssd1 vccd1 vccd1 sky130_fd_sc_hd__decap_4
XFILLER_0_14_118 vssd1 vssd1 vccd1 vccd1 sky130_fd_sc_hd__fill_2
XFILLER_0_2_546 vssd1 vssd1 vccd1 vccd1 sky130_fd_sc_hd__decap_4
XFILLER_0_10_324 vssd1 vssd1 vccd1 vccd1 sky130_fd_sc_hd__fill_1
X_07970_ _02178_ _02180_ vssd1 vssd1 vccd1 vccd1 _02343_ sky130_fd_sc_hd__nand2_1
X_06921_ _01156_ _01158_ _01291_ _01292_ vssd1 vssd1 vccd1 vccd1 _01293_ sky130_fd_sc_hd__o211ai_4
XFILLER_0_93_33 vssd1 vssd1 vccd1 vccd1 sky130_ef_sc_hd__decap_12
X_09640_ _04142_ _04144_ vssd1 vssd1 vccd1 vccd1 _04145_ sky130_fd_sc_hd__xnor2_1
X_06852_ _00976_ _01113_ _01112_ vssd1 vssd1 vccd1 vccd1 _01224_ sky130_fd_sc_hd__a21oi_1
XFILLER_0_93_99 vssd1 vssd1 vccd1 vccd1 sky130_fd_sc_hd__fill_1
X_09571_ _04065_ _04067_ vssd1 vssd1 vccd1 vccd1 _04069_ sky130_fd_sc_hd__xnor2_2
X_05803_ net633 net142 net128 net391 vssd1 vssd1 vccd1 vccd1 _00185_ sky130_fd_sc_hd__a22o_1
X_06783_ _01155_ vssd1 vssd1 vccd1 vccd1 _01156_ sky130_fd_sc_hd__inv_2
X_08522_ _02758_ _02760_ vssd1 vssd1 vccd1 vccd1 _02923_ sky130_fd_sc_hd__nor2_1
X_05734_ _05000_ _05003_ vssd1 vssd1 vccd1 vccd1 _05004_ sky130_fd_sc_hd__and2b_1
X_08453_ _02843_ _02844_ _02845_ vssd1 vssd1 vccd1 vccd1 _02847_ sky130_fd_sc_hd__a21oi_1
XFILLER_0_77_346 vssd1 vssd1 vccd1 vccd1 sky130_fd_sc_hd__fill_2
XFILLER_0_92_305 vssd1 vssd1 vccd1 vccd1 sky130_fd_sc_hd__decap_3
XFILLER_0_77_368 vssd1 vssd1 vccd1 vccd1 sky130_fd_sc_hd__fill_2
X_05665_ _04933_ _04934_ vssd1 vssd1 vccd1 vccd1 _04935_ sky130_fd_sc_hd__nor2_1
XFILLER_0_9_134 vssd1 vssd1 vccd1 vccd1 sky130_fd_sc_hd__decap_6
X_07404_ _01713_ _01714_ _01771_ _01772_ vssd1 vssd1 vccd1 vccd1 _01773_ sky130_fd_sc_hd__or4bb_4
XFILLER_0_92_338 vssd1 vssd1 vccd1 vccd1 sky130_fd_sc_hd__fill_1
X_08384_ net179 net537 net547 net174 vssd1 vssd1 vccd1 vccd1 _02771_ sky130_fd_sc_hd__a22o_1
X_05596_ _04750_ _04864_ _04865_ vssd1 vssd1 vccd1 vccd1 _04866_ sky130_fd_sc_hd__and3_1
XFILLER_0_18_435 vssd1 vssd1 vccd1 vccd1 sky130_ef_sc_hd__decap_12
X_07335_ _01702_ _01703_ vssd1 vssd1 vccd1 vccd1 _01704_ sky130_fd_sc_hd__and2_1
X_07266_ _01479_ _01481_ _01633_ _01634_ vssd1 vssd1 vccd1 vccd1 _01636_ sky130_fd_sc_hd__a211o_1
X_09005_ _03440_ _03449_ vssd1 vssd1 vccd1 vccd1 _03450_ sky130_fd_sc_hd__or2_2
XFILLER_0_5_373 vssd1 vssd1 vccd1 vccd1 sky130_fd_sc_hd__decap_3
X_06217_ _00592_ _00593_ _00474_ _00477_ vssd1 vssd1 vccd1 vccd1 _00595_ sky130_fd_sc_hd__o211ai_1
X_07197_ _01543_ _01565_ vssd1 vssd1 vccd1 vccd1 _01567_ sky130_fd_sc_hd__xnor2_1
X_06148_ _00522_ _00523_ _00524_ vssd1 vssd1 vccd1 vccd1 _00526_ sky130_fd_sc_hd__a21oi_1
X_06079_ _00424_ _00456_ _00457_ vssd1 vssd1 vccd1 vccd1 _00458_ sky130_fd_sc_hd__nand3_2
X_09907_ net122 _04435_ vssd1 vssd1 vccd1 vccd1 _04436_ sky130_fd_sc_hd__xor2_2
Xfanout532 net533 vssd1 vssd1 vccd1 vccd1 net532 sky130_fd_sc_hd__buf_4
Xfanout521 mul.b\[13\] vssd1 vssd1 vccd1 vccd1 net521 sky130_fd_sc_hd__buf_6
Xfanout510 mul.b\[14\] vssd1 vssd1 vccd1 vccd1 net510 sky130_fd_sc_hd__buf_4
Xfanout565 net566 vssd1 vssd1 vccd1 vccd1 net565 sky130_fd_sc_hd__clkbuf_4
Xfanout554 net555 vssd1 vssd1 vccd1 vccd1 net554 sky130_fd_sc_hd__clkbuf_4
Xfanout543 net550 vssd1 vssd1 vccd1 vccd1 net543 sky130_fd_sc_hd__clkbuf_4
Xfanout576 net579 vssd1 vssd1 vccd1 vccd1 net576 sky130_fd_sc_hd__clkbuf_2
XTAP_390 vssd1 vccd1 sky130_fd_sc_hd__tapvpwrvgnd_1
Xfanout598 net599 vssd1 vssd1 vccd1 vccd1 net598 sky130_fd_sc_hd__buf_2
Xfanout587 net588 vssd1 vssd1 vccd1 vccd1 net587 sky130_fd_sc_hd__clkbuf_4
X_09838_ _04212_ _04214_ vssd1 vssd1 vccd1 vccd1 _04360_ sky130_fd_sc_hd__and2b_1
X_09769_ _04107_ _04111_ _04284_ vssd1 vssd1 vccd1 vccd1 _04286_ sky130_fd_sc_hd__o21a_1
XFILLER_0_95_121 vssd1 vssd1 vccd1 vccd1 sky130_fd_sc_hd__decap_4
XPHY_30 vssd1 vssd1 vccd1 vccd1 sky130_fd_sc_hd__decap_3
Xrebuffer70 _01206_ vssd1 vssd1 vccd1 vccd1 net726 sky130_fd_sc_hd__dlygate4sd1_1
XPHY_41 vssd1 vssd1 vccd1 vccd1 sky130_fd_sc_hd__decap_3
XPHY_52 vssd1 vssd1 vccd1 vccd1 sky130_fd_sc_hd__decap_3
XPHY_63 vssd1 vssd1 vccd1 vccd1 sky130_fd_sc_hd__decap_3
XPHY_74 vssd1 vssd1 vccd1 vccd1 sky130_fd_sc_hd__decap_3
XPHY_85 vssd1 vssd1 vccd1 vccd1 sky130_fd_sc_hd__decap_3
XPHY_96 vssd1 vssd1 vccd1 vccd1 sky130_fd_sc_hd__decap_3
XFILLER_0_49_582 vssd1 vssd1 vccd1 vccd1 sky130_fd_sc_hd__fill_1
XFILLER_0_36_265 vssd1 vssd1 vccd1 vccd1 sky130_fd_sc_hd__decap_3
XFILLER_0_51_246 vssd1 vssd1 vccd1 vccd1 sky130_ef_sc_hd__decap_12
XFILLER_0_17_490 vssd1 vssd1 vccd1 vccd1 sky130_fd_sc_hd__decap_4
XFILLER_0_51_268 vssd1 vssd1 vccd1 vccd1 sky130_fd_sc_hd__decap_8
XFILLER_0_32_471 vssd1 vssd1 vccd1 vccd1 sky130_fd_sc_hd__decap_4
XFILLER_0_99_482 vssd1 vssd1 vccd1 vccd1 sky130_ef_sc_hd__decap_12
XFILLER_0_63_69 vssd1 vssd1 vccd1 vccd1 sky130_fd_sc_hd__decap_3
XFILLER_0_59_324 vssd1 vssd1 vccd1 vccd1 sky130_fd_sc_hd__decap_6
XFILLER_0_74_305 vssd1 vssd1 vccd1 vccd1 sky130_fd_sc_hd__decap_3
X_05450_ net347 net356 net559 net567 vssd1 vssd1 vccd1 vccd1 _04720_ sky130_fd_sc_hd__and4_1
X_05381_ _04637_ _04649_ vssd1 vssd1 vccd1 vccd1 _04651_ sky130_fd_sc_hd__and2_1
XFILLER_0_82_360 vssd1 vssd1 vccd1 vccd1 sky130_fd_sc_hd__decap_4
X_07120_ _01351_ _01353_ _01489_ _01490_ vssd1 vssd1 vccd1 vccd1 _01491_ sky130_fd_sc_hd__a211o_1
XFILLER_0_15_449 vssd1 vssd1 vccd1 vccd1 sky130_ef_sc_hd__decap_12
XFILLER_0_70_566 vssd1 vssd1 vccd1 vccd1 sky130_fd_sc_hd__decap_3
XFILLER_0_42_268 vssd1 vssd1 vccd1 vccd1 sky130_fd_sc_hd__decap_6
X_07051_ net348 net358 net434 vssd1 vssd1 vccd1 vccd1 _01422_ sky130_fd_sc_hd__and3_1
XFILLER_0_100_307 vssd1 vssd1 vccd1 vccd1 sky130_fd_sc_hd__fill_1
X_06002_ net616 net142 net128 net376 vssd1 vssd1 vccd1 vccd1 _00382_ sky130_fd_sc_hd__a22o_1
XFILLER_0_2_354 vssd1 vssd1 vccd1 vccd1 sky130_fd_sc_hd__decap_8
XFILLER_0_2_365 vssd1 vssd1 vccd1 vccd1 sky130_fd_sc_hd__fill_2
X_07953_ _02287_ _02324_ vssd1 vssd1 vccd1 vccd1 _02326_ sky130_fd_sc_hd__xor2_1
X_07884_ _02194_ _02195_ _02256_ _02257_ vssd1 vssd1 vccd1 vccd1 _02258_ sky130_fd_sc_hd__and4bb_1
X_06904_ _01137_ _01274_ vssd1 vssd1 vccd1 vccd1 _01276_ sky130_fd_sc_hd__xnor2_1
X_09623_ _04124_ _04125_ vssd1 vssd1 vccd1 vccd1 _04126_ sky130_fd_sc_hd__and2_1
X_06835_ _01134_ _01135_ _01206_ _01207_ vssd1 vssd1 vccd1 vccd1 _01208_ sky130_fd_sc_hd__nor4_1
XFILLER_0_77_121 vssd1 vssd1 vccd1 vccd1 sky130_fd_sc_hd__fill_1
X_09554_ net180 net187 net454 net461 vssd1 vssd1 vccd1 vccd1 _04050_ sky130_fd_sc_hd__and4_1
X_06766_ _01137_ _01138_ vssd1 vssd1 vccd1 vccd1 _01139_ sky130_fd_sc_hd__or2_1
X_09485_ _03969_ _03974_ vssd1 vssd1 vccd1 vccd1 _03975_ sky130_fd_sc_hd__nand2b_1
X_08505_ _02899_ _02903_ vssd1 vssd1 vccd1 vccd1 _02904_ sky130_fd_sc_hd__xnor2_1
XFILLER_0_53_80 vssd1 vssd1 vccd1 vccd1 sky130_fd_sc_hd__decap_8
X_05717_ _04920_ _04922_ _04986_ vssd1 vssd1 vccd1 vccd1 _04987_ sky130_fd_sc_hd__a21o_1
X_06697_ _01036_ _01037_ _01069_ _01070_ vssd1 vssd1 vccd1 vccd1 _01071_ sky130_fd_sc_hd__nor4_4
X_08436_ _02805_ _02806_ _02827_ vssd1 vssd1 vccd1 vccd1 _02828_ sky130_fd_sc_hd__and3_1
X_05648_ net305 net589 _04915_ _04916_ vssd1 vssd1 vccd1 vccd1 _04918_ sky130_fd_sc_hd__a22o_1
X_08367_ _02580_ _02582_ _02751_ _02752_ vssd1 vssd1 vccd1 vccd1 _02753_ sky130_fd_sc_hd__o211a_2
X_05579_ _04847_ _04848_ vssd1 vssd1 vccd1 vccd1 _04849_ sky130_fd_sc_hd__and2b_1
X_07318_ _01566_ _01568_ _01685_ _01686_ vssd1 vssd1 vccd1 vccd1 _01687_ sky130_fd_sc_hd__o211a_2
X_08298_ _02674_ _02675_ _02676_ vssd1 vssd1 vccd1 vccd1 _02677_ sky130_fd_sc_hd__a21o_1
XFILLER_0_61_577 vssd1 vssd1 vccd1 vccd1 sky130_fd_sc_hd__fill_1
X_07249_ _01599_ _01616_ _01617_ vssd1 vssd1 vccd1 vccd1 _01619_ sky130_fd_sc_hd__or3_1
XFILLER_0_5_192 vssd1 vssd1 vccd1 vccd1 sky130_ef_sc_hd__decap_12
XFILLER_0_14_460 vssd1 vssd1 vccd1 vccd1 sky130_ef_sc_hd__decap_12
Xfanout340 net342 vssd1 vssd1 vccd1 vccd1 net340 sky130_fd_sc_hd__clkbuf_4
Xfanout384 mul.a\[1\] vssd1 vssd1 vccd1 vccd1 net384 sky130_fd_sc_hd__clkbuf_4
Xfanout362 net363 vssd1 vssd1 vccd1 vccd1 net362 sky130_fd_sc_hd__clkbuf_4
Xfanout373 net374 vssd1 vssd1 vccd1 vccd1 net373 sky130_fd_sc_hd__clkbuf_4
XFILLER_0_17_29 vssd1 vssd1 vccd1 vccd1 sky130_fd_sc_hd__fill_2
Xfanout351 net728 vssd1 vssd1 vccd1 vccd1 net351 sky130_fd_sc_hd__clkbuf_8
Xfanout395 net396 vssd1 vssd1 vccd1 vccd1 net395 sky130_fd_sc_hd__buf_2
XTAP_1331 vssd1 vccd1 sky130_fd_sc_hd__tapvpwrvgnd_1
XTAP_1320 vssd1 vccd1 sky130_fd_sc_hd__tapvpwrvgnd_1
XFILLER_0_96_474 vssd1 vssd1 vccd1 vccd1 sky130_fd_sc_hd__fill_2
XFILLER_0_33_39 vssd1 vssd1 vccd1 vccd1 sky130_fd_sc_hd__decap_6
XTAP_1342 vssd1 vccd1 sky130_fd_sc_hd__tapvpwrvgnd_1
XFILLER_0_56_349 vssd1 vssd1 vccd1 vccd1 sky130_fd_sc_hd__fill_1
XFILLER_0_64_360 vssd1 vssd1 vccd1 vccd1 sky130_fd_sc_hd__decap_4
Xinput26 wbs_dat_i[29] vssd1 vssd1 vccd1 vccd1 net26 sky130_fd_sc_hd__clkbuf_1
Xinput15 wbs_dat_i[19] vssd1 vssd1 vccd1 vccd1 net15 sky130_fd_sc_hd__clkbuf_1
XFILLER_0_3_107 vssd1 vssd1 vccd1 vccd1 sky130_fd_sc_hd__decap_4
Xinput37 wbs_stb_i vssd1 vssd1 vccd1 vccd1 net37 sky130_fd_sc_hd__buf_1
XFILLER_0_58_36 vssd1 vssd1 vccd1 vccd1 sky130_ef_sc_hd__decap_12
XFILLER_0_58_69 vssd1 vssd1 vccd1 vccd1 sky130_fd_sc_hd__fill_1
XFILLER_0_74_24 vssd1 vssd1 vccd1 vccd1 sky130_fd_sc_hd__decap_4
X_06620_ _00992_ _00993_ vssd1 vssd1 vccd1 vccd1 _00994_ sky130_fd_sc_hd__nand2b_1
XFILLER_0_59_110 vssd1 vssd1 vccd1 vccd1 sky130_fd_sc_hd__fill_2
XFILLER_0_59_132 vssd1 vssd1 vccd1 vccd1 sky130_fd_sc_hd__decap_8
X_06551_ _00917_ _00924_ _00925_ vssd1 vssd1 vccd1 vccd1 _00926_ sky130_fd_sc_hd__nand3_2
XFILLER_0_87_496 vssd1 vssd1 vccd1 vccd1 sky130_fd_sc_hd__fill_1
X_09270_ _03735_ _03737_ vssd1 vssd1 vccd1 vccd1 _03740_ sky130_fd_sc_hd__or2_1
X_05502_ net356 net551 net577 net329 vssd1 vssd1 vccd1 vccd1 _04772_ sky130_fd_sc_hd__a22o_1
X_06482_ _00724_ _00729_ _00855_ vssd1 vssd1 vccd1 vccd1 _00857_ sky130_fd_sc_hd__or3_1
X_08221_ _02431_ _02433_ _02593_ _02594_ vssd1 vssd1 vccd1 vccd1 _02595_ sky130_fd_sc_hd__o211ai_4
X_05433_ _04700_ _04701_ _04702_ vssd1 vssd1 vccd1 vccd1 _04703_ sky130_fd_sc_hd__nand3_1
XFILLER_0_99_54 vssd1 vssd1 vccd1 vccd1 sky130_fd_sc_hd__fill_2
X_08152_ net274 net460 net467 net264 vssd1 vssd1 vccd1 vccd1 _02524_ sky130_fd_sc_hd__a22o_1
X_05364_ _04629_ _04630_ vssd1 vssd1 vccd1 vccd1 _04634_ sky130_fd_sc_hd__nor2_1
X_08083_ _02453_ _02454_ vssd1 vssd1 vccd1 vccd1 _02455_ sky130_fd_sc_hd__or2_1
X_05295_ _04562_ _04563_ _04564_ vssd1 vssd1 vccd1 vccd1 _04565_ sky130_fd_sc_hd__nand3_1
X_07103_ _01333_ net653 net667 _01473_ vssd1 vssd1 vccd1 vccd1 _01474_ sky130_fd_sc_hd__o211a_1
XFILLER_0_70_374 vssd1 vssd1 vccd1 vccd1 sky130_fd_sc_hd__decap_4
X_07034_ _01403_ _01404_ vssd1 vssd1 vccd1 vccd1 _01405_ sky130_fd_sc_hd__nor2_1
XFILLER_0_61_3 vssd1 vssd1 vccd1 vccd1 sky130_fd_sc_hd__decap_3
XFILLER_0_30_249 vssd1 vssd1 vccd1 vccd1 sky130_fd_sc_hd__decap_3
XFILLER_0_2_195 vssd1 vssd1 vccd1 vccd1 sky130_fd_sc_hd__fill_1
X_08985_ _03418_ _03427_ vssd1 vssd1 vccd1 vccd1 _03428_ sky130_fd_sc_hd__and2_1
X_07936_ net164 net593 _02307_ _02308_ vssd1 vssd1 vccd1 vccd1 _02309_ sky130_fd_sc_hd__a22oi_1
X_07867_ net255 net265 net485 net494 vssd1 vssd1 vccd1 vccd1 _02241_ sky130_fd_sc_hd__nand4_1
X_09606_ _03910_ _03912_ _04106_ vssd1 vssd1 vccd1 vccd1 _04107_ sky130_fd_sc_hd__a21oi_1
X_07798_ _02166_ _02167_ _02168_ vssd1 vssd1 vccd1 vccd1 _02169_ sky130_fd_sc_hd__a21o_1
X_06818_ _01182_ _01189_ _01190_ vssd1 vssd1 vccd1 vccd1 _01191_ sky130_fd_sc_hd__nand3_1
X_09537_ _04023_ _04029_ vssd1 vssd1 vccd1 vccd1 _04031_ sky130_fd_sc_hd__xnor2_1
X_06749_ _01120_ _01121_ vssd1 vssd1 vccd1 vccd1 _01122_ sky130_fd_sc_hd__nand2_1
XFILLER_0_65_113 vssd1 vssd1 vccd1 vccd1 sky130_fd_sc_hd__fill_2
XFILLER_0_38_338 vssd1 vssd1 vccd1 vccd1 sky130_ef_sc_hd__decap_12
XFILLER_0_93_444 vssd1 vssd1 vccd1 vccd1 sky130_fd_sc_hd__decap_4
X_09468_ _03764_ _03766_ _03954_ _03955_ vssd1 vssd1 vccd1 vccd1 _03956_ sky130_fd_sc_hd__o211a_1
XFILLER_0_65_157 vssd1 vssd1 vccd1 vccd1 sky130_fd_sc_hd__fill_2
X_08419_ net274 net282 net437 vssd1 vssd1 vccd1 vccd1 _02810_ sky130_fd_sc_hd__and3_1
X_09399_ _03879_ vssd1 vssd1 vccd1 vccd1 _03881_ sky130_fd_sc_hd__inv_2
XFILLER_0_53_308 vssd1 vssd1 vccd1 vccd1 sky130_fd_sc_hd__fill_1
XFILLER_0_34_522 vssd1 vssd1 vccd1 vccd1 sky130_fd_sc_hd__fill_2
XFILLER_0_61_363 vssd1 vssd1 vccd1 vccd1 sky130_fd_sc_hd__decap_8
XFILLER_0_6_490 vssd1 vssd1 vccd1 vccd1 sky130_fd_sc_hd__decap_3
Xfanout192 net198 vssd1 vssd1 vccd1 vccd1 net192 sky130_fd_sc_hd__buf_2
Xfanout181 net182 vssd1 vssd1 vccd1 vccd1 net181 sky130_fd_sc_hd__buf_2
Xfanout170 net171 vssd1 vssd1 vccd1 vccd1 net170 sky130_fd_sc_hd__buf_2
XFILLER_0_88_249 vssd1 vssd1 vccd1 vccd1 sky130_fd_sc_hd__decap_3
XFILLER_0_96_282 vssd1 vssd1 vccd1 vccd1 sky130_fd_sc_hd__fill_2
XTAP_1150 vssd1 vccd1 sky130_fd_sc_hd__tapvpwrvgnd_1
XFILLER_0_56_113 vssd1 vssd1 vccd1 vccd1 sky130_fd_sc_hd__decap_8
XTAP_1183 vssd1 vccd1 sky130_fd_sc_hd__tapvpwrvgnd_1
XTAP_1172 vssd1 vccd1 sky130_fd_sc_hd__tapvpwrvgnd_1
XTAP_1161 vssd1 vccd1 sky130_fd_sc_hd__tapvpwrvgnd_1
XTAP_1194 vssd1 vccd1 sky130_fd_sc_hd__tapvpwrvgnd_1
XFILLER_0_84_466 vssd1 vssd1 vccd1 vccd1 sky130_fd_sc_hd__fill_1
XFILLER_0_71_116 vssd1 vssd1 vccd1 vccd1 sky130_fd_sc_hd__fill_1
XFILLER_0_52_363 vssd1 vssd1 vccd1 vccd1 sky130_fd_sc_hd__fill_1
XFILLER_0_25_555 vssd1 vssd1 vccd1 vccd1 sky130_fd_sc_hd__decap_4
XFILLER_0_69_57 vssd1 vssd1 vccd1 vccd1 sky130_fd_sc_hd__fill_1
XFILLER_0_52_396 vssd1 vssd1 vccd1 vccd1 sky130_fd_sc_hd__decap_4
XFILLER_0_40_525 vssd1 vssd1 vccd1 vccd1 sky130_fd_sc_hd__decap_4
XFILLER_0_100_65 vssd1 vssd1 vccd1 vccd1 sky130_fd_sc_hd__decap_8
X_05080_ net7 mul.b\[11\] net124 vssd1 vssd1 vccd1 vccd1 _00078_ sky130_fd_sc_hd__mux2_1
XTAP_901 vssd1 vccd1 sky130_fd_sc_hd__tapvpwrvgnd_1
XFILLER_0_85_34 vssd1 vssd1 vccd1 vccd1 sky130_fd_sc_hd__decap_8
XTAP_934 vssd1 vccd1 sky130_fd_sc_hd__tapvpwrvgnd_1
XTAP_923 vssd1 vccd1 sky130_fd_sc_hd__tapvpwrvgnd_1
XTAP_912 vssd1 vccd1 sky130_fd_sc_hd__tapvpwrvgnd_1
XFILLER_0_20_282 vssd1 vssd1 vccd1 vccd1 sky130_fd_sc_hd__decap_3
XTAP_978 vssd1 vccd1 sky130_fd_sc_hd__tapvpwrvgnd_1
XTAP_967 vssd1 vccd1 sky130_fd_sc_hd__tapvpwrvgnd_1
XTAP_956 vssd1 vccd1 sky130_fd_sc_hd__tapvpwrvgnd_1
XTAP_945 vssd1 vccd1 sky130_fd_sc_hd__tapvpwrvgnd_1
X_08770_ _03031_ _03033_ _03191_ _03193_ vssd1 vssd1 vccd1 vccd1 _03194_ sky130_fd_sc_hd__a211oi_2
XFILLER_0_85_78 vssd1 vssd1 vccd1 vccd1 sky130_fd_sc_hd__fill_1
XTAP_989 vssd1 vccd1 sky130_fd_sc_hd__tapvpwrvgnd_1
X_05982_ _00323_ _00324_ net684 _00360_ vssd1 vssd1 vccd1 vccd1 _00362_ sky130_fd_sc_hd__o22ai_4
X_07721_ _02034_ _02035_ _02091_ _02092_ vssd1 vssd1 vccd1 vccd1 _02093_ sky130_fd_sc_hd__or4bb_4
X_07652_ _02016_ _02022_ _02023_ vssd1 vssd1 vccd1 vccd1 _02024_ sky130_fd_sc_hd__nand3_1
X_06603_ net195 net627 net635 net188 vssd1 vssd1 vccd1 vccd1 _00977_ sky130_fd_sc_hd__a22oi_1
X_07583_ net177 net592 net600 net170 vssd1 vssd1 vccd1 vccd1 _01955_ sky130_fd_sc_hd__a22oi_1
X_09322_ _03788_ _03796_ vssd1 vssd1 vccd1 vccd1 _03797_ sky130_fd_sc_hd__nand2_1
XFILLER_0_34_82 vssd1 vssd1 vccd1 vccd1 sky130_fd_sc_hd__fill_2
X_06534_ _00904_ _00907_ _00908_ vssd1 vssd1 vccd1 vccd1 _00909_ sky130_fd_sc_hd__and3_1
XFILLER_0_75_444 vssd1 vssd1 vccd1 vccd1 sky130_fd_sc_hd__decap_4
XFILLER_0_75_477 vssd1 vssd1 vccd1 vccd1 sky130_fd_sc_hd__decap_4
XFILLER_0_62_105 vssd1 vssd1 vccd1 vccd1 sky130_fd_sc_hd__decap_8
X_09253_ net157 net161 net505 vssd1 vssd1 vccd1 vccd1 _03721_ sky130_fd_sc_hd__and3_1
X_06465_ _00182_ _00840_ vssd1 vssd1 vccd1 vccd1 _00841_ sky130_fd_sc_hd__nor2_1
XFILLER_0_90_447 vssd1 vssd1 vccd1 vccd1 sky130_fd_sc_hd__decap_3
X_09184_ _03437_ _03439_ _03644_ _03645_ vssd1 vssd1 vccd1 vccd1 _03646_ sky130_fd_sc_hd__a211o_1
X_08204_ _02574_ _02575_ _02354_ _02357_ vssd1 vssd1 vccd1 vccd1 _02577_ sky130_fd_sc_hd__o211a_1
X_05416_ net327 net587 _04683_ _04684_ vssd1 vssd1 vccd1 vccd1 _04686_ sky130_fd_sc_hd__a22o_1
X_06396_ _00771_ _00770_ vssd1 vssd1 vccd1 vccd1 _00772_ sky130_fd_sc_hd__nand2b_1
X_08135_ net254 net473 _02505_ _02506_ vssd1 vssd1 vccd1 vccd1 _02507_ sky130_fd_sc_hd__a22o_1
X_05347_ net385 net575 net585 net378 vssd1 vssd1 vccd1 vccd1 _04617_ sky130_fd_sc_hd__a22oi_1
XFILLER_0_43_330 vssd1 vssd1 vccd1 vccd1 sky130_fd_sc_hd__decap_6
X_08066_ _02286_ _02438_ vssd1 vssd1 vccd1 vccd1 _02439_ sky130_fd_sc_hd__or2_1
X_05278_ _03629_ _04547_ vssd1 vssd1 vccd1 vccd1 _04548_ sky130_fd_sc_hd__nor2_1
XFILLER_0_31_547 vssd1 vssd1 vccd1 vccd1 sky130_fd_sc_hd__fill_2
XFILLER_0_101_446 vssd1 vssd1 vccd1 vccd1 sky130_fd_sc_hd__fill_2
X_07017_ _01386_ _01387_ vssd1 vssd1 vccd1 vccd1 _01388_ sky130_fd_sc_hd__nand2_1
X_08968_ net516 _03408_ _03407_ vssd1 vssd1 vccd1 vccd1 _03409_ sky130_fd_sc_hd__a21bo_1
X_08899_ _03332_ _03333_ vssd1 vssd1 vccd1 vccd1 _03335_ sky130_fd_sc_hd__and2_1
X_07919_ _02289_ _02290_ net149 net618 vssd1 vssd1 vccd1 vccd1 _02292_ sky130_fd_sc_hd__and4bb_1
XPHY_200 vssd1 vssd1 vccd1 vccd1 sky130_fd_sc_hd__decap_3
XFILLER_0_93_241 vssd1 vssd1 vccd1 vccd1 sky130_fd_sc_hd__fill_1
XFILLER_0_38_135 vssd1 vssd1 vccd1 vccd1 sky130_fd_sc_hd__decap_4
XFILLER_0_22_514 vssd1 vssd1 vccd1 vccd1 sky130_ef_sc_hd__decap_12
XFILLER_0_34_363 vssd1 vssd1 vccd1 vccd1 sky130_fd_sc_hd__fill_1
XFILLER_0_39_27 vssd1 vssd1 vccd1 vccd1 sky130_ef_sc_hd__decap_12
XTAP_208 vssd1 vccd1 sky130_fd_sc_hd__tapvpwrvgnd_1
XTAP_219 vssd1 vccd1 sky130_fd_sc_hd__tapvpwrvgnd_1
X_10088_ clknet_3_6_0_wb_clk_i _00084_ _00020_ vssd1 vssd1 vccd1 vccd1 mul.b\[17\]
+ sky130_fd_sc_hd__dfrtp_1
XFILLER_0_55_48 vssd1 vssd1 vccd1 vccd1 sky130_fd_sc_hd__decap_8
XFILLER_0_89_558 vssd1 vssd1 vccd1 vccd1 sky130_fd_sc_hd__fill_2
XFILLER_0_57_400 vssd1 vssd1 vccd1 vccd1 sky130_fd_sc_hd__fill_1
XFILLER_0_29_113 vssd1 vssd1 vccd1 vccd1 sky130_fd_sc_hd__decap_6
XFILLER_0_84_285 vssd1 vssd1 vccd1 vccd1 sky130_fd_sc_hd__decap_6
X_06250_ _00624_ _00625_ _00528_ vssd1 vssd1 vccd1 vccd1 _00627_ sky130_fd_sc_hd__a21o_1
X_05201_ net328 net336 net623 net631 vssd1 vssd1 vccd1 vccd1 _03749_ sky130_fd_sc_hd__and4_1
XFILLER_0_4_246 vssd1 vssd1 vccd1 vccd1 sky130_fd_sc_hd__decap_6
X_06181_ _00556_ _00557_ _00555_ vssd1 vssd1 vccd1 vccd1 _00559_ sky130_fd_sc_hd__a21o_1
XFILLER_0_25_385 vssd1 vssd1 vccd1 vccd1 sky130_fd_sc_hd__decap_6
Xmax_cap101 _00936_ vssd1 vssd1 vccd1 vccd1 net101 sky130_fd_sc_hd__buf_1
Xmax_cap112 _02513_ vssd1 vssd1 vccd1 vccd1 net112 sky130_fd_sc_hd__buf_1
XFILLER_0_52_182 vssd1 vssd1 vccd1 vccd1 sky130_fd_sc_hd__decap_6
XFILLER_0_4_279 vssd1 vssd1 vccd1 vccd1 sky130_fd_sc_hd__decap_4
XFILLER_0_13_558 vssd1 vssd1 vccd1 vccd1 sky130_fd_sc_hd__fill_2
X_05132_ net361 net385 net551 net575 vssd1 vssd1 vccd1 vccd1 _02995_ sky130_fd_sc_hd__nand4_1
XFILLER_0_96_33 vssd1 vssd1 vccd1 vccd1 sky130_fd_sc_hd__fill_1
X_05063_ net25 net409 net127 vssd1 vssd1 vccd1 vccd1 _00095_ sky130_fd_sc_hd__mux2_1
X_09940_ net146 net497 _04168_ _04166_ vssd1 vssd1 vccd1 vccd1 _04472_ sky130_fd_sc_hd__a31o_1
X_09871_ _04358_ _04396_ vssd1 vssd1 vccd1 vccd1 _04397_ sky130_fd_sc_hd__nand2_1
XTAP_720 vssd1 vccd1 sky130_fd_sc_hd__tapvpwrvgnd_1
XTAP_731 vssd1 vccd1 sky130_fd_sc_hd__tapvpwrvgnd_1
XTAP_742 vssd1 vccd1 sky130_fd_sc_hd__tapvpwrvgnd_1
X_08822_ net166 net524 _03245_ _03248_ vssd1 vssd1 vccd1 vccd1 _03250_ sky130_fd_sc_hd__and4_1
XTAP_786 vssd1 vccd1 sky130_fd_sc_hd__tapvpwrvgnd_1
XTAP_775 vssd1 vccd1 sky130_fd_sc_hd__tapvpwrvgnd_1
XTAP_753 vssd1 vccd1 sky130_fd_sc_hd__tapvpwrvgnd_1
XTAP_764 vssd1 vccd1 sky130_fd_sc_hd__tapvpwrvgnd_1
X_08753_ _03022_ _03024_ vssd1 vssd1 vccd1 vccd1 _03175_ sky130_fd_sc_hd__nand2_1
XTAP_797 vssd1 vccd1 sky130_fd_sc_hd__tapvpwrvgnd_1
X_05965_ _00342_ _00343_ _00344_ vssd1 vssd1 vccd1 vccd1 _00345_ sky130_fd_sc_hd__nand3_1
X_07704_ net237 net694 net529 net228 vssd1 vssd1 vccd1 vccd1 _02076_ sky130_fd_sc_hd__a22o_1
XFILLER_0_24_3 vssd1 vssd1 vccd1 vccd1 sky130_fd_sc_hd__fill_1
X_08684_ net173 net525 _03094_ _03096_ vssd1 vssd1 vccd1 vccd1 _03099_ sky130_fd_sc_hd__nand4_2
X_05896_ _00274_ _00275_ _05007_ _05009_ vssd1 vssd1 vccd1 vccd1 _00277_ sky130_fd_sc_hd__o211a_1
XFILLER_0_95_539 vssd1 vssd1 vccd1 vccd1 sky130_fd_sc_hd__decap_3
X_07635_ net359 net368 net409 net414 vssd1 vssd1 vccd1 vccd1 _02007_ sky130_fd_sc_hd__nand4_1
X_07566_ _01936_ _01937_ _01775_ _01777_ vssd1 vssd1 vccd1 vccd1 _01939_ sky130_fd_sc_hd__a211o_1
X_09305_ net267 net276 net399 net406 vssd1 vssd1 vccd1 vccd1 _03778_ sky130_fd_sc_hd__nand4_1
XFILLER_0_8_530 vssd1 vssd1 vccd1 vccd1 sky130_fd_sc_hd__fill_2
XFILLER_0_0_72 vssd1 vssd1 vccd1 vccd1 sky130_ef_sc_hd__decap_12
X_06517_ net365 net456 net461 net355 vssd1 vssd1 vccd1 vccd1 _00892_ sky130_fd_sc_hd__a22o_1
XFILLER_0_48_477 vssd1 vssd1 vccd1 vccd1 sky130_fd_sc_hd__fill_2
X_09236_ net120 _03702_ vssd1 vssd1 vccd1 vccd1 _03703_ sky130_fd_sc_hd__xnor2_1
XFILLER_0_90_211 vssd1 vssd1 vccd1 vccd1 sky130_fd_sc_hd__fill_1
XFILLER_0_63_447 vssd1 vssd1 vccd1 vccd1 sky130_fd_sc_hd__fill_1
X_07497_ _01707_ _01709_ _01866_ _01867_ vssd1 vssd1 vccd1 vccd1 _01868_ sky130_fd_sc_hd__a211oi_4
XFILLER_0_35_127 vssd1 vssd1 vccd1 vccd1 sky130_fd_sc_hd__fill_2
X_06448_ _00699_ net83 _00822_ _00823_ vssd1 vssd1 vccd1 vccd1 _00824_ sky130_fd_sc_hd__o211ai_4
XFILLER_0_90_277 vssd1 vssd1 vccd1 vccd1 sky130_fd_sc_hd__decap_4
X_09167_ _03623_ _03625_ _03434_ _03459_ vssd1 vssd1 vccd1 vccd1 _03627_ sky130_fd_sc_hd__o211a_1
X_06379_ _00635_ _00637_ _00754_ vssd1 vssd1 vccd1 vccd1 _00755_ sky130_fd_sc_hd__a21oi_1
XFILLER_0_31_300 vssd1 vssd1 vccd1 vccd1 sky130_fd_sc_hd__decap_3
X_09098_ _03550_ _03551_ vssd1 vssd1 vccd1 vccd1 _03552_ sky130_fd_sc_hd__or2_1
X_08118_ net201 net528 _02485_ _02487_ vssd1 vssd1 vccd1 vccd1 _02490_ sky130_fd_sc_hd__nand4_1
XFILLER_0_31_344 vssd1 vssd1 vccd1 vccd1 sky130_ef_sc_hd__decap_12
XFILLER_0_101_221 vssd1 vssd1 vccd1 vccd1 sky130_fd_sc_hd__decap_3
X_08049_ _02256_ _02259_ net92 _02421_ vssd1 vssd1 vccd1 vccd1 _02422_ sky130_fd_sc_hd__a211oi_4
X_10011_ net638 vssd1 vssd1 vccd1 vccd1 _00007_ sky130_fd_sc_hd__inv_2
XFILLER_0_98_355 vssd1 vssd1 vccd1 vccd1 sky130_fd_sc_hd__decap_8
XFILLER_0_27_606 vssd1 vssd1 vccd1 vccd1 sky130_fd_sc_hd__fill_1
XFILLER_0_27_617 vssd1 vssd1 vccd1 vccd1 sky130_fd_sc_hd__fill_2
XFILLER_0_26_138 vssd1 vssd1 vccd1 vccd1 sky130_fd_sc_hd__fill_2
XFILLER_0_54_469 vssd1 vssd1 vccd1 vccd1 sky130_fd_sc_hd__decap_6
XFILLER_0_22_333 vssd1 vssd1 vccd1 vccd1 sky130_fd_sc_hd__fill_2
XFILLER_0_22_377 vssd1 vssd1 vccd1 vccd1 sky130_fd_sc_hd__decap_4
XFILLER_0_5_39 vssd1 vssd1 vccd1 vccd1 sky130_fd_sc_hd__decap_8
XFILLER_0_89_322 vssd1 vssd1 vccd1 vccd1 sky130_fd_sc_hd__fill_1
X_05750_ _04946_ _04949_ net390 net488 vssd1 vssd1 vccd1 vccd1 _00132_ sky130_fd_sc_hd__o211a_1
X_05681_ _04943_ _04944_ _04950_ vssd1 vssd1 vccd1 vccd1 _04951_ sky130_fd_sc_hd__nand3_1
XFILLER_0_57_230 vssd1 vssd1 vccd1 vccd1 sky130_fd_sc_hd__decap_3
X_07420_ _01641_ _01643_ _01786_ _01787_ vssd1 vssd1 vccd1 vccd1 _01789_ sky130_fd_sc_hd__a211o_1
XFILLER_0_85_561 vssd1 vssd1 vccd1 vccd1 sky130_fd_sc_hd__decap_8
X_07351_ _01718_ _01719_ vssd1 vssd1 vccd1 vccd1 _01720_ sky130_fd_sc_hd__xnor2_1
X_06302_ _00555_ _00557_ _00556_ vssd1 vssd1 vccd1 vccd1 _00679_ sky130_fd_sc_hd__a21bo_1
X_07282_ net175 net182 net600 net612 vssd1 vssd1 vccd1 vccd1 _01651_ sky130_fd_sc_hd__and4_1
XFILLER_0_45_458 vssd1 vssd1 vccd1 vccd1 sky130_fd_sc_hd__decap_3
X_09021_ net284 net294 net399 net405 vssd1 vssd1 vccd1 vccd1 _03468_ sky130_fd_sc_hd__and4_1
X_06233_ _00608_ _00609_ vssd1 vssd1 vccd1 vccd1 _00610_ sky130_fd_sc_hd__and2b_1
XFILLER_0_32_119 vssd1 vssd1 vccd1 vccd1 sky130_fd_sc_hd__fill_1
X_06164_ net354 net362 net478 vssd1 vssd1 vccd1 vccd1 _00542_ sky130_fd_sc_hd__and3_1
XFILLER_0_13_366 vssd1 vssd1 vccd1 vccd1 sky130_fd_sc_hd__fill_1
X_05115_ net343 net352 net594 net604 vssd1 vssd1 vccd1 vccd1 _02809_ sky130_fd_sc_hd__nand4_1
XFILLER_0_40_141 vssd1 vssd1 vccd1 vccd1 sky130_ef_sc_hd__decap_12
X_06095_ _00367_ _00370_ _00470_ _00472_ vssd1 vssd1 vccd1 vccd1 _00474_ sky130_fd_sc_hd__a211o_1
XFILLER_0_13_388 vssd1 vssd1 vccd1 vccd1 sky130_fd_sc_hd__decap_4
X_09923_ _04451_ _04452_ vssd1 vssd1 vccd1 vccd1 _04453_ sky130_fd_sc_hd__xnor2_2
X_05046_ net6 net306 net133 vssd1 vssd1 vccd1 vccd1 _00109_ sky130_fd_sc_hd__mux2_1
XTAP_550 vssd1 vccd1 sky130_fd_sc_hd__tapvpwrvgnd_1
XTAP_561 vssd1 vccd1 sky130_fd_sc_hd__tapvpwrvgnd_1
X_09854_ net217 net416 net422 net209 vssd1 vssd1 vccd1 vccd1 _04378_ sky130_fd_sc_hd__a22oi_1
X_08805_ _03229_ _03230_ _03231_ vssd1 vssd1 vccd1 vccd1 _03232_ sky130_fd_sc_hd__or3_1
XTAP_572 vssd1 vccd1 sky130_fd_sc_hd__tapvpwrvgnd_1
XTAP_594 vssd1 vccd1 sky130_fd_sc_hd__tapvpwrvgnd_1
XTAP_583 vssd1 vccd1 sky130_fd_sc_hd__tapvpwrvgnd_1
X_09785_ _04302_ vssd1 vssd1 vccd1 vccd1 _04303_ sky130_fd_sc_hd__inv_2
X_06997_ net181 net619 vssd1 vssd1 vccd1 vccd1 _01368_ sky130_fd_sc_hd__nand2_1
X_08736_ _02972_ _02997_ _03153_ _03155_ vssd1 vssd1 vccd1 vccd1 _03156_ sky130_fd_sc_hd__a211oi_4
X_05948_ net379 net479 net488 net371 vssd1 vssd1 vccd1 vccd1 _00328_ sky130_fd_sc_hd__a22o_1
X_08667_ _02912_ _02915_ _03079_ _03080_ vssd1 vssd1 vccd1 vccd1 _03081_ sky130_fd_sc_hd__o211ai_1
X_05879_ _00257_ _00258_ _00155_ vssd1 vssd1 vccd1 vccd1 _00260_ sky130_fd_sc_hd__a21oi_1
X_07618_ _01987_ _01988_ _01976_ vssd1 vssd1 vccd1 vccd1 _01990_ sky130_fd_sc_hd__a21oi_1
X_08598_ net153 net574 vssd1 vssd1 vccd1 vccd1 _03005_ sky130_fd_sc_hd__nand2_1
X_07549_ _01918_ _01919_ _01900_ vssd1 vssd1 vccd1 vccd1 _01922_ sky130_fd_sc_hd__o21ai_1
X_09219_ net118 _03683_ vssd1 vssd1 vccd1 vccd1 _03685_ sky130_fd_sc_hd__or2_1
XFILLER_0_31_130 vssd1 vssd1 vccd1 vccd1 sky130_fd_sc_hd__decap_4
XFILLER_0_98_163 vssd1 vssd1 vccd1 vccd1 sky130_fd_sc_hd__fill_1
XFILLER_0_59_517 vssd1 vssd1 vccd1 vccd1 sky130_fd_sc_hd__decap_4
XFILLER_0_86_358 vssd1 vssd1 vccd1 vccd1 sky130_fd_sc_hd__decap_3
XFILLER_0_67_550 vssd1 vssd1 vccd1 vccd1 sky130_fd_sc_hd__decap_3
XFILLER_0_27_414 vssd1 vssd1 vccd1 vccd1 sky130_fd_sc_hd__fill_1
XFILLER_0_42_417 vssd1 vssd1 vccd1 vccd1 sky130_fd_sc_hd__decap_3
XFILLER_0_22_174 vssd1 vssd1 vccd1 vccd1 sky130_fd_sc_hd__fill_1
X_06920_ net348 net448 _01289_ _01290_ vssd1 vssd1 vccd1 vccd1 _01292_ sky130_fd_sc_hd__a22o_1
X_06851_ net555 net143 net128 net313 _01223_ vssd1 vssd1 vccd1 vccd1 net71 sky130_fd_sc_hd__a221o_1
X_09570_ _04067_ _04065_ vssd1 vssd1 vccd1 vccd1 _04068_ sky130_fd_sc_hd__and2b_1
X_05802_ net142 net139 vssd1 vssd1 vccd1 vccd1 _00184_ sky130_fd_sc_hd__nor2_2
X_06782_ net338 net348 net456 net463 vssd1 vssd1 vccd1 vccd1 _01155_ sky130_fd_sc_hd__nand4_2
X_08521_ _02770_ _02921_ vssd1 vssd1 vccd1 vccd1 _02922_ sky130_fd_sc_hd__xnor2_1
X_05733_ _05001_ _05002_ vssd1 vssd1 vccd1 vccd1 _05003_ sky130_fd_sc_hd__nor2_1
XFILLER_0_26_83 vssd1 vssd1 vccd1 vccd1 sky130_fd_sc_hd__fill_1
X_08452_ _02843_ _02844_ _02845_ vssd1 vssd1 vccd1 vccd1 _02846_ sky130_fd_sc_hd__and3_1
X_07403_ net647 _01770_ _01621_ net719 vssd1 vssd1 vccd1 vccd1 _01772_ sky130_fd_sc_hd__a211o_1
X_05664_ net322 net331 net562 net570 vssd1 vssd1 vccd1 vccd1 _04934_ sky130_fd_sc_hd__and4_2
X_08383_ _02118_ _02723_ _02720_ vssd1 vssd1 vccd1 vccd1 _02770_ sky130_fd_sc_hd__a21o_1
X_05595_ net312 net590 _04862_ _04863_ vssd1 vssd1 vccd1 vccd1 _04865_ sky130_fd_sc_hd__a22o_1
XFILLER_0_18_425 vssd1 vssd1 vccd1 vccd1 sky130_fd_sc_hd__fill_1
XFILLER_0_73_531 vssd1 vssd1 vccd1 vccd1 sky130_fd_sc_hd__fill_2
X_07334_ _01700_ _01701_ _01571_ _01573_ vssd1 vssd1 vccd1 vccd1 _01703_ sky130_fd_sc_hd__o211ai_1
XFILLER_0_18_447 vssd1 vssd1 vccd1 vccd1 sky130_ef_sc_hd__decap_12
XFILLER_0_45_233 vssd1 vssd1 vccd1 vccd1 sky130_fd_sc_hd__fill_2
XFILLER_0_91_3 vssd1 vssd1 vccd1 vccd1 sky130_fd_sc_hd__decap_8
X_07265_ _01479_ _01481_ _01633_ _01634_ vssd1 vssd1 vccd1 vccd1 _01635_ sky130_fd_sc_hd__a211oi_2
X_09004_ _03446_ _03447_ vssd1 vssd1 vccd1 vccd1 _03449_ sky130_fd_sc_hd__xnor2_2
XFILLER_0_60_247 vssd1 vssd1 vccd1 vccd1 sky130_fd_sc_hd__fill_1
XFILLER_0_60_225 vssd1 vssd1 vccd1 vccd1 sky130_fd_sc_hd__fill_1
X_06216_ _00474_ _00477_ _00592_ _00593_ vssd1 vssd1 vccd1 vccd1 _00594_ sky130_fd_sc_hd__a211o_1
X_07196_ _01543_ _01565_ vssd1 vssd1 vccd1 vccd1 _01566_ sky130_fd_sc_hd__and2_1
X_06147_ _00522_ _00523_ _00524_ vssd1 vssd1 vccd1 vccd1 _00525_ sky130_fd_sc_hd__and3_1
X_06078_ _00454_ _00455_ _00350_ net116 vssd1 vssd1 vccd1 vccd1 _00457_ sky130_fd_sc_hd__a211o_1
X_09906_ _04432_ _04433_ vssd1 vssd1 vccd1 vccd1 _04435_ sky130_fd_sc_hd__xnor2_2
X_05029_ net24 net169 net135 vssd1 vssd1 vccd1 vccd1 _00126_ sky130_fd_sc_hd__mux2_1
Xfanout500 net501 vssd1 vssd1 vccd1 vccd1 net500 sky130_fd_sc_hd__clkbuf_4
Xfanout511 net520 vssd1 vssd1 vccd1 vccd1 net511 sky130_fd_sc_hd__clkbuf_4
Xfanout522 net523 vssd1 vssd1 vccd1 vccd1 net522 sky130_fd_sc_hd__buf_2
Xfanout533 net665 vssd1 vssd1 vccd1 vccd1 net533 sky130_fd_sc_hd__buf_4
Xfanout544 net545 vssd1 vssd1 vccd1 vccd1 net544 sky130_fd_sc_hd__buf_4
Xfanout566 mul.b\[8\] vssd1 vssd1 vccd1 vccd1 net566 sky130_fd_sc_hd__buf_4
Xfanout555 net556 vssd1 vssd1 vccd1 vccd1 net555 sky130_fd_sc_hd__clkbuf_4
X_09837_ _04254_ _04256_ vssd1 vssd1 vccd1 vccd1 _04359_ sky130_fd_sc_hd__nand2b_1
XTAP_380 vssd1 vccd1 sky130_fd_sc_hd__tapvpwrvgnd_1
XTAP_391 vssd1 vccd1 sky130_fd_sc_hd__tapvpwrvgnd_1
Xfanout599 mul.b\[4\] vssd1 vssd1 vccd1 vccd1 net599 sky130_fd_sc_hd__clkbuf_2
Xfanout577 net579 vssd1 vssd1 vccd1 vccd1 net577 sky130_fd_sc_hd__buf_4
Xfanout588 mul.b\[5\] vssd1 vssd1 vccd1 vccd1 net588 sky130_fd_sc_hd__buf_4
X_09768_ net117 _04283_ vssd1 vssd1 vccd1 vccd1 _04284_ sky130_fd_sc_hd__xor2_1
X_08719_ net223 net232 net457 mul.b\[19\] vssd1 vssd1 vccd1 vccd1 _03138_ sky130_fd_sc_hd__and4_1
XFILLER_0_95_111 vssd1 vssd1 vccd1 vccd1 sky130_fd_sc_hd__fill_1
Xrebuffer71 _02707_ vssd1 vssd1 vccd1 vccd1 net727 sky130_fd_sc_hd__dlymetal6s2s_1
XFILLER_0_68_347 vssd1 vssd1 vccd1 vccd1 sky130_fd_sc_hd__decap_8
XPHY_20 vssd1 vssd1 vccd1 vccd1 sky130_fd_sc_hd__decap_3
XPHY_31 vssd1 vssd1 vccd1 vccd1 sky130_fd_sc_hd__decap_3
Xrebuffer60 net704 vssd1 vssd1 vccd1 vccd1 net705 sky130_fd_sc_hd__clkbuf_1
X_09699_ _04204_ _04205_ _04206_ vssd1 vssd1 vccd1 vccd1 _04209_ sky130_fd_sc_hd__o21bai_1
XPHY_42 vssd1 vssd1 vccd1 vccd1 sky130_fd_sc_hd__decap_3
XPHY_53 vssd1 vssd1 vccd1 vccd1 sky130_fd_sc_hd__decap_3
XPHY_64 vssd1 vssd1 vccd1 vccd1 sky130_fd_sc_hd__decap_3
XPHY_75 vssd1 vssd1 vccd1 vccd1 sky130_fd_sc_hd__decap_3
XPHY_86 vssd1 vssd1 vccd1 vccd1 sky130_fd_sc_hd__decap_3
XPHY_97 vssd1 vssd1 vccd1 vccd1 sky130_fd_sc_hd__decap_3
XFILLER_0_36_222 vssd1 vssd1 vccd1 vccd1 sky130_fd_sc_hd__fill_2
XFILLER_0_24_417 vssd1 vssd1 vccd1 vccd1 sky130_fd_sc_hd__decap_3
XFILLER_0_32_461 vssd1 vssd1 vccd1 vccd1 sky130_fd_sc_hd__decap_3
XFILLER_0_63_15 vssd1 vssd1 vccd1 vccd1 sky130_fd_sc_hd__decap_8
XFILLER_0_2_29 vssd1 vssd1 vccd1 vccd1 sky130_ef_sc_hd__decap_12
XFILLER_0_63_26 vssd1 vssd1 vccd1 vccd1 sky130_ef_sc_hd__decap_12
XFILLER_0_99_494 vssd1 vssd1 vccd1 vccd1 sky130_fd_sc_hd__decap_3
XFILLER_0_74_317 vssd1 vssd1 vccd1 vccd1 sky130_fd_sc_hd__fill_1
X_05380_ _04637_ _04649_ vssd1 vssd1 vccd1 vccd1 _04650_ sky130_fd_sc_hd__or2_1
XFILLER_0_70_501 vssd1 vssd1 vccd1 vccd1 sky130_fd_sc_hd__fill_2
XFILLER_0_42_203 vssd1 vssd1 vccd1 vccd1 sky130_fd_sc_hd__decap_4
XFILLER_0_82_394 vssd1 vssd1 vccd1 vccd1 sky130_fd_sc_hd__fill_2
XFILLER_0_12_85 vssd1 vssd1 vccd1 vccd1 sky130_ef_sc_hd__decap_12
X_07050_ net357 net434 net440 net348 vssd1 vssd1 vccd1 vccd1 _01421_ sky130_fd_sc_hd__a22o_1
XFILLER_0_70_589 vssd1 vssd1 vccd1 vccd1 sky130_fd_sc_hd__fill_1
X_06001_ _00377_ _00379_ vssd1 vssd1 vccd1 vccd1 _00381_ sky130_fd_sc_hd__or2_1
XFILLER_0_42_247 vssd1 vssd1 vccd1 vccd1 sky130_fd_sc_hd__decap_4
XFILLER_0_88_56 vssd1 vssd1 vccd1 vccd1 sky130_fd_sc_hd__decap_4
XFILLER_0_11_623 vssd1 vssd1 vccd1 vccd1 sky130_fd_sc_hd__fill_2
XFILLER_0_23_461 vssd1 vssd1 vccd1 vccd1 sky130_ef_sc_hd__decap_12
X_07952_ _02324_ _02287_ vssd1 vssd1 vccd1 vccd1 _02325_ sky130_fd_sc_hd__and2b_1
X_07883_ _02254_ _02255_ _02087_ _02089_ vssd1 vssd1 vccd1 vccd1 _02257_ sky130_fd_sc_hd__a211o_1
X_06903_ _01137_ _01274_ vssd1 vssd1 vccd1 vccd1 _01275_ sky130_fd_sc_hd__nand2_1
X_09622_ _03932_ _03936_ _04123_ vssd1 vssd1 vccd1 vccd1 _04125_ sky130_fd_sc_hd__or3_1
X_06834_ net94 _01205_ _01074_ _01077_ vssd1 vssd1 vccd1 vccd1 _01207_ sky130_fd_sc_hd__o211a_1
X_09553_ net187 net454 net461 net180 vssd1 vssd1 vccd1 vccd1 _04049_ sky130_fd_sc_hd__a22o_1
XFILLER_0_77_111 vssd1 vssd1 vccd1 vccd1 sky130_fd_sc_hd__fill_1
X_08504_ _02901_ _02902_ vssd1 vssd1 vccd1 vccd1 _02903_ sky130_fd_sc_hd__nor2_1
X_06765_ net389 net422 _01018_ _01022_ vssd1 vssd1 vccd1 vccd1 _01138_ sky130_fd_sc_hd__a211oi_1
X_09484_ _03669_ _03973_ vssd1 vssd1 vccd1 vccd1 _03974_ sky130_fd_sc_hd__xnor2_1
X_05716_ _04983_ _04984_ vssd1 vssd1 vccd1 vccd1 _04986_ sky130_fd_sc_hd__xor2_1
X_06696_ _01066_ _01068_ _00929_ _00932_ vssd1 vssd1 vccd1 vccd1 _01070_ sky130_fd_sc_hd__o211a_1
X_08435_ _02825_ _02826_ vssd1 vssd1 vccd1 vccd1 _02827_ sky130_fd_sc_hd__nor2_1
X_05647_ net305 net589 _04915_ _04916_ vssd1 vssd1 vccd1 vccd1 _04917_ sky130_fd_sc_hd__nand4_1
X_08366_ _02709_ _02710_ _02749_ vssd1 vssd1 vccd1 vccd1 _02752_ sky130_fd_sc_hd__o21ai_2
XFILLER_0_46_520 vssd1 vssd1 vccd1 vccd1 sky130_fd_sc_hd__decap_4
X_05578_ net305 net599 net609 net297 vssd1 vssd1 vccd1 vccd1 _04848_ sky130_fd_sc_hd__a22o_1
X_07317_ _01668_ _01684_ vssd1 vssd1 vccd1 vccd1 _01686_ sky130_fd_sc_hd__nand2_1
X_08297_ net350 net398 vssd1 vssd1 vccd1 vccd1 _02676_ sky130_fd_sc_hd__and2_1
XFILLER_0_33_225 vssd1 vssd1 vccd1 vccd1 sky130_fd_sc_hd__decap_4
XFILLER_0_61_556 vssd1 vssd1 vccd1 vccd1 sky130_fd_sc_hd__decap_4
X_07248_ _01599_ _01616_ _01617_ vssd1 vssd1 vccd1 vccd1 _01618_ sky130_fd_sc_hd__nor3_1
XFILLER_0_33_258 vssd1 vssd1 vccd1 vccd1 sky130_fd_sc_hd__fill_1
XFILLER_0_14_472 vssd1 vssd1 vccd1 vccd1 sky130_fd_sc_hd__decap_4
X_07179_ _01406_ _01408_ vssd1 vssd1 vccd1 vccd1 _01549_ sky130_fd_sc_hd__nor2_1
Xfanout341 net342 vssd1 vssd1 vccd1 vccd1 net341 sky130_fd_sc_hd__clkbuf_2
Xfanout330 net331 vssd1 vssd1 vccd1 vccd1 net330 sky130_fd_sc_hd__buf_4
Xfanout363 net367 vssd1 vssd1 vccd1 vccd1 net363 sky130_fd_sc_hd__buf_2
Xfanout374 net375 vssd1 vssd1 vccd1 vccd1 net374 sky130_fd_sc_hd__buf_2
Xfanout352 net353 vssd1 vssd1 vccd1 vccd1 net352 sky130_fd_sc_hd__buf_4
Xfanout396 net397 vssd1 vssd1 vccd1 vccd1 net396 sky130_fd_sc_hd__clkbuf_4
Xfanout385 net386 vssd1 vssd1 vccd1 vccd1 net385 sky130_fd_sc_hd__clkbuf_4
XTAP_1332 vssd1 vccd1 sky130_fd_sc_hd__tapvpwrvgnd_1
XTAP_1310 vssd1 vccd1 sky130_fd_sc_hd__tapvpwrvgnd_1
XTAP_1321 vssd1 vccd1 sky130_fd_sc_hd__tapvpwrvgnd_1
XTAP_1343 vssd1 vccd1 sky130_fd_sc_hd__tapvpwrvgnd_1
XFILLER_0_96_486 vssd1 vssd1 vccd1 vccd1 sky130_fd_sc_hd__decap_8
XFILLER_0_68_177 vssd1 vssd1 vccd1 vccd1 sky130_fd_sc_hd__fill_2
XFILLER_0_49_391 vssd1 vssd1 vccd1 vccd1 sky130_fd_sc_hd__fill_1
XFILLER_0_83_169 vssd1 vssd1 vccd1 vccd1 sky130_fd_sc_hd__fill_2
Xinput16 wbs_dat_i[1] vssd1 vssd1 vccd1 vccd1 net16 sky130_fd_sc_hd__clkbuf_1
Xinput27 wbs_dat_i[2] vssd1 vssd1 vccd1 vccd1 net27 sky130_fd_sc_hd__clkbuf_1
Xinput38 wbs_we_i vssd1 vssd1 vccd1 vccd1 net38 sky130_fd_sc_hd__buf_1
XFILLER_0_32_280 vssd1 vssd1 vccd1 vccd1 sky130_fd_sc_hd__fill_1
XFILLER_0_58_48 vssd1 vssd1 vccd1 vccd1 sky130_ef_sc_hd__decap_12
XFILLER_0_20_475 vssd1 vssd1 vccd1 vccd1 sky130_fd_sc_hd__fill_1
XFILLER_0_99_291 vssd1 vssd1 vccd1 vccd1 sky130_fd_sc_hd__decap_6
X_06550_ _00921_ _00922_ _00923_ vssd1 vssd1 vccd1 vccd1 _00925_ sky130_fd_sc_hd__a21o_1
X_05501_ net329 net356 net551 net577 vssd1 vssd1 vccd1 vccd1 _04771_ sky130_fd_sc_hd__nand4_2
X_06481_ _00724_ _00729_ _00855_ vssd1 vssd1 vccd1 vccd1 _00856_ sky130_fd_sc_hd__o21a_1
X_08220_ _02589_ _02591_ _02442_ vssd1 vssd1 vccd1 vccd1 _02594_ sky130_fd_sc_hd__o21ai_2
XFILLER_0_7_403 vssd1 vssd1 vccd1 vccd1 sky130_fd_sc_hd__fill_1
X_05432_ net319 net594 net604 net310 vssd1 vssd1 vccd1 vccd1 _04702_ sky130_fd_sc_hd__a22o_1
XFILLER_0_28_531 vssd1 vssd1 vccd1 vccd1 sky130_fd_sc_hd__fill_1
XFILLER_0_7_447 vssd1 vssd1 vccd1 vccd1 sky130_fd_sc_hd__fill_1
X_08151_ _02521_ _02522_ vssd1 vssd1 vccd1 vccd1 _02523_ sky130_fd_sc_hd__and2_1
X_05363_ _04625_ _04629_ vssd1 vssd1 vccd1 vccd1 _04633_ sky130_fd_sc_hd__nand2_1
XFILLER_0_43_534 vssd1 vssd1 vccd1 vccd1 sky130_fd_sc_hd__decap_8
XFILLER_0_70_353 vssd1 vssd1 vccd1 vccd1 sky130_fd_sc_hd__decap_6
X_08082_ _02120_ _02452_ vssd1 vssd1 vccd1 vccd1 _02454_ sky130_fd_sc_hd__nor2_1
X_05294_ net378 net596 net606 net370 vssd1 vssd1 vccd1 vccd1 _04564_ sky130_fd_sc_hd__a22o_1
X_07102_ _01436_ _01437_ _01470_ _01471_ vssd1 vssd1 vccd1 vccd1 _01473_ sky130_fd_sc_hd__a2bb2o_1
X_07033_ net218 net226 net561 net572 vssd1 vssd1 vccd1 vccd1 _01404_ sky130_fd_sc_hd__and4_1
XFILLER_0_2_141 vssd1 vssd1 vccd1 vccd1 sky130_fd_sc_hd__decap_8
XFILLER_0_11_464 vssd1 vssd1 vccd1 vccd1 sky130_ef_sc_hd__decap_12
X_08984_ _03419_ _03425_ vssd1 vssd1 vccd1 vccd1 _03427_ sky130_fd_sc_hd__xnor2_1
XFILLER_0_54_3 vssd1 vssd1 vccd1 vccd1 sky130_fd_sc_hd__decap_8
X_07935_ net169 net190 net557 net584 vssd1 vssd1 vccd1 vccd1 _02308_ sky130_fd_sc_hd__nand4_2
X_07866_ net264 net485 net494 net254 vssd1 vssd1 vccd1 vccd1 _02240_ sky130_fd_sc_hd__a22o_1
X_09605_ _04104_ _04105_ vssd1 vssd1 vccd1 vccd1 _04106_ sky130_fd_sc_hd__nand2_1
XFILLER_0_97_239 vssd1 vssd1 vccd1 vccd1 sky130_fd_sc_hd__fill_1
X_07797_ net376 net398 vssd1 vssd1 vccd1 vccd1 _02168_ sky130_fd_sc_hd__and2_1
X_06817_ _01186_ _01187_ _01188_ vssd1 vssd1 vccd1 vccd1 _01190_ sky130_fd_sc_hd__a21o_1
XFILLER_0_78_464 vssd1 vssd1 vccd1 vccd1 sky130_fd_sc_hd__decap_3
X_09536_ _04029_ _04023_ vssd1 vssd1 vccd1 vccd1 _04030_ sky130_fd_sc_hd__and2b_1
X_06748_ _01118_ _01119_ _01009_ vssd1 vssd1 vccd1 vccd1 _01121_ sky130_fd_sc_hd__a21o_1
X_09467_ _03952_ _03953_ _03938_ vssd1 vssd1 vccd1 vccd1 _03955_ sky130_fd_sc_hd__o21ai_1
XFILLER_0_65_103 vssd1 vssd1 vccd1 vccd1 sky130_fd_sc_hd__decap_8
X_08418_ net278 net437 net443 net270 vssd1 vssd1 vccd1 vccd1 _02808_ sky130_fd_sc_hd__a22o_1
X_06679_ net287 net523 vssd1 vssd1 vccd1 vccd1 _01053_ sky130_fd_sc_hd__and2_1
X_09398_ _03876_ net471 net180 _03875_ vssd1 vssd1 vccd1 vccd1 _03879_ sky130_fd_sc_hd__and4b_1
X_08349_ net155 mul.b\[5\] _02729_ _02730_ vssd1 vssd1 vccd1 vccd1 _02734_ sky130_fd_sc_hd__and4_1
XFILLER_0_46_372 vssd1 vssd1 vccd1 vccd1 sky130_ef_sc_hd__decap_12
XFILLER_0_34_589 vssd1 vssd1 vccd1 vccd1 sky130_fd_sc_hd__fill_2
XFILLER_0_28_29 vssd1 vssd1 vccd1 vccd1 sky130_ef_sc_hd__decap_12
Xfanout160 mul.a\[29\] vssd1 vssd1 vccd1 vccd1 net160 sky130_fd_sc_hd__clkbuf_4
Xfanout171 mul.a\[27\] vssd1 vssd1 vccd1 vccd1 net171 sky130_fd_sc_hd__buf_4
Xfanout182 net183 vssd1 vssd1 vccd1 vccd1 net182 sky130_fd_sc_hd__clkbuf_2
Xfanout193 net194 vssd1 vssd1 vccd1 vccd1 net193 sky130_fd_sc_hd__buf_2
XFILLER_0_88_217 vssd1 vssd1 vccd1 vccd1 sky130_fd_sc_hd__decap_6
XFILLER_0_96_250 vssd1 vssd1 vccd1 vccd1 sky130_fd_sc_hd__fill_2
XTAP_1140 vssd1 vccd1 sky130_fd_sc_hd__tapvpwrvgnd_1
XFILLER_0_57_615 vssd1 vssd1 vccd1 vccd1 sky130_fd_sc_hd__fill_1
XTAP_1173 vssd1 vccd1 sky130_fd_sc_hd__tapvpwrvgnd_1
XTAP_1151 vssd1 vccd1 sky130_fd_sc_hd__tapvpwrvgnd_1
XTAP_1162 vssd1 vccd1 sky130_fd_sc_hd__tapvpwrvgnd_1
XFILLER_0_60_27 vssd1 vssd1 vccd1 vccd1 sky130_fd_sc_hd__fill_1
XTAP_1195 vssd1 vccd1 sky130_fd_sc_hd__tapvpwrvgnd_1
XTAP_1184 vssd1 vccd1 sky130_fd_sc_hd__tapvpwrvgnd_1
XFILLER_0_44_309 vssd1 vssd1 vccd1 vccd1 sky130_fd_sc_hd__fill_1
XFILLER_0_71_128 vssd1 vssd1 vccd1 vccd1 sky130_fd_sc_hd__fill_1
XFILLER_0_25_534 vssd1 vssd1 vccd1 vccd1 sky130_fd_sc_hd__decap_3
XFILLER_0_69_47 vssd1 vssd1 vccd1 vccd1 sky130_fd_sc_hd__decap_8
XFILLER_0_40_548 vssd1 vssd1 vccd1 vccd1 sky130_fd_sc_hd__fill_2
XTAP_935 vssd1 vccd1 sky130_fd_sc_hd__tapvpwrvgnd_1
XTAP_924 vssd1 vccd1 sky130_fd_sc_hd__tapvpwrvgnd_1
XTAP_913 vssd1 vccd1 sky130_fd_sc_hd__tapvpwrvgnd_1
XTAP_902 vssd1 vccd1 sky130_fd_sc_hd__tapvpwrvgnd_1
XFILLER_0_85_57 vssd1 vssd1 vccd1 vccd1 sky130_ef_sc_hd__decap_12
XTAP_968 vssd1 vccd1 sky130_fd_sc_hd__tapvpwrvgnd_1
XTAP_957 vssd1 vccd1 sky130_fd_sc_hd__tapvpwrvgnd_1
XTAP_946 vssd1 vccd1 sky130_fd_sc_hd__tapvpwrvgnd_1
XTAP_979 vssd1 vccd1 sky130_fd_sc_hd__tapvpwrvgnd_1
X_07720_ _02089_ _02090_ net676 _01926_ vssd1 vssd1 vccd1 vccd1 _02092_ sky130_fd_sc_hd__o211ai_1
X_05981_ _00323_ _00324_ _00358_ _00360_ vssd1 vssd1 vccd1 vccd1 _00361_ sky130_fd_sc_hd__or4_4
X_07651_ _02020_ _02021_ _02017_ vssd1 vssd1 vccd1 vccd1 _02023_ sky130_fd_sc_hd__a21o_1
Xclkbuf_0_wb_clk_i wb_clk_i vssd1 vssd1 vccd1 vccd1 clknet_0_wb_clk_i sky130_fd_sc_hd__clkbuf_16
X_06602_ net188 net195 net627 net635 vssd1 vssd1 vccd1 vccd1 _00976_ sky130_fd_sc_hd__and4_1
X_07582_ net141 _01952_ _01953_ _01954_ vssd1 vssd1 vccd1 vccd1 net45 sky130_fd_sc_hd__a31o_1
XFILLER_0_87_250 vssd1 vssd1 vccd1 vccd1 sky130_fd_sc_hd__decap_4
X_09321_ _03794_ _03795_ vssd1 vssd1 vccd1 vccd1 _03796_ sky130_fd_sc_hd__and2_1
XFILLER_0_75_401 vssd1 vssd1 vccd1 vccd1 sky130_fd_sc_hd__decap_6
X_06533_ net346 net469 _00905_ _00906_ vssd1 vssd1 vccd1 vccd1 _00908_ sky130_fd_sc_hd__a22o_1
XFILLER_0_47_103 vssd1 vssd1 vccd1 vccd1 sky130_fd_sc_hd__decap_8
XFILLER_0_75_489 vssd1 vssd1 vccd1 vccd1 sky130_fd_sc_hd__fill_1
X_09252_ net161 net505 net516 net157 vssd1 vssd1 vccd1 vccd1 _03720_ sky130_fd_sc_hd__a22o_1
XFILLER_0_7_222 vssd1 vssd1 vccd1 vccd1 sky130_fd_sc_hd__fill_2
X_06464_ _00836_ _00839_ vssd1 vssd1 vccd1 vccd1 _00840_ sky130_fd_sc_hd__xnor2_1
XFILLER_0_47_169 vssd1 vssd1 vccd1 vccd1 sky130_fd_sc_hd__fill_1
X_09183_ _03642_ _03643_ net268 net412 vssd1 vssd1 vccd1 vccd1 _03645_ sky130_fd_sc_hd__and4bb_1
X_08203_ _02354_ _02357_ _02574_ _02575_ vssd1 vssd1 vccd1 vccd1 _02576_ sky130_fd_sc_hd__a211oi_2
X_05415_ net327 net587 _04683_ _04684_ vssd1 vssd1 vccd1 vccd1 _04685_ sky130_fd_sc_hd__nand4_1
XFILLER_0_7_255 vssd1 vssd1 vccd1 vccd1 sky130_fd_sc_hd__fill_1
X_06395_ _00648_ _00651_ vssd1 vssd1 vccd1 vccd1 _00771_ sky130_fd_sc_hd__nor2_1
XFILLER_0_28_361 vssd1 vssd1 vccd1 vccd1 sky130_fd_sc_hd__decap_3
X_08134_ net237 net245 net482 net492 vssd1 vssd1 vccd1 vccd1 _02506_ sky130_fd_sc_hd__nand4_2
X_05346_ _04598_ _04615_ vssd1 vssd1 vccd1 vccd1 _04616_ sky130_fd_sc_hd__xnor2_1
XFILLER_0_50_82 vssd1 vssd1 vccd1 vccd1 sky130_fd_sc_hd__fill_2
X_08065_ _02436_ _02437_ vssd1 vssd1 vccd1 vccd1 _02438_ sky130_fd_sc_hd__nor2_1
X_05277_ net97 _04546_ vssd1 vssd1 vccd1 vccd1 _04547_ sky130_fd_sc_hd__or2_1
XFILLER_0_31_559 vssd1 vssd1 vccd1 vccd1 sky130_fd_sc_hd__fill_1
XFILLER_0_59_80 vssd1 vssd1 vccd1 vccd1 sky130_ef_sc_hd__decap_12
X_07016_ _01384_ _01385_ _01267_ vssd1 vssd1 vccd1 vccd1 _01387_ sky130_fd_sc_hd__o21ai_1
XFILLER_0_11_294 vssd1 vssd1 vccd1 vccd1 sky130_fd_sc_hd__decap_8
X_08967_ net171 net174 net506 vssd1 vssd1 vccd1 vccd1 _03408_ sky130_fd_sc_hd__and3_1
X_08898_ _03330_ _03331_ _03132_ _03134_ vssd1 vssd1 vccd1 vccd1 _03333_ sky130_fd_sc_hd__o211ai_1
XFILLER_0_75_90 vssd1 vssd1 vccd1 vccd1 sky130_fd_sc_hd__fill_1
X_07918_ net149 net618 _02289_ _02290_ vssd1 vssd1 vccd1 vccd1 _02291_ sky130_fd_sc_hd__o2bb2a_1
X_07849_ net220 net529 _02218_ _02220_ vssd1 vssd1 vccd1 vccd1 _02222_ sky130_fd_sc_hd__a22o_1
XPHY_201 vssd1 vssd1 vccd1 vccd1 sky130_fd_sc_hd__decap_3
XFILLER_0_38_103 vssd1 vssd1 vccd1 vccd1 sky130_ef_sc_hd__decap_12
X_09519_ net151 net505 net514 net146 vssd1 vssd1 vccd1 vccd1 _04012_ sky130_fd_sc_hd__a22oi_1
XFILLER_0_38_147 vssd1 vssd1 vccd1 vccd1 sky130_fd_sc_hd__decap_3
XFILLER_0_81_437 vssd1 vssd1 vccd1 vccd1 sky130_fd_sc_hd__fill_1
XFILLER_0_22_526 vssd1 vssd1 vccd1 vccd1 sky130_fd_sc_hd__decap_6
XFILLER_0_61_183 vssd1 vssd1 vccd1 vccd1 sky130_fd_sc_hd__fill_1
XFILLER_0_22_537 vssd1 vssd1 vccd1 vccd1 sky130_fd_sc_hd__decap_6
XFILLER_0_34_397 vssd1 vssd1 vccd1 vccd1 sky130_fd_sc_hd__decap_3
XFILLER_0_39_39 vssd1 vssd1 vccd1 vccd1 sky130_ef_sc_hd__decap_12
XTAP_209 vssd1 vccd1 sky130_fd_sc_hd__tapvpwrvgnd_1
XFILLER_0_30_570 vssd1 vssd1 vccd1 vccd1 sky130_fd_sc_hd__decap_8
XFILLER_0_100_491 vssd1 vssd1 vccd1 vccd1 sky130_fd_sc_hd__fill_1
X_10087_ clknet_3_6_0_wb_clk_i _00083_ _00019_ vssd1 vssd1 vccd1 vccd1 mul.b\[16\]
+ sky130_fd_sc_hd__dfrtp_1
XFILLER_0_89_537 vssd1 vssd1 vccd1 vccd1 sky130_fd_sc_hd__fill_2
XFILLER_0_76_209 vssd1 vssd1 vccd1 vccd1 sky130_fd_sc_hd__fill_1
XFILLER_0_84_253 vssd1 vssd1 vccd1 vccd1 sky130_fd_sc_hd__fill_1
XFILLER_0_57_456 vssd1 vssd1 vccd1 vccd1 sky130_fd_sc_hd__decap_8
XFILLER_0_29_169 vssd1 vssd1 vccd1 vccd1 sky130_fd_sc_hd__decap_6
XFILLER_0_44_139 vssd1 vssd1 vccd1 vccd1 sky130_fd_sc_hd__fill_1
X_05200_ _03629_ _03640_ _03706_ vssd1 vssd1 vccd1 vccd1 _03738_ sky130_fd_sc_hd__a21oi_1
X_06180_ _00555_ _00556_ _00557_ vssd1 vssd1 vccd1 vccd1 _00558_ sky130_fd_sc_hd__nand3_1
XFILLER_0_40_312 vssd1 vssd1 vccd1 vccd1 sky130_ef_sc_hd__decap_12
Xmax_cap113 _02248_ vssd1 vssd1 vccd1 vccd1 net113 sky130_fd_sc_hd__clkbuf_2
X_05131_ _02940_ _02951_ _02875_ vssd1 vssd1 vccd1 vccd1 _02984_ sky130_fd_sc_hd__a21oi_1
XFILLER_0_13_537 vssd1 vssd1 vccd1 vccd1 sky130_fd_sc_hd__fill_1
Xmax_cap102 _00934_ vssd1 vssd1 vccd1 vccd1 net102 sky130_fd_sc_hd__buf_2
X_05062_ net26 net402 net126 vssd1 vssd1 vccd1 vccd1 _00096_ sky130_fd_sc_hd__mux2_1
XFILLER_0_40_356 vssd1 vssd1 vccd1 vccd1 sky130_fd_sc_hd__decap_8
X_09870_ _04359_ _04393_ vssd1 vssd1 vccd1 vccd1 _04396_ sky130_fd_sc_hd__xor2_1
XFILLER_0_0_453 vssd1 vssd1 vccd1 vccd1 sky130_ef_sc_hd__decap_12
XTAP_710 vssd1 vccd1 sky130_fd_sc_hd__tapvpwrvgnd_1
X_08821_ net166 net525 _03245_ _03248_ vssd1 vssd1 vccd1 vccd1 _03249_ sky130_fd_sc_hd__a22o_1
XFILLER_0_0_497 vssd1 vssd1 vccd1 vccd1 sky130_fd_sc_hd__fill_1
XTAP_721 vssd1 vccd1 sky130_fd_sc_hd__tapvpwrvgnd_1
XTAP_732 vssd1 vccd1 sky130_fd_sc_hd__tapvpwrvgnd_1
XTAP_743 vssd1 vccd1 sky130_fd_sc_hd__tapvpwrvgnd_1
XTAP_776 vssd1 vccd1 sky130_fd_sc_hd__tapvpwrvgnd_1
XTAP_754 vssd1 vccd1 sky130_fd_sc_hd__tapvpwrvgnd_1
XTAP_765 vssd1 vccd1 sky130_fd_sc_hd__tapvpwrvgnd_1
X_08752_ _03165_ _03173_ vssd1 vssd1 vccd1 vccd1 _03174_ sky130_fd_sc_hd__xnor2_1
XTAP_798 vssd1 vccd1 sky130_fd_sc_hd__tapvpwrvgnd_1
XTAP_787 vssd1 vccd1 sky130_fd_sc_hd__tapvpwrvgnd_1
X_05964_ _00239_ _00241_ _00240_ vssd1 vssd1 vccd1 vccd1 _00344_ sky130_fd_sc_hd__a21bo_1
X_07703_ net245 net510 vssd1 vssd1 vccd1 vccd1 _02075_ sky130_fd_sc_hd__nand2_1
X_08683_ net172 net525 _03094_ _03096_ vssd1 vssd1 vccd1 vccd1 _03098_ sky130_fd_sc_hd__and4_1
X_07634_ net359 net368 net409 net414 vssd1 vssd1 vccd1 vccd1 _02006_ sky130_fd_sc_hd__and4_1
X_05895_ _05007_ _05009_ _00274_ _00275_ vssd1 vssd1 vccd1 vccd1 _00276_ sky130_fd_sc_hd__a211oi_2
XFILLER_0_17_3 vssd1 vssd1 vccd1 vccd1 sky130_ef_sc_hd__decap_12
XFILLER_0_75_220 vssd1 vssd1 vccd1 vccd1 sky130_fd_sc_hd__decap_4
X_07565_ _01775_ net80 _01936_ net659 vssd1 vssd1 vccd1 vccd1 _01938_ sky130_fd_sc_hd__o211ai_4
XFILLER_0_48_434 vssd1 vssd1 vccd1 vccd1 sky130_fd_sc_hd__fill_1
XFILLER_0_48_445 vssd1 vssd1 vccd1 vccd1 sky130_fd_sc_hd__decap_8
X_09304_ net267 net276 net399 net405 vssd1 vssd1 vccd1 vccd1 _03777_ sky130_fd_sc_hd__and4_1
X_07496_ _01864_ _01865_ _01731_ _01733_ vssd1 vssd1 vccd1 vccd1 _01867_ sky130_fd_sc_hd__a211oi_2
XFILLER_0_0_95 vssd1 vssd1 vccd1 vccd1 sky130_fd_sc_hd__decap_8
X_06516_ net355 net365 net454 net461 vssd1 vssd1 vccd1 vccd1 _00891_ sky130_fd_sc_hd__nand4_1
X_09235_ _03699_ _03700_ vssd1 vssd1 vccd1 vccd1 _03702_ sky130_fd_sc_hd__xnor2_1
XFILLER_0_63_415 vssd1 vssd1 vccd1 vccd1 sky130_ef_sc_hd__decap_12
XFILLER_0_8_564 vssd1 vssd1 vccd1 vccd1 sky130_fd_sc_hd__decap_8
X_06447_ _00755_ _00757_ _00820_ _00821_ vssd1 vssd1 vccd1 vccd1 _00823_ sky130_fd_sc_hd__a2bb2o_1
X_09166_ _03434_ _03459_ _03623_ _03625_ vssd1 vssd1 vccd1 vccd1 _03626_ sky130_fd_sc_hd__a211oi_4
X_06378_ _00646_ _00752_ vssd1 vssd1 vccd1 vccd1 _00754_ sky130_fd_sc_hd__xnor2_1
X_09097_ _03548_ _03549_ vssd1 vssd1 vccd1 vccd1 _03551_ sky130_fd_sc_hd__and2_1
X_08117_ net201 net527 _02485_ _02487_ vssd1 vssd1 vccd1 vccd1 _02489_ sky130_fd_sc_hd__and4_1
XFILLER_0_16_386 vssd1 vssd1 vccd1 vccd1 sky130_fd_sc_hd__fill_2
X_05329_ _04567_ _04570_ _04569_ vssd1 vssd1 vccd1 vccd1 _04599_ sky130_fd_sc_hd__a21o_1
X_08048_ _02361_ _02362_ _02418_ _02419_ vssd1 vssd1 vccd1 vccd1 _02421_ sky130_fd_sc_hd__o22a_1
XFILLER_0_31_356 vssd1 vssd1 vccd1 vccd1 sky130_fd_sc_hd__fill_1
XFILLER_0_101_233 vssd1 vssd1 vccd1 vccd1 sky130_fd_sc_hd__fill_1
X_10010_ net638 vssd1 vssd1 vccd1 vccd1 _00006_ sky130_fd_sc_hd__inv_2
X_09999_ net118 _04535_ _04434_ vssd1 vssd1 vccd1 vccd1 _04537_ sky130_fd_sc_hd__mux2_1
XFILLER_0_98_378 vssd1 vssd1 vccd1 vccd1 sky130_fd_sc_hd__decap_3
XFILLER_0_94_573 vssd1 vssd1 vccd1 vccd1 sky130_fd_sc_hd__decap_4
XFILLER_0_94_584 vssd1 vssd1 vccd1 vccd1 sky130_fd_sc_hd__fill_1
XFILLER_0_81_245 vssd1 vssd1 vccd1 vccd1 sky130_fd_sc_hd__decap_6
XFILLER_0_10_507 vssd1 vssd1 vccd1 vccd1 sky130_fd_sc_hd__fill_2
XFILLER_0_82_14 vssd1 vssd1 vccd1 vccd1 sky130_ef_sc_hd__decap_12
XFILLER_0_82_36 vssd1 vssd1 vccd1 vccd1 sky130_ef_sc_hd__decap_12
X_05680_ _04947_ _04948_ vssd1 vssd1 vccd1 vccd1 _04950_ sky130_fd_sc_hd__xnor2_1
X_07350_ net350 net433 vssd1 vssd1 vccd1 vccd1 _01719_ sky130_fd_sc_hd__nand2_1
XFILLER_0_85_573 vssd1 vssd1 vccd1 vccd1 sky130_fd_sc_hd__fill_1
XFILLER_0_17_106 vssd1 vssd1 vccd1 vccd1 sky130_fd_sc_hd__fill_1
X_06301_ _00675_ _00676_ _00674_ vssd1 vssd1 vccd1 vccd1 _00678_ sky130_fd_sc_hd__a21o_1
X_09020_ net294 net401 net406 net284 vssd1 vssd1 vccd1 vccd1 _03467_ sky130_fd_sc_hd__a22o_1
X_07281_ net182 net602 net612 net175 vssd1 vssd1 vccd1 vccd1 _01650_ sky130_fd_sc_hd__a22oi_1
XFILLER_0_13_301 vssd1 vssd1 vccd1 vccd1 sky130_ef_sc_hd__decap_12
X_06232_ net236 net617 _00504_ _00503_ vssd1 vssd1 vccd1 vccd1 _00609_ sky130_fd_sc_hd__a31o_1
X_06163_ net370 net469 vssd1 vssd1 vccd1 vccd1 _00541_ sky130_fd_sc_hd__nand2_1
X_05114_ _02700_ _02722_ _02711_ vssd1 vssd1 vccd1 vccd1 _02798_ sky130_fd_sc_hd__a21o_1
XFILLER_0_40_153 vssd1 vssd1 vccd1 vccd1 sky130_fd_sc_hd__decap_6
X_06094_ _00367_ _00370_ _00470_ _00472_ vssd1 vssd1 vccd1 vccd1 _00473_ sky130_fd_sc_hd__a211oi_2
X_09922_ net185 net436 vssd1 vssd1 vccd1 vccd1 _04452_ sky130_fd_sc_hd__nand2_1
XFILLER_0_0_261 vssd1 vssd1 vccd1 vccd1 sky130_fd_sc_hd__fill_2
X_05045_ net7 net298 net133 vssd1 vssd1 vccd1 vccd1 _00110_ sky130_fd_sc_hd__mux2_1
XTAP_540 vssd1 vccd1 sky130_fd_sc_hd__tapvpwrvgnd_1
XTAP_551 vssd1 vccd1 sky130_fd_sc_hd__tapvpwrvgnd_1
X_09853_ _04195_ _04199_ vssd1 vssd1 vccd1 vccd1 _04377_ sky130_fd_sc_hd__nor2_1
X_09784_ _04147_ _04149_ _04301_ vssd1 vssd1 vccd1 vccd1 _04302_ sky130_fd_sc_hd__a21o_1
X_08804_ _03045_ _03069_ _03068_ vssd1 vssd1 vccd1 vccd1 _03231_ sky130_fd_sc_hd__a21oi_1
XTAP_562 vssd1 vccd1 sky130_fd_sc_hd__tapvpwrvgnd_1
XTAP_573 vssd1 vccd1 sky130_fd_sc_hd__tapvpwrvgnd_1
XTAP_584 vssd1 vccd1 sky130_fd_sc_hd__tapvpwrvgnd_1
X_08735_ _03129_ _03130_ _03151_ _03152_ vssd1 vssd1 vccd1 vccd1 _03155_ sky130_fd_sc_hd__a22oi_4
XTAP_595 vssd1 vccd1 sky130_fd_sc_hd__tapvpwrvgnd_1
X_06996_ _01365_ _01366_ vssd1 vssd1 vccd1 vccd1 _01367_ sky130_fd_sc_hd__nand2b_1
X_05947_ net371 net379 net479 net488 vssd1 vssd1 vccd1 vccd1 _00327_ sky130_fd_sc_hd__and4_1
X_08666_ _03075_ _03076_ _03077_ vssd1 vssd1 vccd1 vccd1 _03080_ sky130_fd_sc_hd__o21ai_1
XFILLER_0_68_507 vssd1 vssd1 vccd1 vccd1 sky130_fd_sc_hd__decap_4
X_05878_ _00155_ _00257_ _00258_ vssd1 vssd1 vccd1 vccd1 _00259_ sky130_fd_sc_hd__and3_2
X_08597_ _03002_ _03003_ vssd1 vssd1 vccd1 vccd1 _03004_ sky130_fd_sc_hd__nor2_1
XFILLER_0_95_337 vssd1 vssd1 vccd1 vccd1 sky130_fd_sc_hd__fill_1
XFILLER_0_72_80 vssd1 vssd1 vccd1 vccd1 sky130_fd_sc_hd__fill_1
X_07617_ _01976_ _01987_ _01988_ vssd1 vssd1 vccd1 vccd1 _01989_ sky130_fd_sc_hd__and3_1
X_07548_ _01900_ _01918_ _01919_ vssd1 vssd1 vccd1 vccd1 _01921_ sky130_fd_sc_hd__or3_4
XFILLER_0_48_264 vssd1 vssd1 vccd1 vccd1 sky130_fd_sc_hd__decap_4
XFILLER_0_48_275 vssd1 vssd1 vccd1 vccd1 sky130_fd_sc_hd__fill_2
XFILLER_0_91_532 vssd1 vssd1 vccd1 vccd1 sky130_fd_sc_hd__decap_8
X_07479_ _01840_ _01848_ vssd1 vssd1 vccd1 vccd1 _01850_ sky130_fd_sc_hd__xnor2_1
XFILLER_0_8_372 vssd1 vssd1 vccd1 vccd1 sky130_fd_sc_hd__fill_1
XFILLER_0_8_361 vssd1 vssd1 vccd1 vccd1 sky130_fd_sc_hd__decap_3
X_09218_ _03680_ _03681_ vssd1 vssd1 vccd1 vccd1 _03683_ sky130_fd_sc_hd__xnor2_1
XFILLER_0_91_587 vssd1 vssd1 vccd1 vccd1 sky130_fd_sc_hd__fill_2
X_09149_ net200 net208 net458 net465 vssd1 vssd1 vccd1 vccd1 _03608_ sky130_fd_sc_hd__and4_1
XFILLER_0_31_142 vssd1 vssd1 vccd1 vccd1 sky130_fd_sc_hd__fill_2
XFILLER_0_6_3 vssd1 vssd1 vccd1 vccd1 sky130_fd_sc_hd__decap_6
XFILLER_0_36_29 vssd1 vssd1 vccd1 vccd1 sky130_fd_sc_hd__decap_4
XFILLER_0_82_510 vssd1 vssd1 vccd1 vccd1 sky130_fd_sc_hd__decap_8
XFILLER_0_82_554 vssd1 vssd1 vccd1 vccd1 sky130_fd_sc_hd__fill_1
XFILLER_0_39_297 vssd1 vssd1 vccd1 vccd1 sky130_fd_sc_hd__fill_1
XFILLER_0_82_587 vssd1 vssd1 vccd1 vccd1 sky130_fd_sc_hd__fill_1
XFILLER_0_82_565 vssd1 vssd1 vccd1 vccd1 sky130_fd_sc_hd__fill_1
XFILLER_0_2_515 vssd1 vssd1 vccd1 vccd1 sky130_ef_sc_hd__decap_12
XFILLER_0_50_451 vssd1 vssd1 vccd1 vccd1 sky130_fd_sc_hd__fill_1
XFILLER_0_10_337 vssd1 vssd1 vccd1 vccd1 sky130_fd_sc_hd__fill_1
X_06850_ _01220_ _01221_ _01222_ vssd1 vssd1 vccd1 vccd1 _01223_ sky130_fd_sc_hd__a21oi_1
XFILLER_0_93_57 vssd1 vssd1 vccd1 vccd1 sky130_fd_sc_hd__decap_8
X_05801_ _04895_ _04973_ _04974_ _00179_ vssd1 vssd1 vccd1 vccd1 _00183_ sky130_fd_sc_hd__a211o_4
XFILLER_0_93_68 vssd1 vssd1 vccd1 vccd1 sky130_fd_sc_hd__fill_2
X_06781_ _01152_ _01153_ vssd1 vssd1 vccd1 vccd1 _01154_ sky130_fd_sc_hd__xnor2_1
X_08520_ _02918_ _02920_ vssd1 vssd1 vccd1 vccd1 _02921_ sky130_fd_sc_hd__and2b_1
X_05732_ net253 net263 net625 net633 vssd1 vssd1 vccd1 vccd1 _05002_ sky130_fd_sc_hd__and4_1
X_08451_ _02674_ _02676_ _02675_ vssd1 vssd1 vccd1 vccd1 _02845_ sky130_fd_sc_hd__a21bo_1
XFILLER_0_77_337 vssd1 vssd1 vccd1 vccd1 sky130_fd_sc_hd__fill_2
X_05663_ net331 net562 net570 net322 vssd1 vssd1 vccd1 vccd1 _04933_ sky130_fd_sc_hd__a22oi_2
X_07402_ _01621_ net719 net685 _01770_ vssd1 vssd1 vccd1 vccd1 _01771_ sky130_fd_sc_hd__o211ai_4
XFILLER_0_85_381 vssd1 vssd1 vccd1 vccd1 sky130_fd_sc_hd__decap_8
X_08382_ net140 _02767_ _02768_ _02769_ vssd1 vssd1 vccd1 vccd1 net50 sky130_fd_sc_hd__a31o_1
X_05594_ net312 net590 _04862_ _04863_ vssd1 vssd1 vccd1 vccd1 _04864_ sky130_fd_sc_hd__nand4_1
XFILLER_0_45_212 vssd1 vssd1 vccd1 vccd1 sky130_fd_sc_hd__decap_6
XFILLER_0_73_543 vssd1 vssd1 vccd1 vccd1 sky130_fd_sc_hd__fill_1
X_07333_ _01571_ _01573_ _01700_ _01701_ vssd1 vssd1 vccd1 vccd1 _01702_ sky130_fd_sc_hd__a211o_1
XFILLER_0_18_459 vssd1 vssd1 vccd1 vccd1 sky130_fd_sc_hd__decap_8
XFILLER_0_42_83 vssd1 vssd1 vccd1 vccd1 sky130_fd_sc_hd__fill_1
XFILLER_0_45_223 vssd1 vssd1 vccd1 vccd1 sky130_fd_sc_hd__fill_1
X_07264_ _01631_ _01632_ _01541_ vssd1 vssd1 vccd1 vccd1 _01634_ sky130_fd_sc_hd__o21a_1
XFILLER_0_84_3 vssd1 vssd1 vccd1 vccd1 sky130_ef_sc_hd__decap_12
X_09003_ _03446_ _03447_ vssd1 vssd1 vccd1 vccd1 _03448_ sky130_fd_sc_hd__nand2_2
X_06215_ _00590_ _00591_ _00486_ vssd1 vssd1 vccd1 vccd1 _00593_ sky130_fd_sc_hd__o21a_1
XFILLER_0_60_259 vssd1 vssd1 vccd1 vccd1 sky130_fd_sc_hd__fill_2
X_07195_ _01548_ _01563_ vssd1 vssd1 vccd1 vccd1 _01565_ sky130_fd_sc_hd__xnor2_1
X_06146_ _00295_ _00396_ _00415_ vssd1 vssd1 vccd1 vccd1 _00524_ sky130_fd_sc_hd__o21ai_1
X_06077_ _00350_ net116 _00454_ _00455_ vssd1 vssd1 vccd1 vccd1 _00456_ sky130_fd_sc_hd__o211ai_4
X_09905_ _04433_ _04432_ vssd1 vssd1 vccd1 vccd1 _04434_ sky130_fd_sc_hd__nand2b_1
X_05028_ net25 net164 net135 vssd1 vssd1 vccd1 vccd1 _00127_ sky130_fd_sc_hd__mux2_1
Xfanout501 net502 vssd1 vssd1 vccd1 vccd1 net501 sky130_fd_sc_hd__buf_2
Xfanout523 net529 vssd1 vssd1 vccd1 vccd1 net523 sky130_fd_sc_hd__clkbuf_2
Xfanout512 net520 vssd1 vssd1 vccd1 vccd1 net512 sky130_fd_sc_hd__buf_2
XFILLER_0_67_91 vssd1 vssd1 vccd1 vccd1 sky130_fd_sc_hd__fill_1
Xfanout534 net535 vssd1 vssd1 vccd1 vccd1 net534 sky130_fd_sc_hd__buf_6
Xfanout545 net546 vssd1 vssd1 vccd1 vccd1 net545 sky130_fd_sc_hd__clkbuf_4
Xfanout556 mul.b\[9\] vssd1 vssd1 vccd1 vccd1 net556 sky130_fd_sc_hd__buf_2
Xfanout589 net591 vssd1 vssd1 vccd1 vccd1 net589 sky130_fd_sc_hd__clkbuf_4
XTAP_370 vssd1 vccd1 sky130_fd_sc_hd__tapvpwrvgnd_1
XTAP_381 vssd1 vccd1 sky130_fd_sc_hd__tapvpwrvgnd_1
XTAP_392 vssd1 vccd1 sky130_fd_sc_hd__tapvpwrvgnd_1
Xfanout567 net569 vssd1 vssd1 vccd1 vccd1 net567 sky130_fd_sc_hd__clkbuf_4
Xfanout578 net579 vssd1 vssd1 vccd1 vccd1 net578 sky130_fd_sc_hd__clkbuf_2
X_09836_ _04356_ _04357_ vssd1 vssd1 vccd1 vccd1 _04358_ sky130_fd_sc_hd__xor2_1
X_09767_ _04281_ _04282_ vssd1 vssd1 vccd1 vccd1 _04283_ sky130_fd_sc_hd__nand2_1
X_06979_ net687 _01212_ _01348_ _01349_ vssd1 vssd1 vccd1 vccd1 _01351_ sky130_fd_sc_hd__o211ai_2
X_08718_ net232 net457 net464 net223 vssd1 vssd1 vccd1 vccd1 _03136_ sky130_fd_sc_hd__a22oi_1
X_09698_ _04204_ _04205_ _04206_ vssd1 vssd1 vccd1 vccd1 _04207_ sky130_fd_sc_hd__or3b_1
X_08649_ _03047_ _03060_ vssd1 vssd1 vccd1 vccd1 _03062_ sky130_fd_sc_hd__xnor2_1
Xrebuffer50 net694 vssd1 vssd1 vccd1 vccd1 net695 sky130_fd_sc_hd__clkbuf_1
XPHY_21 vssd1 vssd1 vccd1 vccd1 sky130_fd_sc_hd__decap_3
XPHY_10 vssd1 vssd1 vccd1 vccd1 sky130_fd_sc_hd__decap_3
Xrebuffer61 net705 vssd1 vssd1 vccd1 vccd1 net706 sky130_fd_sc_hd__clkbuf_1
Xrebuffer72 mul.a\[5\] vssd1 vssd1 vccd1 vccd1 net728 sky130_fd_sc_hd__dlygate4sd1_1
XFILLER_0_95_167 vssd1 vssd1 vccd1 vccd1 sky130_fd_sc_hd__fill_1
XPHY_32 vssd1 vssd1 vccd1 vccd1 sky130_fd_sc_hd__decap_3
XPHY_43 vssd1 vssd1 vccd1 vccd1 sky130_fd_sc_hd__decap_3
XPHY_54 vssd1 vssd1 vccd1 vccd1 sky130_fd_sc_hd__decap_3
XPHY_65 vssd1 vssd1 vccd1 vccd1 sky130_fd_sc_hd__decap_3
XPHY_76 vssd1 vssd1 vccd1 vccd1 sky130_fd_sc_hd__decap_3
XPHY_87 vssd1 vssd1 vccd1 vccd1 sky130_fd_sc_hd__decap_3
XPHY_98 vssd1 vssd1 vccd1 vccd1 sky130_fd_sc_hd__decap_3
XFILLER_0_76_381 vssd1 vssd1 vccd1 vccd1 sky130_ef_sc_hd__decap_12
XFILLER_0_64_554 vssd1 vssd1 vccd1 vccd1 sky130_fd_sc_hd__decap_8
XFILLER_0_91_373 vssd1 vssd1 vccd1 vccd1 sky130_fd_sc_hd__fill_2
XFILLER_0_20_613 vssd1 vssd1 vccd1 vccd1 sky130_fd_sc_hd__fill_1
XFILLER_0_63_38 vssd1 vssd1 vccd1 vccd1 sky130_fd_sc_hd__fill_2
XFILLER_0_87_624 vssd1 vssd1 vccd1 vccd1 sky130_fd_sc_hd__fill_1
XFILLER_0_59_337 vssd1 vssd1 vccd1 vccd1 sky130_fd_sc_hd__fill_2
XFILLER_0_12_20 vssd1 vssd1 vccd1 vccd1 sky130_fd_sc_hd__decap_8
XFILLER_0_27_223 vssd1 vssd1 vccd1 vccd1 sky130_fd_sc_hd__fill_1
XFILLER_0_55_587 vssd1 vssd1 vccd1 vccd1 sky130_fd_sc_hd__fill_1
XFILLER_0_55_576 vssd1 vssd1 vccd1 vccd1 sky130_fd_sc_hd__fill_1
XFILLER_0_6_139 vssd1 vssd1 vccd1 vccd1 sky130_fd_sc_hd__fill_1
XFILLER_0_70_524 vssd1 vssd1 vccd1 vccd1 sky130_fd_sc_hd__fill_2
XFILLER_0_12_97 vssd1 vssd1 vccd1 vccd1 sky130_ef_sc_hd__decap_12
XFILLER_0_12_64 vssd1 vssd1 vccd1 vccd1 sky130_fd_sc_hd__decap_6
XFILLER_0_88_35 vssd1 vssd1 vccd1 vccd1 sky130_fd_sc_hd__fill_1
XFILLER_0_88_24 vssd1 vssd1 vccd1 vccd1 sky130_fd_sc_hd__fill_1
X_06000_ _00377_ _00379_ vssd1 vssd1 vccd1 vccd1 _00380_ sky130_fd_sc_hd__nand2_1
XFILLER_0_2_301 vssd1 vssd1 vccd1 vccd1 sky130_fd_sc_hd__fill_1
XFILLER_0_2_323 vssd1 vssd1 vccd1 vccd1 sky130_ef_sc_hd__decap_12
XFILLER_0_42_259 vssd1 vssd1 vccd1 vccd1 sky130_fd_sc_hd__decap_4
XFILLER_0_50_270 vssd1 vssd1 vccd1 vccd1 sky130_ef_sc_hd__decap_12
XFILLER_0_23_473 vssd1 vssd1 vccd1 vccd1 sky130_ef_sc_hd__decap_12
XFILLER_0_100_309 vssd1 vssd1 vccd1 vccd1 sky130_fd_sc_hd__fill_1
X_07951_ _02288_ _02322_ vssd1 vssd1 vccd1 vccd1 _02324_ sky130_fd_sc_hd__xnor2_1
XFILLER_0_10_167 vssd1 vssd1 vccd1 vccd1 sky130_fd_sc_hd__fill_2
XFILLER_0_10_178 vssd1 vssd1 vccd1 vccd1 sky130_fd_sc_hd__decap_6
X_06902_ _01269_ _01272_ vssd1 vssd1 vccd1 vccd1 _01274_ sky130_fd_sc_hd__xor2_1
X_07882_ _02087_ _02089_ _02254_ _02255_ vssd1 vssd1 vccd1 vccd1 _02256_ sky130_fd_sc_hd__o211ai_4
X_09621_ _03932_ _03936_ _04123_ vssd1 vssd1 vccd1 vccd1 _04124_ sky130_fd_sc_hd__o21ai_1
X_06833_ _01074_ _01077_ net94 _01205_ vssd1 vssd1 vccd1 vccd1 _01206_ sky130_fd_sc_hd__a211oi_4
XFILLER_0_37_83 vssd1 vssd1 vccd1 vccd1 sky130_fd_sc_hd__decap_6
X_06764_ _01018_ _01022_ net389 net422 vssd1 vssd1 vccd1 vccd1 _01137_ sky130_fd_sc_hd__o211a_1
X_09552_ _04046_ _04047_ vssd1 vssd1 vccd1 vccd1 _04048_ sky130_fd_sc_hd__nand2_1
X_08503_ _02121_ _02718_ _02900_ _02117_ vssd1 vssd1 vccd1 vccd1 _02902_ sky130_fd_sc_hd__o211a_1
X_05715_ _04983_ _04984_ vssd1 vssd1 vccd1 vccd1 _04985_ sky130_fd_sc_hd__nand2b_1
X_09483_ _03971_ _03972_ vssd1 vssd1 vccd1 vccd1 _03973_ sky130_fd_sc_hd__nor2_1
X_06695_ _00929_ _00932_ _01066_ _01068_ vssd1 vssd1 vccd1 vccd1 _01069_ sky130_fd_sc_hd__a211oi_4
XFILLER_0_92_104 vssd1 vssd1 vccd1 vccd1 sky130_fd_sc_hd__fill_1
X_08434_ _02823_ _02824_ _02652_ _02654_ vssd1 vssd1 vccd1 vccd1 _02826_ sky130_fd_sc_hd__o211a_1
XFILLER_0_77_167 vssd1 vssd1 vccd1 vccd1 sky130_fd_sc_hd__fill_1
XFILLER_0_65_329 vssd1 vssd1 vccd1 vccd1 sky130_fd_sc_hd__decap_6
X_05646_ net312 net339 net553 net580 vssd1 vssd1 vccd1 vccd1 _04916_ sky130_fd_sc_hd__nand4_1
X_08365_ _02709_ _02710_ _02749_ vssd1 vssd1 vccd1 vccd1 _02751_ sky130_fd_sc_hd__or3_1
X_05577_ net297 net305 net599 net609 vssd1 vssd1 vccd1 vccd1 _04847_ sky130_fd_sc_hd__and4_1
XFILLER_0_61_502 vssd1 vssd1 vccd1 vccd1 sky130_fd_sc_hd__fill_2
X_07316_ _01668_ _01684_ vssd1 vssd1 vccd1 vccd1 _01685_ sky130_fd_sc_hd__or2_2
X_08296_ net333 net341 net403 net410 vssd1 vssd1 vccd1 vccd1 _02675_ sky130_fd_sc_hd__nand4_2
X_07247_ _01613_ _01614_ _01615_ vssd1 vssd1 vccd1 vccd1 _01617_ sky130_fd_sc_hd__a21oi_1
X_07178_ _01546_ _01547_ vssd1 vssd1 vccd1 vccd1 _01548_ sky130_fd_sc_hd__nor2_1
X_06129_ _00505_ _00506_ vssd1 vssd1 vccd1 vccd1 _00507_ sky130_fd_sc_hd__xnor2_1
XFILLER_0_41_281 vssd1 vssd1 vccd1 vccd1 sky130_ef_sc_hd__decap_12
Xfanout320 net321 vssd1 vssd1 vccd1 vccd1 net320 sky130_fd_sc_hd__buf_2
Xfanout331 mul.a\[7\] vssd1 vssd1 vccd1 vccd1 net331 sky130_fd_sc_hd__buf_4
Xfanout342 mul.a\[6\] vssd1 vssd1 vccd1 vccd1 net342 sky130_fd_sc_hd__clkbuf_4
Xfanout364 net366 vssd1 vssd1 vccd1 vccd1 net364 sky130_fd_sc_hd__buf_2
Xfanout375 net376 vssd1 vssd1 vccd1 vccd1 net375 sky130_fd_sc_hd__buf_4
Xfanout353 net354 vssd1 vssd1 vccd1 vccd1 net353 sky130_fd_sc_hd__clkbuf_2
Xfanout397 mul.b\[30\] vssd1 vssd1 vccd1 vccd1 net397 sky130_fd_sc_hd__clkbuf_4
Xfanout386 mul.a\[0\] vssd1 vssd1 vccd1 vccd1 net386 sky130_fd_sc_hd__buf_2
X_09819_ _04337_ _04338_ vssd1 vssd1 vccd1 vccd1 _04340_ sky130_fd_sc_hd__xnor2_1
XTAP_1311 vssd1 vccd1 sky130_fd_sc_hd__tapvpwrvgnd_1
XTAP_1322 vssd1 vccd1 sky130_fd_sc_hd__tapvpwrvgnd_1
XTAP_1300 vssd1 vccd1 sky130_fd_sc_hd__tapvpwrvgnd_1
XTAP_1344 vssd1 vccd1 sky130_fd_sc_hd__tapvpwrvgnd_1
XTAP_1333 vssd1 vccd1 sky130_fd_sc_hd__tapvpwrvgnd_1
XFILLER_0_68_189 vssd1 vssd1 vccd1 vccd1 sky130_fd_sc_hd__decap_6
Xinput28 wbs_dat_i[30] vssd1 vssd1 vccd1 vccd1 net28 sky130_fd_sc_hd__clkbuf_1
XFILLER_0_91_181 vssd1 vssd1 vccd1 vccd1 sky130_fd_sc_hd__decap_6
Xinput17 wbs_dat_i[20] vssd1 vssd1 vccd1 vccd1 net17 sky130_fd_sc_hd__clkbuf_1
XFILLER_0_37_587 vssd1 vssd1 vccd1 vccd1 sky130_fd_sc_hd__fill_2
XFILLER_0_99_281 vssd1 vssd1 vccd1 vccd1 sky130_fd_sc_hd__decap_6
XFILLER_0_90_25 vssd1 vssd1 vccd1 vccd1 sky130_fd_sc_hd__decap_3
XFILLER_0_74_104 vssd1 vssd1 vccd1 vccd1 sky130_fd_sc_hd__decap_6
X_05500_ _04683_ _04685_ vssd1 vssd1 vccd1 vccd1 _04770_ sky130_fd_sc_hd__nand2_1
X_06480_ _00850_ _00853_ vssd1 vssd1 vccd1 vccd1 _00855_ sky130_fd_sc_hd__xnor2_1
X_05431_ net310 net319 net594 net604 vssd1 vssd1 vccd1 vccd1 _04701_ sky130_fd_sc_hd__nand4_2
X_08150_ net307 net432 _02519_ _02520_ vssd1 vssd1 vccd1 vccd1 _02522_ sky130_fd_sc_hd__nand4_2
X_05362_ _04628_ _04631_ _04596_ vssd1 vssd1 vccd1 vccd1 _04632_ sky130_fd_sc_hd__o21bai_1
XFILLER_0_28_587 vssd1 vssd1 vccd1 vccd1 sky130_fd_sc_hd__fill_1
X_07101_ _01436_ _01437_ _01470_ _01471_ vssd1 vssd1 vccd1 vccd1 _01472_ sky130_fd_sc_hd__or4bb_4
X_08081_ _02120_ _02452_ vssd1 vssd1 vccd1 vccd1 _02453_ sky130_fd_sc_hd__and2_1
XFILLER_0_15_237 vssd1 vssd1 vccd1 vccd1 sky130_fd_sc_hd__decap_4
X_05293_ net363 net614 vssd1 vssd1 vccd1 vccd1 _04563_ sky130_fd_sc_hd__and2_1
X_07032_ net226 net561 net569 net218 vssd1 vssd1 vccd1 vccd1 _01403_ sky130_fd_sc_hd__a22oi_1
Xclkbuf_3_0_0_wb_clk_i clknet_0_wb_clk_i vssd1 vssd1 vccd1 vccd1 clknet_3_0_0_wb_clk_i
+ sky130_fd_sc_hd__clkbuf_8
XFILLER_0_11_476 vssd1 vssd1 vccd1 vccd1 sky130_fd_sc_hd__decap_4
XFILLER_0_2_197 vssd1 vssd1 vccd1 vccd1 sky130_ef_sc_hd__decap_12
X_08983_ _03425_ _03419_ vssd1 vssd1 vccd1 vccd1 _03426_ sky130_fd_sc_hd__and2b_1
X_07934_ net190 net557 net584 net169 vssd1 vssd1 vccd1 vccd1 _02307_ sky130_fd_sc_hd__a22o_1
XFILLER_0_47_3 vssd1 vssd1 vccd1 vccd1 sky130_fd_sc_hd__decap_4
XFILLER_0_48_93 vssd1 vssd1 vccd1 vccd1 sky130_fd_sc_hd__decap_8
X_07865_ net246 net510 _02076_ _02077_ net695 vssd1 vssd1 vccd1 vccd1 _02239_ sky130_fd_sc_hd__a32o_1
X_09604_ _04102_ _04103_ _04087_ vssd1 vssd1 vccd1 vccd1 _04105_ sky130_fd_sc_hd__o21ai_1
XFILLER_0_78_421 vssd1 vssd1 vccd1 vccd1 sky130_fd_sc_hd__decap_8
X_07796_ net359 net368 net402 net409 vssd1 vssd1 vccd1 vccd1 _02167_ sky130_fd_sc_hd__nand4_1
XFILLER_0_3_95 vssd1 vssd1 vccd1 vccd1 sky130_ef_sc_hd__decap_12
X_06816_ _01186_ _01187_ _01188_ vssd1 vssd1 vccd1 vccd1 _01189_ sky130_fd_sc_hd__nand3_1
X_06747_ _01009_ _01118_ _01119_ vssd1 vssd1 vccd1 vccd1 _01120_ sky130_fd_sc_hd__nand3_1
X_09535_ _04027_ _04028_ vssd1 vssd1 vccd1 vccd1 _04029_ sky130_fd_sc_hd__or2_1
X_09466_ _03938_ _03952_ _03953_ vssd1 vssd1 vccd1 vccd1 _03954_ sky130_fd_sc_hd__or3_1
Xwire74 _00599_ vssd1 vssd1 vccd1 vccd1 net74 sky130_fd_sc_hd__buf_2
X_06678_ _01048_ _01051_ vssd1 vssd1 vccd1 vccd1 _01052_ sky130_fd_sc_hd__xor2_1
XFILLER_0_93_424 vssd1 vssd1 vccd1 vccd1 sky130_fd_sc_hd__fill_2
X_08417_ _02624_ _02631_ _02630_ vssd1 vssd1 vccd1 vccd1 _02807_ sky130_fd_sc_hd__a21o_1
X_05629_ net262 net273 net626 net633 vssd1 vssd1 vccd1 vccd1 _04899_ sky130_fd_sc_hd__and4_1
XFILLER_0_80_107 vssd1 vssd1 vccd1 vccd1 sky130_fd_sc_hd__fill_1
X_09397_ net180 net471 _03875_ _03877_ vssd1 vssd1 vccd1 vccd1 _03878_ sky130_fd_sc_hd__a22o_1
X_08348_ net155 net593 _02729_ _02730_ vssd1 vssd1 vccd1 vccd1 _02732_ sky130_fd_sc_hd__a22o_1
XFILLER_0_80_118 vssd1 vssd1 vccd1 vccd1 sky130_fd_sc_hd__decap_3
XFILLER_0_46_384 vssd1 vssd1 vccd1 vccd1 sky130_fd_sc_hd__decap_3
X_08279_ _02640_ _02654_ _02655_ vssd1 vssd1 vccd1 vccd1 _02657_ sky130_fd_sc_hd__and3_2
Xfanout150 mul.a\[31\] vssd1 vssd1 vccd1 vccd1 net150 sky130_fd_sc_hd__buf_2
Xfanout183 mul.a\[25\] vssd1 vssd1 vccd1 vccd1 net183 sky130_fd_sc_hd__clkbuf_4
Xfanout172 net173 vssd1 vssd1 vccd1 vccd1 net172 sky130_fd_sc_hd__clkbuf_4
Xfanout161 net162 vssd1 vssd1 vccd1 vccd1 net161 sky130_fd_sc_hd__buf_2
Xfanout194 net198 vssd1 vssd1 vccd1 vccd1 net194 sky130_fd_sc_hd__dlymetal6s2s_1
XFILLER_0_69_421 vssd1 vssd1 vccd1 vccd1 sky130_fd_sc_hd__decap_8
XFILLER_0_44_18 vssd1 vssd1 vccd1 vccd1 sky130_fd_sc_hd__decap_8
XFILLER_0_44_29 vssd1 vssd1 vccd1 vccd1 sky130_fd_sc_hd__fill_1
XTAP_1141 vssd1 vccd1 sky130_fd_sc_hd__tapvpwrvgnd_1
XTAP_1130 vssd1 vccd1 sky130_fd_sc_hd__tapvpwrvgnd_1
XFILLER_0_29_318 vssd1 vssd1 vccd1 vccd1 sky130_fd_sc_hd__fill_1
XTAP_1174 vssd1 vccd1 sky130_fd_sc_hd__tapvpwrvgnd_1
XTAP_1152 vssd1 vccd1 sky130_fd_sc_hd__tapvpwrvgnd_1
XTAP_1163 vssd1 vccd1 sky130_fd_sc_hd__tapvpwrvgnd_1
XTAP_1196 vssd1 vccd1 sky130_fd_sc_hd__tapvpwrvgnd_1
XTAP_1185 vssd1 vccd1 sky130_fd_sc_hd__tapvpwrvgnd_1
XFILLER_0_25_502 vssd1 vssd1 vccd1 vccd1 sky130_fd_sc_hd__fill_2
XFILLER_0_52_343 vssd1 vssd1 vccd1 vccd1 sky130_fd_sc_hd__decap_3
XFILLER_0_8_29 vssd1 vssd1 vccd1 vccd1 sky130_fd_sc_hd__decap_6
XFILLER_0_4_418 vssd1 vssd1 vccd1 vccd1 sky130_fd_sc_hd__fill_2
XFILLER_0_25_568 vssd1 vssd1 vccd1 vccd1 sky130_fd_sc_hd__decap_4
XFILLER_0_0_624 vssd1 vssd1 vccd1 vccd1 sky130_fd_sc_hd__fill_1
XTAP_925 vssd1 vccd1 sky130_fd_sc_hd__tapvpwrvgnd_1
XTAP_914 vssd1 vccd1 sky130_fd_sc_hd__tapvpwrvgnd_1
XTAP_903 vssd1 vccd1 sky130_fd_sc_hd__tapvpwrvgnd_1
XTAP_958 vssd1 vccd1 sky130_fd_sc_hd__tapvpwrvgnd_1
XTAP_947 vssd1 vccd1 sky130_fd_sc_hd__tapvpwrvgnd_1
XTAP_936 vssd1 vccd1 sky130_fd_sc_hd__tapvpwrvgnd_1
X_05980_ _00356_ _00357_ _00255_ _00257_ vssd1 vssd1 vccd1 vccd1 _00360_ sky130_fd_sc_hd__o211a_1
XFILLER_0_85_69 vssd1 vssd1 vccd1 vccd1 sky130_fd_sc_hd__fill_2
XTAP_969 vssd1 vccd1 sky130_fd_sc_hd__tapvpwrvgnd_1
XFILLER_0_79_207 vssd1 vssd1 vccd1 vccd1 sky130_fd_sc_hd__decap_8
XFILLER_0_18_74 vssd1 vssd1 vccd1 vccd1 sky130_fd_sc_hd__decap_8
XFILLER_0_18_85 vssd1 vssd1 vccd1 vccd1 sky130_ef_sc_hd__decap_12
X_07650_ _02017_ _02020_ _02021_ vssd1 vssd1 vccd1 vccd1 _02022_ sky130_fd_sc_hd__nand3_1
X_06601_ _00972_ _00973_ vssd1 vssd1 vccd1 vccd1 _00975_ sky130_fd_sc_hd__xor2_1
X_07581_ net510 net143 net129 net275 vssd1 vssd1 vccd1 vccd1 _01954_ sky130_fd_sc_hd__a22o_1
X_09320_ _03791_ _03792_ _03602_ _03604_ vssd1 vssd1 vccd1 vccd1 _03795_ sky130_fd_sc_hd__o211ai_1
XFILLER_0_34_62 vssd1 vssd1 vccd1 vccd1 sky130_ef_sc_hd__decap_12
X_06532_ net346 net469 _00905_ _00906_ vssd1 vssd1 vccd1 vccd1 _00907_ sky130_fd_sc_hd__nand4_1
XFILLER_0_75_424 vssd1 vssd1 vccd1 vccd1 sky130_fd_sc_hd__decap_6
X_09251_ _03712_ _03715_ _03717_ vssd1 vssd1 vccd1 vccd1 _03719_ sky130_fd_sc_hd__nand3_1
X_08202_ _02572_ _02573_ _02411_ _02413_ vssd1 vssd1 vccd1 vccd1 _02575_ sky130_fd_sc_hd__a211oi_2
X_06463_ _00600_ _00838_ _00837_ vssd1 vssd1 vccd1 vccd1 _00839_ sky130_fd_sc_hd__o21ai_1
X_09182_ net268 net411 _03642_ _03643_ vssd1 vssd1 vccd1 vccd1 _03644_ sky130_fd_sc_hd__o2bb2a_1
X_05414_ net362 net551 net576 net335 vssd1 vssd1 vccd1 vccd1 _04684_ sky130_fd_sc_hd__a22o_1
X_06394_ _00766_ _00769_ vssd1 vssd1 vccd1 vccd1 _00770_ sky130_fd_sc_hd__xor2_2
X_08133_ net245 net482 net491 net237 vssd1 vssd1 vccd1 vccd1 _02505_ sky130_fd_sc_hd__a22o_1
XFILLER_0_55_192 vssd1 vssd1 vccd1 vccd1 sky130_fd_sc_hd__fill_1
XFILLER_0_7_289 vssd1 vssd1 vccd1 vccd1 sky130_fd_sc_hd__fill_2
X_05345_ _04613_ _04614_ vssd1 vssd1 vccd1 vccd1 _04615_ sky130_fd_sc_hd__nor2_1
XFILLER_0_28_395 vssd1 vssd1 vccd1 vccd1 sky130_fd_sc_hd__fill_1
XFILLER_0_50_61 vssd1 vssd1 vccd1 vccd1 sky130_fd_sc_hd__decap_4
X_08064_ _02433_ _02434_ _02269_ _02271_ vssd1 vssd1 vccd1 vccd1 _02437_ sky130_fd_sc_hd__o211a_1
XFILLER_0_16_579 vssd1 vssd1 vccd1 vccd1 sky130_fd_sc_hd__decap_3
XFILLER_0_31_516 vssd1 vssd1 vccd1 vccd1 sky130_fd_sc_hd__fill_1
X_05276_ _04536_ _04544_ _04143_ vssd1 vssd1 vccd1 vccd1 _04546_ sky130_fd_sc_hd__o21a_1
X_07015_ _01267_ _01384_ _01385_ vssd1 vssd1 vccd1 vccd1 _01386_ sky130_fd_sc_hd__or3_1
X_08966_ net174 net506 net516 net171 vssd1 vssd1 vccd1 vccd1 _03407_ sky130_fd_sc_hd__a22o_1
X_08897_ _03132_ _03134_ _03330_ _03331_ vssd1 vssd1 vccd1 vccd1 _03332_ sky130_fd_sc_hd__a211o_1
X_07917_ net154 net159 net600 net610 vssd1 vssd1 vccd1 vccd1 _02290_ sky130_fd_sc_hd__and4_1
XFILLER_0_98_516 vssd1 vssd1 vccd1 vccd1 sky130_ef_sc_hd__decap_12
X_07848_ net204 net212 net538 net548 vssd1 vssd1 vccd1 vccd1 _02220_ sky130_fd_sc_hd__nand4_1
XFILLER_0_78_251 vssd1 vssd1 vccd1 vccd1 sky130_fd_sc_hd__fill_1
XFILLER_0_66_402 vssd1 vssd1 vccd1 vccd1 sky130_fd_sc_hd__decap_4
X_07779_ _02136_ _02149_ vssd1 vssd1 vccd1 vccd1 _02150_ sky130_fd_sc_hd__xor2_1
X_09518_ _03864_ _04009_ vssd1 vssd1 vccd1 vccd1 _04010_ sky130_fd_sc_hd__nand2_2
XPHY_202 vssd1 vssd1 vccd1 vccd1 sky130_fd_sc_hd__decap_3
XFILLER_0_93_221 vssd1 vssd1 vccd1 vccd1 sky130_fd_sc_hd__decap_3
XFILLER_0_66_446 vssd1 vssd1 vccd1 vccd1 sky130_fd_sc_hd__decap_3
XFILLER_0_38_115 vssd1 vssd1 vccd1 vccd1 sky130_fd_sc_hd__decap_4
X_09449_ _03925_ _03934_ vssd1 vssd1 vccd1 vccd1 _03936_ sky130_fd_sc_hd__nor2_1
XFILLER_0_81_449 vssd1 vssd1 vccd1 vccd1 sky130_ef_sc_hd__decap_12
XFILLER_0_46_181 vssd1 vssd1 vccd1 vccd1 sky130_fd_sc_hd__fill_2
XFILLER_0_34_365 vssd1 vssd1 vccd1 vccd1 sky130_ef_sc_hd__decap_12
XFILLER_0_55_17 vssd1 vssd1 vccd1 vccd1 sky130_fd_sc_hd__decap_4
XFILLER_0_89_505 vssd1 vssd1 vccd1 vccd1 sky130_fd_sc_hd__decap_4
X_10086_ clknet_3_6_0_wb_clk_i _00082_ _00018_ vssd1 vssd1 vccd1 vccd1 mul.b\[15\]
+ sky130_fd_sc_hd__dfrtp_1
XFILLER_0_71_16 vssd1 vssd1 vccd1 vccd1 sky130_fd_sc_hd__decap_8
XFILLER_0_29_104 vssd1 vssd1 vccd1 vccd1 sky130_fd_sc_hd__decap_8
XFILLER_0_29_126 vssd1 vssd1 vccd1 vccd1 sky130_ef_sc_hd__decap_12
XFILLER_0_72_405 vssd1 vssd1 vccd1 vccd1 sky130_ef_sc_hd__decap_12
XFILLER_0_52_162 vssd1 vssd1 vccd1 vccd1 sky130_fd_sc_hd__decap_6
X_05130_ _02875_ _02951_ _02940_ vssd1 vssd1 vccd1 vccd1 _02973_ sky130_fd_sc_hd__a21boi_2
XFILLER_0_4_226 vssd1 vssd1 vccd1 vccd1 sky130_fd_sc_hd__decap_8
XFILLER_0_13_505 vssd1 vssd1 vccd1 vccd1 sky130_fd_sc_hd__fill_1
Xmax_cap114 _01618_ vssd1 vssd1 vccd1 vccd1 net114 sky130_fd_sc_hd__clkbuf_1
XFILLER_0_52_195 vssd1 vssd1 vccd1 vccd1 sky130_fd_sc_hd__fill_1
XFILLER_0_20_75 vssd1 vssd1 vccd1 vccd1 sky130_fd_sc_hd__decap_3
XFILLER_0_40_324 vssd1 vssd1 vccd1 vccd1 sky130_fd_sc_hd__decap_4
X_05061_ net28 net398 net126 vssd1 vssd1 vccd1 vccd1 _00097_ sky130_fd_sc_hd__mux2_1
XFILLER_0_0_410 vssd1 vssd1 vccd1 vccd1 sky130_fd_sc_hd__decap_8
XTAP_700 vssd1 vccd1 sky130_fd_sc_hd__tapvpwrvgnd_1
X_08820_ net157 net161 net536 net544 vssd1 vssd1 vccd1 vccd1 _03248_ sky130_fd_sc_hd__nand4_1
XFILLER_0_0_465 vssd1 vssd1 vccd1 vccd1 sky130_fd_sc_hd__decap_8
XFILLER_0_29_51 vssd1 vssd1 vccd1 vccd1 sky130_fd_sc_hd__decap_4
XFILLER_0_29_62 vssd1 vssd1 vccd1 vccd1 sky130_fd_sc_hd__fill_2
XTAP_711 vssd1 vccd1 sky130_fd_sc_hd__tapvpwrvgnd_1
XTAP_722 vssd1 vccd1 sky130_fd_sc_hd__tapvpwrvgnd_1
XTAP_733 vssd1 vccd1 sky130_fd_sc_hd__tapvpwrvgnd_1
XTAP_777 vssd1 vccd1 sky130_fd_sc_hd__tapvpwrvgnd_1
XTAP_744 vssd1 vccd1 sky130_fd_sc_hd__tapvpwrvgnd_1
XTAP_755 vssd1 vccd1 sky130_fd_sc_hd__tapvpwrvgnd_1
XTAP_766 vssd1 vccd1 sky130_fd_sc_hd__tapvpwrvgnd_1
X_08751_ _03171_ _03172_ vssd1 vssd1 vccd1 vccd1 _03173_ sky130_fd_sc_hd__nand2_1
XTAP_799 vssd1 vccd1 sky130_fd_sc_hd__tapvpwrvgnd_1
XTAP_788 vssd1 vccd1 sky130_fd_sc_hd__tapvpwrvgnd_1
X_05963_ _00340_ _00341_ _00339_ vssd1 vssd1 vccd1 vccd1 _00343_ sky130_fd_sc_hd__a21o_1
X_07702_ _02069_ _02071_ _02072_ vssd1 vssd1 vccd1 vccd1 _02074_ sky130_fd_sc_hd__a21o_1
X_08682_ net174 net525 _03094_ _03096_ vssd1 vssd1 vccd1 vccd1 _03097_ sky130_fd_sc_hd__a22o_1
X_05894_ _00271_ _00273_ _00168_ _00170_ vssd1 vssd1 vccd1 vccd1 _00275_ sky130_fd_sc_hd__o211a_1
X_07633_ net368 net409 net414 net359 vssd1 vssd1 vccd1 vccd1 _02005_ sky130_fd_sc_hd__a22o_1
X_07564_ _01835_ _01836_ _01932_ _01934_ vssd1 vssd1 vccd1 vccd1 _01937_ sky130_fd_sc_hd__a22o_1
XFILLER_0_0_41 vssd1 vssd1 vccd1 vccd1 sky130_ef_sc_hd__decap_12
XFILLER_0_48_413 vssd1 vssd1 vccd1 vccd1 sky130_fd_sc_hd__decap_6
X_09303_ net276 net399 net405 net267 vssd1 vssd1 vccd1 vccd1 _03776_ sky130_fd_sc_hd__a22o_1
X_07495_ _01731_ _01733_ _01864_ _01865_ vssd1 vssd1 vccd1 vccd1 _01866_ sky130_fd_sc_hd__o211a_2
XFILLER_0_8_521 vssd1 vssd1 vccd1 vccd1 sky130_fd_sc_hd__decap_3
XFILLER_0_0_63 vssd1 vssd1 vccd1 vccd1 sky130_fd_sc_hd__fill_1
X_06515_ net373 net447 vssd1 vssd1 vccd1 vccd1 _00890_ sky130_fd_sc_hd__and2_1
X_09234_ _03700_ _03699_ vssd1 vssd1 vccd1 vccd1 _03701_ sky130_fd_sc_hd__nand2b_1
XFILLER_0_63_427 vssd1 vssd1 vccd1 vccd1 sky130_ef_sc_hd__decap_12
XFILLER_0_61_93 vssd1 vssd1 vccd1 vccd1 sky130_ef_sc_hd__decap_12
X_06446_ _00755_ _00757_ _00820_ _00821_ vssd1 vssd1 vccd1 vccd1 _00822_ sky130_fd_sc_hd__or4bb_4
XFILLER_0_35_107 vssd1 vssd1 vccd1 vccd1 sky130_fd_sc_hd__decap_4
X_09165_ _03599_ _03600_ _03621_ _03622_ vssd1 vssd1 vccd1 vccd1 _03625_ sky130_fd_sc_hd__a22oi_4
XFILLER_0_63_449 vssd1 vssd1 vccd1 vccd1 sky130_fd_sc_hd__decap_4
XFILLER_0_8_587 vssd1 vssd1 vccd1 vccd1 sky130_fd_sc_hd__fill_1
X_08116_ net201 net528 _02485_ _02487_ vssd1 vssd1 vccd1 vccd1 _02488_ sky130_fd_sc_hd__a22o_1
XFILLER_0_16_365 vssd1 vssd1 vccd1 vccd1 sky130_fd_sc_hd__decap_4
X_06377_ _00646_ _00752_ vssd1 vssd1 vccd1 vccd1 _00753_ sky130_fd_sc_hd__or2_1
X_09096_ _03548_ _03549_ vssd1 vssd1 vccd1 vccd1 _03550_ sky130_fd_sc_hd__nor2_1
XFILLER_0_16_398 vssd1 vssd1 vccd1 vccd1 sky130_fd_sc_hd__decap_6
X_05328_ net343 net352 net624 net632 vssd1 vssd1 vccd1 vccd1 _04598_ sky130_fd_sc_hd__and4_1
X_08047_ _02361_ _02362_ _02418_ _02419_ vssd1 vssd1 vccd1 vccd1 _02420_ sky130_fd_sc_hd__nor4_2
X_05259_ net370 net551 net576 net345 vssd1 vssd1 vccd1 vccd1 _04383_ sky130_fd_sc_hd__a22o_1
XFILLER_0_3_270 vssd1 vssd1 vccd1 vccd1 sky130_fd_sc_hd__fill_2
X_09998_ net122 _04435_ net118 vssd1 vssd1 vccd1 vccd1 _04535_ sky130_fd_sc_hd__a21bo_1
X_08949_ net120 _03387_ vssd1 vssd1 vccd1 vccd1 _03390_ sky130_fd_sc_hd__xnor2_1
XFILLER_0_98_335 vssd1 vssd1 vccd1 vccd1 sky130_fd_sc_hd__decap_8
XFILLER_0_66_243 vssd1 vssd1 vccd1 vccd1 sky130_fd_sc_hd__fill_1
XFILLER_0_39_446 vssd1 vssd1 vccd1 vccd1 sky130_fd_sc_hd__fill_2
XFILLER_0_26_118 vssd1 vssd1 vccd1 vccd1 sky130_fd_sc_hd__decap_3
XFILLER_0_50_611 vssd1 vssd1 vccd1 vccd1 sky130_fd_sc_hd__fill_1
XFILLER_0_62_471 vssd1 vssd1 vccd1 vccd1 sky130_fd_sc_hd__decap_4
XFILLER_0_1_207 vssd1 vssd1 vccd1 vccd1 sky130_fd_sc_hd__fill_1
XFILLER_0_34_195 vssd1 vssd1 vccd1 vccd1 sky130_fd_sc_hd__fill_1
XFILLER_0_22_346 vssd1 vssd1 vccd1 vccd1 sky130_fd_sc_hd__decap_8
X_10069_ net643 vssd1 vssd1 vccd1 vccd1 _00065_ sky130_fd_sc_hd__inv_2
XFILLER_0_89_335 vssd1 vssd1 vccd1 vccd1 sky130_fd_sc_hd__fill_1
XFILLER_0_82_48 vssd1 vssd1 vccd1 vccd1 sky130_ef_sc_hd__decap_12
XFILLER_0_82_26 vssd1 vssd1 vccd1 vccd1 sky130_fd_sc_hd__fill_2
XFILLER_0_77_519 vssd1 vssd1 vccd1 vccd1 sky130_fd_sc_hd__decap_3
XFILLER_0_97_390 vssd1 vssd1 vccd1 vccd1 sky130_fd_sc_hd__fill_2
XFILLER_0_57_254 vssd1 vssd1 vccd1 vccd1 sky130_fd_sc_hd__decap_3
XFILLER_0_85_596 vssd1 vssd1 vccd1 vccd1 sky130_fd_sc_hd__fill_2
X_06300_ _00674_ _00675_ _00676_ vssd1 vssd1 vccd1 vccd1 _00677_ sky130_fd_sc_hd__nand3_1
X_07280_ net529 net143 net129 net289 _01649_ vssd1 vssd1 vccd1 vccd1 net43 sky130_fd_sc_hd__a221o_1
XFILLER_0_45_405 vssd1 vssd1 vccd1 vccd1 sky130_fd_sc_hd__fill_2
XFILLER_0_5_513 vssd1 vssd1 vccd1 vccd1 sky130_fd_sc_hd__fill_1
X_06231_ _00606_ _00607_ vssd1 vssd1 vccd1 vccd1 _00608_ sky130_fd_sc_hd__xnor2_1
XFILLER_0_45_449 vssd1 vssd1 vccd1 vccd1 sky130_fd_sc_hd__fill_1
XFILLER_0_60_419 vssd1 vssd1 vccd1 vccd1 sky130_fd_sc_hd__fill_1
XFILLER_0_53_482 vssd1 vssd1 vccd1 vccd1 sky130_fd_sc_hd__decap_8
XFILLER_0_13_313 vssd1 vssd1 vccd1 vccd1 sky130_fd_sc_hd__decap_4
X_06162_ _00436_ _00437_ _00438_ vssd1 vssd1 vccd1 vccd1 _00540_ sky130_fd_sc_hd__o21ba_1
XFILLER_0_25_162 vssd1 vssd1 vccd1 vccd1 sky130_fd_sc_hd__decap_6
X_05113_ _02755_ _02766_ _02634_ vssd1 vssd1 vccd1 vccd1 _02787_ sky130_fd_sc_hd__a21o_1
X_06093_ _00468_ _00469_ _00321_ vssd1 vssd1 vccd1 vccd1 _00472_ sky130_fd_sc_hd__a21oi_2
X_09921_ _04446_ _04450_ vssd1 vssd1 vccd1 vccd1 _04451_ sky130_fd_sc_hd__xnor2_1
X_05044_ net8 net289 net132 vssd1 vssd1 vccd1 vccd1 _00111_ sky130_fd_sc_hd__mux2_1
XTAP_530 vssd1 vccd1 sky130_fd_sc_hd__tapvpwrvgnd_1
XTAP_541 vssd1 vccd1 sky130_fd_sc_hd__tapvpwrvgnd_1
XTAP_552 vssd1 vccd1 sky130_fd_sc_hd__tapvpwrvgnd_1
X_09852_ _04244_ _04247_ vssd1 vssd1 vccd1 vccd1 _04376_ sky130_fd_sc_hd__or2_1
X_09783_ net122 _04299_ vssd1 vssd1 vccd1 vccd1 _04301_ sky130_fd_sc_hd__xor2_1
X_08803_ _03227_ _03228_ _03043_ _03071_ vssd1 vssd1 vccd1 vccd1 _03230_ sky130_fd_sc_hd__a211oi_1
XTAP_563 vssd1 vccd1 sky130_fd_sc_hd__tapvpwrvgnd_1
XTAP_574 vssd1 vccd1 sky130_fd_sc_hd__tapvpwrvgnd_1
XTAP_585 vssd1 vccd1 sky130_fd_sc_hd__tapvpwrvgnd_1
X_08734_ _03129_ _03130_ _03151_ _03152_ vssd1 vssd1 vccd1 vccd1 _03154_ sky130_fd_sc_hd__nand4_2
XTAP_596 vssd1 vccd1 sky130_fd_sc_hd__tapvpwrvgnd_1
X_06995_ net195 net602 net612 net188 vssd1 vssd1 vccd1 vccd1 _01366_ sky130_fd_sc_hd__a22o_1
X_05946_ net388 net470 vssd1 vssd1 vccd1 vccd1 _00326_ sky130_fd_sc_hd__nand2_1
X_08665_ _03075_ _03076_ _03077_ vssd1 vssd1 vccd1 vccd1 _03079_ sky130_fd_sc_hd__or3_1
X_05877_ _00255_ _00256_ _00132_ vssd1 vssd1 vccd1 vccd1 _00258_ sky130_fd_sc_hd__a21o_1
X_08596_ net158 net566 _03001_ vssd1 vssd1 vccd1 vccd1 _03003_ sky130_fd_sc_hd__and3_1
XFILLER_0_95_327 vssd1 vssd1 vccd1 vccd1 sky130_fd_sc_hd__fill_1
X_07616_ _01985_ _01986_ _01977_ vssd1 vssd1 vccd1 vccd1 _01988_ sky130_fd_sc_hd__o21ai_1
X_07547_ _01900_ _01918_ _01919_ vssd1 vssd1 vccd1 vccd1 _01920_ sky130_fd_sc_hd__nor3_1
X_07478_ _01846_ _01847_ vssd1 vssd1 vccd1 vccd1 _01848_ sky130_fd_sc_hd__and2b_1
X_09217_ _03680_ _03681_ vssd1 vssd1 vccd1 vccd1 _03682_ sky130_fd_sc_hd__or2_1
XFILLER_0_91_566 vssd1 vssd1 vccd1 vccd1 sky130_fd_sc_hd__decap_4
X_06429_ _00802_ _00803_ _00795_ vssd1 vssd1 vccd1 vccd1 _00805_ sky130_fd_sc_hd__a21o_1
XFILLER_0_44_460 vssd1 vssd1 vccd1 vccd1 sky130_fd_sc_hd__decap_6
X_09148_ net208 net458 net465 net200 vssd1 vssd1 vccd1 vccd1 _03606_ sky130_fd_sc_hd__a22oi_1
X_09079_ _03505_ _03529_ vssd1 vssd1 vccd1 vccd1 _03532_ sky130_fd_sc_hd__xnor2_1
XFILLER_0_98_121 vssd1 vssd1 vccd1 vccd1 sky130_fd_sc_hd__decap_8
XFILLER_0_86_349 vssd1 vssd1 vccd1 vccd1 sky130_fd_sc_hd__fill_1
XFILLER_0_86_316 vssd1 vssd1 vccd1 vccd1 sky130_fd_sc_hd__fill_2
XFILLER_0_82_533 vssd1 vssd1 vccd1 vccd1 sky130_fd_sc_hd__decap_4
XFILLER_0_54_257 vssd1 vssd1 vccd1 vccd1 sky130_fd_sc_hd__fill_1
XFILLER_0_22_110 vssd1 vssd1 vccd1 vccd1 sky130_fd_sc_hd__fill_1
XFILLER_0_50_441 vssd1 vssd1 vccd1 vccd1 sky130_fd_sc_hd__fill_1
XFILLER_0_2_527 vssd1 vssd1 vccd1 vccd1 sky130_fd_sc_hd__decap_4
X_05800_ net2 _01849_ vssd1 vssd1 vccd1 vccd1 _00182_ sky130_fd_sc_hd__or2_4
X_06780_ net382 net429 vssd1 vssd1 vccd1 vccd1 _01153_ sky130_fd_sc_hd__nand2_1
X_05731_ net263 net625 net633 net252 vssd1 vssd1 vccd1 vccd1 _05001_ sky130_fd_sc_hd__a22oi_1
X_08450_ net341 net398 _02840_ _02841_ vssd1 vssd1 vccd1 vccd1 _02844_ sky130_fd_sc_hd__nand4_1
X_05662_ _04873_ _04875_ _04930_ vssd1 vssd1 vccd1 vccd1 _04932_ sky130_fd_sc_hd__and3_1
X_08381_ net467 net144 net130 net229 vssd1 vssd1 vccd1 vccd1 _02769_ sky130_fd_sc_hd__a22o_1
X_07401_ _01733_ _01734_ _01767_ _01768_ vssd1 vssd1 vccd1 vccd1 _01770_ sky130_fd_sc_hd__a2bb2o_1
X_07332_ net375 net413 _01698_ _01699_ vssd1 vssd1 vccd1 vccd1 _01701_ sky130_fd_sc_hd__and4_1
X_05593_ net322 net351 net553 net580 vssd1 vssd1 vccd1 vccd1 _04863_ sky130_fd_sc_hd__nand4_2
XFILLER_0_85_393 vssd1 vssd1 vccd1 vccd1 sky130_fd_sc_hd__decap_4
X_07263_ _01541_ _01631_ _01632_ vssd1 vssd1 vccd1 vccd1 _01633_ sky130_fd_sc_hd__nor3_4
X_09002_ _03289_ _03292_ vssd1 vssd1 vccd1 vccd1 _03447_ sky130_fd_sc_hd__or2_2
XFILLER_0_5_365 vssd1 vssd1 vccd1 vccd1 sky130_fd_sc_hd__decap_8
XFILLER_0_5_332 vssd1 vssd1 vccd1 vccd1 sky130_fd_sc_hd__decap_4
X_06214_ _00486_ _00590_ _00591_ vssd1 vssd1 vccd1 vccd1 _00592_ sky130_fd_sc_hd__nor3_2
X_07194_ _01546_ _01547_ _01563_ vssd1 vssd1 vccd1 vccd1 _01564_ sky130_fd_sc_hd__or3_1
X_06145_ _00502_ _00521_ vssd1 vssd1 vccd1 vccd1 _00523_ sky130_fd_sc_hd__nand2_1
XFILLER_0_77_3 vssd1 vssd1 vccd1 vccd1 sky130_fd_sc_hd__decap_4
XFILLER_0_13_154 vssd1 vssd1 vccd1 vccd1 sky130_fd_sc_hd__fill_2
XFILLER_0_6_40 vssd1 vssd1 vccd1 vccd1 sky130_fd_sc_hd__fill_1
XFILLER_0_13_187 vssd1 vssd1 vccd1 vccd1 sky130_fd_sc_hd__decap_3
XFILLER_0_13_198 vssd1 vssd1 vccd1 vccd1 sky130_fd_sc_hd__fill_2
X_06076_ _00452_ _00453_ _00435_ vssd1 vssd1 vccd1 vccd1 _00455_ sky130_fd_sc_hd__a21o_1
X_09904_ _04291_ _04292_ _04295_ vssd1 vssd1 vccd1 vccd1 _04433_ sky130_fd_sc_hd__o21ba_1
X_05027_ net26 net160 net135 vssd1 vssd1 vccd1 vccd1 _00128_ sky130_fd_sc_hd__mux2_1
Xfanout524 net526 vssd1 vssd1 vccd1 vccd1 net524 sky130_fd_sc_hd__buf_2
Xfanout513 net520 vssd1 vssd1 vccd1 vccd1 net513 sky130_fd_sc_hd__clkbuf_4
Xfanout502 mul.b\[15\] vssd1 vssd1 vccd1 vccd1 net502 sky130_fd_sc_hd__buf_4
Xfanout557 net558 vssd1 vssd1 vccd1 vccd1 net557 sky130_fd_sc_hd__buf_4
XFILLER_0_67_81 vssd1 vssd1 vccd1 vccd1 sky130_fd_sc_hd__fill_1
Xfanout535 net536 vssd1 vssd1 vccd1 vccd1 net535 sky130_fd_sc_hd__buf_6
X_09835_ _04193_ _04216_ _04191_ vssd1 vssd1 vccd1 vccd1 _04357_ sky130_fd_sc_hd__o21a_1
XTAP_360 vssd1 vccd1 sky130_fd_sc_hd__tapvpwrvgnd_1
Xfanout546 net550 vssd1 vssd1 vccd1 vccd1 net546 sky130_fd_sc_hd__buf_4
Xfanout568 net569 vssd1 vssd1 vccd1 vccd1 net568 sky130_fd_sc_hd__clkbuf_4
XTAP_371 vssd1 vccd1 sky130_fd_sc_hd__tapvpwrvgnd_1
XTAP_382 vssd1 vccd1 sky130_fd_sc_hd__tapvpwrvgnd_1
XTAP_393 vssd1 vccd1 sky130_fd_sc_hd__tapvpwrvgnd_1
Xfanout579 mul.b\[6\] vssd1 vssd1 vccd1 vccd1 net579 sky130_fd_sc_hd__buf_4
X_09766_ _04124_ _04128_ _04280_ vssd1 vssd1 vccd1 vccd1 _04282_ sky130_fd_sc_hd__nand3_1
X_06978_ net687 _01212_ _01348_ _01349_ vssd1 vssd1 vccd1 vccd1 _01350_ sky130_fd_sc_hd__o211a_1
X_08717_ _03133_ _03134_ vssd1 vssd1 vccd1 vccd1 _03135_ sky130_fd_sc_hd__nand2_1
X_05929_ net243 net625 net633 net235 vssd1 vssd1 vccd1 vccd1 _00309_ sky130_fd_sc_hd__a22oi_1
X_09697_ _04050_ _04053_ vssd1 vssd1 vccd1 vccd1 _04206_ sky130_fd_sc_hd__or2_1
X_08648_ _03048_ _03058_ vssd1 vssd1 vccd1 vccd1 _03060_ sky130_fd_sc_hd__xnor2_1
XFILLER_0_95_113 vssd1 vssd1 vccd1 vccd1 sky130_fd_sc_hd__fill_1
Xrebuffer51 mul.a\[28\] vssd1 vssd1 vccd1 vccd1 net696 sky130_fd_sc_hd__buf_1
Xrebuffer40 _01769_ vssd1 vssd1 vccd1 vccd1 net685 sky130_fd_sc_hd__buf_6
XPHY_22 vssd1 vssd1 vccd1 vccd1 sky130_fd_sc_hd__decap_3
Xrebuffer62 mul.a\[2\] vssd1 vssd1 vccd1 vccd1 net707 sky130_fd_sc_hd__clkbuf_2
XPHY_11 vssd1 vssd1 vccd1 vccd1 sky130_fd_sc_hd__decap_3
XPHY_33 vssd1 vssd1 vccd1 vccd1 sky130_fd_sc_hd__decap_3
XPHY_44 vssd1 vssd1 vccd1 vccd1 sky130_fd_sc_hd__decap_3
XPHY_55 vssd1 vssd1 vccd1 vccd1 sky130_fd_sc_hd__decap_3
XFILLER_0_49_530 vssd1 vssd1 vccd1 vccd1 sky130_fd_sc_hd__decap_8
X_08579_ net250 net450 _02981_ _02982_ vssd1 vssd1 vccd1 vccd1 _02985_ sky130_fd_sc_hd__and4_2
XPHY_66 vssd1 vssd1 vccd1 vccd1 sky130_fd_sc_hd__decap_3
XPHY_77 vssd1 vssd1 vccd1 vccd1 sky130_fd_sc_hd__decap_3
XPHY_88 vssd1 vssd1 vccd1 vccd1 sky130_fd_sc_hd__decap_3
XFILLER_0_76_393 vssd1 vssd1 vccd1 vccd1 sky130_fd_sc_hd__decap_8
XPHY_99 vssd1 vssd1 vccd1 vccd1 sky130_fd_sc_hd__decap_3
XFILLER_0_8_192 vssd1 vssd1 vccd1 vccd1 sky130_fd_sc_hd__decap_4
XFILLER_0_32_441 vssd1 vssd1 vccd1 vccd1 sky130_fd_sc_hd__fill_1
XFILLER_0_32_452 vssd1 vssd1 vccd1 vccd1 sky130_fd_sc_hd__fill_2
XFILLER_0_99_463 vssd1 vssd1 vccd1 vccd1 sky130_ef_sc_hd__decap_12
XFILLER_0_86_102 vssd1 vssd1 vccd1 vccd1 sky130_fd_sc_hd__decap_6
XFILLER_0_59_305 vssd1 vssd1 vccd1 vccd1 sky130_fd_sc_hd__decap_4
XFILLER_0_86_124 vssd1 vssd1 vccd1 vccd1 sky130_fd_sc_hd__decap_4
XFILLER_0_86_168 vssd1 vssd1 vccd1 vccd1 sky130_fd_sc_hd__fill_2
XFILLER_0_67_360 vssd1 vssd1 vccd1 vccd1 sky130_fd_sc_hd__fill_2
XFILLER_0_27_257 vssd1 vssd1 vccd1 vccd1 sky130_fd_sc_hd__decap_6
XFILLER_0_27_279 vssd1 vssd1 vccd1 vccd1 sky130_fd_sc_hd__fill_1
XFILLER_0_70_558 vssd1 vssd1 vccd1 vccd1 sky130_fd_sc_hd__decap_8
XFILLER_0_2_335 vssd1 vssd1 vccd1 vccd1 sky130_fd_sc_hd__fill_1
X_07950_ _02288_ _02322_ vssd1 vssd1 vccd1 vccd1 _02323_ sky130_fd_sc_hd__and2_1
X_06901_ _01269_ _01272_ vssd1 vssd1 vccd1 vccd1 _01273_ sky130_fd_sc_hd__nand2_1
X_07881_ _02251_ _02252_ _02217_ vssd1 vssd1 vccd1 vccd1 _02255_ sky130_fd_sc_hd__a21o_1
X_09620_ _03669_ _04122_ vssd1 vssd1 vccd1 vccd1 _04123_ sky130_fd_sc_hd__xnor2_1
X_06832_ _01202_ _01203_ _01147_ vssd1 vssd1 vccd1 vccd1 _01205_ sky130_fd_sc_hd__o21a_1
XFILLER_0_37_62 vssd1 vssd1 vccd1 vccd1 sky130_fd_sc_hd__decap_4
X_06763_ _01016_ _01035_ _01033_ vssd1 vssd1 vccd1 vccd1 _01136_ sky130_fd_sc_hd__a21oi_1
X_09551_ net217 net428 _04043_ _04045_ vssd1 vssd1 vccd1 vccd1 _04047_ sky130_fd_sc_hd__nand4_1
XFILLER_0_77_113 vssd1 vssd1 vccd1 vccd1 sky130_fd_sc_hd__decap_8
X_08502_ _02117_ _02900_ vssd1 vssd1 vccd1 vccd1 _02901_ sky130_fd_sc_hd__nor2_1
X_05714_ _04916_ _04917_ vssd1 vssd1 vccd1 vccd1 _04984_ sky130_fd_sc_hd__nand2_1
X_09482_ net123 _03970_ vssd1 vssd1 vccd1 vccd1 _03972_ sky130_fd_sc_hd__and2b_1
X_06694_ _01064_ _01065_ _01047_ vssd1 vssd1 vccd1 vccd1 _01068_ sky130_fd_sc_hd__a21oi_2
X_08433_ _02652_ _02654_ _02823_ _02824_ vssd1 vssd1 vccd1 vccd1 _02825_ sky130_fd_sc_hd__a211oi_2
X_05645_ net339 net553 net580 net312 vssd1 vssd1 vccd1 vccd1 _04915_ sky130_fd_sc_hd__a22o_1
X_08364_ _02709_ _02710_ _02749_ vssd1 vssd1 vccd1 vccd1 _02750_ sky130_fd_sc_hd__nor3_1
X_05576_ net288 net621 vssd1 vssd1 vccd1 vccd1 _04846_ sky130_fd_sc_hd__nand2_1
XFILLER_0_46_533 vssd1 vssd1 vccd1 vccd1 sky130_fd_sc_hd__decap_6
XFILLER_0_73_341 vssd1 vssd1 vccd1 vccd1 sky130_ef_sc_hd__decap_12
XFILLER_0_18_268 vssd1 vssd1 vccd1 vccd1 sky130_fd_sc_hd__decap_4
X_07315_ _01531_ _01682_ vssd1 vssd1 vccd1 vccd1 _01684_ sky130_fd_sc_hd__xnor2_1
XFILLER_0_46_577 vssd1 vssd1 vccd1 vccd1 sky130_fd_sc_hd__decap_4
X_08295_ net341 net403 net410 net333 vssd1 vssd1 vccd1 vccd1 _02674_ sky130_fd_sc_hd__a22o_1
XFILLER_0_33_216 vssd1 vssd1 vccd1 vccd1 sky130_fd_sc_hd__fill_2
X_07246_ _01613_ _01614_ _01615_ vssd1 vssd1 vccd1 vccd1 _01616_ sky130_fd_sc_hd__and3_2
X_07177_ net391 net410 _01544_ _01545_ vssd1 vssd1 vccd1 vccd1 _01547_ sky130_fd_sc_hd__a22oi_1
X_06128_ net236 net617 vssd1 vssd1 vccd1 vccd1 _00506_ sky130_fd_sc_hd__nand2_1
XFILLER_0_41_293 vssd1 vssd1 vccd1 vccd1 sky130_fd_sc_hd__fill_2
X_06059_ net336 net345 net503 net511 vssd1 vssd1 vccd1 vccd1 _00438_ sky130_fd_sc_hd__and4_1
Xfanout332 net334 vssd1 vssd1 vccd1 vccd1 net332 sky130_fd_sc_hd__clkbuf_4
Xfanout310 net311 vssd1 vssd1 vccd1 vccd1 net310 sky130_fd_sc_hd__clkbuf_4
Xfanout321 net322 vssd1 vssd1 vccd1 vccd1 net321 sky130_fd_sc_hd__clkbuf_4
Xfanout354 net355 vssd1 vssd1 vccd1 vccd1 net354 sky130_fd_sc_hd__clkbuf_2
Xfanout343 net344 vssd1 vssd1 vccd1 vccd1 net343 sky130_fd_sc_hd__buf_4
Xfanout365 net366 vssd1 vssd1 vccd1 vccd1 net365 sky130_fd_sc_hd__buf_4
Xfanout398 mul.b\[30\] vssd1 vssd1 vccd1 vccd1 net398 sky130_fd_sc_hd__clkbuf_4
Xfanout376 mul.a\[2\] vssd1 vssd1 vccd1 vccd1 net376 sky130_fd_sc_hd__buf_6
Xfanout387 net389 vssd1 vssd1 vccd1 vccd1 net387 sky130_fd_sc_hd__clkbuf_4
X_09818_ net199 net428 vssd1 vssd1 vccd1 vccd1 _04338_ sky130_fd_sc_hd__nand2_1
X_09749_ _04261_ _04262_ vssd1 vssd1 vccd1 vccd1 _04264_ sky130_fd_sc_hd__or2_1
XTAP_1312 vssd1 vccd1 sky130_fd_sc_hd__tapvpwrvgnd_1
XTAP_1323 vssd1 vccd1 sky130_fd_sc_hd__tapvpwrvgnd_1
XTAP_1301 vssd1 vccd1 sky130_fd_sc_hd__tapvpwrvgnd_1
XTAP_1345 vssd1 vccd1 sky130_fd_sc_hd__tapvpwrvgnd_1
XTAP_1334 vssd1 vccd1 sky130_fd_sc_hd__tapvpwrvgnd_1
XFILLER_0_37_500 vssd1 vssd1 vccd1 vccd1 sky130_fd_sc_hd__decap_4
XFILLER_0_37_511 vssd1 vssd1 vccd1 vccd1 sky130_fd_sc_hd__fill_1
XFILLER_0_49_382 vssd1 vssd1 vccd1 vccd1 sky130_fd_sc_hd__fill_1
Xinput18 wbs_dat_i[21] vssd1 vssd1 vccd1 vccd1 net18 sky130_fd_sc_hd__clkbuf_1
XFILLER_0_64_374 vssd1 vssd1 vccd1 vccd1 sky130_fd_sc_hd__decap_4
Xinput29 wbs_dat_i[31] vssd1 vssd1 vccd1 vccd1 net29 sky130_fd_sc_hd__clkbuf_1
XFILLER_0_20_411 vssd1 vssd1 vccd1 vccd1 sky130_fd_sc_hd__fill_1
XFILLER_0_74_16 vssd1 vssd1 vccd1 vccd1 sky130_fd_sc_hd__fill_1
XFILLER_0_99_271 vssd1 vssd1 vccd1 vccd1 sky130_fd_sc_hd__decap_8
XFILLER_0_87_422 vssd1 vssd1 vccd1 vccd1 sky130_fd_sc_hd__decap_3
XFILLER_0_59_102 vssd1 vssd1 vccd1 vccd1 sky130_fd_sc_hd__decap_8
XFILLER_0_87_488 vssd1 vssd1 vccd1 vccd1 sky130_fd_sc_hd__decap_8
XFILLER_0_75_617 vssd1 vssd1 vccd1 vccd1 sky130_fd_sc_hd__fill_2
X_05430_ net301 net614 vssd1 vssd1 vccd1 vccd1 _04700_ sky130_fd_sc_hd__and2_1
X_05361_ _04629_ _04630_ vssd1 vssd1 vccd1 vccd1 _04631_ sky130_fd_sc_hd__and2_1
XFILLER_0_99_46 vssd1 vssd1 vccd1 vccd1 sky130_fd_sc_hd__decap_8
XFILLER_0_43_525 vssd1 vssd1 vccd1 vccd1 sky130_fd_sc_hd__fill_2
X_07100_ _01468_ _01469_ _01328_ _01330_ vssd1 vssd1 vccd1 vccd1 _01471_ sky130_fd_sc_hd__a211o_1
XFILLER_0_99_57 vssd1 vssd1 vccd1 vccd1 sky130_fd_sc_hd__decap_4
XFILLER_0_70_322 vssd1 vssd1 vccd1 vccd1 sky130_fd_sc_hd__fill_1
X_08080_ _02445_ _02450_ vssd1 vssd1 vccd1 vccd1 _02452_ sky130_fd_sc_hd__xnor2_1
X_05292_ net370 net378 net596 net606 vssd1 vssd1 vccd1 vccd1 _04562_ sky130_fd_sc_hd__nand4_1
XFILLER_0_70_388 vssd1 vssd1 vccd1 vccd1 sky130_fd_sc_hd__decap_8
X_07031_ _01268_ _01276_ _01275_ vssd1 vssd1 vccd1 vccd1 _01402_ sky130_fd_sc_hd__o21ai_1
XFILLER_0_2_187 vssd1 vssd1 vccd1 vccd1 sky130_fd_sc_hd__decap_8
X_08982_ _03423_ _03424_ vssd1 vssd1 vccd1 vccd1 _03425_ sky130_fd_sc_hd__or2_1
X_07933_ net183 net574 _02164_ _02163_ vssd1 vssd1 vccd1 vccd1 _02306_ sky130_fd_sc_hd__a31o_1
X_07864_ _02059_ _02061_ vssd1 vssd1 vccd1 vccd1 _02238_ sky130_fd_sc_hd__nand2_1
X_09603_ _04087_ _04102_ _04103_ vssd1 vssd1 vccd1 vccd1 _04104_ sky130_fd_sc_hd__or3_1
X_06815_ _01053_ _01055_ _01054_ vssd1 vssd1 vccd1 vccd1 _01188_ sky130_fd_sc_hd__a21bo_1
X_07795_ net368 net402 net409 net359 vssd1 vssd1 vccd1 vccd1 _02166_ sky130_fd_sc_hd__a22o_1
XFILLER_0_64_60 vssd1 vssd1 vccd1 vccd1 sky130_fd_sc_hd__decap_4
XFILLER_0_78_444 vssd1 vssd1 vccd1 vccd1 sky130_ef_sc_hd__decap_12
X_06746_ net218 net591 _01116_ _01117_ vssd1 vssd1 vccd1 vccd1 _01119_ sky130_fd_sc_hd__a22o_1
X_09534_ _04026_ net468 net172 _04024_ vssd1 vssd1 vccd1 vccd1 _04028_ sky130_fd_sc_hd__and4b_1
X_09465_ _03794_ _03797_ _03951_ vssd1 vssd1 vccd1 vccd1 _03953_ sky130_fd_sc_hd__and3_1
XFILLER_0_78_477 vssd1 vssd1 vccd1 vccd1 sky130_ef_sc_hd__decap_12
X_06677_ net512 _01050_ _01049_ vssd1 vssd1 vccd1 vccd1 _01051_ sky130_fd_sc_hd__a21bo_1
X_08416_ _02803_ _02804_ _02621_ _02635_ vssd1 vssd1 vccd1 vccd1 _02806_ sky130_fd_sc_hd__a211o_4
XFILLER_0_65_138 vssd1 vssd1 vccd1 vccd1 sky130_fd_sc_hd__fill_1
X_05628_ _04897_ vssd1 vssd1 vccd1 vccd1 _04898_ sky130_fd_sc_hd__inv_2
X_09396_ _03876_ vssd1 vssd1 vccd1 vccd1 _03877_ sky130_fd_sc_hd__inv_2
XFILLER_0_46_341 vssd1 vssd1 vccd1 vccd1 sky130_fd_sc_hd__fill_1
X_08347_ net155 net593 _02729_ _02730_ vssd1 vssd1 vccd1 vccd1 _02731_ sky130_fd_sc_hd__a22oi_1
X_05559_ _04826_ _04827_ _04825_ vssd1 vssd1 vccd1 vccd1 _04829_ sky130_fd_sc_hd__a21o_1
X_08278_ _02652_ _02653_ _02646_ vssd1 vssd1 vccd1 vccd1 _02655_ sky130_fd_sc_hd__a21o_1
XFILLER_0_6_471 vssd1 vssd1 vccd1 vccd1 sky130_fd_sc_hd__decap_4
X_07229_ _01589_ _01597_ vssd1 vssd1 vccd1 vccd1 _01599_ sky130_fd_sc_hd__xnor2_1
Xfanout140 net141 vssd1 vssd1 vccd1 vccd1 net140 sky130_fd_sc_hd__clkbuf_4
Xfanout173 net174 vssd1 vssd1 vccd1 vccd1 net173 sky130_fd_sc_hd__clkbuf_4
Xfanout162 net163 vssd1 vssd1 vccd1 vccd1 net162 sky130_fd_sc_hd__clkbuf_4
Xfanout151 net152 vssd1 vssd1 vccd1 vccd1 net151 sky130_fd_sc_hd__buf_2
Xfanout195 net198 vssd1 vssd1 vccd1 vccd1 net195 sky130_fd_sc_hd__clkbuf_4
Xfanout184 net186 vssd1 vssd1 vccd1 vccd1 net184 sky130_fd_sc_hd__buf_4
XFILLER_0_84_414 vssd1 vssd1 vccd1 vccd1 sky130_fd_sc_hd__fill_1
XTAP_1131 vssd1 vccd1 sky130_fd_sc_hd__tapvpwrvgnd_1
XTAP_1120 vssd1 vccd1 sky130_fd_sc_hd__tapvpwrvgnd_1
XTAP_1153 vssd1 vccd1 sky130_fd_sc_hd__tapvpwrvgnd_1
XTAP_1164 vssd1 vccd1 sky130_fd_sc_hd__tapvpwrvgnd_1
XTAP_1142 vssd1 vccd1 sky130_fd_sc_hd__tapvpwrvgnd_1
XTAP_1197 vssd1 vccd1 sky130_fd_sc_hd__tapvpwrvgnd_1
XTAP_1186 vssd1 vccd1 sky130_fd_sc_hd__tapvpwrvgnd_1
XTAP_1175 vssd1 vccd1 sky130_fd_sc_hd__tapvpwrvgnd_1
XFILLER_0_60_29 vssd1 vssd1 vccd1 vccd1 sky130_fd_sc_hd__fill_2
XFILLER_0_69_38 vssd1 vssd1 vccd1 vccd1 sky130_fd_sc_hd__fill_1
XFILLER_0_100_79 vssd1 vssd1 vccd1 vccd1 sky130_fd_sc_hd__decap_4
XFILLER_0_20_230 vssd1 vssd1 vccd1 vccd1 sky130_fd_sc_hd__decap_4
XFILLER_0_20_241 vssd1 vssd1 vccd1 vccd1 sky130_fd_sc_hd__fill_1
XTAP_926 vssd1 vccd1 sky130_fd_sc_hd__tapvpwrvgnd_1
XTAP_915 vssd1 vccd1 sky130_fd_sc_hd__tapvpwrvgnd_1
XTAP_904 vssd1 vccd1 sky130_fd_sc_hd__tapvpwrvgnd_1
XTAP_959 vssd1 vccd1 sky130_fd_sc_hd__tapvpwrvgnd_1
XTAP_948 vssd1 vccd1 sky130_fd_sc_hd__tapvpwrvgnd_1
XTAP_937 vssd1 vccd1 sky130_fd_sc_hd__tapvpwrvgnd_1
XFILLER_0_18_53 vssd1 vssd1 vccd1 vccd1 sky130_fd_sc_hd__fill_1
X_06600_ _00972_ _00973_ vssd1 vssd1 vccd1 vccd1 _00974_ sky130_fd_sc_hd__and2b_1
X_07580_ _01949_ _01950_ _01951_ vssd1 vssd1 vccd1 vccd1 _01953_ sky130_fd_sc_hd__nand3_1
XFILLER_0_87_263 vssd1 vssd1 vccd1 vccd1 sky130_fd_sc_hd__decap_3
XFILLER_0_34_41 vssd1 vssd1 vccd1 vccd1 sky130_fd_sc_hd__fill_1
X_06531_ net338 net478 net486 net330 vssd1 vssd1 vccd1 vccd1 _00906_ sky130_fd_sc_hd__a22o_1
XFILLER_0_75_414 vssd1 vssd1 vccd1 vccd1 sky130_fd_sc_hd__decap_4
X_09250_ _03715_ _03717_ _03712_ vssd1 vssd1 vccd1 vccd1 _03718_ sky130_fd_sc_hd__a21o_1
XFILLER_0_34_74 vssd1 vssd1 vccd1 vccd1 sky130_fd_sc_hd__decap_8
X_08201_ _02411_ _02413_ _02572_ _02573_ vssd1 vssd1 vccd1 vccd1 _02574_ sky130_fd_sc_hd__o211a_1
X_06462_ _00596_ _00714_ vssd1 vssd1 vccd1 vccd1 _00838_ sky130_fd_sc_hd__nand2_1
XFILLER_0_90_439 vssd1 vssd1 vccd1 vccd1 sky130_fd_sc_hd__decap_8
X_09181_ net249 net258 net417 net424 vssd1 vssd1 vccd1 vccd1 _03643_ sky130_fd_sc_hd__and4_1
XFILLER_0_62_119 vssd1 vssd1 vccd1 vccd1 sky130_ef_sc_hd__decap_12
X_05413_ net335 net362 net551 net576 vssd1 vssd1 vccd1 vccd1 _04683_ sky130_fd_sc_hd__nand4_1
XFILLER_0_7_235 vssd1 vssd1 vccd1 vccd1 sky130_fd_sc_hd__decap_4
X_06393_ net461 _00767_ _00768_ vssd1 vssd1 vccd1 vccd1 _00769_ sky130_fd_sc_hd__a21bo_1
X_08132_ net237 net500 _02371_ _02372_ net519 vssd1 vssd1 vccd1 vccd1 _02504_ sky130_fd_sc_hd__a32o_1
XFILLER_0_7_279 vssd1 vssd1 vccd1 vccd1 sky130_fd_sc_hd__fill_1
X_05344_ _04571_ _04599_ _04612_ vssd1 vssd1 vccd1 vccd1 _04614_ sky130_fd_sc_hd__a21oi_1
XFILLER_0_70_141 vssd1 vssd1 vccd1 vccd1 sky130_ef_sc_hd__decap_12
X_08063_ _02435_ vssd1 vssd1 vccd1 vccd1 _02436_ sky130_fd_sc_hd__inv_2
X_05275_ _04143_ _04536_ _04544_ vssd1 vssd1 vccd1 vccd1 _04545_ sky130_fd_sc_hd__nor3_1
XFILLER_0_101_405 vssd1 vssd1 vccd1 vccd1 sky130_ef_sc_hd__decap_12
X_07014_ net202 net591 _01382_ _01383_ vssd1 vssd1 vccd1 vccd1 _01385_ sky130_fd_sc_hd__a22oi_1
XFILLER_0_101_427 vssd1 vssd1 vccd1 vccd1 sky130_fd_sc_hd__decap_4
XFILLER_0_101_449 vssd1 vssd1 vccd1 vccd1 sky130_ef_sc_hd__decap_12
X_08965_ _03403_ _03404_ _03247_ _03250_ vssd1 vssd1 vccd1 vccd1 _03406_ sky130_fd_sc_hd__a211o_1
X_07916_ net159 net600 net610 net154 vssd1 vssd1 vccd1 vccd1 _02289_ sky130_fd_sc_hd__a22oi_1
X_08896_ _03328_ _03329_ net286 net412 vssd1 vssd1 vccd1 vccd1 _03331_ sky130_fd_sc_hd__and4bb_1
XFILLER_0_98_528 vssd1 vssd1 vccd1 vccd1 sky130_fd_sc_hd__decap_4
X_07847_ net203 net212 net538 net548 vssd1 vssd1 vccd1 vccd1 _02219_ sky130_fd_sc_hd__and4_1
X_07778_ _02137_ _02147_ vssd1 vssd1 vccd1 vccd1 _02149_ sky130_fd_sc_hd__xnor2_1
X_09517_ net524 _03714_ vssd1 vssd1 vccd1 vccd1 _04009_ sky130_fd_sc_hd__nand2_2
X_06729_ net197 net620 vssd1 vssd1 vccd1 vccd1 _01102_ sky130_fd_sc_hd__nand2_1
XPHY_203 vssd1 vssd1 vccd1 vccd1 sky130_fd_sc_hd__decap_3
X_09448_ _03932_ _03933_ vssd1 vssd1 vccd1 vccd1 _03934_ sky130_fd_sc_hd__or2_1
X_09379_ net151 net156 net505 net514 vssd1 vssd1 vccd1 vccd1 _03859_ sky130_fd_sc_hd__and4_1
XFILLER_0_53_108 vssd1 vssd1 vccd1 vccd1 sky130_fd_sc_hd__decap_4
XFILLER_0_34_377 vssd1 vssd1 vccd1 vccd1 sky130_fd_sc_hd__decap_3
XFILLER_0_34_388 vssd1 vssd1 vccd1 vccd1 sky130_fd_sc_hd__fill_1
XFILLER_0_30_583 vssd1 vssd1 vccd1 vccd1 sky130_fd_sc_hd__fill_2
X_10085_ clknet_3_1_0_wb_clk_i _00081_ _00017_ vssd1 vssd1 vccd1 vccd1 mul.b\[14\]
+ sky130_fd_sc_hd__dfrtp_1
XFILLER_0_97_561 vssd1 vssd1 vccd1 vccd1 sky130_fd_sc_hd__decap_4
XFILLER_0_29_138 vssd1 vssd1 vccd1 vccd1 sky130_fd_sc_hd__fill_2
XFILLER_0_72_417 vssd1 vssd1 vccd1 vccd1 sky130_fd_sc_hd__decap_3
XFILLER_0_52_141 vssd1 vssd1 vccd1 vccd1 sky130_fd_sc_hd__decap_4
XFILLER_0_40_303 vssd1 vssd1 vccd1 vccd1 sky130_fd_sc_hd__decap_4
Xmax_cap104 _04715_ vssd1 vssd1 vccd1 vccd1 net104 sky130_fd_sc_hd__buf_1
Xmax_cap115 _01330_ vssd1 vssd1 vccd1 vccd1 net115 sky130_fd_sc_hd__buf_1
X_05060_ net29 net393 net126 vssd1 vssd1 vccd1 vccd1 _00098_ sky130_fd_sc_hd__mux2_1
XFILLER_0_21_561 vssd1 vssd1 vccd1 vccd1 sky130_fd_sc_hd__decap_4
XTAP_701 vssd1 vccd1 sky130_fd_sc_hd__tapvpwrvgnd_1
XFILLER_0_0_477 vssd1 vssd1 vccd1 vccd1 sky130_ef_sc_hd__decap_12
XFILLER_0_29_30 vssd1 vssd1 vccd1 vccd1 sky130_fd_sc_hd__fill_1
XTAP_712 vssd1 vccd1 sky130_fd_sc_hd__tapvpwrvgnd_1
XTAP_723 vssd1 vccd1 sky130_fd_sc_hd__tapvpwrvgnd_1
XTAP_734 vssd1 vccd1 sky130_fd_sc_hd__tapvpwrvgnd_1
XTAP_767 vssd1 vccd1 sky130_fd_sc_hd__tapvpwrvgnd_1
XTAP_745 vssd1 vccd1 sky130_fd_sc_hd__tapvpwrvgnd_1
XTAP_756 vssd1 vccd1 sky130_fd_sc_hd__tapvpwrvgnd_1
X_08750_ _03168_ _03169_ _03009_ _03011_ vssd1 vssd1 vccd1 vccd1 _03172_ sky130_fd_sc_hd__o211ai_1
XTAP_789 vssd1 vccd1 sky130_fd_sc_hd__tapvpwrvgnd_1
XTAP_778 vssd1 vccd1 sky130_fd_sc_hd__tapvpwrvgnd_1
X_05962_ _00339_ _00340_ _00341_ vssd1 vssd1 vccd1 vccd1 _00342_ sky130_fd_sc_hd__nand3_1
X_08681_ net161 net168 net701 net544 vssd1 vssd1 vccd1 vccd1 _03096_ sky130_fd_sc_hd__nand4_2
X_07701_ _02069_ _02071_ _02072_ vssd1 vssd1 vccd1 vccd1 _02073_ sky130_fd_sc_hd__nand3_1
X_05893_ _00168_ _00170_ _00271_ _00273_ vssd1 vssd1 vccd1 vccd1 _00274_ sky130_fd_sc_hd__a211oi_2
X_07632_ _01999_ _02003_ vssd1 vssd1 vccd1 vccd1 _02004_ sky130_fd_sc_hd__xnor2_1
XFILLER_0_45_51 vssd1 vssd1 vccd1 vccd1 sky130_fd_sc_hd__decap_4
XFILLER_0_45_84 vssd1 vssd1 vccd1 vccd1 sky130_fd_sc_hd__decap_3
XFILLER_0_88_572 vssd1 vssd1 vccd1 vccd1 sky130_fd_sc_hd__fill_2
X_09302_ _03163_ _03774_ vssd1 vssd1 vccd1 vccd1 _03775_ sky130_fd_sc_hd__xnor2_1
X_07563_ _01835_ _01836_ _01932_ _01934_ vssd1 vssd1 vccd1 vccd1 _01936_ sky130_fd_sc_hd__nand4_2
X_07494_ _01861_ _01863_ _01850_ vssd1 vssd1 vccd1 vccd1 _01865_ sky130_fd_sc_hd__o21ai_1
XFILLER_0_0_53 vssd1 vssd1 vccd1 vccd1 sky130_fd_sc_hd__decap_3
X_06514_ _00887_ _00888_ vssd1 vssd1 vccd1 vccd1 _00889_ sky130_fd_sc_hd__nor2_1
X_09233_ _03538_ _03539_ _03537_ vssd1 vssd1 vccd1 vccd1 _03700_ sky130_fd_sc_hd__a21boi_1
XFILLER_0_75_288 vssd1 vssd1 vccd1 vccd1 sky130_fd_sc_hd__decap_4
X_06445_ _00818_ _00819_ _00695_ _00697_ vssd1 vssd1 vccd1 vccd1 _00821_ sky130_fd_sc_hd__o211ai_2
XFILLER_0_90_225 vssd1 vssd1 vccd1 vccd1 sky130_fd_sc_hd__decap_8
X_09164_ _03599_ _03600_ _03621_ _03622_ vssd1 vssd1 vccd1 vccd1 _03624_ sky130_fd_sc_hd__nand4_1
XFILLER_0_63_439 vssd1 vssd1 vccd1 vccd1 sky130_fd_sc_hd__decap_8
XFILLER_0_16_322 vssd1 vssd1 vccd1 vccd1 sky130_fd_sc_hd__decap_3
X_08115_ net190 net193 net539 net549 vssd1 vssd1 vccd1 vccd1 _02487_ sky130_fd_sc_hd__nand4_1
X_06376_ _00735_ _00750_ vssd1 vssd1 vccd1 vccd1 _00752_ sky130_fd_sc_hd__xnor2_1
X_09095_ _03385_ _03386_ _03388_ vssd1 vssd1 vccd1 vccd1 _03549_ sky130_fd_sc_hd__o21a_1
X_05327_ _04584_ _04586_ vssd1 vssd1 vccd1 vccd1 _04597_ sky130_fd_sc_hd__xor2_1
XFILLER_0_43_163 vssd1 vssd1 vccd1 vccd1 sky130_fd_sc_hd__decap_4
X_08046_ _02416_ _02417_ _02250_ _02253_ vssd1 vssd1 vccd1 vccd1 _02419_ sky130_fd_sc_hd__a211oi_2
X_05258_ net345 net369 net551 net576 vssd1 vssd1 vccd1 vccd1 _04372_ sky130_fd_sc_hd__nand4_2
XFILLER_0_101_246 vssd1 vssd1 vccd1 vccd1 sky130_fd_sc_hd__decap_6
X_05189_ _03585_ _03596_ _03607_ vssd1 vssd1 vccd1 vccd1 _03618_ sky130_fd_sc_hd__and3_2
X_09997_ _04526_ _04533_ vssd1 vssd1 vccd1 vccd1 _04534_ sky130_fd_sc_hd__xnor2_4
X_08948_ net120 _03387_ vssd1 vssd1 vccd1 vccd1 _03388_ sky130_fd_sc_hd__nand2_1
X_08879_ net147 net392 net566 vssd1 vssd1 vccd1 vccd1 _03313_ sky130_fd_sc_hd__nand3_1
XFILLER_0_79_561 vssd1 vssd1 vccd1 vccd1 sky130_ef_sc_hd__decap_12
XFILLER_0_94_531 vssd1 vssd1 vccd1 vccd1 sky130_fd_sc_hd__fill_1
Xsplit56 net534 vssd1 vssd1 vccd1 vccd1 net701 sky130_fd_sc_hd__dlymetal6s2s_1
XFILLER_0_81_225 vssd1 vssd1 vccd1 vccd1 sky130_fd_sc_hd__decap_4
XFILLER_0_19_182 vssd1 vssd1 vccd1 vccd1 sky130_fd_sc_hd__fill_1
XFILLER_0_34_130 vssd1 vssd1 vccd1 vccd1 sky130_fd_sc_hd__decap_4
XFILLER_0_34_141 vssd1 vssd1 vccd1 vccd1 sky130_fd_sc_hd__decap_3
XFILLER_0_66_17 vssd1 vssd1 vccd1 vccd1 sky130_fd_sc_hd__fill_2
X_10137_ clknet_3_2_0_wb_clk_i _00002_ vssd1 vssd1 vccd1 vccd1 val_y_reg.wb_helper.wbs_ack_o
+ sky130_fd_sc_hd__dfxtp_1
X_10068_ net643 vssd1 vssd1 vccd1 vccd1 _00064_ sky130_fd_sc_hd__inv_2
XFILLER_0_15_10 vssd1 vssd1 vccd1 vccd1 sky130_fd_sc_hd__decap_3
XFILLER_0_15_54 vssd1 vssd1 vccd1 vccd1 sky130_fd_sc_hd__fill_2
XFILLER_0_72_203 vssd1 vssd1 vccd1 vccd1 sky130_fd_sc_hd__fill_2
XFILLER_0_57_277 vssd1 vssd1 vccd1 vccd1 sky130_fd_sc_hd__decap_3
XFILLER_0_5_503 vssd1 vssd1 vccd1 vccd1 sky130_fd_sc_hd__fill_1
X_06230_ net227 net617 vssd1 vssd1 vccd1 vccd1 _00607_ sky130_fd_sc_hd__nand2_1
XFILLER_0_38_491 vssd1 vssd1 vccd1 vccd1 sky130_fd_sc_hd__fill_1
XFILLER_0_25_152 vssd1 vssd1 vccd1 vccd1 sky130_fd_sc_hd__decap_4
XFILLER_0_13_325 vssd1 vssd1 vccd1 vccd1 sky130_fd_sc_hd__decap_3
X_06161_ net379 net469 _00429_ _00428_ vssd1 vssd1 vccd1 vccd1 _00539_ sky130_fd_sc_hd__a31o_1
XFILLER_0_41_623 vssd1 vssd1 vccd1 vccd1 sky130_fd_sc_hd__fill_2
X_06092_ _00321_ _00468_ _00469_ vssd1 vssd1 vccd1 vccd1 _00471_ sky130_fd_sc_hd__nand3_1
X_05112_ _02634_ _02755_ _02766_ vssd1 vssd1 vccd1 vccd1 _02776_ sky130_fd_sc_hd__nand3_1
X_09920_ _04447_ _04449_ vssd1 vssd1 vccd1 vccd1 _04450_ sky130_fd_sc_hd__xnor2_1
X_05043_ net9 net283 net132 vssd1 vssd1 vccd1 vccd1 _00112_ sky130_fd_sc_hd__mux2_1
XFILLER_0_21_391 vssd1 vssd1 vccd1 vccd1 sky130_fd_sc_hd__fill_1
X_09851_ _04364_ _04373_ vssd1 vssd1 vccd1 vccd1 _04375_ sky130_fd_sc_hd__xor2_1
XTAP_520 vssd1 vccd1 sky130_fd_sc_hd__tapvpwrvgnd_1
XTAP_531 vssd1 vccd1 sky130_fd_sc_hd__tapvpwrvgnd_1
XTAP_542 vssd1 vccd1 sky130_fd_sc_hd__tapvpwrvgnd_1
X_09782_ _04299_ net122 vssd1 vssd1 vccd1 vccd1 _04300_ sky130_fd_sc_hd__and2b_1
X_08802_ _03043_ _03071_ _03227_ _03228_ vssd1 vssd1 vccd1 vccd1 _03229_ sky130_fd_sc_hd__o211a_1
XTAP_553 vssd1 vccd1 sky130_fd_sc_hd__tapvpwrvgnd_1
XTAP_564 vssd1 vccd1 sky130_fd_sc_hd__tapvpwrvgnd_1
XTAP_575 vssd1 vccd1 sky130_fd_sc_hd__tapvpwrvgnd_1
X_06994_ net188 net195 net602 net612 vssd1 vssd1 vccd1 vccd1 _01365_ sky130_fd_sc_hd__and4_1
X_08733_ _03129_ _03130_ _03151_ _03152_ vssd1 vssd1 vccd1 vccd1 _03153_ sky130_fd_sc_hd__and4_1
XFILLER_0_56_83 vssd1 vssd1 vccd1 vccd1 sky130_fd_sc_hd__fill_1
X_05945_ net372 net496 _00237_ _00236_ vssd1 vssd1 vccd1 vccd1 _00325_ sky130_fd_sc_hd__a31o_1
XTAP_597 vssd1 vccd1 sky130_fd_sc_hd__tapvpwrvgnd_1
XTAP_586 vssd1 vccd1 sky130_fd_sc_hd__tapvpwrvgnd_1
XFILLER_0_22_3 vssd1 vssd1 vccd1 vccd1 sky130_fd_sc_hd__fill_2
X_08664_ _03075_ _03076_ _03077_ vssd1 vssd1 vccd1 vccd1 _03078_ sky130_fd_sc_hd__nor3_1
X_05876_ _00132_ _00255_ _00256_ vssd1 vssd1 vccd1 vccd1 _00257_ sky130_fd_sc_hd__nand3_2
X_08595_ net158 net566 _03001_ vssd1 vssd1 vccd1 vccd1 _03002_ sky130_fd_sc_hd__a21oi_1
XFILLER_0_48_200 vssd1 vssd1 vccd1 vccd1 sky130_fd_sc_hd__decap_6
X_07615_ _01977_ _01985_ _01986_ vssd1 vssd1 vccd1 vccd1 _01987_ sky130_fd_sc_hd__or3_1
XFILLER_0_76_531 vssd1 vssd1 vccd1 vccd1 sky130_fd_sc_hd__fill_1
X_07546_ _01915_ _01916_ _01917_ vssd1 vssd1 vccd1 vccd1 _01919_ sky130_fd_sc_hd__a21oi_1
XFILLER_0_91_501 vssd1 vssd1 vccd1 vccd1 sky130_fd_sc_hd__decap_3
XFILLER_0_63_203 vssd1 vssd1 vccd1 vccd1 sky130_fd_sc_hd__decap_6
X_09216_ _03519_ _03522_ _03518_ vssd1 vssd1 vccd1 vccd1 _03681_ sky130_fd_sc_hd__a21oi_1
XFILLER_0_63_225 vssd1 vssd1 vccd1 vccd1 sky130_fd_sc_hd__decap_4
X_07477_ _01844_ _01845_ _01692_ vssd1 vssd1 vccd1 vccd1 _01847_ sky130_fd_sc_hd__a21o_1
XFILLER_0_48_288 vssd1 vssd1 vccd1 vccd1 sky130_fd_sc_hd__fill_1
XFILLER_0_16_141 vssd1 vssd1 vccd1 vccd1 sky130_fd_sc_hd__decap_4
X_06428_ _00795_ _00802_ _00803_ vssd1 vssd1 vccd1 vccd1 _00804_ sky130_fd_sc_hd__nand3_1
X_09147_ _03603_ _03604_ vssd1 vssd1 vccd1 vccd1 _03605_ sky130_fd_sc_hd__nand2_1
X_06359_ _00612_ _00733_ vssd1 vssd1 vccd1 vccd1 _00735_ sky130_fd_sc_hd__xnor2_2
X_09078_ _03505_ _03529_ vssd1 vssd1 vccd1 vccd1 _03530_ sky130_fd_sc_hd__and2b_1
X_08029_ net283 net459 net466 net275 vssd1 vssd1 vccd1 vccd1 _02402_ sky130_fd_sc_hd__a22o_1
XFILLER_0_31_188 vssd1 vssd1 vccd1 vccd1 sky130_fd_sc_hd__fill_1
XFILLER_0_99_623 vssd1 vssd1 vccd1 vccd1 sky130_fd_sc_hd__fill_2
XFILLER_0_67_564 vssd1 vssd1 vccd1 vccd1 sky130_ef_sc_hd__decap_12
XFILLER_0_35_461 vssd1 vssd1 vccd1 vccd1 sky130_ef_sc_hd__decap_12
XFILLER_0_50_431 vssd1 vssd1 vccd1 vccd1 sky130_fd_sc_hd__fill_2
XFILLER_0_50_486 vssd1 vssd1 vccd1 vccd1 sky130_ef_sc_hd__decap_12
XFILLER_0_50_475 vssd1 vssd1 vccd1 vccd1 sky130_fd_sc_hd__fill_1
XFILLER_0_93_15 vssd1 vssd1 vccd1 vccd1 sky130_ef_sc_hd__decap_12
XFILLER_0_89_111 vssd1 vssd1 vccd1 vccd1 sky130_fd_sc_hd__fill_1
X_05730_ _04997_ _04998_ vssd1 vssd1 vccd1 vccd1 _05000_ sky130_fd_sc_hd__xor2_1
X_05661_ _04873_ _04875_ _04930_ vssd1 vssd1 vccd1 vccd1 _04931_ sky130_fd_sc_hd__a21oi_2
XFILLER_0_26_97 vssd1 vssd1 vccd1 vccd1 sky130_fd_sc_hd__decap_4
X_08380_ _02595_ _02601_ _02765_ vssd1 vssd1 vccd1 vccd1 _02768_ sky130_fd_sc_hd__a21o_1
XFILLER_0_58_531 vssd1 vssd1 vccd1 vccd1 sky130_fd_sc_hd__fill_1
X_07400_ _01733_ _01734_ _01767_ _01768_ vssd1 vssd1 vccd1 vccd1 _01769_ sky130_fd_sc_hd__or4bb_4
XFILLER_0_9_105 vssd1 vssd1 vccd1 vccd1 sky130_fd_sc_hd__fill_2
XFILLER_0_92_309 vssd1 vssd1 vccd1 vccd1 sky130_fd_sc_hd__decap_6
X_07331_ net375 net413 _01698_ _01699_ vssd1 vssd1 vccd1 vccd1 _01700_ sky130_fd_sc_hd__a22oi_2
X_05592_ net351 net553 net580 net322 vssd1 vssd1 vccd1 vccd1 _04862_ sky130_fd_sc_hd__a22o_1
XFILLER_0_42_85 vssd1 vssd1 vccd1 vccd1 sky130_ef_sc_hd__decap_12
XFILLER_0_45_225 vssd1 vssd1 vccd1 vccd1 sky130_fd_sc_hd__decap_8
X_07262_ _01629_ _01630_ _01474_ _01476_ vssd1 vssd1 vccd1 vccd1 _01632_ sky130_fd_sc_hd__a211oi_2
X_09001_ _03444_ _03445_ vssd1 vssd1 vccd1 vccd1 _03446_ sky130_fd_sc_hd__nor2_1
X_06213_ _00587_ _00589_ _00468_ _00471_ vssd1 vssd1 vccd1 vccd1 _00591_ sky130_fd_sc_hd__o211a_1
X_07193_ _01559_ _01561_ vssd1 vssd1 vccd1 vccd1 _01563_ sky130_fd_sc_hd__xor2_1
XFILLER_0_5_388 vssd1 vssd1 vccd1 vccd1 sky130_fd_sc_hd__decap_4
X_06144_ _00502_ _00521_ vssd1 vssd1 vccd1 vccd1 _00522_ sky130_fd_sc_hd__or2_2
X_06075_ _00435_ _00452_ _00453_ vssd1 vssd1 vccd1 vccd1 _00454_ sky130_fd_sc_hd__nand3_4
X_05026_ net28 net154 net134 vssd1 vssd1 vccd1 vccd1 _00129_ sky130_fd_sc_hd__mux2_1
X_09903_ _04430_ _04431_ vssd1 vssd1 vccd1 vccd1 _04432_ sky130_fd_sc_hd__xnor2_2
Xfanout503 net504 vssd1 vssd1 vccd1 vccd1 net503 sky130_fd_sc_hd__clkbuf_4
Xfanout514 net517 vssd1 vssd1 vccd1 vccd1 net514 sky130_fd_sc_hd__buf_2
Xfanout525 net526 vssd1 vssd1 vccd1 vccd1 net525 sky130_fd_sc_hd__buf_2
Xfanout547 net548 vssd1 vssd1 vccd1 vccd1 net547 sky130_fd_sc_hd__buf_6
XTAP_350 vssd1 vccd1 sky130_fd_sc_hd__tapvpwrvgnd_1
XFILLER_0_6_85 vssd1 vssd1 vccd1 vccd1 sky130_ef_sc_hd__decap_12
X_09834_ _04333_ _04355_ vssd1 vssd1 vccd1 vccd1 _04356_ sky130_fd_sc_hd__xnor2_1
Xfanout536 net539 vssd1 vssd1 vccd1 vccd1 net536 sky130_fd_sc_hd__buf_6
Xfanout558 mul.b\[9\] vssd1 vssd1 vccd1 vccd1 net558 sky130_fd_sc_hd__buf_4
XTAP_372 vssd1 vccd1 sky130_fd_sc_hd__tapvpwrvgnd_1
XTAP_361 vssd1 vccd1 sky130_fd_sc_hd__tapvpwrvgnd_1
XTAP_383 vssd1 vccd1 sky130_fd_sc_hd__tapvpwrvgnd_1
XTAP_394 vssd1 vccd1 sky130_fd_sc_hd__tapvpwrvgnd_1
Xfanout569 mul.b\[7\] vssd1 vssd1 vccd1 vccd1 net569 sky130_fd_sc_hd__clkbuf_8
X_09765_ _04124_ _04128_ _04280_ vssd1 vssd1 vccd1 vccd1 _04281_ sky130_fd_sc_hd__a21o_1
X_06977_ _01346_ _01347_ _01132_ net89 vssd1 vssd1 vccd1 vccd1 _01349_ sky130_fd_sc_hd__a211o_1
XFILLER_0_96_604 vssd1 vssd1 vccd1 vccd1 sky130_fd_sc_hd__fill_1
X_08716_ net270 net431 _03131_ _03132_ vssd1 vssd1 vccd1 vccd1 _03134_ sky130_fd_sc_hd__nand4_2
Xrebuffer30 _01923_ vssd1 vssd1 vccd1 vccd1 net675 sky130_fd_sc_hd__clkbuf_1
X_05928_ _00305_ _00306_ vssd1 vssd1 vccd1 vccd1 _00308_ sky130_fd_sc_hd__xor2_1
X_09696_ net187 net447 _04201_ _04203_ vssd1 vssd1 vccd1 vccd1 _04205_ sky130_fd_sc_hd__and4_1
X_08647_ _03058_ _03048_ vssd1 vssd1 vccd1 vccd1 _03059_ sky130_fd_sc_hd__and2b_1
Xrebuffer52 net535 vssd1 vssd1 vccd1 vccd1 net697 sky130_fd_sc_hd__buf_2
Xrebuffer41 _02103_ vssd1 vssd1 vccd1 vccd1 net686 sky130_fd_sc_hd__clkbuf_1
X_05859_ net329 net337 net531 net541 vssd1 vssd1 vccd1 vccd1 _00240_ sky130_fd_sc_hd__nand4_2
XPHY_12 vssd1 vssd1 vccd1 vccd1 sky130_fd_sc_hd__decap_3
Xrebuffer63 _00571_ vssd1 vssd1 vccd1 vccd1 net708 sky130_fd_sc_hd__clkbuf_1
XPHY_23 vssd1 vssd1 vccd1 vccd1 sky130_fd_sc_hd__decap_3
XPHY_34 vssd1 vssd1 vccd1 vccd1 sky130_fd_sc_hd__decap_3
XPHY_45 vssd1 vssd1 vccd1 vccd1 sky130_fd_sc_hd__decap_3
XPHY_56 vssd1 vssd1 vccd1 vccd1 sky130_fd_sc_hd__decap_3
X_08578_ net250 net450 _02981_ _02982_ vssd1 vssd1 vccd1 vccd1 _02983_ sky130_fd_sc_hd__a22oi_4
XPHY_67 vssd1 vssd1 vccd1 vccd1 sky130_fd_sc_hd__decap_3
XPHY_78 vssd1 vssd1 vccd1 vccd1 sky130_fd_sc_hd__decap_3
XPHY_89 vssd1 vssd1 vccd1 vccd1 sky130_fd_sc_hd__decap_3
XFILLER_0_64_512 vssd1 vssd1 vccd1 vccd1 sky130_ef_sc_hd__decap_12
X_07529_ net246 net255 net510 net521 vssd1 vssd1 vccd1 vccd1 _01902_ sky130_fd_sc_hd__and4_1
XFILLER_0_91_353 vssd1 vssd1 vccd1 vccd1 sky130_ef_sc_hd__decap_12
XFILLER_0_8_171 vssd1 vssd1 vccd1 vccd1 sky130_fd_sc_hd__fill_2
XFILLER_0_51_239 vssd1 vssd1 vccd1 vccd1 sky130_fd_sc_hd__fill_1
XFILLER_0_32_475 vssd1 vssd1 vccd1 vccd1 sky130_fd_sc_hd__fill_1
XFILLER_0_99_475 vssd1 vssd1 vccd1 vccd1 sky130_fd_sc_hd__fill_1
XFILLER_0_86_158 vssd1 vssd1 vccd1 vccd1 sky130_fd_sc_hd__decap_6
XFILLER_0_74_309 vssd1 vssd1 vccd1 vccd1 sky130_fd_sc_hd__decap_4
XFILLER_0_12_33 vssd1 vssd1 vccd1 vccd1 sky130_ef_sc_hd__decap_12
XFILLER_0_82_386 vssd1 vssd1 vccd1 vccd1 sky130_fd_sc_hd__fill_1
XFILLER_0_23_442 vssd1 vssd1 vccd1 vccd1 sky130_fd_sc_hd__decap_6
XFILLER_0_10_147 vssd1 vssd1 vccd1 vccd1 sky130_ef_sc_hd__decap_12
XFILLER_0_10_136 vssd1 vssd1 vccd1 vccd1 sky130_fd_sc_hd__decap_4
X_06900_ _01270_ _01271_ vssd1 vssd1 vccd1 vccd1 _01272_ sky130_fd_sc_hd__and2b_1
X_07880_ _02217_ _02251_ _02252_ vssd1 vssd1 vccd1 vccd1 _02254_ sky130_fd_sc_hd__nand3_2
X_06831_ _01147_ _01202_ _01203_ vssd1 vssd1 vccd1 vccd1 _01204_ sky130_fd_sc_hd__nor3_2
X_06762_ _01132_ _01133_ _01098_ vssd1 vssd1 vccd1 vccd1 _01135_ sky130_fd_sc_hd__o21a_1
X_09550_ net217 net428 _04043_ _04045_ vssd1 vssd1 vccd1 vccd1 _04046_ sky130_fd_sc_hd__a22o_1
X_09481_ _03970_ net123 vssd1 vssd1 vccd1 vccd1 _03971_ sky130_fd_sc_hd__and2b_1
XFILLER_0_77_103 vssd1 vssd1 vccd1 vccd1 sky130_fd_sc_hd__fill_1
X_08501_ net601 net610 net620 net150 vssd1 vssd1 vccd1 vccd1 _02900_ sky130_fd_sc_hd__o31a_1
X_05713_ _04981_ _04982_ vssd1 vssd1 vccd1 vccd1 _04983_ sky130_fd_sc_hd__nand2_1
X_08432_ _02821_ _02822_ _02807_ vssd1 vssd1 vccd1 vccd1 _02824_ sky130_fd_sc_hd__a21oi_1
X_06693_ _01047_ _01064_ _01065_ vssd1 vssd1 vccd1 vccd1 _01067_ sky130_fd_sc_hd__nand3_1
XFILLER_0_53_95 vssd1 vssd1 vccd1 vccd1 sky130_fd_sc_hd__decap_8
X_05644_ _04863_ _04864_ vssd1 vssd1 vccd1 vccd1 _04914_ sky130_fd_sc_hd__nand2_1
X_08363_ _02712_ _02748_ vssd1 vssd1 vccd1 vccd1 _02749_ sky130_fd_sc_hd__xnor2_2
X_05575_ _04843_ _04844_ vssd1 vssd1 vccd1 vccd1 _04845_ sky130_fd_sc_hd__nor2_1
X_08294_ _02671_ _02672_ vssd1 vssd1 vccd1 vccd1 _02673_ sky130_fd_sc_hd__xor2_1
XFILLER_0_73_353 vssd1 vssd1 vccd1 vccd1 sky130_ef_sc_hd__decap_12
X_07314_ _01531_ _01682_ vssd1 vssd1 vccd1 vccd1 _01683_ sky130_fd_sc_hd__nand2_1
X_07245_ _01453_ _01461_ _01460_ vssd1 vssd1 vccd1 vccd1 _01615_ sky130_fd_sc_hd__a21bo_1
X_07176_ net390 net410 _01544_ _01545_ vssd1 vssd1 vccd1 vccd1 _01546_ sky130_fd_sc_hd__and4_1
X_06127_ _00503_ _00504_ vssd1 vssd1 vccd1 vccd1 _00505_ sky130_fd_sc_hd__nand2b_1
X_06058_ net345 net503 net511 net336 vssd1 vssd1 vccd1 vccd1 _00437_ sky130_fd_sc_hd__a22oi_2
Xfanout300 mul.a\[11\] vssd1 vssd1 vccd1 vccd1 net300 sky130_fd_sc_hd__buf_2
Xfanout322 mul.a\[8\] vssd1 vssd1 vccd1 vccd1 net322 sky130_fd_sc_hd__buf_6
Xfanout311 net313 vssd1 vssd1 vccd1 vccd1 net311 sky130_fd_sc_hd__clkbuf_4
Xfanout333 net334 vssd1 vssd1 vccd1 vccd1 net333 sky130_fd_sc_hd__buf_2
Xfanout366 net367 vssd1 vssd1 vccd1 vccd1 net366 sky130_fd_sc_hd__buf_2
Xfanout355 net358 vssd1 vssd1 vccd1 vccd1 net355 sky130_fd_sc_hd__clkbuf_2
Xfanout344 net345 vssd1 vssd1 vccd1 vccd1 net344 sky130_fd_sc_hd__buf_4
Xfanout399 net400 vssd1 vssd1 vccd1 vccd1 net399 sky130_fd_sc_hd__clkbuf_4
Xfanout388 net389 vssd1 vssd1 vccd1 vccd1 net388 sky130_fd_sc_hd__clkbuf_2
Xfanout377 net382 vssd1 vssd1 vccd1 vccd1 net377 sky130_fd_sc_hd__clkbuf_4
X_09817_ _04335_ _04336_ vssd1 vssd1 vccd1 vccd1 _04337_ sky130_fd_sc_hd__or2_1
XFILLER_0_94_91 vssd1 vssd1 vccd1 vccd1 sky130_fd_sc_hd__fill_2
X_09748_ _04222_ _04260_ vssd1 vssd1 vccd1 vccd1 _04262_ sky130_fd_sc_hd__nor2_1
XTAP_1313 vssd1 vccd1 sky130_fd_sc_hd__tapvpwrvgnd_1
XTAP_1302 vssd1 vccd1 sky130_fd_sc_hd__tapvpwrvgnd_1
X_09679_ _04177_ _04185_ vssd1 vssd1 vccd1 vccd1 _04187_ sky130_fd_sc_hd__and2b_1
XTAP_1346 vssd1 vccd1 sky130_fd_sc_hd__tapvpwrvgnd_1
XTAP_1335 vssd1 vccd1 sky130_fd_sc_hd__tapvpwrvgnd_1
XTAP_1324 vssd1 vccd1 sky130_fd_sc_hd__tapvpwrvgnd_1
XFILLER_0_68_169 vssd1 vssd1 vccd1 vccd1 sky130_fd_sc_hd__decap_8
XFILLER_0_56_309 vssd1 vssd1 vccd1 vccd1 sky130_fd_sc_hd__decap_6
XFILLER_0_49_361 vssd1 vssd1 vccd1 vccd1 sky130_fd_sc_hd__decap_3
XFILLER_0_64_353 vssd1 vssd1 vccd1 vccd1 sky130_fd_sc_hd__fill_1
Xinput19 wbs_dat_i[22] vssd1 vssd1 vccd1 vccd1 net19 sky130_fd_sc_hd__clkbuf_1
XFILLER_0_9_491 vssd1 vssd1 vccd1 vccd1 sky130_fd_sc_hd__decap_8
XFILLER_0_24_206 vssd1 vssd1 vccd1 vccd1 sky130_fd_sc_hd__decap_6
XFILLER_0_87_401 vssd1 vssd1 vccd1 vccd1 sky130_fd_sc_hd__decap_4
XFILLER_0_90_49 vssd1 vssd1 vccd1 vccd1 sky130_fd_sc_hd__fill_2
XFILLER_0_59_169 vssd1 vssd1 vccd1 vccd1 sky130_fd_sc_hd__fill_1
XFILLER_0_74_128 vssd1 vssd1 vccd1 vccd1 sky130_fd_sc_hd__decap_4
XFILLER_0_23_54 vssd1 vssd1 vccd1 vccd1 sky130_fd_sc_hd__fill_2
X_05360_ _04625_ _04627_ vssd1 vssd1 vccd1 vccd1 _04630_ sky130_fd_sc_hd__xnor2_1
XFILLER_0_23_76 vssd1 vssd1 vccd1 vccd1 sky130_fd_sc_hd__decap_6
XFILLER_0_82_150 vssd1 vssd1 vccd1 vccd1 sky130_fd_sc_hd__fill_2
XFILLER_0_70_301 vssd1 vssd1 vccd1 vccd1 sky130_fd_sc_hd__fill_1
XFILLER_0_15_217 vssd1 vssd1 vccd1 vccd1 sky130_fd_sc_hd__fill_1
XFILLER_0_28_589 vssd1 vssd1 vccd1 vccd1 sky130_fd_sc_hd__fill_1
XFILLER_0_82_183 vssd1 vssd1 vccd1 vccd1 sky130_ef_sc_hd__decap_12
X_05291_ _03782_ _03804_ _03793_ vssd1 vssd1 vccd1 vccd1 _04561_ sky130_fd_sc_hd__a21o_1
XFILLER_0_43_559 vssd1 vssd1 vccd1 vccd1 sky130_fd_sc_hd__fill_1
XFILLER_0_3_623 vssd1 vssd1 vccd1 vccd1 sky130_fd_sc_hd__fill_2
X_07030_ _01363_ _01399_ vssd1 vssd1 vccd1 vccd1 _01401_ sky130_fd_sc_hd__xor2_1
XFILLER_0_51_592 vssd1 vssd1 vccd1 vccd1 sky130_fd_sc_hd__decap_4
X_08981_ net200 net472 _03420_ _03422_ vssd1 vssd1 vccd1 vccd1 _03424_ sky130_fd_sc_hd__and4_1
XFILLER_0_11_489 vssd1 vssd1 vccd1 vccd1 sky130_fd_sc_hd__decap_3
X_07932_ net176 net196 net557 net584 _02143_ vssd1 vssd1 vccd1 vccd1 _02305_ sky130_fd_sc_hd__a41o_1
X_07863_ _02233_ _02234_ _02235_ vssd1 vssd1 vccd1 vccd1 _02237_ sky130_fd_sc_hd__a21oi_1
X_09602_ _03948_ _03950_ _04101_ vssd1 vssd1 vccd1 vccd1 _04103_ sky130_fd_sc_hd__and3_1
XFILLER_0_3_53 vssd1 vssd1 vccd1 vccd1 sky130_fd_sc_hd__decap_3
X_06814_ _01184_ _01185_ _01183_ vssd1 vssd1 vccd1 vccd1 _01187_ sky130_fd_sc_hd__a21o_1
X_07794_ _02160_ _02164_ vssd1 vssd1 vccd1 vccd1 _02165_ sky130_fd_sc_hd__xnor2_2
XFILLER_0_64_72 vssd1 vssd1 vccd1 vccd1 sky130_ef_sc_hd__decap_12
XFILLER_0_3_75 vssd1 vssd1 vccd1 vccd1 sky130_fd_sc_hd__fill_2
X_09533_ net172 net468 _04025_ _04026_ vssd1 vssd1 vccd1 vccd1 _04027_ sky130_fd_sc_hd__o2bb2a_1
X_06745_ net218 net587 _01116_ _01117_ vssd1 vssd1 vccd1 vccd1 _01118_ sky130_fd_sc_hd__nand4_2
X_09464_ _03794_ _03797_ _03951_ vssd1 vssd1 vccd1 vccd1 _03952_ sky130_fd_sc_hd__a21oi_1
XFILLER_0_78_489 vssd1 vssd1 vccd1 vccd1 sky130_fd_sc_hd__decap_6
XFILLER_0_78_456 vssd1 vssd1 vccd1 vccd1 sky130_fd_sc_hd__decap_8
X_06676_ net293 net302 net504 vssd1 vssd1 vccd1 vccd1 _01050_ sky130_fd_sc_hd__and3_1
X_08415_ _02621_ net111 _02803_ _02804_ vssd1 vssd1 vccd1 vccd1 _02805_ sky130_fd_sc_hd__o211ai_4
X_09395_ net167 net173 net481 net490 vssd1 vssd1 vccd1 vccd1 _03876_ sky130_fd_sc_hd__and4_1
X_05627_ net272 net626 net634 net262 vssd1 vssd1 vccd1 vccd1 _04897_ sky130_fd_sc_hd__a22o_1
XFILLER_0_19_501 vssd1 vssd1 vccd1 vccd1 sky130_fd_sc_hd__decap_3
XFILLER_0_19_523 vssd1 vssd1 vccd1 vccd1 sky130_fd_sc_hd__fill_1
X_08346_ net160 net176 net557 mul.b\[6\] vssd1 vssd1 vccd1 vccd1 _02730_ sky130_fd_sc_hd__nand4_2
XFILLER_0_46_331 vssd1 vssd1 vccd1 vccd1 sky130_fd_sc_hd__fill_1
X_05558_ _04825_ _04826_ _04827_ vssd1 vssd1 vccd1 vccd1 _04828_ sky130_fd_sc_hd__nand3_1
X_08277_ _02646_ _02652_ _02653_ vssd1 vssd1 vccd1 vccd1 _02654_ sky130_fd_sc_hd__nand3_2
XFILLER_0_73_194 vssd1 vssd1 vccd1 vccd1 sky130_fd_sc_hd__fill_2
X_05489_ net387 net522 _04725_ _04724_ net531 vssd1 vssd1 vccd1 vccd1 _04759_ sky130_fd_sc_hd__a32o_1
XFILLER_0_61_378 vssd1 vssd1 vccd1 vccd1 sky130_fd_sc_hd__decap_6
X_07228_ _01589_ _01597_ vssd1 vssd1 vccd1 vccd1 _01598_ sky130_fd_sc_hd__and2_1
X_07159_ _01527_ _01528_ vssd1 vssd1 vccd1 vccd1 _01529_ sky130_fd_sc_hd__and2b_1
XFILLER_0_42_592 vssd1 vssd1 vccd1 vccd1 sky130_fd_sc_hd__fill_1
Xfanout130 _00184_ vssd1 vssd1 vccd1 vccd1 net130 sky130_fd_sc_hd__clkbuf_4
Xfanout163 mul.a\[28\] vssd1 vssd1 vccd1 vccd1 net163 sky130_fd_sc_hd__clkbuf_2
Xfanout174 mul.a\[26\] vssd1 vssd1 vccd1 vccd1 net174 sky130_fd_sc_hd__buf_2
Xfanout152 net153 vssd1 vssd1 vccd1 vccd1 net152 sky130_fd_sc_hd__clkbuf_2
Xfanout141 _00181_ vssd1 vssd1 vccd1 vccd1 net141 sky130_fd_sc_hd__clkbuf_4
Xfanout196 net198 vssd1 vssd1 vccd1 vccd1 net196 sky130_fd_sc_hd__clkbuf_2
Xfanout185 net187 vssd1 vssd1 vccd1 vccd1 net185 sky130_fd_sc_hd__buf_2
XFILLER_0_96_253 vssd1 vssd1 vccd1 vccd1 sky130_fd_sc_hd__decap_4
XTAP_1132 vssd1 vccd1 sky130_fd_sc_hd__tapvpwrvgnd_1
XTAP_1121 vssd1 vccd1 sky130_fd_sc_hd__tapvpwrvgnd_1
XTAP_1110 vssd1 vccd1 sky130_fd_sc_hd__tapvpwrvgnd_1
XTAP_1154 vssd1 vccd1 sky130_fd_sc_hd__tapvpwrvgnd_1
XTAP_1165 vssd1 vccd1 sky130_fd_sc_hd__tapvpwrvgnd_1
XTAP_1143 vssd1 vccd1 sky130_fd_sc_hd__tapvpwrvgnd_1
XFILLER_0_56_128 vssd1 vssd1 vccd1 vccd1 sky130_ef_sc_hd__decap_12
XTAP_1198 vssd1 vccd1 sky130_fd_sc_hd__tapvpwrvgnd_1
XTAP_1187 vssd1 vccd1 sky130_fd_sc_hd__tapvpwrvgnd_1
XTAP_1176 vssd1 vccd1 sky130_fd_sc_hd__tapvpwrvgnd_1
XFILLER_0_37_364 vssd1 vssd1 vccd1 vccd1 sky130_ef_sc_hd__decap_12
XFILLER_0_92_481 vssd1 vssd1 vccd1 vccd1 sky130_ef_sc_hd__decap_12
XFILLER_0_64_194 vssd1 vssd1 vccd1 vccd1 sky130_fd_sc_hd__fill_2
XFILLER_0_52_323 vssd1 vssd1 vccd1 vccd1 sky130_ef_sc_hd__decap_12
XFILLER_0_25_559 vssd1 vssd1 vccd1 vccd1 sky130_fd_sc_hd__fill_1
XFILLER_0_40_507 vssd1 vssd1 vccd1 vccd1 sky130_fd_sc_hd__decap_8
XTAP_916 vssd1 vccd1 sky130_fd_sc_hd__tapvpwrvgnd_1
XTAP_905 vssd1 vccd1 sky130_fd_sc_hd__tapvpwrvgnd_1
XTAP_949 vssd1 vccd1 sky130_fd_sc_hd__tapvpwrvgnd_1
XTAP_938 vssd1 vccd1 sky130_fd_sc_hd__tapvpwrvgnd_1
XTAP_927 vssd1 vccd1 sky130_fd_sc_hd__tapvpwrvgnd_1
XFILLER_0_87_220 vssd1 vssd1 vccd1 vccd1 sky130_fd_sc_hd__decap_4
X_06530_ net330 net338 net477 net486 vssd1 vssd1 vccd1 vccd1 _00905_ sky130_fd_sc_hd__nand4_1
X_06461_ net678 _00712_ _00713_ vssd1 vssd1 vccd1 vccd1 _00837_ sky130_fd_sc_hd__a21bo_1
X_08200_ _02570_ _02571_ _02557_ vssd1 vssd1 vccd1 vccd1 _02573_ sky130_fd_sc_hd__a21o_1
X_05412_ _04372_ _04394_ vssd1 vssd1 vccd1 vccd1 _04682_ sky130_fd_sc_hd__nand2_1
XFILLER_0_28_320 vssd1 vssd1 vccd1 vccd1 sky130_fd_sc_hd__decap_4
X_09180_ net258 net417 net424 net248 vssd1 vssd1 vccd1 vccd1 _03642_ sky130_fd_sc_hd__a22oi_1
XFILLER_0_28_353 vssd1 vssd1 vccd1 vccd1 sky130_fd_sc_hd__decap_8
X_06392_ net373 net454 net461 net363 vssd1 vssd1 vccd1 vccd1 _00768_ sky130_fd_sc_hd__a22o_1
XFILLER_0_50_41 vssd1 vssd1 vccd1 vccd1 sky130_fd_sc_hd__decap_6
X_08131_ _02384_ _02386_ vssd1 vssd1 vccd1 vccd1 _02503_ sky130_fd_sc_hd__nand2_1
X_05343_ _04571_ _04599_ _04612_ vssd1 vssd1 vccd1 vccd1 _04613_ sky130_fd_sc_hd__and3_1
XFILLER_0_50_74 vssd1 vssd1 vccd1 vccd1 sky130_fd_sc_hd__decap_8
XFILLER_0_70_153 vssd1 vssd1 vccd1 vccd1 sky130_fd_sc_hd__fill_2
X_08062_ _02269_ _02271_ _02433_ _02434_ vssd1 vssd1 vccd1 vccd1 _02435_ sky130_fd_sc_hd__a211o_1
X_05274_ _04503_ _04525_ _03268_ _03290_ vssd1 vssd1 vccd1 vccd1 _04544_ sky130_fd_sc_hd__o211a_1
XFILLER_0_70_197 vssd1 vssd1 vccd1 vccd1 sky130_fd_sc_hd__fill_2
X_07013_ net202 net587 _01382_ _01383_ vssd1 vssd1 vccd1 vccd1 _01384_ sky130_fd_sc_hd__and4_1
XFILLER_0_101_417 vssd1 vssd1 vccd1 vccd1 sky130_fd_sc_hd__decap_3
XFILLER_0_11_275 vssd1 vssd1 vccd1 vccd1 sky130_fd_sc_hd__fill_1
XFILLER_0_11_264 vssd1 vssd1 vccd1 vccd1 sky130_fd_sc_hd__decap_3
X_08964_ _03247_ _03250_ _03403_ _03404_ vssd1 vssd1 vccd1 vccd1 _03405_ sky130_fd_sc_hd__o211ai_2
X_07915_ _02192_ _02194_ vssd1 vssd1 vccd1 vccd1 _02288_ sky130_fd_sc_hd__or2_1
X_08895_ net286 net412 _03328_ _03329_ vssd1 vssd1 vccd1 vccd1 _03330_ sky130_fd_sc_hd__o2bb2a_1
X_07846_ net212 net538 net548 net203 vssd1 vssd1 vccd1 vccd1 _02218_ sky130_fd_sc_hd__a22o_1
X_07777_ _02137_ _02147_ vssd1 vssd1 vccd1 vccd1 _02148_ sky130_fd_sc_hd__and2b_1
X_09516_ net140 _04006_ _04007_ _04008_ vssd1 vssd1 vccd1 vccd1 net59 sky130_fd_sc_hd__a31o_1
X_06728_ _01099_ _01100_ vssd1 vssd1 vccd1 vccd1 _01101_ sky130_fd_sc_hd__nand2b_1
X_09447_ _03929_ _03931_ _03777_ _03780_ vssd1 vssd1 vccd1 vccd1 _03933_ sky130_fd_sc_hd__a211oi_1
XFILLER_0_78_286 vssd1 vssd1 vccd1 vccd1 sky130_fd_sc_hd__decap_6
X_06659_ _01017_ _01031_ _01032_ vssd1 vssd1 vccd1 vccd1 _01033_ sky130_fd_sc_hd__and3_1
XFILLER_0_38_139 vssd1 vssd1 vccd1 vccd1 sky130_fd_sc_hd__fill_1
XFILLER_0_81_429 vssd1 vssd1 vccd1 vccd1 sky130_fd_sc_hd__fill_1
X_09378_ net156 net505 net514 net151 vssd1 vssd1 vccd1 vccd1 _03857_ sky130_fd_sc_hd__a22o_1
X_08329_ _02460_ _02479_ _02478_ vssd1 vssd1 vccd1 vccd1 _02712_ sky130_fd_sc_hd__o21ai_2
XFILLER_0_100_472 vssd1 vssd1 vccd1 vccd1 sky130_fd_sc_hd__decap_4
X_10084_ clknet_3_1_0_wb_clk_i _00080_ _00016_ vssd1 vssd1 vccd1 vccd1 mul.b\[13\]
+ sky130_fd_sc_hd__dfrtp_1
XFILLER_0_89_529 vssd1 vssd1 vccd1 vccd1 sky130_fd_sc_hd__decap_8
XFILLER_0_97_595 vssd1 vssd1 vccd1 vccd1 sky130_fd_sc_hd__fill_1
XFILLER_0_44_109 vssd1 vssd1 vccd1 vccd1 sky130_ef_sc_hd__decap_12
Xmax_cap116 _00352_ vssd1 vssd1 vccd1 vccd1 net116 sky130_fd_sc_hd__clkbuf_2
XFILLER_0_96_15 vssd1 vssd1 vccd1 vccd1 sky130_ef_sc_hd__decap_12
XFILLER_0_21_551 vssd1 vssd1 vccd1 vccd1 sky130_fd_sc_hd__fill_1
XFILLER_0_0_489 vssd1 vssd1 vccd1 vccd1 sky130_fd_sc_hd__decap_8
XFILLER_0_29_42 vssd1 vssd1 vccd1 vccd1 sky130_fd_sc_hd__fill_1
XTAP_702 vssd1 vccd1 sky130_fd_sc_hd__tapvpwrvgnd_1
XTAP_713 vssd1 vccd1 sky130_fd_sc_hd__tapvpwrvgnd_1
XTAP_724 vssd1 vccd1 sky130_fd_sc_hd__tapvpwrvgnd_1
XTAP_768 vssd1 vccd1 sky130_fd_sc_hd__tapvpwrvgnd_1
XTAP_735 vssd1 vccd1 sky130_fd_sc_hd__tapvpwrvgnd_1
XTAP_746 vssd1 vccd1 sky130_fd_sc_hd__tapvpwrvgnd_1
XTAP_757 vssd1 vccd1 sky130_fd_sc_hd__tapvpwrvgnd_1
X_07700_ _01908_ _01910_ _01909_ vssd1 vssd1 vccd1 vccd1 _02072_ sky130_fd_sc_hd__a21bo_1
XTAP_779 vssd1 vccd1 sky130_fd_sc_hd__tapvpwrvgnd_1
X_05961_ net327 net531 net541 net319 vssd1 vssd1 vccd1 vccd1 _00341_ sky130_fd_sc_hd__a22o_1
X_08680_ net161 net166 net701 net544 vssd1 vssd1 vccd1 vccd1 _03095_ sky130_fd_sc_hd__and4_1
X_05892_ _00269_ _00270_ _05013_ vssd1 vssd1 vccd1 vccd1 _00273_ sky130_fd_sc_hd__a21oi_1
X_07631_ _02000_ _02001_ vssd1 vssd1 vccd1 vccd1 _02003_ sky130_fd_sc_hd__xnor2_1
X_07562_ _01835_ _01836_ _01932_ _01934_ vssd1 vssd1 vccd1 vccd1 _01935_ sky130_fd_sc_hd__and4_1
X_09301_ net294 net136 _03773_ _03310_ vssd1 vssd1 vccd1 vccd1 _03774_ sky130_fd_sc_hd__o22a_1
X_06513_ net380 net389 net434 net440 vssd1 vssd1 vccd1 vccd1 _00888_ sky130_fd_sc_hd__and4_1
XFILLER_0_48_404 vssd1 vssd1 vccd1 vccd1 sky130_fd_sc_hd__fill_1
X_07493_ _01850_ _01861_ _01863_ vssd1 vssd1 vccd1 vccd1 _01864_ sky130_fd_sc_hd__or3_2
X_09232_ _03697_ _03698_ vssd1 vssd1 vccd1 vccd1 _03699_ sky130_fd_sc_hd__xnor2_2
X_06444_ _00695_ _00697_ _00818_ _00819_ vssd1 vssd1 vccd1 vccd1 _00820_ sky130_fd_sc_hd__a211o_2
X_09163_ _03599_ _03600_ _03621_ _03622_ vssd1 vssd1 vccd1 vccd1 _03623_ sky130_fd_sc_hd__and4_1
X_06375_ _00735_ _00750_ vssd1 vssd1 vccd1 vccd1 _00751_ sky130_fd_sc_hd__or2_1
X_08114_ net184 net193 net538 net547 vssd1 vssd1 vccd1 vccd1 _02486_ sky130_fd_sc_hd__and4_1
X_05326_ _04591_ _04593_ vssd1 vssd1 vccd1 vccd1 _04596_ sky130_fd_sc_hd__xnor2_1
X_09094_ net120 _03546_ vssd1 vssd1 vccd1 vccd1 _03548_ sky130_fd_sc_hd__xnor2_2
XFILLER_0_31_326 vssd1 vssd1 vccd1 vccd1 sky130_fd_sc_hd__decap_4
X_08045_ _02250_ _02253_ _02416_ _02417_ vssd1 vssd1 vccd1 vccd1 _02418_ sky130_fd_sc_hd__o211a_1
X_05257_ _03039_ _03061_ vssd1 vssd1 vccd1 vccd1 _04361_ sky130_fd_sc_hd__nand2_1
XFILLER_0_101_225 vssd1 vssd1 vccd1 vccd1 sky130_fd_sc_hd__decap_8
X_05188_ _03367_ _03389_ vssd1 vssd1 vccd1 vccd1 _03607_ sky130_fd_sc_hd__xnor2_1
X_09996_ _04527_ _04532_ vssd1 vssd1 vccd1 vccd1 _04533_ sky130_fd_sc_hd__xnor2_2
X_08947_ _03385_ _03386_ vssd1 vssd1 vccd1 vccd1 _03387_ sky130_fd_sc_hd__xor2_1
X_08878_ net326 net392 vssd1 vssd1 vccd1 vccd1 _03311_ sky130_fd_sc_hd__and2b_1
X_07829_ net324 net433 _02197_ _02198_ vssd1 vssd1 vccd1 vccd1 _02200_ sky130_fd_sc_hd__nand4_2
XFILLER_0_79_573 vssd1 vssd1 vccd1 vccd1 sky130_fd_sc_hd__decap_3
XFILLER_0_66_201 vssd1 vssd1 vccd1 vccd1 sky130_fd_sc_hd__fill_1
XFILLER_0_81_259 vssd1 vssd1 vccd1 vccd1 sky130_fd_sc_hd__fill_1
XFILLER_0_34_164 vssd1 vssd1 vccd1 vccd1 sky130_fd_sc_hd__fill_1
XFILLER_0_34_197 vssd1 vssd1 vccd1 vccd1 sky130_fd_sc_hd__fill_1
X_10136_ clknet_3_4_0_wb_clk_i _00130_ _00066_ vssd1 vssd1 vccd1 vccd1 mul.a\[31\]
+ sky130_fd_sc_hd__dfrtp_2
X_10067_ net643 vssd1 vssd1 vccd1 vccd1 _00063_ sky130_fd_sc_hd__inv_2
XFILLER_0_89_337 vssd1 vssd1 vccd1 vccd1 sky130_ef_sc_hd__decap_12
XFILLER_0_89_359 vssd1 vssd1 vccd1 vccd1 sky130_fd_sc_hd__fill_1
XFILLER_0_57_201 vssd1 vssd1 vccd1 vccd1 sky130_fd_sc_hd__decap_3
XFILLER_0_72_226 vssd1 vssd1 vccd1 vccd1 sky130_fd_sc_hd__fill_1
XFILLER_0_72_215 vssd1 vssd1 vccd1 vccd1 sky130_fd_sc_hd__decap_6
XFILLER_0_31_54 vssd1 vssd1 vccd1 vccd1 sky130_fd_sc_hd__fill_2
XFILLER_0_5_559 vssd1 vssd1 vccd1 vccd1 sky130_fd_sc_hd__fill_1
X_06160_ _00536_ _00537_ vssd1 vssd1 vccd1 vccd1 _00538_ sky130_fd_sc_hd__and2_1
X_06091_ _00321_ _00468_ _00469_ vssd1 vssd1 vccd1 vccd1 _00470_ sky130_fd_sc_hd__and3_1
X_05111_ _02678_ _02689_ _02744_ vssd1 vssd1 vccd1 vccd1 _02766_ sky130_fd_sc_hd__a21o_1
XFILLER_0_13_337 vssd1 vssd1 vccd1 vccd1 sky130_fd_sc_hd__fill_1
XFILLER_0_13_348 vssd1 vssd1 vccd1 vccd1 sky130_fd_sc_hd__decap_4
X_05042_ net10 net275 net132 vssd1 vssd1 vccd1 vccd1 _00113_ sky130_fd_sc_hd__mux2_1
XFILLER_0_0_253 vssd1 vssd1 vccd1 vccd1 sky130_fd_sc_hd__decap_3
X_09850_ _04373_ vssd1 vssd1 vccd1 vccd1 _04374_ sky130_fd_sc_hd__inv_2
XTAP_510 vssd1 vccd1 sky130_fd_sc_hd__tapvpwrvgnd_1
XTAP_521 vssd1 vccd1 sky130_fd_sc_hd__tapvpwrvgnd_1
XTAP_532 vssd1 vccd1 sky130_fd_sc_hd__tapvpwrvgnd_1
XTAP_543 vssd1 vccd1 sky130_fd_sc_hd__tapvpwrvgnd_1
X_09781_ _04297_ _04298_ vssd1 vssd1 vccd1 vccd1 _04299_ sky130_fd_sc_hd__xnor2_1
X_08801_ _03199_ _03200_ _03224_ vssd1 vssd1 vccd1 vccd1 _03228_ sky130_fd_sc_hd__o21ai_1
XTAP_554 vssd1 vccd1 sky130_fd_sc_hd__tapvpwrvgnd_1
XTAP_565 vssd1 vccd1 sky130_fd_sc_hd__tapvpwrvgnd_1
XTAP_576 vssd1 vccd1 sky130_fd_sc_hd__tapvpwrvgnd_1
X_06993_ _01142_ _01280_ _01278_ vssd1 vssd1 vccd1 vccd1 _01364_ sky130_fd_sc_hd__o21a_1
X_08732_ _03147_ _03149_ _02986_ _02988_ vssd1 vssd1 vccd1 vccd1 _03152_ sky130_fd_sc_hd__o211ai_4
X_05944_ net297 net305 net562 net571 vssd1 vssd1 vccd1 vccd1 _00324_ sky130_fd_sc_hd__and4_2
XTAP_598 vssd1 vccd1 sky130_fd_sc_hd__tapvpwrvgnd_1
XTAP_587 vssd1 vccd1 sky130_fd_sc_hd__tapvpwrvgnd_1
X_08663_ _02877_ _02906_ _02905_ vssd1 vssd1 vccd1 vccd1 _03077_ sky130_fd_sc_hd__a21oi_1
X_05875_ _00252_ _00254_ _00151_ _00153_ vssd1 vssd1 vccd1 vccd1 _00256_ sky130_fd_sc_hd__o211ai_2
X_08594_ net342 net394 vssd1 vssd1 vccd1 vccd1 _03001_ sky130_fd_sc_hd__and2b_1
X_07614_ _01983_ _01984_ _01978_ vssd1 vssd1 vccd1 vccd1 _01986_ sky130_fd_sc_hd__a21oi_1
X_07545_ _01915_ _01916_ _01917_ vssd1 vssd1 vccd1 vccd1 _01918_ sky130_fd_sc_hd__and3_4
X_07476_ _01692_ _01844_ _01845_ vssd1 vssd1 vccd1 vccd1 _01846_ sky130_fd_sc_hd__and3_1
X_09215_ _03677_ _03679_ vssd1 vssd1 vccd1 vccd1 _03680_ sky130_fd_sc_hd__xnor2_1
X_06427_ _00799_ _00800_ _00801_ vssd1 vssd1 vccd1 vccd1 _00803_ sky130_fd_sc_hd__a21o_1
X_09146_ net241 net430 _03601_ _03602_ vssd1 vssd1 vccd1 vccd1 _03604_ sky130_fd_sc_hd__nand4_2
X_06358_ _00612_ _00733_ vssd1 vssd1 vccd1 vccd1 _00734_ sky130_fd_sc_hd__nand2_1
X_09077_ _03527_ _03528_ vssd1 vssd1 vccd1 vccd1 _03529_ sky130_fd_sc_hd__and2_1
XFILLER_0_71_281 vssd1 vssd1 vccd1 vccd1 sky130_ef_sc_hd__decap_12
X_05309_ _03323_ _04577_ _04578_ vssd1 vssd1 vccd1 vccd1 _04579_ sky130_fd_sc_hd__and3_1
X_06289_ _00663_ _00664_ _00660_ vssd1 vssd1 vccd1 vccd1 _00666_ sky130_fd_sc_hd__a21oi_1
XFILLER_0_31_134 vssd1 vssd1 vccd1 vccd1 sky130_fd_sc_hd__fill_1
XFILLER_0_44_495 vssd1 vssd1 vccd1 vccd1 sky130_fd_sc_hd__decap_3
X_08028_ _02399_ _02400_ vssd1 vssd1 vccd1 vccd1 _02401_ sky130_fd_sc_hd__xor2_1
X_09979_ _04454_ _04513_ vssd1 vssd1 vccd1 vccd1 _04515_ sky130_fd_sc_hd__xnor2_2
XFILLER_0_67_532 vssd1 vssd1 vccd1 vccd1 sky130_fd_sc_hd__fill_1
XFILLER_0_67_576 vssd1 vssd1 vccd1 vccd1 sky130_fd_sc_hd__decap_8
XFILLER_0_39_267 vssd1 vssd1 vccd1 vccd1 sky130_fd_sc_hd__fill_1
XFILLER_0_94_395 vssd1 vssd1 vccd1 vccd1 sky130_ef_sc_hd__decap_12
XFILLER_0_35_473 vssd1 vssd1 vccd1 vccd1 sky130_fd_sc_hd__decap_6
XFILLER_0_35_495 vssd1 vssd1 vccd1 vccd1 sky130_fd_sc_hd__decap_8
XFILLER_0_10_307 vssd1 vssd1 vccd1 vccd1 sky130_fd_sc_hd__fill_1
XFILLER_0_50_498 vssd1 vssd1 vccd1 vccd1 sky130_fd_sc_hd__decap_8
X_10119_ clknet_3_1_0_wb_clk_i _00113_ _00049_ vssd1 vssd1 vccd1 vccd1 mul.a\[14\]
+ sky130_fd_sc_hd__dfrtp_2
XFILLER_0_26_65 vssd1 vssd1 vccd1 vccd1 sky130_fd_sc_hd__decap_3
X_05660_ _04913_ _04928_ vssd1 vssd1 vccd1 vccd1 _04930_ sky130_fd_sc_hd__xnor2_2
X_05591_ _04771_ _04773_ vssd1 vssd1 vccd1 vccd1 _04861_ sky130_fd_sc_hd__nand2_1
XFILLER_0_42_20 vssd1 vssd1 vccd1 vccd1 sky130_fd_sc_hd__decap_8
X_07330_ net358 net367 net418 net423 vssd1 vssd1 vccd1 vccd1 _01699_ sky130_fd_sc_hd__nand4_1
XFILLER_0_58_587 vssd1 vssd1 vccd1 vccd1 sky130_fd_sc_hd__fill_1
X_09000_ _03441_ _03442_ net222 net449 vssd1 vssd1 vccd1 vccd1 _03445_ sky130_fd_sc_hd__and4bb_1
X_07261_ _01474_ _01476_ _01629_ _01630_ vssd1 vssd1 vccd1 vccd1 _01631_ sky130_fd_sc_hd__o211a_1
XFILLER_0_42_97 vssd1 vssd1 vccd1 vccd1 sky130_fd_sc_hd__fill_1
X_06212_ _00468_ _00471_ _00587_ _00589_ vssd1 vssd1 vccd1 vccd1 _00590_ sky130_fd_sc_hd__a211oi_4
XFILLER_0_26_473 vssd1 vssd1 vccd1 vccd1 sky130_fd_sc_hd__decap_3
XFILLER_0_26_484 vssd1 vssd1 vccd1 vccd1 sky130_fd_sc_hd__fill_2
X_07192_ _01410_ _01559_ _01560_ vssd1 vssd1 vccd1 vccd1 _01562_ sky130_fd_sc_hd__nand3_1
XFILLER_0_53_281 vssd1 vssd1 vccd1 vccd1 sky130_fd_sc_hd__decap_4
XFILLER_0_13_101 vssd1 vssd1 vccd1 vccd1 sky130_fd_sc_hd__decap_8
X_06143_ _00519_ _00520_ vssd1 vssd1 vccd1 vccd1 _00521_ sky130_fd_sc_hd__nand2_1
XFILLER_0_41_443 vssd1 vssd1 vccd1 vccd1 sky130_fd_sc_hd__decap_4
X_06074_ _00449_ _00450_ _00451_ vssd1 vssd1 vccd1 vccd1 _00453_ sky130_fd_sc_hd__a21o_1
X_05025_ net29 net150 net134 vssd1 vssd1 vccd1 vccd1 _00130_ sky130_fd_sc_hd__mux2_1
X_09902_ _04269_ _04287_ _04286_ vssd1 vssd1 vccd1 vccd1 _04431_ sky130_fd_sc_hd__o21ba_1
Xfanout515 net516 vssd1 vssd1 vccd1 vccd1 net515 sky130_fd_sc_hd__buf_6
Xfanout504 net509 vssd1 vssd1 vccd1 vccd1 net504 sky130_fd_sc_hd__clkbuf_4
XFILLER_0_67_61 vssd1 vssd1 vccd1 vccd1 sky130_fd_sc_hd__fill_1
Xfanout548 net549 vssd1 vssd1 vccd1 vccd1 net548 sky130_fd_sc_hd__buf_4
Xfanout537 net538 vssd1 vssd1 vccd1 vccd1 net537 sky130_fd_sc_hd__buf_6
XTAP_351 vssd1 vccd1 sky130_fd_sc_hd__tapvpwrvgnd_1
XTAP_340 vssd1 vccd1 sky130_fd_sc_hd__tapvpwrvgnd_1
XFILLER_0_6_97 vssd1 vssd1 vccd1 vccd1 sky130_fd_sc_hd__decap_4
X_09833_ _04334_ _04354_ vssd1 vssd1 vccd1 vccd1 _04355_ sky130_fd_sc_hd__xor2_1
Xfanout526 net529 vssd1 vssd1 vccd1 vccd1 net526 sky130_fd_sc_hd__clkbuf_2
Xfanout559 net561 vssd1 vssd1 vccd1 vccd1 net559 sky130_fd_sc_hd__buf_2
XTAP_373 vssd1 vccd1 sky130_fd_sc_hd__tapvpwrvgnd_1
XTAP_362 vssd1 vccd1 sky130_fd_sc_hd__tapvpwrvgnd_1
XTAP_384 vssd1 vccd1 sky130_fd_sc_hd__tapvpwrvgnd_1
X_09764_ _04277_ _04279_ vssd1 vssd1 vccd1 vccd1 _04280_ sky130_fd_sc_hd__xnor2_1
XTAP_395 vssd1 vccd1 sky130_fd_sc_hd__tapvpwrvgnd_1
X_06976_ _01132_ net89 _01346_ _01347_ vssd1 vssd1 vccd1 vccd1 _01348_ sky130_fd_sc_hd__o211ai_4
X_08715_ net270 net431 _03131_ _03132_ vssd1 vssd1 vccd1 vccd1 _03133_ sky130_fd_sc_hd__a22o_1
X_05927_ _00305_ _00306_ vssd1 vssd1 vccd1 vccd1 _00307_ sky130_fd_sc_hd__and2b_1
X_09695_ net187 net447 _04201_ _04203_ vssd1 vssd1 vccd1 vccd1 _04204_ sky130_fd_sc_hd__a22oi_2
Xrebuffer20 net539 vssd1 vssd1 vccd1 vccd1 net665 sky130_fd_sc_hd__buf_1
X_08646_ _03049_ _03057_ vssd1 vssd1 vccd1 vccd1 _03058_ sky130_fd_sc_hd__xnor2_1
Xrebuffer53 net697 vssd1 vssd1 vccd1 vccd1 net698 sky130_fd_sc_hd__clkbuf_1
Xrebuffer31 net675 vssd1 vssd1 vccd1 vccd1 net676 sky130_fd_sc_hd__clkbuf_1
XPHY_13 vssd1 vssd1 vccd1 vccd1 sky130_fd_sc_hd__decap_3
X_05858_ net347 net522 vssd1 vssd1 vccd1 vccd1 _00239_ sky130_fd_sc_hd__and2_1
Xrebuffer64 net708 vssd1 vssd1 vccd1 vccd1 net709 sky130_fd_sc_hd__clkbuf_1
Xrebuffer42 _01210_ vssd1 vssd1 vccd1 vccd1 net687 sky130_fd_sc_hd__clkbuf_2
XFILLER_0_95_148 vssd1 vssd1 vccd1 vccd1 sky130_fd_sc_hd__fill_1
XPHY_24 vssd1 vssd1 vccd1 vccd1 sky130_fd_sc_hd__decap_3
XPHY_35 vssd1 vssd1 vccd1 vccd1 sky130_fd_sc_hd__decap_3
XPHY_46 vssd1 vssd1 vccd1 vccd1 sky130_fd_sc_hd__decap_3
X_08577_ net232 net240 net457 net464 vssd1 vssd1 vccd1 vccd1 _02982_ sky130_fd_sc_hd__nand4_2
X_05789_ _04931_ _00169_ vssd1 vssd1 vccd1 vccd1 _00171_ sky130_fd_sc_hd__xnor2_1
XPHY_57 vssd1 vssd1 vccd1 vccd1 sky130_fd_sc_hd__decap_3
XPHY_68 vssd1 vssd1 vccd1 vccd1 sky130_fd_sc_hd__decap_3
XPHY_79 vssd1 vssd1 vccd1 vccd1 sky130_fd_sc_hd__decap_3
XFILLER_0_64_524 vssd1 vssd1 vccd1 vccd1 sky130_fd_sc_hd__decap_8
X_07528_ net255 net508 net518 net246 vssd1 vssd1 vccd1 vccd1 _01901_ sky130_fd_sc_hd__a22o_1
XFILLER_0_49_587 vssd1 vssd1 vccd1 vccd1 sky130_fd_sc_hd__fill_2
XFILLER_0_64_546 vssd1 vssd1 vccd1 vccd1 sky130_fd_sc_hd__fill_2
XFILLER_0_17_440 vssd1 vssd1 vccd1 vccd1 sky130_fd_sc_hd__decap_8
X_07459_ _01678_ _01681_ _01825_ vssd1 vssd1 vccd1 vccd1 _01828_ sky130_fd_sc_hd__o21ai_2
XFILLER_0_91_365 vssd1 vssd1 vccd1 vccd1 sky130_fd_sc_hd__decap_8
X_09129_ net185 net480 net489 net178 vssd1 vssd1 vccd1 vccd1 _03586_ sky130_fd_sc_hd__a22o_1
XFILLER_0_32_421 vssd1 vssd1 vccd1 vccd1 sky130_fd_sc_hd__fill_2
XFILLER_0_32_487 vssd1 vssd1 vccd1 vccd1 sky130_fd_sc_hd__fill_2
XFILLER_0_32_498 vssd1 vssd1 vccd1 vccd1 sky130_fd_sc_hd__fill_1
XFILLER_0_4_3 vssd1 vssd1 vccd1 vccd1 sky130_fd_sc_hd__decap_6
XFILLER_0_55_568 vssd1 vssd1 vccd1 vccd1 sky130_fd_sc_hd__decap_8
XFILLER_0_55_557 vssd1 vssd1 vccd1 vccd1 sky130_fd_sc_hd__decap_3
XFILLER_0_12_45 vssd1 vssd1 vccd1 vccd1 sky130_ef_sc_hd__decap_12
XFILLER_0_82_365 vssd1 vssd1 vccd1 vccd1 sky130_fd_sc_hd__decap_6
XFILLER_0_70_516 vssd1 vssd1 vccd1 vccd1 sky130_fd_sc_hd__decap_8
XFILLER_0_42_207 vssd1 vssd1 vccd1 vccd1 sky130_fd_sc_hd__fill_1
XFILLER_0_88_16 vssd1 vssd1 vccd1 vccd1 sky130_fd_sc_hd__decap_8
XFILLER_0_35_281 vssd1 vssd1 vccd1 vccd1 sky130_fd_sc_hd__fill_2
XFILLER_0_10_115 vssd1 vssd1 vccd1 vccd1 sky130_fd_sc_hd__decap_8
XFILLER_0_10_104 vssd1 vssd1 vccd1 vccd1 sky130_fd_sc_hd__fill_2
XFILLER_0_10_159 vssd1 vssd1 vccd1 vccd1 sky130_fd_sc_hd__fill_1
X_06830_ _01200_ _01201_ _01069_ _01071_ vssd1 vssd1 vccd1 vccd1 _01203_ sky130_fd_sc_hd__a211oi_2
X_06761_ _01098_ _01132_ _01133_ vssd1 vssd1 vccd1 vccd1 _01134_ sky130_fd_sc_hd__nor3_1
X_08500_ _02896_ _02898_ vssd1 vssd1 vccd1 vccd1 _02899_ sky130_fd_sc_hd__xor2_1
X_09480_ _03163_ _03774_ net136 net296 vssd1 vssd1 vccd1 vccd1 _03970_ sky130_fd_sc_hd__o2bb2a_1
X_05712_ _04979_ _04980_ _04934_ vssd1 vssd1 vccd1 vccd1 _04982_ sky130_fd_sc_hd__a21o_1
X_06692_ _01047_ _01064_ _01065_ vssd1 vssd1 vccd1 vccd1 _01066_ sky130_fd_sc_hd__and3_1
X_08431_ _02807_ _02821_ _02822_ vssd1 vssd1 vccd1 vccd1 _02823_ sky130_fd_sc_hd__and3_1
X_05643_ _04844_ _04912_ vssd1 vssd1 vccd1 vccd1 _04913_ sky130_fd_sc_hd__xnor2_2
XFILLER_0_77_159 vssd1 vssd1 vccd1 vccd1 sky130_fd_sc_hd__fill_2
X_08362_ _02713_ _02746_ vssd1 vssd1 vccd1 vccd1 _02748_ sky130_fd_sc_hd__xnor2_2
X_05574_ net272 net280 net626 net634 vssd1 vssd1 vccd1 vccd1 _04844_ sky130_fd_sc_hd__and4_1
XFILLER_0_46_524 vssd1 vssd1 vccd1 vccd1 sky130_fd_sc_hd__fill_1
X_08293_ net164 net574 vssd1 vssd1 vccd1 vccd1 _02672_ sky130_fd_sc_hd__nand2_1
XFILLER_0_18_248 vssd1 vssd1 vccd1 vccd1 sky130_fd_sc_hd__fill_1
X_07313_ _01679_ _01680_ vssd1 vssd1 vccd1 vccd1 _01682_ sky130_fd_sc_hd__xnor2_1
XFILLER_0_73_365 vssd1 vssd1 vccd1 vccd1 sky130_fd_sc_hd__decap_6
X_07244_ _01611_ _01612_ _01604_ vssd1 vssd1 vccd1 vccd1 _01614_ sky130_fd_sc_hd__a21o_1
XFILLER_0_73_398 vssd1 vssd1 vccd1 vccd1 sky130_ef_sc_hd__decap_12
XFILLER_0_5_175 vssd1 vssd1 vccd1 vccd1 sky130_ef_sc_hd__decap_12
X_07175_ net210 net218 net564 net572 vssd1 vssd1 vccd1 vccd1 _01545_ sky130_fd_sc_hd__nand4_4
X_06126_ net253 net599 net608 net244 vssd1 vssd1 vccd1 vccd1 _00504_ sky130_fd_sc_hd__a22o_1
X_06057_ net354 net495 vssd1 vssd1 vccd1 vccd1 _00436_ sky130_fd_sc_hd__nand2_1
Xfanout323 net326 vssd1 vssd1 vccd1 vccd1 net323 sky130_fd_sc_hd__clkbuf_4
XFILLER_0_1_381 vssd1 vssd1 vccd1 vccd1 sky130_fd_sc_hd__fill_2
Xfanout312 net313 vssd1 vssd1 vccd1 vccd1 net312 sky130_fd_sc_hd__clkbuf_4
Xfanout301 net302 vssd1 vssd1 vccd1 vccd1 net301 sky130_fd_sc_hd__clkbuf_4
Xfanout334 mul.a\[7\] vssd1 vssd1 vccd1 vccd1 net334 sky130_fd_sc_hd__buf_4
Xfanout345 net346 vssd1 vssd1 vccd1 vccd1 net345 sky130_fd_sc_hd__buf_4
Xfanout356 net357 vssd1 vssd1 vccd1 vccd1 net356 sky130_fd_sc_hd__clkbuf_4
Xfanout389 mul.a\[0\] vssd1 vssd1 vccd1 vccd1 net389 sky130_fd_sc_hd__clkbuf_4
Xfanout367 mul.a\[3\] vssd1 vssd1 vccd1 vccd1 net367 sky130_fd_sc_hd__buf_4
Xfanout378 net382 vssd1 vssd1 vccd1 vccd1 net378 sky130_fd_sc_hd__clkbuf_2
X_09816_ net187 net191 net435 net441 vssd1 vssd1 vccd1 vccd1 _04336_ sky130_fd_sc_hd__and4_1
X_09747_ _04222_ _04260_ vssd1 vssd1 vccd1 vccd1 _04261_ sky130_fd_sc_hd__and2_1
X_06959_ _01311_ _01328_ _01329_ vssd1 vssd1 vccd1 vccd1 _01331_ sky130_fd_sc_hd__or3_1
XFILLER_0_68_104 vssd1 vssd1 vccd1 vccd1 sky130_ef_sc_hd__decap_12
XTAP_1314 vssd1 vccd1 sky130_fd_sc_hd__tapvpwrvgnd_1
XTAP_1303 vssd1 vccd1 sky130_fd_sc_hd__tapvpwrvgnd_1
XFILLER_0_96_446 vssd1 vssd1 vccd1 vccd1 sky130_ef_sc_hd__decap_12
X_09678_ _04183_ _04184_ vssd1 vssd1 vccd1 vccd1 _04185_ sky130_fd_sc_hd__nor2_1
XTAP_1347 vssd1 vccd1 sky130_fd_sc_hd__tapvpwrvgnd_1
XTAP_1336 vssd1 vccd1 sky130_fd_sc_hd__tapvpwrvgnd_1
XTAP_1325 vssd1 vccd1 sky130_fd_sc_hd__tapvpwrvgnd_1
X_08629_ _02999_ _03000_ _03037_ _03038_ vssd1 vssd1 vccd1 vccd1 _03040_ sky130_fd_sc_hd__nor4_1
XFILLER_0_68_159 vssd1 vssd1 vccd1 vccd1 sky130_fd_sc_hd__decap_3
XFILLER_0_64_365 vssd1 vssd1 vccd1 vccd1 sky130_fd_sc_hd__fill_2
XFILLER_0_17_281 vssd1 vssd1 vccd1 vccd1 sky130_fd_sc_hd__decap_3
XFILLER_0_32_251 vssd1 vssd1 vccd1 vccd1 sky130_fd_sc_hd__fill_1
XFILLER_0_87_446 vssd1 vssd1 vccd1 vccd1 sky130_fd_sc_hd__fill_2
XFILLER_0_28_513 vssd1 vssd1 vccd1 vccd1 sky130_fd_sc_hd__fill_2
XFILLER_0_7_407 vssd1 vssd1 vccd1 vccd1 sky130_ef_sc_hd__decap_12
XFILLER_0_99_15 vssd1 vssd1 vccd1 vccd1 sky130_ef_sc_hd__decap_12
XFILLER_0_55_376 vssd1 vssd1 vccd1 vccd1 sky130_fd_sc_hd__decap_4
XFILLER_0_82_195 vssd1 vssd1 vccd1 vccd1 sky130_fd_sc_hd__fill_1
X_05290_ _03837_ _03869_ _03858_ vssd1 vssd1 vccd1 vccd1 _04560_ sky130_fd_sc_hd__a21o_1
XFILLER_0_23_273 vssd1 vssd1 vccd1 vccd1 sky130_fd_sc_hd__decap_4
XFILLER_0_11_446 vssd1 vssd1 vccd1 vccd1 sky130_fd_sc_hd__fill_2
XFILLER_0_11_435 vssd1 vssd1 vccd1 vccd1 sky130_fd_sc_hd__decap_4
X_08980_ net200 net471 _03420_ _03422_ vssd1 vssd1 vccd1 vccd1 _03423_ sky130_fd_sc_hd__a22oi_1
X_07931_ _02165_ _02172_ _02171_ vssd1 vssd1 vccd1 vccd1 _02304_ sky130_fd_sc_hd__a21oi_1
XFILLER_0_48_85 vssd1 vssd1 vccd1 vccd1 sky130_fd_sc_hd__decap_4
X_07862_ _02233_ _02234_ _02235_ vssd1 vssd1 vccd1 vccd1 _02236_ sky130_fd_sc_hd__and3_2
X_09601_ _03948_ _03950_ _04101_ vssd1 vssd1 vccd1 vccd1 _04102_ sky130_fd_sc_hd__a21oi_1
XFILLER_0_3_32 vssd1 vssd1 vccd1 vccd1 sky130_fd_sc_hd__decap_3
X_06813_ _01183_ _01184_ _01185_ vssd1 vssd1 vccd1 vccd1 _01186_ sky130_fd_sc_hd__nand3_1
X_07793_ _02161_ _02162_ vssd1 vssd1 vccd1 vccd1 _02164_ sky130_fd_sc_hd__xnor2_2
X_09532_ net162 net166 net477 net486 vssd1 vssd1 vccd1 vccd1 _04026_ sky130_fd_sc_hd__and4_1
X_06744_ net252 net552 net577 net225 vssd1 vssd1 vccd1 vccd1 _01117_ sky130_fd_sc_hd__a22o_1
X_09463_ _03939_ _03949_ vssd1 vssd1 vccd1 vccd1 _03951_ sky130_fd_sc_hd__xnor2_1
Xwire77 _04885_ vssd1 vssd1 vccd1 vccd1 net77 sky130_fd_sc_hd__clkbuf_1
X_06675_ net302 net504 net512 net292 vssd1 vssd1 vccd1 vccd1 _01049_ sky130_fd_sc_hd__a22o_1
XFILLER_0_93_416 vssd1 vssd1 vccd1 vccd1 sky130_fd_sc_hd__decap_8
X_08414_ _02789_ _02790_ _02801_ vssd1 vssd1 vccd1 vccd1 _02804_ sky130_fd_sc_hd__o21ai_2
XFILLER_0_80_50 vssd1 vssd1 vccd1 vccd1 sky130_fd_sc_hd__decap_4
X_09394_ net173 net481 net490 net167 vssd1 vssd1 vccd1 vccd1 _03875_ sky130_fd_sc_hd__a22o_1
X_05626_ _04784_ _04858_ _04857_ vssd1 vssd1 vccd1 vccd1 _04896_ sky130_fd_sc_hd__a21o_1
X_08345_ net176 net557 net584 net160 vssd1 vssd1 vccd1 vccd1 _02729_ sky130_fd_sc_hd__a22o_1
XFILLER_0_93_449 vssd1 vssd1 vccd1 vccd1 sky130_fd_sc_hd__decap_6
X_05557_ net357 net364 net533 net543 vssd1 vssd1 vccd1 vccd1 _04827_ sky130_fd_sc_hd__nand4_1
X_08276_ _02650_ _02651_ _02525_ _02527_ vssd1 vssd1 vccd1 vccd1 _02653_ sky130_fd_sc_hd__o211ai_2
XFILLER_0_61_335 vssd1 vssd1 vccd1 vccd1 sky130_fd_sc_hd__fill_1
X_05488_ _04755_ _04756_ _04754_ vssd1 vssd1 vccd1 vccd1 _04758_ sky130_fd_sc_hd__a21o_1
X_07227_ _01590_ _01595_ vssd1 vssd1 vccd1 vccd1 _01597_ sky130_fd_sc_hd__xnor2_1
X_07158_ net210 net235 net556 net578 _01384_ vssd1 vssd1 vccd1 vccd1 _01528_ sky130_fd_sc_hd__a41o_1
XFILLER_0_42_560 vssd1 vssd1 vccd1 vccd1 sky130_ef_sc_hd__decap_12
X_06109_ net272 net297 net553 net580 vssd1 vssd1 vccd1 vccd1 _00487_ sky130_fd_sc_hd__nand4_2
X_07089_ _01457_ _01458_ _01459_ vssd1 vssd1 vccd1 vccd1 _01460_ sky130_fd_sc_hd__nand3_1
Xfanout131 _00184_ vssd1 vssd1 vccd1 vccd1 net131 sky130_fd_sc_hd__clkbuf_2
Xfanout120 net121 vssd1 vssd1 vccd1 vccd1 net120 sky130_fd_sc_hd__clkbuf_4
Xfanout164 mul.a\[28\] vssd1 vssd1 vccd1 vccd1 net164 sky130_fd_sc_hd__clkbuf_4
Xfanout153 mul.a\[30\] vssd1 vssd1 vccd1 vccd1 net153 sky130_fd_sc_hd__buf_2
Xfanout142 _02210_ vssd1 vssd1 vccd1 vccd1 net142 sky130_fd_sc_hd__clkbuf_4
Xfanout197 net198 vssd1 vssd1 vccd1 vccd1 net197 sky130_fd_sc_hd__clkbuf_4
Xfanout186 net187 vssd1 vssd1 vccd1 vccd1 net186 sky130_fd_sc_hd__clkbuf_2
Xfanout175 net177 vssd1 vssd1 vccd1 vccd1 net175 sky130_fd_sc_hd__buf_2
XFILLER_0_96_243 vssd1 vssd1 vccd1 vccd1 sky130_fd_sc_hd__fill_2
XTAP_1122 vssd1 vccd1 sky130_fd_sc_hd__tapvpwrvgnd_1
XTAP_1111 vssd1 vccd1 sky130_fd_sc_hd__tapvpwrvgnd_1
XTAP_1100 vssd1 vccd1 sky130_fd_sc_hd__tapvpwrvgnd_1
XFILLER_0_69_446 vssd1 vssd1 vccd1 vccd1 sky130_fd_sc_hd__fill_2
XTAP_1155 vssd1 vccd1 sky130_fd_sc_hd__tapvpwrvgnd_1
XTAP_1144 vssd1 vccd1 sky130_fd_sc_hd__tapvpwrvgnd_1
XTAP_1133 vssd1 vccd1 sky130_fd_sc_hd__tapvpwrvgnd_1
XTAP_1199 vssd1 vccd1 sky130_fd_sc_hd__tapvpwrvgnd_1
XTAP_1188 vssd1 vccd1 sky130_fd_sc_hd__tapvpwrvgnd_1
XTAP_1177 vssd1 vccd1 sky130_fd_sc_hd__tapvpwrvgnd_1
XTAP_1166 vssd1 vccd1 sky130_fd_sc_hd__tapvpwrvgnd_1
XFILLER_0_92_471 vssd1 vssd1 vccd1 vccd1 sky130_fd_sc_hd__fill_1
XFILLER_0_37_376 vssd1 vssd1 vccd1 vccd1 sky130_ef_sc_hd__decap_12
XFILLER_0_92_493 vssd1 vssd1 vccd1 vccd1 sky130_fd_sc_hd__decap_6
XFILLER_0_52_335 vssd1 vssd1 vccd1 vccd1 sky130_fd_sc_hd__decap_8
XFILLER_0_100_15 vssd1 vssd1 vccd1 vccd1 sky130_ef_sc_hd__decap_12
XTAP_917 vssd1 vccd1 sky130_fd_sc_hd__tapvpwrvgnd_1
XTAP_906 vssd1 vccd1 sky130_fd_sc_hd__tapvpwrvgnd_1
XFILLER_0_85_17 vssd1 vssd1 vccd1 vccd1 sky130_fd_sc_hd__decap_6
XTAP_939 vssd1 vccd1 sky130_fd_sc_hd__tapvpwrvgnd_1
XTAP_928 vssd1 vccd1 sky130_fd_sc_hd__tapvpwrvgnd_1
XFILLER_0_20_298 vssd1 vssd1 vccd1 vccd1 sky130_fd_sc_hd__fill_1
XFILLER_0_87_254 vssd1 vssd1 vccd1 vccd1 sky130_fd_sc_hd__fill_1
X_06460_ _00833_ _00834_ vssd1 vssd1 vccd1 vccd1 _00836_ sky130_fd_sc_hd__xor2_2
XFILLER_0_75_449 vssd1 vssd1 vccd1 vccd1 sky130_fd_sc_hd__decap_4
X_05411_ _04361_ _04427_ _04416_ vssd1 vssd1 vccd1 vccd1 _04681_ sky130_fd_sc_hd__a21bo_1
X_08130_ _02498_ _02499_ _02500_ vssd1 vssd1 vccd1 vccd1 _02502_ sky130_fd_sc_hd__a21oi_1
XFILLER_0_16_516 vssd1 vssd1 vccd1 vccd1 sky130_fd_sc_hd__fill_1
XFILLER_0_28_365 vssd1 vssd1 vccd1 vccd1 sky130_ef_sc_hd__decap_12
X_06391_ net365 net373 net454 vssd1 vssd1 vccd1 vccd1 _00767_ sky130_fd_sc_hd__and3_1
X_05342_ _04609_ _04610_ _04607_ vssd1 vssd1 vccd1 vccd1 _04612_ sky130_fd_sc_hd__a21bo_1
X_08061_ _02431_ _02432_ _02131_ _02134_ vssd1 vssd1 vccd1 vccd1 _02434_ sky130_fd_sc_hd__o211a_1
X_05273_ _03268_ _03290_ _04503_ _04525_ vssd1 vssd1 vccd1 vccd1 _04536_ sky130_fd_sc_hd__a211oi_4
XFILLER_0_70_176 vssd1 vssd1 vccd1 vccd1 sky130_fd_sc_hd__fill_2
XFILLER_0_3_432 vssd1 vssd1 vccd1 vccd1 sky130_ef_sc_hd__decap_12
XFILLER_0_24_582 vssd1 vssd1 vccd1 vccd1 sky130_fd_sc_hd__decap_6
X_07012_ net234 net556 net578 net209 vssd1 vssd1 vccd1 vccd1 _01383_ sky130_fd_sc_hd__a22o_1
XFILLER_0_3_476 vssd1 vssd1 vccd1 vccd1 sky130_fd_sc_hd__fill_1
X_08963_ _03400_ _03401_ _03402_ vssd1 vssd1 vccd1 vccd1 _03404_ sky130_fd_sc_hd__nand3_1
X_07914_ _02152_ _02154_ vssd1 vssd1 vccd1 vccd1 _02287_ sky130_fd_sc_hd__nand2_1
XFILLER_0_45_3 vssd1 vssd1 vccd1 vccd1 sky130_fd_sc_hd__fill_2
X_08894_ net270 net278 net419 net425 vssd1 vssd1 vccd1 vccd1 _03329_ sky130_fd_sc_hd__and4_1
X_07845_ _02215_ _02216_ vssd1 vssd1 vccd1 vccd1 _02217_ sky130_fd_sc_hd__and2_1
X_07776_ _02138_ _02145_ vssd1 vssd1 vccd1 vccd1 _02147_ sky130_fd_sc_hd__xnor2_1
X_09515_ net415 net145 net131 net171 vssd1 vssd1 vccd1 vccd1 _04008_ sky130_fd_sc_hd__a22o_1
X_06727_ net210 net603 net613 net203 vssd1 vssd1 vccd1 vccd1 _01100_ sky130_fd_sc_hd__a22o_1
X_09446_ _03777_ _03780_ _03929_ _03931_ vssd1 vssd1 vccd1 vccd1 _03932_ sky130_fd_sc_hd__o211a_1
XFILLER_0_66_416 vssd1 vssd1 vccd1 vccd1 sky130_fd_sc_hd__decap_4
XFILLER_0_93_246 vssd1 vssd1 vccd1 vccd1 sky130_ef_sc_hd__decap_12
XFILLER_0_66_438 vssd1 vssd1 vccd1 vccd1 sky130_fd_sc_hd__decap_8
XFILLER_0_19_310 vssd1 vssd1 vccd1 vccd1 sky130_fd_sc_hd__decap_4
X_06658_ _01029_ _01030_ _01023_ vssd1 vssd1 vccd1 vccd1 _01032_ sky130_fd_sc_hd__o21ai_1
X_09377_ net140 _03854_ _03855_ _03856_ vssd1 vssd1 vccd1 vccd1 net58 sky130_fd_sc_hd__a31o_1
X_05609_ _04875_ _04876_ _04877_ vssd1 vssd1 vccd1 vccd1 _04879_ sky130_fd_sc_hd__a21oi_1
X_06589_ _00835_ _00956_ _00957_ vssd1 vssd1 vccd1 vccd1 _00963_ sky130_fd_sc_hd__a21o_1
X_08328_ net727 _02708_ _02540_ _02578_ vssd1 vssd1 vccd1 vccd1 _02710_ sky130_fd_sc_hd__o211a_1
XFILLER_0_74_493 vssd1 vssd1 vccd1 vccd1 sky130_fd_sc_hd__decap_3
X_08259_ _02621_ _02622_ _02633_ vssd1 vssd1 vccd1 vccd1 _02635_ sky130_fd_sc_hd__nor3_1
X_10083_ clknet_3_1_0_wb_clk_i _00079_ _00015_ vssd1 vssd1 vccd1 vccd1 mul.b\[12\]
+ sky130_fd_sc_hd__dfrtp_1
XFILLER_0_65_460 vssd1 vssd1 vccd1 vccd1 sky130_fd_sc_hd__fill_2
XFILLER_0_25_335 vssd1 vssd1 vccd1 vccd1 sky130_fd_sc_hd__fill_1
XFILLER_0_25_357 vssd1 vssd1 vccd1 vccd1 sky130_ef_sc_hd__decap_12
XFILLER_0_37_195 vssd1 vssd1 vccd1 vccd1 sky130_fd_sc_hd__decap_3
Xmax_cap106 _03430_ vssd1 vssd1 vccd1 vccd1 net106 sky130_fd_sc_hd__buf_1
XFILLER_0_13_519 vssd1 vssd1 vccd1 vccd1 sky130_fd_sc_hd__fill_2
XFILLER_0_20_56 vssd1 vssd1 vccd1 vccd1 sky130_fd_sc_hd__fill_1
XFILLER_0_20_67 vssd1 vssd1 vccd1 vccd1 sky130_fd_sc_hd__decap_8
XFILLER_0_96_27 vssd1 vssd1 vccd1 vccd1 sky130_fd_sc_hd__fill_1
XFILLER_0_0_424 vssd1 vssd1 vccd1 vccd1 sky130_ef_sc_hd__decap_12
XTAP_703 vssd1 vccd1 sky130_fd_sc_hd__tapvpwrvgnd_1
XTAP_714 vssd1 vccd1 sky130_fd_sc_hd__tapvpwrvgnd_1
XTAP_725 vssd1 vccd1 sky130_fd_sc_hd__tapvpwrvgnd_1
XTAP_736 vssd1 vccd1 sky130_fd_sc_hd__tapvpwrvgnd_1
XTAP_747 vssd1 vccd1 sky130_fd_sc_hd__tapvpwrvgnd_1
XTAP_758 vssd1 vccd1 sky130_fd_sc_hd__tapvpwrvgnd_1
XTAP_769 vssd1 vccd1 sky130_fd_sc_hd__tapvpwrvgnd_1
X_05960_ net319 net327 net530 net541 vssd1 vssd1 vccd1 vccd1 _00340_ sky130_fd_sc_hd__nand4_2
X_05891_ _05013_ _00269_ _00270_ vssd1 vssd1 vccd1 vccd1 _00272_ sky130_fd_sc_hd__nand3_1
XFILLER_0_45_31 vssd1 vssd1 vccd1 vccd1 sky130_fd_sc_hd__fill_2
X_07630_ net384 net398 _02001_ vssd1 vssd1 vccd1 vccd1 _02002_ sky130_fd_sc_hd__and3_1
XFILLER_0_88_530 vssd1 vssd1 vccd1 vccd1 sky130_fd_sc_hd__fill_2
X_07561_ _01930_ _01931_ _01771_ net658 vssd1 vssd1 vccd1 vccd1 _01934_ sky130_fd_sc_hd__o211ai_2
X_09300_ net294 net392 vssd1 vssd1 vccd1 vccd1 _03773_ sky130_fd_sc_hd__and2b_1
X_06512_ net389 net434 net440 net379 vssd1 vssd1 vccd1 vccd1 _00887_ sky130_fd_sc_hd__a22oi_1
X_07492_ _01702_ _01705_ _01860_ vssd1 vssd1 vccd1 vccd1 _01863_ sky130_fd_sc_hd__and3_1
X_09231_ _03504_ _03532_ _03530_ vssd1 vssd1 vccd1 vccd1 _03698_ sky130_fd_sc_hd__a21oi_2
X_06443_ _00816_ _00817_ _00763_ vssd1 vssd1 vccd1 vccd1 _00819_ sky130_fd_sc_hd__o21a_1
X_09162_ _03617_ net105 _03448_ _03450_ vssd1 vssd1 vccd1 vccd1 _03622_ sky130_fd_sc_hd__o211ai_4
X_06374_ _00632_ _00748_ vssd1 vssd1 vccd1 vccd1 _00750_ sky130_fd_sc_hd__xnor2_1
XFILLER_0_90_249 vssd1 vssd1 vccd1 vccd1 sky130_fd_sc_hd__decap_3
X_08113_ net193 net537 net549 net184 vssd1 vssd1 vccd1 vccd1 _02485_ sky130_fd_sc_hd__a22o_1
XFILLER_0_9_42 vssd1 vssd1 vccd1 vccd1 sky130_ef_sc_hd__decap_12
X_05325_ _04556_ _04557_ _04594_ vssd1 vssd1 vccd1 vccd1 _04595_ sky130_fd_sc_hd__or3_1
XFILLER_0_28_195 vssd1 vssd1 vccd1 vccd1 sky130_fd_sc_hd__fill_1
XFILLER_0_43_121 vssd1 vssd1 vccd1 vccd1 sky130_fd_sc_hd__fill_1
X_09093_ net120 _03546_ vssd1 vssd1 vccd1 vccd1 _03547_ sky130_fd_sc_hd__nand2_1
X_08044_ _02394_ _02395_ _02415_ vssd1 vssd1 vccd1 vccd1 _02417_ sky130_fd_sc_hd__a21o_1
XFILLER_0_9_97 vssd1 vssd1 vccd1 vccd1 sky130_fd_sc_hd__decap_8
XFILLER_0_12_530 vssd1 vssd1 vccd1 vccd1 sky130_fd_sc_hd__fill_2
X_05256_ _03028_ _03104_ _03093_ vssd1 vssd1 vccd1 vccd1 _04350_ sky130_fd_sc_hd__a21bo_1
X_05187_ _03563_ _03574_ _03410_ vssd1 vssd1 vccd1 vccd1 _03596_ sky130_fd_sc_hd__a21o_1
XFILLER_0_101_259 vssd1 vssd1 vccd1 vccd1 sky130_fd_sc_hd__fill_1
XFILLER_0_12_596 vssd1 vssd1 vccd1 vccd1 sky130_fd_sc_hd__fill_2
XFILLER_0_86_71 vssd1 vssd1 vccd1 vccd1 sky130_fd_sc_hd__fill_1
X_09995_ _04528_ _04531_ vssd1 vssd1 vccd1 vccd1 _04532_ sky130_fd_sc_hd__xnor2_2
X_08946_ _03229_ _03232_ vssd1 vssd1 vccd1 vccd1 _03386_ sky130_fd_sc_hd__and2b_1
XFILLER_0_86_93 vssd1 vssd1 vccd1 vccd1 sky130_fd_sc_hd__decap_3
X_08877_ net147 net566 vssd1 vssd1 vccd1 vccd1 _03310_ sky130_fd_sc_hd__and2_4
X_07828_ net324 net432 _02197_ _02198_ vssd1 vssd1 vccd1 vccd1 _02199_ sky130_fd_sc_hd__a22o_1
X_07759_ _02121_ _02129_ vssd1 vssd1 vccd1 vccd1 _02130_ sky130_fd_sc_hd__xnor2_1
XFILLER_0_39_427 vssd1 vssd1 vccd1 vccd1 sky130_fd_sc_hd__fill_1
XFILLER_0_94_577 vssd1 vssd1 vccd1 vccd1 sky130_fd_sc_hd__fill_1
X_09429_ _03759_ _03762_ _03911_ vssd1 vssd1 vccd1 vccd1 _03914_ sky130_fd_sc_hd__or3b_1
XFILLER_0_54_408 vssd1 vssd1 vccd1 vccd1 sky130_fd_sc_hd__decap_4
XFILLER_0_35_611 vssd1 vssd1 vccd1 vccd1 sky130_fd_sc_hd__fill_1
XFILLER_0_47_471 vssd1 vssd1 vccd1 vccd1 sky130_fd_sc_hd__fill_1
XFILLER_0_62_441 vssd1 vssd1 vccd1 vccd1 sky130_fd_sc_hd__decap_6
XFILLER_0_62_430 vssd1 vssd1 vccd1 vccd1 sky130_fd_sc_hd__fill_1
XFILLER_0_22_305 vssd1 vssd1 vccd1 vccd1 sky130_fd_sc_hd__decap_3
XFILLER_0_62_496 vssd1 vssd1 vccd1 vccd1 sky130_fd_sc_hd__decap_8
XFILLER_0_15_390 vssd1 vssd1 vccd1 vccd1 sky130_fd_sc_hd__fill_2
X_10135_ clknet_3_4_0_wb_clk_i _00129_ _00065_ vssd1 vssd1 vccd1 vccd1 mul.a\[30\]
+ sky130_fd_sc_hd__dfrtp_2
X_10066_ net643 vssd1 vssd1 vccd1 vccd1 _00062_ sky130_fd_sc_hd__inv_2
XFILLER_0_97_382 vssd1 vssd1 vccd1 vccd1 sky130_fd_sc_hd__decap_8
XFILLER_0_57_246 vssd1 vssd1 vccd1 vccd1 sky130_fd_sc_hd__decap_8
XFILLER_0_5_505 vssd1 vssd1 vccd1 vccd1 sky130_fd_sc_hd__decap_8
XFILLER_0_31_33 vssd1 vssd1 vccd1 vccd1 sky130_fd_sc_hd__decap_3
XFILLER_0_38_460 vssd1 vssd1 vccd1 vccd1 sky130_fd_sc_hd__fill_2
XFILLER_0_53_430 vssd1 vssd1 vccd1 vccd1 sky130_fd_sc_hd__fill_1
XFILLER_0_5_527 vssd1 vssd1 vccd1 vccd1 sky130_fd_sc_hd__fill_2
XFILLER_0_31_77 vssd1 vssd1 vccd1 vccd1 sky130_fd_sc_hd__fill_1
X_05110_ _02678_ _02689_ _02744_ vssd1 vssd1 vccd1 vccd1 _02755_ sky130_fd_sc_hd__nand3_1
XFILLER_0_53_496 vssd1 vssd1 vccd1 vccd1 sky130_fd_sc_hd__decap_8
X_06090_ net86 _00467_ _00363_ net703 vssd1 vssd1 vccd1 vccd1 _00469_ sky130_fd_sc_hd__o211ai_2
XFILLER_0_40_113 vssd1 vssd1 vccd1 vccd1 sky130_fd_sc_hd__decap_6
X_05041_ net11 net265 net134 vssd1 vssd1 vccd1 vccd1 _00114_ sky130_fd_sc_hd__mux2_1
XTAP_500 vssd1 vccd1 sky130_fd_sc_hd__tapvpwrvgnd_1
X_08800_ _03199_ _03200_ _03224_ vssd1 vssd1 vccd1 vccd1 _03227_ sky130_fd_sc_hd__or3_1
XTAP_511 vssd1 vccd1 sky130_fd_sc_hd__tapvpwrvgnd_1
XTAP_522 vssd1 vccd1 sky130_fd_sc_hd__tapvpwrvgnd_1
XTAP_533 vssd1 vccd1 sky130_fd_sc_hd__tapvpwrvgnd_1
X_09780_ _04142_ _04144_ _04140_ vssd1 vssd1 vccd1 vccd1 _04298_ sky130_fd_sc_hd__a21oi_1
XTAP_544 vssd1 vccd1 sky130_fd_sc_hd__tapvpwrvgnd_1
XTAP_555 vssd1 vccd1 sky130_fd_sc_hd__tapvpwrvgnd_1
XTAP_566 vssd1 vccd1 sky130_fd_sc_hd__tapvpwrvgnd_1
X_06992_ _01244_ _01259_ _01258_ vssd1 vssd1 vccd1 vccd1 _01363_ sky130_fd_sc_hd__o21ai_1
X_08731_ _02986_ _02988_ _03147_ _03149_ vssd1 vssd1 vccd1 vccd1 _03151_ sky130_fd_sc_hd__a211o_1
X_05943_ net305 net562 net570 net297 vssd1 vssd1 vccd1 vccd1 _00323_ sky130_fd_sc_hd__a22oi_4
XTAP_577 vssd1 vccd1 sky130_fd_sc_hd__tapvpwrvgnd_1
XTAP_599 vssd1 vccd1 sky130_fd_sc_hd__tapvpwrvgnd_1
XTAP_588 vssd1 vccd1 sky130_fd_sc_hd__tapvpwrvgnd_1
X_08662_ _03073_ _03074_ _02874_ _02909_ vssd1 vssd1 vccd1 vccd1 _03076_ sky130_fd_sc_hd__a211oi_2
XFILLER_0_56_85 vssd1 vssd1 vccd1 vccd1 sky130_fd_sc_hd__decap_6
X_05874_ _00151_ _00153_ _00252_ _00254_ vssd1 vssd1 vccd1 vccd1 _00255_ sky130_fd_sc_hd__a211o_2
X_07613_ _01978_ _01983_ _01984_ vssd1 vssd1 vccd1 vccd1 _01985_ sky130_fd_sc_hd__and3_1
X_08593_ _02996_ _02998_ _02805_ _02829_ vssd1 vssd1 vccd1 vccd1 _03000_ sky130_fd_sc_hd__o211a_1
X_07544_ _01749_ _01758_ _01757_ vssd1 vssd1 vccd1 vccd1 _01917_ sky130_fd_sc_hd__a21bo_1
XFILLER_0_48_224 vssd1 vssd1 vccd1 vccd1 sky130_fd_sc_hd__decap_3
X_07475_ _01841_ _01842_ _01843_ vssd1 vssd1 vccd1 vccd1 _01845_ sky130_fd_sc_hd__nand3_1
XFILLER_0_36_419 vssd1 vssd1 vccd1 vccd1 sky130_fd_sc_hd__fill_1
X_09214_ _03678_ vssd1 vssd1 vccd1 vccd1 _03679_ sky130_fd_sc_hd__inv_2
XFILLER_0_91_514 vssd1 vssd1 vccd1 vccd1 sky130_ef_sc_hd__decap_12
XFILLER_0_8_332 vssd1 vssd1 vccd1 vccd1 sky130_fd_sc_hd__decap_6
X_06426_ _00799_ _00800_ _00801_ vssd1 vssd1 vccd1 vccd1 _00802_ sky130_fd_sc_hd__nand3_1
XFILLER_0_91_558 vssd1 vssd1 vccd1 vccd1 sky130_fd_sc_hd__fill_2
XFILLER_0_8_387 vssd1 vssd1 vccd1 vccd1 sky130_fd_sc_hd__decap_4
X_09145_ net239 net430 _03601_ _03602_ vssd1 vssd1 vccd1 vccd1 _03603_ sky130_fd_sc_hd__a22o_1
XFILLER_0_8_398 vssd1 vssd1 vccd1 vccd1 sky130_fd_sc_hd__fill_1
XFILLER_0_16_154 vssd1 vssd1 vccd1 vccd1 sky130_ef_sc_hd__decap_12
X_06357_ _00731_ _00732_ vssd1 vssd1 vccd1 vccd1 _00733_ sky130_fd_sc_hd__and2_1
X_09076_ net119 _03526_ vssd1 vssd1 vccd1 vccd1 _03528_ sky130_fd_sc_hd__nand2_1
XFILLER_0_16_187 vssd1 vssd1 vccd1 vccd1 sky130_fd_sc_hd__decap_3
X_05308_ net377 net575 net585 net369 vssd1 vssd1 vccd1 vccd1 _04578_ sky130_fd_sc_hd__a22o_1
X_06288_ _00660_ _00663_ _00664_ vssd1 vssd1 vccd1 vccd1 _00665_ sky130_fd_sc_hd__and3_1
XFILLER_0_31_113 vssd1 vssd1 vccd1 vccd1 sky130_fd_sc_hd__fill_2
X_08027_ net316 net432 vssd1 vssd1 vccd1 vccd1 _02400_ sky130_fd_sc_hd__nand2_1
XFILLER_0_4_582 vssd1 vssd1 vccd1 vccd1 sky130_fd_sc_hd__fill_1
X_05239_ net301 net622 net630 net292 vssd1 vssd1 vccd1 vccd1 _04165_ sky130_fd_sc_hd__a22oi_1
X_09978_ _04490_ _04512_ vssd1 vssd1 vccd1 vccd1 _04513_ sky130_fd_sc_hd__xnor2_1
X_08929_ _03205_ _03211_ _03210_ vssd1 vssd1 vccd1 vccd1 _03368_ sky130_fd_sc_hd__a21oi_1
XFILLER_0_79_393 vssd1 vssd1 vccd1 vccd1 sky130_fd_sc_hd__decap_4
XFILLER_0_94_363 vssd1 vssd1 vccd1 vccd1 sky130_fd_sc_hd__fill_1
XFILLER_0_39_279 vssd1 vssd1 vccd1 vccd1 sky130_fd_sc_hd__fill_1
XFILLER_0_50_411 vssd1 vssd1 vccd1 vccd1 sky130_fd_sc_hd__fill_1
X_10118_ clknet_3_1_0_wb_clk_i _00112_ _00048_ vssd1 vssd1 vccd1 vccd1 mul.a\[13\]
+ sky130_fd_sc_hd__dfrtp_2
XFILLER_0_89_113 vssd1 vssd1 vccd1 vccd1 sky130_ef_sc_hd__decap_12
X_10049_ net640 vssd1 vssd1 vccd1 vccd1 _00045_ sky130_fd_sc_hd__inv_2
XFILLER_0_58_533 vssd1 vssd1 vccd1 vccd1 sky130_fd_sc_hd__fill_1
X_05590_ _04770_ _04776_ _04775_ vssd1 vssd1 vccd1 vccd1 _04860_ sky130_fd_sc_hd__a21boi_1
XFILLER_0_73_503 vssd1 vssd1 vccd1 vccd1 sky130_fd_sc_hd__fill_1
XFILLER_0_42_43 vssd1 vssd1 vccd1 vccd1 sky130_fd_sc_hd__fill_1
X_07260_ _01568_ _01569_ _01626_ _01627_ vssd1 vssd1 vccd1 vccd1 _01630_ sky130_fd_sc_hd__a2bb2o_1
X_06211_ _00585_ _00586_ _00417_ vssd1 vssd1 vccd1 vccd1 _00589_ sky130_fd_sc_hd__a21oi_1
X_07191_ _01410_ _01560_ vssd1 vssd1 vccd1 vccd1 _01561_ sky130_fd_sc_hd__nand2_1
XFILLER_0_5_357 vssd1 vssd1 vccd1 vccd1 sky130_fd_sc_hd__fill_1
XFILLER_0_13_124 vssd1 vssd1 vccd1 vccd1 sky130_ef_sc_hd__decap_12
X_06142_ _00406_ _00518_ vssd1 vssd1 vccd1 vccd1 _00520_ sky130_fd_sc_hd__or2_1
X_06073_ _00449_ _00450_ _00451_ vssd1 vssd1 vccd1 vccd1 _00452_ sky130_fd_sc_hd__nand3_4
X_09901_ _04428_ _04429_ vssd1 vssd1 vccd1 vccd1 _04430_ sky130_fd_sc_hd__nor2_1
X_05024_ net2 net3 _01870_ net37 vssd1 vssd1 vccd1 vccd1 _01881_ sky130_fd_sc_hd__or4b_4
XFILLER_0_41_499 vssd1 vssd1 vccd1 vccd1 sky130_fd_sc_hd__decap_4
XFILLER_0_6_54 vssd1 vssd1 vccd1 vccd1 sky130_ef_sc_hd__decap_12
Xfanout505 net507 vssd1 vssd1 vccd1 vccd1 net505 sky130_fd_sc_hd__buf_2
Xfanout538 net539 vssd1 vssd1 vccd1 vccd1 net538 sky130_fd_sc_hd__buf_2
Xfanout527 net529 vssd1 vssd1 vccd1 vccd1 net527 sky130_fd_sc_hd__buf_2
Xfanout516 net517 vssd1 vssd1 vccd1 vccd1 net516 sky130_fd_sc_hd__buf_6
XTAP_341 vssd1 vccd1 sky130_fd_sc_hd__tapvpwrvgnd_1
XTAP_330 vssd1 vccd1 sky130_fd_sc_hd__tapvpwrvgnd_1
X_09832_ _04352_ _04353_ vssd1 vssd1 vccd1 vccd1 _04354_ sky130_fd_sc_hd__nor2_1
X_09763_ _04278_ vssd1 vssd1 vccd1 vccd1 _04279_ sky130_fd_sc_hd__inv_2
Xfanout549 net550 vssd1 vssd1 vccd1 vccd1 net549 sky130_fd_sc_hd__clkbuf_2
XTAP_352 vssd1 vccd1 sky130_fd_sc_hd__tapvpwrvgnd_1
XTAP_374 vssd1 vccd1 sky130_fd_sc_hd__tapvpwrvgnd_1
XTAP_363 vssd1 vccd1 sky130_fd_sc_hd__tapvpwrvgnd_1
XTAP_385 vssd1 vccd1 sky130_fd_sc_hd__tapvpwrvgnd_1
X_08714_ net251 net260 net437 net443 vssd1 vssd1 vccd1 vccd1 _03132_ sky130_fd_sc_hd__nand4_4
XTAP_396 vssd1 vccd1 sky130_fd_sc_hd__tapvpwrvgnd_1
X_06975_ _01344_ _01345_ _01206_ net713 vssd1 vssd1 vccd1 vccd1 _01347_ sky130_fd_sc_hd__a211o_4
X_05926_ _00203_ _00206_ vssd1 vssd1 vccd1 vccd1 _00306_ sky130_fd_sc_hd__or2_1
Xrebuffer21 _00573_ vssd1 vssd1 vccd1 vccd1 net666 sky130_fd_sc_hd__buf_1
X_09694_ _04202_ vssd1 vssd1 vccd1 vccd1 _04203_ sky130_fd_sc_hd__inv_2
Xrebuffer10 net654 vssd1 vssd1 vccd1 vccd1 net655 sky130_fd_sc_hd__clkbuf_1
X_08645_ _03051_ _03055_ vssd1 vssd1 vccd1 vccd1 _03057_ sky130_fd_sc_hd__xor2_1
XFILLER_0_95_105 vssd1 vssd1 vccd1 vccd1 sky130_fd_sc_hd__decap_6
Xrebuffer32 _01767_ vssd1 vssd1 vccd1 vccd1 net677 sky130_fd_sc_hd__buf_1
Xrebuffer54 net697 vssd1 vssd1 vccd1 vccd1 net699 sky130_fd_sc_hd__clkbuf_1
X_05857_ _00234_ _00237_ vssd1 vssd1 vccd1 vccd1 _00238_ sky130_fd_sc_hd__xnor2_1
Xrebuffer43 net687 vssd1 vssd1 vccd1 vccd1 net688 sky130_fd_sc_hd__clkbuf_1
X_08576_ net240 net457 net464 net231 vssd1 vssd1 vccd1 vccd1 _02981_ sky130_fd_sc_hd__a22o_1
XPHY_14 vssd1 vssd1 vccd1 vccd1 sky130_fd_sc_hd__decap_3
XPHY_25 vssd1 vssd1 vccd1 vccd1 sky130_fd_sc_hd__decap_3
XPHY_36 vssd1 vssd1 vccd1 vccd1 sky130_fd_sc_hd__decap_3
XPHY_47 vssd1 vssd1 vccd1 vccd1 sky130_fd_sc_hd__decap_3
Xrebuffer65 _01472_ vssd1 vssd1 vccd1 vccd1 net721 sky130_fd_sc_hd__buf_6
XFILLER_0_76_330 vssd1 vssd1 vccd1 vccd1 sky130_fd_sc_hd__fill_2
X_07527_ _01891_ _01899_ vssd1 vssd1 vccd1 vccd1 _01900_ sky130_fd_sc_hd__xnor2_1
X_05788_ _04873_ _04875_ _04930_ _00169_ vssd1 vssd1 vccd1 vccd1 _00170_ sky130_fd_sc_hd__a211o_1
XPHY_58 vssd1 vssd1 vccd1 vccd1 sky130_fd_sc_hd__decap_3
XPHY_69 vssd1 vssd1 vccd1 vccd1 sky130_fd_sc_hd__decap_3
XFILLER_0_91_311 vssd1 vssd1 vccd1 vccd1 sky130_fd_sc_hd__fill_2
X_07458_ _01678_ _01681_ _01825_ vssd1 vssd1 vccd1 vccd1 _01826_ sky130_fd_sc_hd__o21a_1
X_07389_ _01754_ _01755_ _01756_ vssd1 vssd1 vccd1 vccd1 _01758_ sky130_fd_sc_hd__a21o_1
X_06409_ _00783_ _00784_ vssd1 vssd1 vccd1 vccd1 _00785_ sky130_fd_sc_hd__and2b_1
XFILLER_0_32_400 vssd1 vssd1 vccd1 vccd1 sky130_fd_sc_hd__decap_3
X_09128_ net178 net499 _03407_ _03408_ net516 vssd1 vssd1 vccd1 vccd1 _03584_ sky130_fd_sc_hd__a32o_1
XFILLER_0_32_411 vssd1 vssd1 vccd1 vccd1 sky130_fd_sc_hd__fill_1
X_09059_ net558 net579 net147 vssd1 vssd1 vccd1 vccd1 _03510_ sky130_fd_sc_hd__o21ai_2
XFILLER_0_32_477 vssd1 vssd1 vccd1 vccd1 sky130_fd_sc_hd__decap_3
XFILLER_0_12_190 vssd1 vssd1 vccd1 vccd1 sky130_fd_sc_hd__fill_1
XFILLER_0_87_617 vssd1 vssd1 vccd1 vccd1 sky130_fd_sc_hd__fill_1
XFILLER_0_86_138 vssd1 vssd1 vccd1 vccd1 sky130_fd_sc_hd__fill_2
XFILLER_0_86_149 vssd1 vssd1 vccd1 vccd1 sky130_fd_sc_hd__fill_1
XFILLER_0_55_503 vssd1 vssd1 vccd1 vccd1 sky130_fd_sc_hd__fill_1
XFILLER_0_94_182 vssd1 vssd1 vccd1 vccd1 sky130_fd_sc_hd__fill_2
XFILLER_0_27_238 vssd1 vssd1 vccd1 vccd1 sky130_fd_sc_hd__decap_3
XFILLER_0_12_79 vssd1 vssd1 vccd1 vccd1 sky130_fd_sc_hd__decap_4
XFILLER_0_12_57 vssd1 vssd1 vccd1 vccd1 sky130_fd_sc_hd__fill_1
XFILLER_0_2_305 vssd1 vssd1 vccd1 vccd1 sky130_fd_sc_hd__decap_3
XFILLER_0_2_349 vssd1 vssd1 vccd1 vccd1 sky130_fd_sc_hd__fill_2
XFILLER_0_10_127 vssd1 vssd1 vccd1 vccd1 sky130_fd_sc_hd__decap_4
X_06760_ _01130_ _01131_ _01014_ vssd1 vssd1 vccd1 vccd1 _01133_ sky130_fd_sc_hd__a21oi_1
X_05711_ _04934_ _04979_ _04980_ vssd1 vssd1 vccd1 vccd1 _04981_ sky130_fd_sc_hd__nand3_1
X_06691_ _01061_ _01062_ _01063_ vssd1 vssd1 vccd1 vccd1 _01065_ sky130_fd_sc_hd__a21o_1
X_08430_ _02818_ _02819_ _02813_ vssd1 vssd1 vccd1 vccd1 _02822_ sky130_fd_sc_hd__a21o_1
XFILLER_0_53_53 vssd1 vssd1 vccd1 vccd1 sky130_fd_sc_hd__decap_3
X_05642_ _04910_ _04911_ vssd1 vssd1 vccd1 vccd1 _04912_ sky130_fd_sc_hd__nor2_1
X_08361_ _02713_ _02746_ vssd1 vssd1 vccd1 vccd1 _02747_ sky130_fd_sc_hd__and2b_1
XFILLER_0_58_363 vssd1 vssd1 vccd1 vccd1 sky130_fd_sc_hd__fill_1
X_05573_ net280 net626 net634 net272 vssd1 vssd1 vccd1 vccd1 _04843_ sky130_fd_sc_hd__a22oi_1
XFILLER_0_46_503 vssd1 vssd1 vccd1 vccd1 sky130_fd_sc_hd__fill_1
X_08292_ _02668_ _02669_ vssd1 vssd1 vccd1 vccd1 _02671_ sky130_fd_sc_hd__xnor2_1
XFILLER_0_73_333 vssd1 vssd1 vccd1 vccd1 sky130_fd_sc_hd__decap_3
X_07312_ _01680_ _01679_ vssd1 vssd1 vccd1 vccd1 _01681_ sky130_fd_sc_hd__and2b_1
X_07243_ _01604_ _01611_ _01612_ vssd1 vssd1 vccd1 vccd1 _01613_ sky130_fd_sc_hd__nand3_1
XFILLER_0_5_187 vssd1 vssd1 vccd1 vccd1 sky130_fd_sc_hd__fill_1
X_07174_ net218 net564 net572 net210 vssd1 vssd1 vccd1 vccd1 _01544_ sky130_fd_sc_hd__a22o_1
XFILLER_0_75_3 vssd1 vssd1 vccd1 vccd1 sky130_fd_sc_hd__decap_4
XFILLER_0_14_477 vssd1 vssd1 vccd1 vccd1 sky130_fd_sc_hd__fill_1
XFILLER_0_14_499 vssd1 vssd1 vccd1 vccd1 sky130_fd_sc_hd__decap_3
X_06125_ net244 net253 net597 net608 vssd1 vssd1 vccd1 vccd1 _00503_ sky130_fd_sc_hd__and4_1
X_06056_ _00425_ _00433_ vssd1 vssd1 vccd1 vccd1 _00435_ sky130_fd_sc_hd__xor2_2
Xfanout313 net318 vssd1 vssd1 vccd1 vccd1 net313 sky130_fd_sc_hd__clkbuf_4
Xfanout302 net309 vssd1 vssd1 vccd1 vccd1 net302 sky130_fd_sc_hd__clkbuf_4
Xfanout324 net326 vssd1 vssd1 vccd1 vccd1 net324 sky130_fd_sc_hd__clkbuf_4
Xfanout335 net337 vssd1 vssd1 vccd1 vccd1 net335 sky130_fd_sc_hd__clkbuf_4
Xfanout346 net349 vssd1 vssd1 vccd1 vccd1 net346 sky130_fd_sc_hd__buf_2
Xfanout357 net358 vssd1 vssd1 vccd1 vccd1 net357 sky130_fd_sc_hd__buf_4
X_09815_ net191 net435 net441 net187 vssd1 vssd1 vccd1 vccd1 _04335_ sky130_fd_sc_hd__a22oi_1
Xfanout368 mul.a\[3\] vssd1 vssd1 vccd1 vccd1 net368 sky130_fd_sc_hd__buf_4
Xfanout379 net380 vssd1 vssd1 vccd1 vccd1 net379 sky130_fd_sc_hd__buf_2
X_09746_ _04223_ _04258_ vssd1 vssd1 vccd1 vccd1 _04260_ sky130_fd_sc_hd__xnor2_1
X_06958_ _01311_ _01328_ _01329_ vssd1 vssd1 vccd1 vccd1 _01330_ sky130_fd_sc_hd__nor3_1
XFILLER_0_69_617 vssd1 vssd1 vccd1 vccd1 sky130_fd_sc_hd__fill_2
X_05909_ _00225_ _00287_ _00288_ vssd1 vssd1 vccd1 vccd1 _00289_ sky130_fd_sc_hd__nand3_1
X_09677_ _04180_ _04182_ _04013_ _04015_ vssd1 vssd1 vccd1 vccd1 _04184_ sky130_fd_sc_hd__a211oi_1
XTAP_1304 vssd1 vccd1 sky130_fd_sc_hd__tapvpwrvgnd_1
X_08628_ _03035_ _03036_ _02862_ _02865_ vssd1 vssd1 vccd1 vccd1 _03038_ sky130_fd_sc_hd__o211a_1
XFILLER_0_68_116 vssd1 vssd1 vccd1 vccd1 sky130_fd_sc_hd__decap_4
X_06889_ _01260_ _01226_ vssd1 vssd1 vccd1 vccd1 _01261_ sky130_fd_sc_hd__nand2b_1
XTAP_1337 vssd1 vccd1 sky130_fd_sc_hd__tapvpwrvgnd_1
XTAP_1326 vssd1 vccd1 sky130_fd_sc_hd__tapvpwrvgnd_1
XTAP_1315 vssd1 vccd1 sky130_fd_sc_hd__tapvpwrvgnd_1
XFILLER_0_96_458 vssd1 vssd1 vccd1 vccd1 sky130_fd_sc_hd__decap_4
X_08559_ net224 net474 _02959_ _02960_ vssd1 vssd1 vccd1 vccd1 _02963_ sky130_fd_sc_hd__and4_1
XFILLER_0_37_558 vssd1 vssd1 vccd1 vccd1 sky130_fd_sc_hd__fill_2
XFILLER_0_52_506 vssd1 vssd1 vccd1 vccd1 sky130_fd_sc_hd__fill_2
XFILLER_0_20_425 vssd1 vssd1 vccd1 vccd1 sky130_fd_sc_hd__fill_2
XFILLER_0_99_252 vssd1 vssd1 vccd1 vccd1 sky130_fd_sc_hd__decap_8
XFILLER_0_99_241 vssd1 vssd1 vccd1 vccd1 sky130_fd_sc_hd__decap_4
XFILLER_0_90_29 vssd1 vssd1 vccd1 vccd1 sky130_ef_sc_hd__decap_12
XFILLER_0_7_419 vssd1 vssd1 vccd1 vccd1 sky130_ef_sc_hd__decap_12
XFILLER_0_99_27 vssd1 vssd1 vccd1 vccd1 sky130_ef_sc_hd__decap_12
XFILLER_0_55_388 vssd1 vssd1 vccd1 vccd1 sky130_fd_sc_hd__decap_4
Xrebuffer1 _02537_ vssd1 vssd1 vccd1 vccd1 net646 sky130_fd_sc_hd__buf_1
XFILLER_0_51_561 vssd1 vssd1 vccd1 vccd1 sky130_fd_sc_hd__decap_8
XFILLER_0_2_124 vssd1 vssd1 vccd1 vccd1 sky130_fd_sc_hd__decap_3
XFILLER_0_61_9 vssd1 vssd1 vccd1 vccd1 sky130_fd_sc_hd__decap_8
X_07930_ _02139_ _02144_ _02146_ vssd1 vssd1 vccd1 vccd1 _02303_ sky130_fd_sc_hd__a21o_1
XFILLER_0_48_42 vssd1 vssd1 vccd1 vccd1 sky130_fd_sc_hd__fill_1
X_07861_ _02074_ _02079_ _02073_ vssd1 vssd1 vccd1 vccd1 _02235_ sky130_fd_sc_hd__a21bo_1
XFILLER_0_47_7 vssd1 vssd1 vccd1 vccd1 sky130_fd_sc_hd__fill_1
X_07792_ net190 net565 _02161_ vssd1 vssd1 vccd1 vccd1 _02163_ sky130_fd_sc_hd__and3_1
X_09600_ _04089_ _04098_ vssd1 vssd1 vccd1 vccd1 _04101_ sky130_fd_sc_hd__xnor2_1
X_06812_ net269 net689 net546 net259 vssd1 vssd1 vccd1 vccd1 _01185_ sky130_fd_sc_hd__a22o_1
X_06743_ net225 net252 net552 net577 vssd1 vssd1 vccd1 vccd1 _01116_ sky130_fd_sc_hd__nand4_2
X_09531_ _04024_ vssd1 vssd1 vccd1 vccd1 _04025_ sky130_fd_sc_hd__inv_2
XFILLER_0_64_85 vssd1 vssd1 vccd1 vccd1 sky130_ef_sc_hd__decap_12
X_09462_ _03939_ _03949_ vssd1 vssd1 vccd1 vccd1 _03950_ sky130_fd_sc_hd__nand2_1
X_06674_ net311 net495 vssd1 vssd1 vccd1 vccd1 _01048_ sky130_fd_sc_hd__nand2_1
X_08413_ _02789_ _02790_ _02801_ vssd1 vssd1 vccd1 vccd1 _02803_ sky130_fd_sc_hd__or3_4
X_09393_ net167 net498 _03720_ _03721_ net516 vssd1 vssd1 vccd1 vccd1 _03874_ sky130_fd_sc_hd__a32o_1
X_05625_ _04816_ _04893_ _04894_ vssd1 vssd1 vccd1 vccd1 _04895_ sky130_fd_sc_hd__a21o_1
X_08344_ net171 mul.b\[7\] _02545_ _02544_ vssd1 vssd1 vccd1 vccd1 _02728_ sky130_fd_sc_hd__a31o_1
XFILLER_0_58_171 vssd1 vssd1 vccd1 vccd1 sky130_fd_sc_hd__fill_1
X_05556_ net364 net533 net543 net357 vssd1 vssd1 vccd1 vccd1 _04826_ sky130_fd_sc_hd__a22o_1
X_08275_ _02525_ _02527_ _02650_ _02651_ vssd1 vssd1 vccd1 vccd1 _02652_ sky130_fd_sc_hd__a211o_1
X_05487_ _04754_ _04755_ _04756_ vssd1 vssd1 vccd1 vccd1 _04757_ sky130_fd_sc_hd__nand3_1
XFILLER_0_89_60 vssd1 vssd1 vccd1 vccd1 sky130_ef_sc_hd__decap_12
X_07226_ _01595_ _01590_ vssd1 vssd1 vccd1 vccd1 _01596_ sky130_fd_sc_hd__and2b_1
XFILLER_0_6_485 vssd1 vssd1 vccd1 vccd1 sky130_fd_sc_hd__fill_2
XFILLER_0_14_274 vssd1 vssd1 vccd1 vccd1 sky130_ef_sc_hd__decap_12
X_07157_ _01404_ _01526_ vssd1 vssd1 vccd1 vccd1 _01527_ sky130_fd_sc_hd__xor2_1
XFILLER_0_42_572 vssd1 vssd1 vccd1 vccd1 sky130_fd_sc_hd__fill_2
X_06108_ _00485_ vssd1 vssd1 vccd1 vccd1 _00486_ sky130_fd_sc_hd__inv_2
X_07088_ _01317_ _01319_ _01318_ vssd1 vssd1 vccd1 vccd1 _01459_ sky130_fd_sc_hd__a21bo_1
Xfanout121 net122 vssd1 vssd1 vccd1 vccd1 net121 sky130_fd_sc_hd__clkbuf_4
X_06039_ _00415_ _00416_ _00298_ _00319_ vssd1 vssd1 vccd1 vccd1 _00418_ sky130_fd_sc_hd__a211oi_1
Xfanout154 mul.a\[30\] vssd1 vssd1 vccd1 vccd1 net154 sky130_fd_sc_hd__buf_4
Xfanout132 _01881_ vssd1 vssd1 vccd1 vccd1 net132 sky130_fd_sc_hd__buf_4
Xfanout143 _02210_ vssd1 vssd1 vccd1 vccd1 net143 sky130_fd_sc_hd__buf_2
Xfanout165 net696 vssd1 vssd1 vccd1 vccd1 net165 sky130_fd_sc_hd__buf_2
Xfanout176 net177 vssd1 vssd1 vccd1 vccd1 net176 sky130_fd_sc_hd__clkbuf_4
Xfanout198 mul.a\[23\] vssd1 vssd1 vccd1 vccd1 net198 sky130_fd_sc_hd__clkbuf_4
Xfanout187 mul.a\[24\] vssd1 vssd1 vccd1 vccd1 net187 sky130_fd_sc_hd__clkbuf_4
X_09729_ _04045_ _04047_ vssd1 vssd1 vccd1 vccd1 _04242_ sky130_fd_sc_hd__nand2_1
XTAP_1123 vssd1 vccd1 sky130_fd_sc_hd__tapvpwrvgnd_1
XTAP_1112 vssd1 vccd1 sky130_fd_sc_hd__tapvpwrvgnd_1
XTAP_1101 vssd1 vccd1 sky130_fd_sc_hd__tapvpwrvgnd_1
XTAP_1156 vssd1 vccd1 sky130_fd_sc_hd__tapvpwrvgnd_1
XTAP_1145 vssd1 vccd1 sky130_fd_sc_hd__tapvpwrvgnd_1
XTAP_1134 vssd1 vccd1 sky130_fd_sc_hd__tapvpwrvgnd_1
XTAP_1189 vssd1 vccd1 sky130_fd_sc_hd__tapvpwrvgnd_1
XTAP_1178 vssd1 vccd1 sky130_fd_sc_hd__tapvpwrvgnd_1
XTAP_1167 vssd1 vccd1 sky130_fd_sc_hd__tapvpwrvgnd_1
XFILLER_0_64_141 vssd1 vssd1 vccd1 vccd1 sky130_ef_sc_hd__decap_12
XFILLER_0_37_344 vssd1 vssd1 vccd1 vccd1 sky130_fd_sc_hd__fill_1
XFILLER_0_37_355 vssd1 vssd1 vccd1 vccd1 sky130_fd_sc_hd__fill_2
XFILLER_0_37_388 vssd1 vssd1 vccd1 vccd1 sky130_fd_sc_hd__decap_4
XFILLER_0_100_27 vssd1 vssd1 vccd1 vccd1 sky130_fd_sc_hd__fill_1
XFILLER_0_33_561 vssd1 vssd1 vccd1 vccd1 sky130_fd_sc_hd__fill_1
XTAP_907 vssd1 vccd1 sky130_fd_sc_hd__tapvpwrvgnd_1
XTAP_929 vssd1 vccd1 sky130_fd_sc_hd__tapvpwrvgnd_1
XTAP_918 vssd1 vccd1 sky130_fd_sc_hd__tapvpwrvgnd_1
XFILLER_0_18_67 vssd1 vssd1 vccd1 vccd1 sky130_fd_sc_hd__decap_3
XFILLER_0_47_119 vssd1 vssd1 vccd1 vccd1 sky130_ef_sc_hd__decap_12
X_05410_ _04274_ _04285_ _04296_ _04328_ vssd1 vssd1 vccd1 vccd1 _04680_ sky130_fd_sc_hd__a31o_1
XFILLER_0_90_409 vssd1 vssd1 vccd1 vccd1 sky130_fd_sc_hd__fill_1
XFILLER_0_71_601 vssd1 vssd1 vccd1 vccd1 sky130_fd_sc_hd__fill_2
X_06390_ net379 net447 vssd1 vssd1 vccd1 vccd1 _00766_ sky130_fd_sc_hd__nand2_1
XFILLER_0_16_539 vssd1 vssd1 vccd1 vccd1 sky130_fd_sc_hd__fill_2
XFILLER_0_28_377 vssd1 vssd1 vccd1 vccd1 sky130_ef_sc_hd__decap_12
X_05341_ _04607_ _04609_ _04610_ vssd1 vssd1 vccd1 vccd1 _04611_ sky130_fd_sc_hd__and3_1
XFILLER_0_70_133 vssd1 vssd1 vccd1 vccd1 sky130_fd_sc_hd__decap_6
X_08060_ _02131_ _02134_ _02431_ _02432_ vssd1 vssd1 vccd1 vccd1 _02433_ sky130_fd_sc_hd__a211oi_4
X_05272_ _04328_ _04339_ _04481_ _04492_ vssd1 vssd1 vccd1 vccd1 _04525_ sky130_fd_sc_hd__a2bb2oi_1
XFILLER_0_3_444 vssd1 vssd1 vccd1 vccd1 sky130_fd_sc_hd__decap_4
X_07011_ net209 net235 net552 net578 vssd1 vssd1 vccd1 vccd1 _01382_ sky130_fd_sc_hd__nand4_1
XFILLER_0_11_211 vssd1 vssd1 vccd1 vccd1 sky130_fd_sc_hd__fill_2
XFILLER_0_11_244 vssd1 vssd1 vccd1 vccd1 sky130_fd_sc_hd__fill_1
X_08962_ _03400_ _03401_ _03402_ vssd1 vssd1 vccd1 vccd1 _03403_ sky130_fd_sc_hd__a21o_1
X_08893_ net278 net419 net425 net270 vssd1 vssd1 vccd1 vccd1 _03328_ sky130_fd_sc_hd__a22oi_1
X_07913_ _02275_ _02282_ _02273_ vssd1 vssd1 vccd1 vccd1 _02286_ sky130_fd_sc_hd__o21ai_1
XFILLER_0_75_51 vssd1 vssd1 vccd1 vccd1 sky130_fd_sc_hd__decap_4
X_07844_ _02212_ _02214_ _02047_ _02049_ vssd1 vssd1 vccd1 vccd1 _02216_ sky130_fd_sc_hd__o211ai_1
XFILLER_0_38_3 vssd1 vssd1 vccd1 vccd1 sky130_ef_sc_hd__decap_12
XFILLER_0_75_84 vssd1 vssd1 vccd1 vccd1 sky130_fd_sc_hd__decap_6
X_07775_ _02138_ _02145_ vssd1 vssd1 vccd1 vccd1 _02146_ sky130_fd_sc_hd__and2b_1
X_09514_ _03849_ _03854_ _04005_ vssd1 vssd1 vccd1 vccd1 _04007_ sky130_fd_sc_hd__a21o_1
X_06726_ net203 net210 net603 net613 vssd1 vssd1 vccd1 vccd1 _01099_ sky130_fd_sc_hd__and4_1
X_09445_ _03930_ vssd1 vssd1 vccd1 vccd1 _03931_ sky130_fd_sc_hd__inv_2
XFILLER_0_66_406 vssd1 vssd1 vccd1 vccd1 sky130_fd_sc_hd__fill_1
X_06657_ _01023_ _01029_ _01030_ vssd1 vssd1 vccd1 vccd1 _01031_ sky130_fd_sc_hd__or3_1
XFILLER_0_38_119 vssd1 vssd1 vccd1 vccd1 sky130_fd_sc_hd__fill_1
XFILLER_0_93_225 vssd1 vssd1 vccd1 vccd1 sky130_fd_sc_hd__decap_6
XFILLER_0_59_480 vssd1 vssd1 vccd1 vccd1 sky130_fd_sc_hd__fill_2
X_05608_ _04875_ _04876_ _04877_ vssd1 vssd1 vccd1 vccd1 _04878_ sky130_fd_sc_hd__and3_1
XFILLER_0_93_258 vssd1 vssd1 vccd1 vccd1 sky130_fd_sc_hd__decap_8
X_09376_ net421 net145 net131 net177 vssd1 vssd1 vccd1 vccd1 _03856_ sky130_fd_sc_hd__a22o_1
XFILLER_0_74_450 vssd1 vssd1 vccd1 vccd1 sky130_fd_sc_hd__decap_4
XFILLER_0_19_366 vssd1 vssd1 vccd1 vccd1 sky130_fd_sc_hd__decap_3
X_06588_ _00596_ _00714_ _00836_ _00958_ vssd1 vssd1 vccd1 vccd1 _00962_ sky130_fd_sc_hd__and4_1
XFILLER_0_46_141 vssd1 vssd1 vccd1 vccd1 sky130_fd_sc_hd__fill_2
X_08327_ _02540_ _02578_ net727 _02708_ vssd1 vssd1 vccd1 vccd1 _02709_ sky130_fd_sc_hd__a211oi_4
X_05539_ _04718_ _04808_ vssd1 vssd1 vccd1 vccd1 _04809_ sky130_fd_sc_hd__xnor2_2
X_08258_ _02624_ _02632_ vssd1 vssd1 vccd1 vccd1 _02633_ sky130_fd_sc_hd__xnor2_1
XFILLER_0_61_144 vssd1 vssd1 vccd1 vccd1 sky130_ef_sc_hd__decap_12
XFILLER_0_34_336 vssd1 vssd1 vccd1 vccd1 sky130_fd_sc_hd__decap_8
X_07209_ _01577_ _01578_ vssd1 vssd1 vccd1 vccd1 _01579_ sky130_fd_sc_hd__or2_1
XFILLER_0_15_561 vssd1 vssd1 vccd1 vccd1 sky130_fd_sc_hd__fill_1
X_08189_ net317 net325 net421 net427 vssd1 vssd1 vccd1 vccd1 _02562_ sky130_fd_sc_hd__nand4_2
XFILLER_0_30_531 vssd1 vssd1 vccd1 vccd1 sky130_fd_sc_hd__fill_1
XFILLER_0_100_452 vssd1 vssd1 vccd1 vccd1 sky130_fd_sc_hd__fill_1
X_10082_ clknet_3_1_0_wb_clk_i _00078_ _00014_ vssd1 vssd1 vccd1 vccd1 mul.b\[11\]
+ sky130_fd_sc_hd__dfrtp_4
XFILLER_0_89_509 vssd1 vssd1 vccd1 vccd1 sky130_fd_sc_hd__fill_1
XFILLER_0_69_222 vssd1 vssd1 vccd1 vccd1 sky130_fd_sc_hd__fill_2
XFILLER_0_84_247 vssd1 vssd1 vccd1 vccd1 sky130_fd_sc_hd__decap_4
XFILLER_0_69_288 vssd1 vssd1 vccd1 vccd1 sky130_fd_sc_hd__decap_6
XFILLER_0_53_623 vssd1 vssd1 vccd1 vccd1 sky130_fd_sc_hd__fill_2
XFILLER_0_80_475 vssd1 vssd1 vccd1 vccd1 sky130_fd_sc_hd__fill_1
Xmax_cap107 _03277_ vssd1 vssd1 vccd1 vccd1 net107 sky130_fd_sc_hd__buf_1
XFILLER_0_25_369 vssd1 vssd1 vccd1 vccd1 sky130_fd_sc_hd__decap_6
XFILLER_0_0_403 vssd1 vssd1 vccd1 vccd1 sky130_fd_sc_hd__fill_2
XFILLER_0_40_328 vssd1 vssd1 vccd1 vccd1 sky130_fd_sc_hd__fill_1
XFILLER_0_96_39 vssd1 vssd1 vccd1 vccd1 sky130_ef_sc_hd__decap_12
XFILLER_0_0_436 vssd1 vssd1 vccd1 vccd1 sky130_ef_sc_hd__decap_12
XFILLER_0_29_11 vssd1 vssd1 vccd1 vccd1 sky130_fd_sc_hd__fill_2
XTAP_704 vssd1 vccd1 sky130_fd_sc_hd__tapvpwrvgnd_1
XTAP_715 vssd1 vccd1 sky130_fd_sc_hd__tapvpwrvgnd_1
XFILLER_0_29_55 vssd1 vssd1 vccd1 vccd1 sky130_fd_sc_hd__fill_1
XTAP_726 vssd1 vccd1 sky130_fd_sc_hd__tapvpwrvgnd_1
XTAP_737 vssd1 vccd1 sky130_fd_sc_hd__tapvpwrvgnd_1
XTAP_748 vssd1 vccd1 sky130_fd_sc_hd__tapvpwrvgnd_1
XTAP_759 vssd1 vccd1 sky130_fd_sc_hd__tapvpwrvgnd_1
X_05890_ _05013_ _00269_ _00270_ vssd1 vssd1 vccd1 vccd1 _00271_ sky130_fd_sc_hd__and3_1
X_07560_ _01932_ vssd1 vssd1 vccd1 vccd1 _01933_ sky130_fd_sc_hd__inv_2
X_06511_ _00884_ _00885_ vssd1 vssd1 vccd1 vccd1 _00886_ sky130_fd_sc_hd__and2_1
X_09230_ _03694_ _03696_ vssd1 vssd1 vccd1 vccd1 _03697_ sky130_fd_sc_hd__nor2_1
XFILLER_0_75_225 vssd1 vssd1 vccd1 vccd1 sky130_fd_sc_hd__decap_4
X_07491_ _01861_ vssd1 vssd1 vccd1 vccd1 _01862_ sky130_fd_sc_hd__inv_2
XFILLER_0_75_269 vssd1 vssd1 vccd1 vccd1 sky130_fd_sc_hd__decap_4
XFILLER_0_61_64 vssd1 vssd1 vccd1 vccd1 sky130_ef_sc_hd__decap_12
X_06442_ _00763_ _00816_ _00817_ vssd1 vssd1 vccd1 vccd1 _00818_ sky130_fd_sc_hd__nor3_2
X_09161_ _03448_ _03450_ _03617_ net105 vssd1 vssd1 vccd1 vccd1 _03621_ sky130_fd_sc_hd__a211o_1
X_06373_ _00632_ _00748_ vssd1 vssd1 vccd1 vccd1 _00749_ sky130_fd_sc_hd__or2_1
X_09092_ _03544_ _03545_ vssd1 vssd1 vccd1 vccd1 _03546_ sky130_fd_sc_hd__and2_1
X_08112_ _02443_ _02482_ vssd1 vssd1 vccd1 vccd1 _02484_ sky130_fd_sc_hd__xnor2_2
X_05324_ _04591_ _04593_ _04590_ vssd1 vssd1 vccd1 vccd1 _04594_ sky130_fd_sc_hd__a21oi_1
XFILLER_0_43_111 vssd1 vssd1 vccd1 vccd1 sky130_fd_sc_hd__fill_1
X_08043_ _02394_ _02395_ _02415_ vssd1 vssd1 vccd1 vccd1 _02416_ sky130_fd_sc_hd__nand3_4
XFILLER_0_9_54 vssd1 vssd1 vccd1 vccd1 sky130_fd_sc_hd__fill_2
XFILLER_0_16_369 vssd1 vssd1 vccd1 vccd1 sky130_fd_sc_hd__fill_1
X_05255_ _04307_ _04317_ _02612_ vssd1 vssd1 vccd1 vccd1 _04339_ sky130_fd_sc_hd__a21oi_1
XFILLER_0_43_199 vssd1 vssd1 vccd1 vccd1 sky130_ef_sc_hd__decap_12
XFILLER_0_101_81 vssd1 vssd1 vccd1 vccd1 sky130_fd_sc_hd__decap_3
XFILLER_0_3_274 vssd1 vssd1 vccd1 vccd1 sky130_fd_sc_hd__fill_2
X_05186_ _03410_ _03563_ _03574_ vssd1 vssd1 vccd1 vccd1 _03585_ sky130_fd_sc_hd__nand3_1
X_09994_ _04529_ _04530_ vssd1 vssd1 vccd1 vccd1 _04531_ sky130_fd_sc_hd__xnor2_1
XFILLER_0_12_586 vssd1 vssd1 vccd1 vccd1 sky130_fd_sc_hd__fill_2
XFILLER_0_86_83 vssd1 vssd1 vccd1 vccd1 sky130_fd_sc_hd__fill_1
X_08945_ _03383_ _03384_ vssd1 vssd1 vccd1 vccd1 _03385_ sky130_fd_sc_hd__nand2_1
XFILLER_0_98_306 vssd1 vssd1 vccd1 vccd1 sky130_fd_sc_hd__fill_2
X_08876_ _03305_ _03307_ _03129_ _03154_ vssd1 vssd1 vccd1 vccd1 _03309_ sky130_fd_sc_hd__o211a_1
X_07827_ net308 net316 net439 net446 vssd1 vssd1 vccd1 vccd1 _02198_ sky130_fd_sc_hd__nand4_4
X_07758_ _02126_ _02127_ vssd1 vssd1 vccd1 vccd1 _02129_ sky130_fd_sc_hd__xnor2_1
X_06709_ _00943_ net714 net693 _01082_ vssd1 vssd1 vccd1 vccd1 _01083_ sky130_fd_sc_hd__o211ai_4
X_07689_ net274 net485 _02058_ _02059_ vssd1 vssd1 vccd1 vccd1 _02061_ sky130_fd_sc_hd__nand4_2
X_09428_ _03759_ _03762_ _03911_ vssd1 vssd1 vccd1 vccd1 _03912_ sky130_fd_sc_hd__o21bai_1
X_09359_ _03834_ _03835_ _03836_ vssd1 vssd1 vccd1 vccd1 _03838_ sky130_fd_sc_hd__nor3_1
XFILLER_0_74_280 vssd1 vssd1 vccd1 vccd1 sky130_fd_sc_hd__decap_8
XFILLER_0_62_475 vssd1 vssd1 vccd1 vccd1 sky130_fd_sc_hd__fill_1
X_10134_ clknet_3_5_0_wb_clk_i _00128_ _00064_ vssd1 vssd1 vccd1 vccd1 mul.a\[29\]
+ sky130_fd_sc_hd__dfrtp_4
X_10065_ net644 vssd1 vssd1 vccd1 vccd1 _00061_ sky130_fd_sc_hd__inv_2
XFILLER_0_15_46 vssd1 vssd1 vccd1 vccd1 sky130_fd_sc_hd__decap_8
XFILLER_0_15_57 vssd1 vssd1 vccd1 vccd1 sky130_ef_sc_hd__decap_12
XFILLER_0_15_79 vssd1 vssd1 vccd1 vccd1 sky130_ef_sc_hd__decap_12
XFILLER_0_25_111 vssd1 vssd1 vccd1 vccd1 sky130_fd_sc_hd__fill_1
XFILLER_0_80_261 vssd1 vssd1 vccd1 vccd1 sky130_fd_sc_hd__fill_1
XFILLER_0_13_317 vssd1 vssd1 vccd1 vccd1 sky130_fd_sc_hd__fill_1
X_05040_ net12 net256 net134 vssd1 vssd1 vccd1 vccd1 _00115_ sky130_fd_sc_hd__mux2_1
XFILLER_0_0_222 vssd1 vssd1 vccd1 vccd1 sky130_fd_sc_hd__fill_2
XFILLER_0_0_277 vssd1 vssd1 vccd1 vccd1 sky130_fd_sc_hd__decap_3
XFILLER_0_0_288 vssd1 vssd1 vccd1 vccd1 sky130_fd_sc_hd__fill_1
XTAP_501 vssd1 vccd1 sky130_fd_sc_hd__tapvpwrvgnd_1
XTAP_512 vssd1 vccd1 sky130_fd_sc_hd__tapvpwrvgnd_1
XTAP_523 vssd1 vccd1 sky130_fd_sc_hd__tapvpwrvgnd_1
XTAP_534 vssd1 vccd1 sky130_fd_sc_hd__tapvpwrvgnd_1
XTAP_545 vssd1 vccd1 sky130_fd_sc_hd__tapvpwrvgnd_1
XTAP_556 vssd1 vccd1 sky130_fd_sc_hd__tapvpwrvgnd_1
XTAP_567 vssd1 vccd1 sky130_fd_sc_hd__tapvpwrvgnd_1
X_06991_ net139 _01360_ _01361_ _01362_ vssd1 vssd1 vccd1 vccd1 net41 sky130_fd_sc_hd__a31o_1
X_08730_ _02986_ _02988_ _03147_ _03149_ vssd1 vssd1 vccd1 vccd1 _03150_ sky130_fd_sc_hd__a211oi_2
X_05942_ _00319_ _00320_ _00199_ _00220_ vssd1 vssd1 vccd1 vccd1 _00322_ sky130_fd_sc_hd__o211a_1
XTAP_589 vssd1 vccd1 sky130_fd_sc_hd__tapvpwrvgnd_1
XTAP_578 vssd1 vccd1 sky130_fd_sc_hd__tapvpwrvgnd_1
X_08661_ _02874_ _02909_ _03073_ _03074_ vssd1 vssd1 vccd1 vccd1 _03075_ sky130_fd_sc_hd__o211a_1
XFILLER_0_56_75 vssd1 vssd1 vccd1 vccd1 sky130_fd_sc_hd__fill_1
X_05873_ _00250_ _00251_ _00233_ vssd1 vssd1 vccd1 vccd1 _00254_ sky130_fd_sc_hd__a21oi_1
X_07612_ _01981_ _01982_ _01839_ vssd1 vssd1 vccd1 vccd1 _01984_ sky130_fd_sc_hd__a21o_1
X_08592_ _02805_ _02829_ _02996_ _02998_ vssd1 vssd1 vccd1 vccd1 _02999_ sky130_fd_sc_hd__a211oi_4
XFILLER_0_72_52 vssd1 vssd1 vccd1 vccd1 sky130_ef_sc_hd__decap_12
XFILLER_0_72_41 vssd1 vssd1 vccd1 vccd1 sky130_fd_sc_hd__decap_8
X_07543_ _01913_ _01914_ _01907_ vssd1 vssd1 vccd1 vccd1 _01916_ sky130_fd_sc_hd__a21o_1
X_07474_ _01841_ _01842_ _01843_ vssd1 vssd1 vccd1 vccd1 _01844_ sky130_fd_sc_hd__a21o_1
X_09213_ _03507_ _03515_ _03514_ vssd1 vssd1 vccd1 vccd1 _03678_ sky130_fd_sc_hd__a21boi_1
XFILLER_0_91_526 vssd1 vssd1 vccd1 vccd1 sky130_fd_sc_hd__decap_3
X_06425_ _00674_ _00676_ _00675_ vssd1 vssd1 vccd1 vccd1 _00801_ sky130_fd_sc_hd__a21bo_1
X_09144_ net222 net233 net437 net442 vssd1 vssd1 vccd1 vccd1 _03602_ sky130_fd_sc_hd__nand4_2
XFILLER_0_16_166 vssd1 vssd1 vccd1 vccd1 sky130_fd_sc_hd__decap_4
X_06356_ _00610_ _00615_ _00730_ vssd1 vssd1 vccd1 vccd1 _00732_ sky130_fd_sc_hd__or3_1
XFILLER_0_44_475 vssd1 vssd1 vccd1 vccd1 sky130_fd_sc_hd__fill_1
X_09075_ net119 _03526_ vssd1 vssd1 vccd1 vccd1 _03527_ sky130_fd_sc_hd__or2_1
X_05307_ _03236_ _03312_ vssd1 vssd1 vccd1 vccd1 _04577_ sky130_fd_sc_hd__or2_1
X_06287_ net363 net469 _00661_ _00662_ vssd1 vssd1 vccd1 vccd1 _00664_ sky130_fd_sc_hd__a22o_1
X_08026_ net445 _02398_ _02397_ vssd1 vssd1 vccd1 vccd1 _02399_ sky130_fd_sc_hd__a21bo_1
X_05238_ net292 net301 net622 net630 vssd1 vssd1 vccd1 vccd1 _04154_ sky130_fd_sc_hd__and4_1
XFILLER_0_31_169 vssd1 vssd1 vccd1 vccd1 sky130_fd_sc_hd__decap_4
X_05169_ _03367_ _03389_ vssd1 vssd1 vccd1 vccd1 _03399_ sky130_fd_sc_hd__and2b_1
X_09977_ _04491_ _04511_ vssd1 vssd1 vccd1 vccd1 _04512_ sky130_fd_sc_hd__xnor2_1
X_08928_ _03355_ _03364_ vssd1 vssd1 vccd1 vccd1 _03366_ sky130_fd_sc_hd__xor2_1
X_08859_ net230 net449 _03288_ _03289_ vssd1 vssd1 vccd1 vccd1 _03291_ sky130_fd_sc_hd__o2bb2a_1
XFILLER_0_86_309 vssd1 vssd1 vccd1 vccd1 sky130_fd_sc_hd__fill_1
XFILLER_0_67_501 vssd1 vssd1 vccd1 vccd1 sky130_fd_sc_hd__decap_3
XFILLER_0_67_512 vssd1 vssd1 vccd1 vccd1 sky130_ef_sc_hd__decap_12
XFILLER_0_39_225 vssd1 vssd1 vccd1 vccd1 sky130_fd_sc_hd__decap_4
XFILLER_0_47_291 vssd1 vssd1 vccd1 vccd1 sky130_fd_sc_hd__decap_4
XFILLER_0_2_509 vssd1 vssd1 vccd1 vccd1 sky130_fd_sc_hd__decap_3
XFILLER_0_30_180 vssd1 vssd1 vccd1 vccd1 sky130_fd_sc_hd__fill_1
X_10117_ clknet_3_1_0_wb_clk_i _00111_ _00047_ vssd1 vssd1 vccd1 vccd1 mul.a\[12\]
+ sky130_fd_sc_hd__dfrtp_1
XFILLER_0_26_23 vssd1 vssd1 vccd1 vccd1 sky130_fd_sc_hd__fill_1
X_10048_ net639 vssd1 vssd1 vccd1 vccd1 _00044_ sky130_fd_sc_hd__inv_2
XFILLER_0_89_125 vssd1 vssd1 vccd1 vccd1 sky130_fd_sc_hd__decap_3
XFILLER_0_26_45 vssd1 vssd1 vccd1 vccd1 sky130_fd_sc_hd__fill_2
XFILLER_0_42_11 vssd1 vssd1 vccd1 vccd1 sky130_fd_sc_hd__decap_3
XFILLER_0_58_556 vssd1 vssd1 vccd1 vccd1 sky130_ef_sc_hd__decap_12
XFILLER_0_73_515 vssd1 vssd1 vccd1 vccd1 sky130_fd_sc_hd__decap_3
XFILLER_0_85_397 vssd1 vssd1 vccd1 vccd1 sky130_fd_sc_hd__fill_1
X_06210_ _00417_ _00585_ _00586_ vssd1 vssd1 vccd1 vccd1 _00588_ sky130_fd_sc_hd__nand3_1
XFILLER_0_60_209 vssd1 vssd1 vccd1 vccd1 sky130_fd_sc_hd__decap_3
X_07190_ _01270_ _01411_ vssd1 vssd1 vccd1 vccd1 _01560_ sky130_fd_sc_hd__nand2b_1
X_06141_ _00406_ _00518_ vssd1 vssd1 vccd1 vccd1 _00519_ sky130_fd_sc_hd__nand2_1
XFILLER_0_77_7 vssd1 vssd1 vccd1 vccd1 sky130_fd_sc_hd__fill_1
XFILLER_0_13_136 vssd1 vssd1 vccd1 vccd1 sky130_fd_sc_hd__decap_8
XFILLER_0_13_147 vssd1 vssd1 vccd1 vccd1 sky130_fd_sc_hd__fill_1
X_06072_ _00338_ _00346_ _00345_ vssd1 vssd1 vccd1 vccd1 _00451_ sky130_fd_sc_hd__a21bo_1
XFILLER_0_41_467 vssd1 vssd1 vccd1 vccd1 sky130_ef_sc_hd__decap_12
X_09900_ _04266_ _04290_ _04426_ vssd1 vssd1 vccd1 vccd1 _04429_ sky130_fd_sc_hd__and3_1
XFILLER_0_6_22 vssd1 vssd1 vccd1 vccd1 sky130_fd_sc_hd__decap_6
X_05023_ net4 val_a_reg.wb_helper.wbs_ack_o net38 vssd1 vssd1 vccd1 vccd1 _01870_
+ sky130_fd_sc_hd__nand3_1
Xwire8 _03768_ vssd1 vssd1 vccd1 vccd1 net718 sky130_fd_sc_hd__buf_1
Xfanout506 net507 vssd1 vssd1 vccd1 vccd1 net506 sky130_fd_sc_hd__buf_4
XFILLER_0_6_66 vssd1 vssd1 vccd1 vccd1 sky130_fd_sc_hd__decap_4
XFILLER_0_1_564 vssd1 vssd1 vccd1 vccd1 sky130_fd_sc_hd__fill_2
Xfanout539 mul.b\[11\] vssd1 vssd1 vccd1 vccd1 net539 sky130_fd_sc_hd__buf_6
Xfanout528 net529 vssd1 vssd1 vccd1 vccd1 net528 sky130_fd_sc_hd__clkbuf_2
XTAP_342 vssd1 vccd1 sky130_fd_sc_hd__tapvpwrvgnd_1
XTAP_331 vssd1 vccd1 sky130_fd_sc_hd__tapvpwrvgnd_1
XTAP_320 vssd1 vccd1 sky130_fd_sc_hd__tapvpwrvgnd_1
X_09831_ _04183_ _04187_ _04351_ vssd1 vssd1 vccd1 vccd1 _04353_ sky130_fd_sc_hd__nor3_1
Xfanout517 net520 vssd1 vssd1 vccd1 vccd1 net517 sky130_fd_sc_hd__buf_6
X_09762_ _03670_ _04122_ _04120_ vssd1 vssd1 vccd1 vccd1 _04278_ sky130_fd_sc_hd__a21oi_1
XTAP_353 vssd1 vccd1 sky130_fd_sc_hd__tapvpwrvgnd_1
XTAP_375 vssd1 vccd1 sky130_fd_sc_hd__tapvpwrvgnd_1
XTAP_364 vssd1 vccd1 sky130_fd_sc_hd__tapvpwrvgnd_1
X_06974_ net726 net713 _01344_ _01345_ vssd1 vssd1 vccd1 vccd1 _01346_ sky130_fd_sc_hd__o211ai_4
X_08713_ net260 net437 net443 net250 vssd1 vssd1 vccd1 vccd1 _03131_ sky130_fd_sc_hd__a22o_1
X_05925_ _00303_ _00304_ vssd1 vssd1 vccd1 vccd1 _00305_ sky130_fd_sc_hd__xnor2_1
XTAP_386 vssd1 vccd1 sky130_fd_sc_hd__tapvpwrvgnd_1
XTAP_397 vssd1 vccd1 sky130_fd_sc_hd__tapvpwrvgnd_1
Xrebuffer11 _01769_ vssd1 vssd1 vccd1 vccd1 net656 sky130_fd_sc_hd__buf_1
XFILLER_0_20_3 vssd1 vssd1 vccd1 vccd1 sky130_ef_sc_hd__decap_12
X_09693_ net172 net180 net454 net462 vssd1 vssd1 vccd1 vccd1 _04202_ sky130_fd_sc_hd__and4_1
X_08644_ _03051_ _03055_ vssd1 vssd1 vccd1 vccd1 _03056_ sky130_fd_sc_hd__and2_1
XFILLER_0_68_309 vssd1 vssd1 vccd1 vccd1 sky130_fd_sc_hd__fill_1
Xrebuffer55 net697 vssd1 vssd1 vccd1 vccd1 net700 sky130_fd_sc_hd__clkbuf_1
X_05856_ _00235_ _00236_ vssd1 vssd1 vccd1 vccd1 _00237_ sky130_fd_sc_hd__nor2_1
Xrebuffer33 _00594_ vssd1 vssd1 vccd1 vccd1 net678 sky130_fd_sc_hd__clkbuf_1
Xrebuffer22 _01472_ vssd1 vssd1 vccd1 vccd1 net667 sky130_fd_sc_hd__buf_1
Xrebuffer44 net536 vssd1 vssd1 vccd1 vccd1 net689 sky130_fd_sc_hd__buf_1
X_08575_ _02978_ _02979_ vssd1 vssd1 vccd1 vccd1 _02980_ sky130_fd_sc_hd__xnor2_2
XPHY_15 vssd1 vssd1 vccd1 vccd1 sky130_fd_sc_hd__decap_3
X_05787_ _00166_ _00167_ vssd1 vssd1 vccd1 vccd1 _00169_ sky130_fd_sc_hd__xnor2_1
XPHY_26 vssd1 vssd1 vccd1 vccd1 sky130_fd_sc_hd__decap_3
XPHY_37 vssd1 vssd1 vccd1 vccd1 sky130_fd_sc_hd__decap_3
Xrebuffer66 net721 vssd1 vssd1 vccd1 vccd1 net722 sky130_fd_sc_hd__clkbuf_1
X_07526_ _01897_ _01898_ vssd1 vssd1 vccd1 vccd1 _01899_ sky130_fd_sc_hd__and2b_1
XPHY_48 vssd1 vssd1 vccd1 vccd1 sky130_fd_sc_hd__decap_3
XPHY_59 vssd1 vssd1 vccd1 vccd1 sky130_fd_sc_hd__decap_3
XFILLER_0_8_163 vssd1 vssd1 vccd1 vccd1 sky130_fd_sc_hd__decap_8
XFILLER_0_17_420 vssd1 vssd1 vccd1 vccd1 sky130_fd_sc_hd__fill_1
X_07457_ _01812_ _01823_ vssd1 vssd1 vccd1 vccd1 _01825_ sky130_fd_sc_hd__xnor2_2
XFILLER_0_91_389 vssd1 vssd1 vccd1 vccd1 sky130_fd_sc_hd__decap_3
X_07388_ _01754_ _01755_ _01756_ vssd1 vssd1 vccd1 vccd1 _01757_ sky130_fd_sc_hd__nand3_1
X_06408_ net344 net478 net487 net338 vssd1 vssd1 vccd1 vccd1 _00784_ sky130_fd_sc_hd__a22o_1
XFILLER_0_44_250 vssd1 vssd1 vccd1 vccd1 sky130_fd_sc_hd__fill_2
X_09127_ net185 net192 net480 net489 _03424_ vssd1 vssd1 vccd1 vccd1 _03583_ sky130_fd_sc_hd__a41o_1
XFILLER_0_17_497 vssd1 vssd1 vccd1 vccd1 sky130_fd_sc_hd__decap_6
X_06339_ _00714_ _00715_ vssd1 vssd1 vccd1 vccd1 _00716_ sky130_fd_sc_hd__xor2_1
XFILLER_0_44_272 vssd1 vssd1 vccd1 vccd1 sky130_fd_sc_hd__fill_2
X_09058_ net326 net136 _03314_ _03163_ vssd1 vssd1 vccd1 vccd1 _03508_ sky130_fd_sc_hd__a2bb2o_1
X_08009_ net246 net502 _02227_ _02228_ net510 vssd1 vssd1 vccd1 vccd1 _02382_ sky130_fd_sc_hd__a32o_1
XFILLER_0_99_401 vssd1 vssd1 vccd1 vccd1 sky130_fd_sc_hd__fill_2
XFILLER_0_99_445 vssd1 vssd1 vccd1 vccd1 sky130_fd_sc_hd__decap_3
XFILLER_0_59_309 vssd1 vssd1 vccd1 vccd1 sky130_fd_sc_hd__fill_1
XFILLER_0_67_386 vssd1 vssd1 vccd1 vccd1 sky130_fd_sc_hd__fill_2
XFILLER_0_94_194 vssd1 vssd1 vccd1 vccd1 sky130_fd_sc_hd__fill_2
XFILLER_0_82_378 vssd1 vssd1 vccd1 vccd1 sky130_fd_sc_hd__decap_8
XFILLER_0_37_66 vssd1 vssd1 vccd1 vccd1 sky130_fd_sc_hd__fill_1
XFILLER_0_53_10 vssd1 vssd1 vccd1 vccd1 sky130_fd_sc_hd__decap_4
X_05710_ net297 net589 _04977_ _04978_ vssd1 vssd1 vccd1 vccd1 _04980_ sky130_fd_sc_hd__nand4_2
X_06690_ _01061_ _01062_ _01063_ vssd1 vssd1 vccd1 vccd1 _01064_ sky130_fd_sc_hd__nand3_2
X_05641_ _04852_ _04854_ _04909_ vssd1 vssd1 vccd1 vccd1 _04911_ sky130_fd_sc_hd__and3_1
X_08360_ _02724_ _02745_ vssd1 vssd1 vccd1 vccd1 _02746_ sky130_fd_sc_hd__xor2_2
XFILLER_0_58_320 vssd1 vssd1 vccd1 vccd1 sky130_fd_sc_hd__fill_1
XFILLER_0_85_150 vssd1 vssd1 vccd1 vccd1 sky130_fd_sc_hd__decap_4
X_05572_ _04766_ _04840_ vssd1 vssd1 vccd1 vccd1 _04842_ sky130_fd_sc_hd__xnor2_2
X_07311_ _01404_ _01524_ _01525_ _01529_ vssd1 vssd1 vccd1 vccd1 _01680_ sky130_fd_sc_hd__a31oi_2
X_08291_ net169 net565 _02668_ vssd1 vssd1 vccd1 vccd1 _02670_ sky130_fd_sc_hd__and3_1
XFILLER_0_61_518 vssd1 vssd1 vccd1 vccd1 sky130_fd_sc_hd__decap_6
X_07242_ _01608_ _01609_ _01610_ vssd1 vssd1 vccd1 vccd1 _01612_ sky130_fd_sc_hd__a21o_1
XFILLER_0_73_389 vssd1 vssd1 vccd1 vccd1 sky130_fd_sc_hd__decap_3
XFILLER_0_5_122 vssd1 vssd1 vccd1 vccd1 sky130_fd_sc_hd__fill_1
X_07173_ _01434_ _01436_ vssd1 vssd1 vccd1 vccd1 _01543_ sky130_fd_sc_hd__or2_1
X_06124_ _00500_ _00501_ vssd1 vssd1 vccd1 vccd1 _00502_ sky130_fd_sc_hd__nand2_1
XFILLER_0_41_264 vssd1 vssd1 vccd1 vccd1 sky130_fd_sc_hd__fill_1
XFILLER_0_41_275 vssd1 vssd1 vccd1 vccd1 sky130_fd_sc_hd__fill_2
XFILLER_0_68_3 vssd1 vssd1 vccd1 vccd1 sky130_fd_sc_hd__decap_8
X_06055_ _00425_ _00433_ vssd1 vssd1 vccd1 vccd1 _00434_ sky130_fd_sc_hd__and2_1
Xfanout314 net318 vssd1 vssd1 vccd1 vccd1 net314 sky130_fd_sc_hd__buf_4
Xfanout303 net309 vssd1 vssd1 vccd1 vccd1 net303 sky130_fd_sc_hd__clkbuf_4
Xfanout325 net326 vssd1 vssd1 vccd1 vccd1 net325 sky130_fd_sc_hd__buf_2
Xfanout347 net349 vssd1 vssd1 vccd1 vccd1 net347 sky130_fd_sc_hd__buf_4
Xfanout336 net337 vssd1 vssd1 vccd1 vccd1 net336 sky130_fd_sc_hd__buf_2
X_09814_ _04200_ _04210_ _04207_ vssd1 vssd1 vccd1 vccd1 _04334_ sky130_fd_sc_hd__o21ai_1
Xfanout369 net370 vssd1 vssd1 vccd1 vccd1 net369 sky130_fd_sc_hd__clkbuf_4
Xfanout358 mul.a\[4\] vssd1 vssd1 vccd1 vccd1 net358 sky130_fd_sc_hd__buf_4
XFILLER_0_94_83 vssd1 vssd1 vccd1 vccd1 sky130_fd_sc_hd__fill_1
X_09745_ _04223_ _04256_ _04257_ vssd1 vssd1 vccd1 vccd1 _04259_ sky130_fd_sc_hd__and3_1
X_06957_ _01325_ _01326_ _01327_ vssd1 vssd1 vccd1 vccd1 _01329_ sky130_fd_sc_hd__a21oi_1
X_05908_ net280 net591 _00285_ _00286_ vssd1 vssd1 vccd1 vccd1 _00288_ sky130_fd_sc_hd__a22o_1
X_06888_ _01244_ _01259_ vssd1 vssd1 vccd1 vccd1 _01260_ sky130_fd_sc_hd__xnor2_1
X_09676_ _04013_ _04015_ _04180_ _04182_ vssd1 vssd1 vccd1 vccd1 _04183_ sky130_fd_sc_hd__o211a_1
XTAP_1305 vssd1 vccd1 sky130_fd_sc_hd__tapvpwrvgnd_1
X_08627_ _02862_ _02865_ _03035_ _03036_ vssd1 vssd1 vccd1 vccd1 _03037_ sky130_fd_sc_hd__a211oi_2
X_05839_ _00201_ _00219_ vssd1 vssd1 vccd1 vccd1 _00220_ sky130_fd_sc_hd__or2_2
XTAP_1338 vssd1 vccd1 sky130_fd_sc_hd__tapvpwrvgnd_1
XTAP_1327 vssd1 vccd1 sky130_fd_sc_hd__tapvpwrvgnd_1
XTAP_1316 vssd1 vccd1 sky130_fd_sc_hd__tapvpwrvgnd_1
X_08558_ net223 net474 _02959_ _02960_ vssd1 vssd1 vccd1 vccd1 _02961_ sky130_fd_sc_hd__a22oi_1
XFILLER_0_76_161 vssd1 vssd1 vccd1 vccd1 sky130_fd_sc_hd__decap_3
X_08489_ _02883_ _02884_ _02885_ vssd1 vssd1 vccd1 vccd1 _02887_ sky130_fd_sc_hd__a21boi_1
XFILLER_0_76_183 vssd1 vssd1 vccd1 vccd1 sky130_ef_sc_hd__decap_12
X_07509_ _01877_ _01878_ _01879_ vssd1 vssd1 vccd1 vccd1 _01882_ sky130_fd_sc_hd__and3_1
XFILLER_0_64_378 vssd1 vssd1 vccd1 vccd1 sky130_fd_sc_hd__fill_1
XFILLER_0_32_253 vssd1 vssd1 vccd1 vccd1 sky130_fd_sc_hd__decap_8
XFILLER_0_99_231 vssd1 vssd1 vccd1 vccd1 sky130_fd_sc_hd__fill_2
XFILLER_0_55_334 vssd1 vssd1 vccd1 vccd1 sky130_fd_sc_hd__fill_2
XFILLER_0_23_57 vssd1 vssd1 vccd1 vccd1 sky130_fd_sc_hd__fill_1
XFILLER_0_15_209 vssd1 vssd1 vccd1 vccd1 sky130_fd_sc_hd__decap_8
XFILLER_0_99_39 vssd1 vssd1 vccd1 vccd1 sky130_fd_sc_hd__fill_2
XFILLER_0_82_175 vssd1 vssd1 vccd1 vccd1 sky130_fd_sc_hd__decap_3
XFILLER_0_70_359 vssd1 vssd1 vccd1 vccd1 sky130_fd_sc_hd__fill_1
Xrebuffer2 net685 vssd1 vssd1 vccd1 vccd1 net647 sky130_fd_sc_hd__clkbuf_1
XFILLER_0_2_103 vssd1 vssd1 vccd1 vccd1 sky130_fd_sc_hd__fill_1
XFILLER_0_2_136 vssd1 vssd1 vccd1 vccd1 sky130_fd_sc_hd__decap_4
XFILLER_0_23_253 vssd1 vssd1 vccd1 vccd1 sky130_fd_sc_hd__decap_4
XFILLER_0_23_286 vssd1 vssd1 vccd1 vccd1 sky130_fd_sc_hd__decap_3
XFILLER_0_48_65 vssd1 vssd1 vccd1 vccd1 sky130_fd_sc_hd__fill_1
XFILLER_0_48_76 vssd1 vssd1 vccd1 vccd1 sky130_fd_sc_hd__decap_8
X_07860_ _02225_ _02226_ _02231_ vssd1 vssd1 vccd1 vccd1 _02234_ sky130_fd_sc_hd__a21o_1
X_07791_ net190 net565 vssd1 vssd1 vccd1 vccd1 _02162_ sky130_fd_sc_hd__nand2_1
XFILLER_0_3_45 vssd1 vssd1 vccd1 vccd1 sky130_fd_sc_hd__decap_8
X_06811_ net259 net269 net689 net546 vssd1 vssd1 vccd1 vccd1 _01184_ sky130_fd_sc_hd__nand4_1
X_06742_ _00976_ _01114_ vssd1 vssd1 vccd1 vccd1 _01115_ sky130_fd_sc_hd__xnor2_1
X_09530_ net166 net477 net486 net162 vssd1 vssd1 vccd1 vccd1 _04024_ sky130_fd_sc_hd__a22o_1
X_09461_ _03940_ _03947_ vssd1 vssd1 vccd1 vccd1 _03949_ sky130_fd_sc_hd__xnor2_1
XFILLER_0_64_97 vssd1 vssd1 vccd1 vccd1 sky130_fd_sc_hd__decap_8
XFILLER_0_64_64 vssd1 vssd1 vccd1 vccd1 sky130_fd_sc_hd__fill_1
XFILLER_0_3_89 vssd1 vssd1 vccd1 vccd1 sky130_fd_sc_hd__fill_2
X_06673_ _01038_ _01046_ vssd1 vssd1 vccd1 vccd1 _01047_ sky130_fd_sc_hd__xor2_2
X_08412_ _02789_ _02790_ _02801_ vssd1 vssd1 vccd1 vccd1 _02802_ sky130_fd_sc_hd__nor3_1
XFILLER_0_74_610 vssd1 vssd1 vccd1 vccd1 sky130_fd_sc_hd__fill_1
X_09392_ _03734_ _03739_ vssd1 vssd1 vccd1 vccd1 _03873_ sky130_fd_sc_hd__and2_1
X_05624_ _04891_ _04892_ vssd1 vssd1 vccd1 vccd1 _04894_ sky130_fd_sc_hd__and2_1
X_08343_ _02466_ _02470_ vssd1 vssd1 vccd1 vccd1 _02727_ sky130_fd_sc_hd__nand2_2
XFILLER_0_86_481 vssd1 vssd1 vccd1 vccd1 sky130_fd_sc_hd__decap_8
XFILLER_0_73_120 vssd1 vssd1 vccd1 vccd1 sky130_fd_sc_hd__decap_3
X_05555_ net372 net523 vssd1 vssd1 vccd1 vccd1 _04825_ sky130_fd_sc_hd__and2_1
XFILLER_0_19_537 vssd1 vssd1 vccd1 vccd1 sky130_fd_sc_hd__decap_3
X_08274_ net274 net453 _02647_ _02648_ vssd1 vssd1 vccd1 vccd1 _02651_ sky130_fd_sc_hd__and4_2
XFILLER_0_73_153 vssd1 vssd1 vccd1 vccd1 sky130_fd_sc_hd__decap_8
XFILLER_0_73_186 vssd1 vssd1 vccd1 vccd1 sky130_fd_sc_hd__decap_8
X_07225_ _01593_ _01594_ vssd1 vssd1 vccd1 vccd1 _01595_ sky130_fd_sc_hd__or2_1
X_05486_ net371 net531 net543 net364 vssd1 vssd1 vccd1 vccd1 _04756_ sky130_fd_sc_hd__a22o_1
XFILLER_0_6_431 vssd1 vssd1 vccd1 vccd1 sky130_ef_sc_hd__decap_12
XFILLER_0_61_337 vssd1 vssd1 vccd1 vccd1 sky130_fd_sc_hd__decap_3
XFILLER_0_6_475 vssd1 vssd1 vccd1 vccd1 sky130_fd_sc_hd__fill_1
XFILLER_0_27_592 vssd1 vssd1 vccd1 vccd1 sky130_fd_sc_hd__fill_1
XFILLER_0_89_72 vssd1 vssd1 vccd1 vccd1 sky130_fd_sc_hd__decap_4
XFILLER_0_14_253 vssd1 vssd1 vccd1 vccd1 sky130_ef_sc_hd__decap_12
X_07156_ _01524_ _01525_ vssd1 vssd1 vccd1 vccd1 _01526_ sky130_fd_sc_hd__nand2_1
X_07087_ _01455_ _01456_ _01454_ vssd1 vssd1 vccd1 vccd1 _01458_ sky130_fd_sc_hd__a21o_1
X_06107_ _00310_ _00412_ _00411_ vssd1 vssd1 vccd1 vccd1 _00485_ sky130_fd_sc_hd__a21o_1
XFILLER_0_14_286 vssd1 vssd1 vccd1 vccd1 sky130_ef_sc_hd__decap_12
X_06038_ _00298_ _00319_ _00415_ _00416_ vssd1 vssd1 vccd1 vccd1 _00417_ sky130_fd_sc_hd__o211a_1
Xfanout122 _02936_ vssd1 vssd1 vccd1 vccd1 net122 sky130_fd_sc_hd__clkbuf_8
Xfanout155 mul.a\[30\] vssd1 vssd1 vccd1 vccd1 net155 sky130_fd_sc_hd__buf_2
Xfanout144 _02210_ vssd1 vssd1 vccd1 vccd1 net144 sky130_fd_sc_hd__clkbuf_4
Xfanout133 _01881_ vssd1 vssd1 vccd1 vccd1 net133 sky130_fd_sc_hd__clkbuf_2
Xfanout177 mul.a\[26\] vssd1 vssd1 vccd1 vccd1 net177 sky130_fd_sc_hd__clkbuf_2
Xfanout199 net206 vssd1 vssd1 vccd1 vccd1 net199 sky130_fd_sc_hd__clkbuf_4
Xfanout166 net168 vssd1 vssd1 vccd1 vccd1 net166 sky130_fd_sc_hd__buf_2
Xfanout188 net189 vssd1 vssd1 vccd1 vccd1 net188 sky130_fd_sc_hd__buf_2
X_07989_ _02359_ _02360_ _02187_ _02190_ vssd1 vssd1 vccd1 vccd1 _02362_ sky130_fd_sc_hd__o211a_1
X_09728_ _04093_ _04095_ vssd1 vssd1 vccd1 vccd1 _04240_ sky130_fd_sc_hd__or2_1
X_09659_ net141 _04162_ _04163_ _04164_ vssd1 vssd1 vccd1 vccd1 net60 sky130_fd_sc_hd__a31o_1
XTAP_1113 vssd1 vccd1 sky130_fd_sc_hd__tapvpwrvgnd_1
XTAP_1102 vssd1 vccd1 sky130_fd_sc_hd__tapvpwrvgnd_1
XFILLER_0_69_437 vssd1 vssd1 vccd1 vccd1 sky130_fd_sc_hd__decap_6
XTAP_1146 vssd1 vccd1 sky130_fd_sc_hd__tapvpwrvgnd_1
XTAP_1135 vssd1 vccd1 sky130_fd_sc_hd__tapvpwrvgnd_1
XTAP_1124 vssd1 vccd1 sky130_fd_sc_hd__tapvpwrvgnd_1
XTAP_1179 vssd1 vccd1 sky130_fd_sc_hd__tapvpwrvgnd_1
XTAP_1157 vssd1 vccd1 sky130_fd_sc_hd__tapvpwrvgnd_1
XTAP_1168 vssd1 vccd1 sky130_fd_sc_hd__tapvpwrvgnd_1
XFILLER_0_80_602 vssd1 vssd1 vccd1 vccd1 sky130_fd_sc_hd__fill_2
XFILLER_0_64_153 vssd1 vssd1 vccd1 vccd1 sky130_fd_sc_hd__decap_4
XFILLER_0_64_186 vssd1 vssd1 vccd1 vccd1 sky130_fd_sc_hd__decap_8
XFILLER_0_52_304 vssd1 vssd1 vccd1 vccd1 sky130_fd_sc_hd__decap_4
XFILLER_0_25_518 vssd1 vssd1 vccd1 vccd1 sky130_fd_sc_hd__decap_3
XFILLER_0_64_197 vssd1 vssd1 vccd1 vccd1 sky130_fd_sc_hd__fill_1
XTAP_908 vssd1 vccd1 sky130_fd_sc_hd__tapvpwrvgnd_1
XTAP_919 vssd1 vccd1 sky130_fd_sc_hd__tapvpwrvgnd_1
XFILLER_0_18_13 vssd1 vssd1 vccd1 vccd1 sky130_fd_sc_hd__decap_3
XFILLER_0_75_407 vssd1 vssd1 vccd1 vccd1 sky130_fd_sc_hd__fill_1
XFILLER_0_55_120 vssd1 vssd1 vccd1 vccd1 sky130_fd_sc_hd__fill_2
XFILLER_0_7_239 vssd1 vssd1 vccd1 vccd1 sky130_fd_sc_hd__fill_1
X_05340_ _04565_ _04600_ _04606_ vssd1 vssd1 vccd1 vccd1 _04610_ sky130_fd_sc_hd__a21o_1
XFILLER_0_28_389 vssd1 vssd1 vccd1 vccd1 sky130_fd_sc_hd__decap_6
X_05271_ _04328_ _04339_ _04481_ _04492_ vssd1 vssd1 vccd1 vccd1 _04514_ sky130_fd_sc_hd__or4bb_4
XFILLER_0_43_337 vssd1 vssd1 vccd1 vccd1 sky130_fd_sc_hd__decap_4
XFILLER_0_24_573 vssd1 vssd1 vccd1 vccd1 sky130_fd_sc_hd__decap_6
X_07010_ _01235_ _01380_ vssd1 vssd1 vccd1 vccd1 _01381_ sky130_fd_sc_hd__xnor2_2
XFILLER_0_11_223 vssd1 vssd1 vccd1 vccd1 sky130_fd_sc_hd__fill_1
XFILLER_0_11_256 vssd1 vssd1 vccd1 vccd1 sky130_fd_sc_hd__decap_8
XFILLER_0_3_489 vssd1 vssd1 vccd1 vccd1 sky130_ef_sc_hd__decap_12
X_08961_ net163 net524 vssd1 vssd1 vccd1 vccd1 _03402_ sky130_fd_sc_hd__and2_1
X_08892_ _03178_ _03180_ vssd1 vssd1 vccd1 vccd1 _03327_ sky130_fd_sc_hd__or2_1
X_07912_ net140 _02283_ _02284_ _02285_ vssd1 vssd1 vccd1 vccd1 net47 sky130_fd_sc_hd__a31o_1
X_07843_ _02047_ _02049_ _02212_ _02214_ vssd1 vssd1 vccd1 vccd1 _02215_ sky130_fd_sc_hd__a211o_1
X_07774_ _02139_ _02144_ vssd1 vssd1 vccd1 vccd1 _02145_ sky130_fd_sc_hd__xor2_1
X_09513_ _03849_ _03854_ _04005_ vssd1 vssd1 vccd1 vccd1 _04006_ sky130_fd_sc_hd__nand3_1
X_06725_ _00870_ _00998_ _01000_ vssd1 vssd1 vccd1 vccd1 _01098_ sky130_fd_sc_hd__o21ba_1
X_09444_ net276 net395 _03926_ _03928_ vssd1 vssd1 vccd1 vccd1 _03930_ sky130_fd_sc_hd__and4_1
X_06656_ _01026_ _01027_ _01028_ vssd1 vssd1 vccd1 vccd1 _01030_ sky130_fd_sc_hd__a21oi_1
XFILLER_0_93_237 vssd1 vssd1 vccd1 vccd1 sky130_fd_sc_hd__decap_4
XFILLER_0_66_429 vssd1 vssd1 vccd1 vccd1 sky130_fd_sc_hd__decap_3
X_05607_ _04781_ _04800_ vssd1 vssd1 vccd1 vccd1 _04877_ sky130_fd_sc_hd__or2_1
X_09375_ _03850_ _03853_ vssd1 vssd1 vccd1 vccd1 _03855_ sky130_fd_sc_hd__nand2_1
XFILLER_0_19_334 vssd1 vssd1 vccd1 vccd1 sky130_fd_sc_hd__fill_2
X_06587_ net573 net143 net128 net331 _00961_ vssd1 vssd1 vccd1 vccd1 net69 sky130_fd_sc_hd__a221o_1
X_08326_ _02664_ _02665_ _02705_ _02706_ vssd1 vssd1 vccd1 vccd1 _02708_ sky130_fd_sc_hd__a2bb2oi_2
X_05538_ _04806_ _04807_ vssd1 vssd1 vccd1 vccd1 _04808_ sky130_fd_sc_hd__nor2_1
XFILLER_0_19_389 vssd1 vssd1 vccd1 vccd1 sky130_fd_sc_hd__decap_3
XFILLER_0_34_304 vssd1 vssd1 vccd1 vccd1 sky130_fd_sc_hd__decap_4
X_08257_ _02630_ _02631_ vssd1 vssd1 vccd1 vccd1 _02632_ sky130_fd_sc_hd__and2b_1
XFILLER_0_6_261 vssd1 vssd1 vccd1 vccd1 sky130_fd_sc_hd__decap_3
X_05469_ _04736_ _04737_ _04121_ _04545_ vssd1 vssd1 vccd1 vccd1 _04739_ sky130_fd_sc_hd__a211oi_1
X_08188_ net325 net421 net426 net316 vssd1 vssd1 vccd1 vccd1 _02560_ sky130_fd_sc_hd__a22o_1
XFILLER_0_61_156 vssd1 vssd1 vccd1 vccd1 sky130_ef_sc_hd__decap_12
X_07208_ _01575_ _01576_ net334 net450 vssd1 vssd1 vccd1 vccd1 _01578_ sky130_fd_sc_hd__and4bb_1
X_07139_ net181 net619 _01366_ _01365_ vssd1 vssd1 vccd1 vccd1 _01509_ sky130_fd_sc_hd__a31o_1
X_10081_ clknet_3_1_0_wb_clk_i _00077_ _00013_ vssd1 vssd1 vccd1 vccd1 mul.b\[10\]
+ sky130_fd_sc_hd__dfrtp_1
XFILLER_0_57_418 vssd1 vssd1 vccd1 vccd1 sky130_fd_sc_hd__decap_6
XFILLER_0_65_484 vssd1 vssd1 vccd1 vccd1 sky130_fd_sc_hd__fill_2
XFILLER_0_37_164 vssd1 vssd1 vccd1 vccd1 sky130_fd_sc_hd__fill_1
XFILLER_0_37_175 vssd1 vssd1 vccd1 vccd1 sky130_fd_sc_hd__decap_4
Xmax_cap108 _03125_ vssd1 vssd1 vccd1 vccd1 net108 sky130_fd_sc_hd__buf_1
XFILLER_0_52_145 vssd1 vssd1 vccd1 vccd1 sky130_fd_sc_hd__fill_1
XFILLER_0_40_307 vssd1 vssd1 vccd1 vccd1 sky130_fd_sc_hd__fill_1
XFILLER_0_96_29 vssd1 vssd1 vccd1 vccd1 sky130_fd_sc_hd__decap_4
XFILLER_0_21_543 vssd1 vssd1 vccd1 vccd1 sky130_fd_sc_hd__decap_8
XFILLER_0_21_565 vssd1 vssd1 vccd1 vccd1 sky130_fd_sc_hd__fill_1
XFILLER_0_29_34 vssd1 vssd1 vccd1 vccd1 sky130_fd_sc_hd__decap_8
XTAP_705 vssd1 vccd1 sky130_fd_sc_hd__tapvpwrvgnd_1
XTAP_716 vssd1 vccd1 sky130_fd_sc_hd__tapvpwrvgnd_1
XFILLER_0_29_78 vssd1 vssd1 vccd1 vccd1 sky130_fd_sc_hd__decap_3
XTAP_727 vssd1 vccd1 sky130_fd_sc_hd__tapvpwrvgnd_1
XTAP_738 vssd1 vccd1 sky130_fd_sc_hd__tapvpwrvgnd_1
XTAP_749 vssd1 vccd1 sky130_fd_sc_hd__tapvpwrvgnd_1
XFILLER_0_45_55 vssd1 vssd1 vccd1 vccd1 sky130_fd_sc_hd__fill_1
XFILLER_0_88_587 vssd1 vssd1 vccd1 vccd1 sky130_fd_sc_hd__fill_1
X_07490_ _01702_ _01705_ _01860_ vssd1 vssd1 vccd1 vccd1 _01861_ sky130_fd_sc_hd__a21oi_1
X_06510_ _00776_ _00778_ _00883_ vssd1 vssd1 vccd1 vccd1 _00885_ sky130_fd_sc_hd__or3_1
XFILLER_0_0_57 vssd1 vssd1 vccd1 vccd1 sky130_fd_sc_hd__decap_6
X_06441_ _00814_ _00815_ _00690_ _00693_ vssd1 vssd1 vccd1 vccd1 _00817_ sky130_fd_sc_hd__o211a_1
XFILLER_0_61_76 vssd1 vssd1 vccd1 vccd1 sky130_ef_sc_hd__decap_12
XFILLER_0_90_207 vssd1 vssd1 vccd1 vccd1 sky130_fd_sc_hd__decap_4
X_09160_ _03448_ _03450_ _03617_ net105 vssd1 vssd1 vccd1 vccd1 _03620_ sky130_fd_sc_hd__a211oi_2
XFILLER_0_8_548 vssd1 vssd1 vccd1 vccd1 sky130_fd_sc_hd__decap_3
X_06372_ _00746_ _00747_ vssd1 vssd1 vccd1 vccd1 _00748_ sky130_fd_sc_hd__nand2_1
X_09091_ _03540_ _03541_ _03543_ vssd1 vssd1 vccd1 vccd1 _03545_ sky130_fd_sc_hd__o21ai_1
XFILLER_0_83_281 vssd1 vssd1 vccd1 vccd1 sky130_fd_sc_hd__decap_4
X_08111_ _02443_ _02482_ vssd1 vssd1 vccd1 vccd1 _02483_ sky130_fd_sc_hd__nand2_1
XFILLER_0_56_495 vssd1 vssd1 vccd1 vccd1 sky130_ef_sc_hd__decap_12
X_05323_ _04590_ _04592_ vssd1 vssd1 vccd1 vccd1 _04593_ sky130_fd_sc_hd__nor2_1
XFILLER_0_28_197 vssd1 vssd1 vccd1 vccd1 sky130_ef_sc_hd__decap_12
X_08042_ _02413_ _02414_ vssd1 vssd1 vccd1 vccd1 _02415_ sky130_fd_sc_hd__nor2_1
X_05254_ _02612_ _04307_ _04317_ vssd1 vssd1 vccd1 vccd1 _04328_ sky130_fd_sc_hd__and3_1
XFILLER_0_43_156 vssd1 vssd1 vccd1 vccd1 sky130_fd_sc_hd__fill_1
XFILLER_0_43_167 vssd1 vssd1 vccd1 vccd1 sky130_fd_sc_hd__fill_1
XFILLER_0_24_381 vssd1 vssd1 vccd1 vccd1 sky130_ef_sc_hd__decap_12
XFILLER_0_101_93 vssd1 vssd1 vccd1 vccd1 sky130_fd_sc_hd__fill_2
X_05185_ _02919_ _03421_ _03553_ vssd1 vssd1 vccd1 vccd1 _03574_ sky130_fd_sc_hd__a21o_1
X_09993_ _03163_ _04362_ net137 net257 vssd1 vssd1 vccd1 vccd1 _04530_ sky130_fd_sc_hd__o2bb2a_1
X_08944_ _03380_ _03381_ _03382_ vssd1 vssd1 vccd1 vccd1 _03384_ sky130_fd_sc_hd__o21ai_1
XFILLER_0_50_3 vssd1 vssd1 vccd1 vccd1 sky130_ef_sc_hd__decap_12
X_08875_ _03129_ _03154_ net702 _03307_ vssd1 vssd1 vccd1 vccd1 _03308_ sky130_fd_sc_hd__a211oi_4
X_07826_ net316 net439 net446 net308 vssd1 vssd1 vccd1 vccd1 _02197_ sky130_fd_sc_hd__a22o_1
X_07757_ _02127_ _02126_ vssd1 vssd1 vccd1 vccd1 _02128_ sky130_fd_sc_hd__and2b_1
XFILLER_0_79_554 vssd1 vssd1 vccd1 vccd1 sky130_fd_sc_hd__decap_6
X_06708_ _01005_ _01006_ _01079_ _01080_ vssd1 vssd1 vccd1 vccd1 _01082_ sky130_fd_sc_hd__a22o_1
X_07688_ net274 net485 _02058_ _02059_ vssd1 vssd1 vccd1 vccd1 _02060_ sky130_fd_sc_hd__a22o_1
XFILLER_0_94_568 vssd1 vssd1 vccd1 vccd1 sky130_fd_sc_hd__fill_2
X_09427_ _03893_ _03909_ vssd1 vssd1 vccd1 vccd1 _03911_ sky130_fd_sc_hd__xnor2_1
X_06639_ _01011_ _01012_ vssd1 vssd1 vccd1 vccd1 _01013_ sky130_fd_sc_hd__or2_1
X_09358_ _03687_ _03689_ vssd1 vssd1 vccd1 vccd1 _03836_ sky130_fd_sc_hd__nor2_1
XFILLER_0_81_229 vssd1 vssd1 vccd1 vccd1 sky130_fd_sc_hd__fill_1
XFILLER_0_81_207 vssd1 vssd1 vccd1 vccd1 sky130_fd_sc_hd__decap_4
XFILLER_0_35_624 vssd1 vssd1 vccd1 vccd1 sky130_fd_sc_hd__fill_1
XFILLER_0_47_484 vssd1 vssd1 vccd1 vccd1 sky130_fd_sc_hd__fill_2
X_08309_ net325 net413 _02686_ _02687_ vssd1 vssd1 vccd1 vccd1 _02690_ sky130_fd_sc_hd__a22oi_2
XFILLER_0_34_134 vssd1 vssd1 vccd1 vccd1 sky130_fd_sc_hd__fill_1
X_09289_ _03757_ _03758_ vssd1 vssd1 vccd1 vccd1 _03761_ sky130_fd_sc_hd__xor2_1
XFILLER_0_62_487 vssd1 vssd1 vccd1 vccd1 sky130_fd_sc_hd__fill_1
X_10133_ clknet_3_5_0_wb_clk_i _00127_ _00063_ vssd1 vssd1 vccd1 vccd1 mul.a\[28\]
+ sky130_fd_sc_hd__dfrtp_4
X_10064_ net644 vssd1 vssd1 vccd1 vccd1 _00060_ sky130_fd_sc_hd__inv_2
XFILLER_0_97_362 vssd1 vssd1 vccd1 vccd1 sky130_fd_sc_hd__decap_4
XFILLER_0_15_25 vssd1 vssd1 vccd1 vccd1 sky130_fd_sc_hd__decap_8
XFILLER_0_15_69 vssd1 vssd1 vccd1 vccd1 sky130_fd_sc_hd__decap_3
XFILLER_0_26_624 vssd1 vssd1 vccd1 vccd1 sky130_fd_sc_hd__fill_1
XFILLER_0_65_281 vssd1 vssd1 vccd1 vccd1 sky130_fd_sc_hd__fill_2
XFILLER_0_65_270 vssd1 vssd1 vccd1 vccd1 sky130_fd_sc_hd__fill_1
XFILLER_0_31_46 vssd1 vssd1 vccd1 vccd1 sky130_fd_sc_hd__decap_8
XFILLER_0_31_57 vssd1 vssd1 vccd1 vccd1 sky130_ef_sc_hd__decap_12
XTAP_502 vssd1 vccd1 sky130_fd_sc_hd__tapvpwrvgnd_1
XTAP_513 vssd1 vccd1 sky130_fd_sc_hd__tapvpwrvgnd_1
XTAP_524 vssd1 vccd1 sky130_fd_sc_hd__tapvpwrvgnd_1
XTAP_535 vssd1 vccd1 sky130_fd_sc_hd__tapvpwrvgnd_1
XTAP_546 vssd1 vccd1 sky130_fd_sc_hd__tapvpwrvgnd_1
XTAP_557 vssd1 vccd1 sky130_fd_sc_hd__tapvpwrvgnd_1
X_06990_ net550 net143 net129 net306 vssd1 vssd1 vccd1 vccd1 _01362_ sky130_fd_sc_hd__a22o_1
X_05941_ _00199_ _00220_ _00319_ _00320_ vssd1 vssd1 vccd1 vccd1 _00321_ sky130_fd_sc_hd__a211oi_2
XTAP_568 vssd1 vccd1 sky130_fd_sc_hd__tapvpwrvgnd_1
XTAP_579 vssd1 vccd1 sky130_fd_sc_hd__tapvpwrvgnd_1
X_08660_ _03043_ _03044_ _03070_ vssd1 vssd1 vccd1 vccd1 _03074_ sky130_fd_sc_hd__o21ai_1
X_05872_ _00233_ _00250_ _00251_ vssd1 vssd1 vccd1 vccd1 _00253_ sky130_fd_sc_hd__nand3_1
X_07611_ _01839_ _01981_ _01982_ vssd1 vssd1 vccd1 vccd1 _01983_ sky130_fd_sc_hd__nand3_1
X_08591_ _02972_ _02974_ _02994_ vssd1 vssd1 vccd1 vccd1 _02998_ sky130_fd_sc_hd__a21oi_2
XFILLER_0_88_395 vssd1 vssd1 vccd1 vccd1 sky130_fd_sc_hd__fill_2
XFILLER_0_88_373 vssd1 vssd1 vccd1 vccd1 sky130_fd_sc_hd__fill_1
X_07542_ _01907_ _01913_ net669 vssd1 vssd1 vccd1 vccd1 _01915_ sky130_fd_sc_hd__nand3_1
X_07473_ net391 net398 vssd1 vssd1 vccd1 vccd1 _01843_ sky130_fd_sc_hd__and2_1
X_09212_ _03668_ _03675_ vssd1 vssd1 vccd1 vccd1 _03677_ sky130_fd_sc_hd__xor2_1
XFILLER_0_91_505 vssd1 vssd1 vccd1 vccd1 sky130_fd_sc_hd__decap_4
XFILLER_0_76_579 vssd1 vssd1 vccd1 vccd1 sky130_fd_sc_hd__fill_2
XFILLER_0_63_229 vssd1 vssd1 vccd1 vccd1 sky130_fd_sc_hd__fill_1
X_06424_ _00797_ _00798_ _00796_ vssd1 vssd1 vccd1 vccd1 _00800_ sky130_fd_sc_hd__a21o_1
X_09143_ net230 net436 net442 net222 vssd1 vssd1 vccd1 vccd1 _03601_ sky130_fd_sc_hd__a22o_1
X_06355_ _00610_ _00615_ _00730_ vssd1 vssd1 vccd1 vccd1 _00731_ sky130_fd_sc_hd__o21ai_2
XFILLER_0_44_421 vssd1 vssd1 vccd1 vccd1 sky130_fd_sc_hd__decap_3
XFILLER_0_98_3 vssd1 vssd1 vccd1 vccd1 sky130_ef_sc_hd__decap_12
X_05306_ _04573_ _04574_ _04559_ vssd1 vssd1 vccd1 vccd1 _04576_ sky130_fd_sc_hd__a21o_1
X_09074_ _03523_ _03524_ vssd1 vssd1 vccd1 vccd1 _03526_ sky130_fd_sc_hd__xnor2_1
X_06286_ net362 net469 _00661_ _00662_ vssd1 vssd1 vccd1 vccd1 _00663_ sky130_fd_sc_hd__nand4_1
X_08025_ net300 net307 net438 vssd1 vssd1 vccd1 vccd1 _02398_ sky130_fd_sc_hd__and3_1
X_05237_ _04121_ _04132_ vssd1 vssd1 vccd1 vccd1 _04143_ sky130_fd_sc_hd__or2_1
X_05168_ _03225_ _03378_ vssd1 vssd1 vccd1 vccd1 _03389_ sky130_fd_sc_hd__xnor2_1
XFILLER_0_6_9 vssd1 vssd1 vccd1 vccd1 sky130_fd_sc_hd__fill_1
X_09976_ _04507_ _04510_ vssd1 vssd1 vccd1 vccd1 _04511_ sky130_fd_sc_hd__xnor2_1
X_05099_ _02612_ _02623_ vssd1 vssd1 vccd1 vccd1 _02634_ sky130_fd_sc_hd__nor2_1
X_08927_ _03364_ _03355_ vssd1 vssd1 vccd1 vccd1 _03365_ sky130_fd_sc_hd__nand2b_1
X_08858_ net216 net223 net458 net465 vssd1 vssd1 vccd1 vccd1 _03289_ sky130_fd_sc_hd__and4_1
XFILLER_0_98_137 vssd1 vssd1 vccd1 vccd1 sky130_fd_sc_hd__decap_3
X_07809_ net350 net414 _02177_ _02178_ vssd1 vssd1 vccd1 vccd1 _02180_ sky130_fd_sc_hd__nand4_2
X_08789_ _03204_ _03212_ vssd1 vssd1 vccd1 vccd1 _03215_ sky130_fd_sc_hd__xnor2_1
XFILLER_0_67_524 vssd1 vssd1 vccd1 vccd1 sky130_fd_sc_hd__decap_8
XFILLER_0_39_215 vssd1 vssd1 vccd1 vccd1 sky130_fd_sc_hd__fill_1
XFILLER_0_94_343 vssd1 vssd1 vccd1 vccd1 sky130_fd_sc_hd__fill_1
XFILLER_0_39_248 vssd1 vssd1 vccd1 vccd1 sky130_fd_sc_hd__fill_2
XFILLER_0_94_365 vssd1 vssd1 vccd1 vccd1 sky130_fd_sc_hd__decap_6
XFILLER_0_62_251 vssd1 vssd1 vccd1 vccd1 sky130_fd_sc_hd__fill_1
XFILLER_0_50_468 vssd1 vssd1 vccd1 vccd1 sky130_fd_sc_hd__decap_3
XFILLER_0_22_137 vssd1 vssd1 vccd1 vccd1 sky130_fd_sc_hd__decap_3
XFILLER_0_22_159 vssd1 vssd1 vccd1 vccd1 sky130_fd_sc_hd__fill_1
X_10116_ clknet_3_1_0_wb_clk_i _00110_ _00046_ vssd1 vssd1 vccd1 vccd1 mul.a\[11\]
+ sky130_fd_sc_hd__dfrtp_4
X_10047_ net639 vssd1 vssd1 vccd1 vccd1 _00043_ sky130_fd_sc_hd__inv_2
XFILLER_0_26_79 vssd1 vssd1 vccd1 vccd1 sky130_fd_sc_hd__decap_4
XFILLER_0_58_568 vssd1 vssd1 vccd1 vccd1 sky130_fd_sc_hd__decap_4
XFILLER_0_73_505 vssd1 vssd1 vccd1 vccd1 sky130_fd_sc_hd__decap_3
XFILLER_0_45_218 vssd1 vssd1 vccd1 vccd1 sky130_fd_sc_hd__fill_1
XFILLER_0_26_410 vssd1 vssd1 vccd1 vccd1 sky130_fd_sc_hd__decap_8
XFILLER_0_26_421 vssd1 vssd1 vccd1 vccd1 sky130_fd_sc_hd__decap_8
XFILLER_0_5_337 vssd1 vssd1 vccd1 vccd1 sky130_ef_sc_hd__decap_12
X_06140_ _00516_ _00517_ vssd1 vssd1 vccd1 vccd1 _00518_ sky130_fd_sc_hd__and2_1
XFILLER_0_41_402 vssd1 vssd1 vccd1 vccd1 sky130_fd_sc_hd__decap_6
X_06071_ _00447_ _00448_ _00440_ vssd1 vssd1 vccd1 vccd1 _00450_ sky130_fd_sc_hd__a21o_1
X_05022_ net638 vssd1 vssd1 vccd1 vccd1 _00003_ sky130_fd_sc_hd__inv_2
XFILLER_0_41_479 vssd1 vssd1 vccd1 vccd1 sky130_fd_sc_hd__decap_4
XFILLER_0_6_45 vssd1 vssd1 vccd1 vccd1 sky130_fd_sc_hd__decap_6
XFILLER_0_21_181 vssd1 vssd1 vccd1 vccd1 sky130_fd_sc_hd__fill_2
Xfanout518 net520 vssd1 vssd1 vccd1 vccd1 net518 sky130_fd_sc_hd__clkbuf_4
Xfanout507 net509 vssd1 vssd1 vccd1 vccd1 net507 sky130_fd_sc_hd__buf_4
XTAP_332 vssd1 vccd1 sky130_fd_sc_hd__tapvpwrvgnd_1
XTAP_321 vssd1 vccd1 sky130_fd_sc_hd__tapvpwrvgnd_1
XTAP_310 vssd1 vccd1 sky130_fd_sc_hd__tapvpwrvgnd_1
X_09830_ _04183_ _04187_ _04351_ vssd1 vssd1 vccd1 vccd1 _04352_ sky130_fd_sc_hd__o21a_1
Xfanout529 mul.b\[12\] vssd1 vssd1 vccd1 vccd1 net529 sky130_fd_sc_hd__buf_4
X_09761_ _04275_ _04276_ vssd1 vssd1 vccd1 vccd1 _04277_ sky130_fd_sc_hd__nor2_1
XTAP_343 vssd1 vccd1 sky130_fd_sc_hd__tapvpwrvgnd_1
XTAP_354 vssd1 vccd1 sky130_fd_sc_hd__tapvpwrvgnd_1
XTAP_376 vssd1 vccd1 sky130_fd_sc_hd__tapvpwrvgnd_1
XTAP_365 vssd1 vccd1 sky130_fd_sc_hd__tapvpwrvgnd_1
X_06973_ _01341_ _01342_ _01264_ vssd1 vssd1 vccd1 vccd1 _01345_ sky130_fd_sc_hd__o21ai_2
X_08712_ _03127_ _03128_ _02955_ _02969_ vssd1 vssd1 vccd1 vccd1 _03130_ sky130_fd_sc_hd__a211o_2
X_05924_ net253 net616 vssd1 vssd1 vccd1 vccd1 _00304_ sky130_fd_sc_hd__nand2_1
XTAP_387 vssd1 vccd1 sky130_fd_sc_hd__tapvpwrvgnd_1
XTAP_398 vssd1 vccd1 sky130_fd_sc_hd__tapvpwrvgnd_1
XFILLER_0_83_52 vssd1 vssd1 vccd1 vccd1 sky130_fd_sc_hd__decap_4
XFILLER_0_83_41 vssd1 vssd1 vccd1 vccd1 sky130_fd_sc_hd__fill_1
Xrebuffer12 _01773_ vssd1 vssd1 vccd1 vccd1 net657 sky130_fd_sc_hd__clkbuf_1
X_09692_ net180 net454 net462 net172 vssd1 vssd1 vccd1 vccd1 _04201_ sky130_fd_sc_hd__a22o_1
X_08643_ _02885_ _03054_ vssd1 vssd1 vccd1 vccd1 _03055_ sky130_fd_sc_hd__xor2_1
Xrebuffer45 net536 vssd1 vssd1 vccd1 vccd1 net690 sky130_fd_sc_hd__dlymetal6s2s_1
XFILLER_0_13_3 vssd1 vssd1 vccd1 vccd1 sky130_fd_sc_hd__fill_2
X_05855_ net356 net364 net509 net513 vssd1 vssd1 vccd1 vccd1 _00236_ sky130_fd_sc_hd__and4_1
Xrebuffer34 mul.a\[3\] vssd1 vssd1 vccd1 vccd1 net679 sky130_fd_sc_hd__clkbuf_2
Xrebuffer23 _01196_ vssd1 vssd1 vccd1 vccd1 net668 sky130_fd_sc_hd__clkbuf_1
X_08574_ net278 net430 vssd1 vssd1 vccd1 vccd1 _02979_ sky130_fd_sc_hd__and2_1
Xrebuffer67 _02517_ vssd1 vssd1 vccd1 vccd1 net723 sky130_fd_sc_hd__dlygate4sd1_1
Xrebuffer56 _01462_ vssd1 vssd1 vccd1 vccd1 net720 sky130_fd_sc_hd__dlygate4sd1_1
XPHY_16 vssd1 vssd1 vccd1 vccd1 sky130_fd_sc_hd__decap_3
X_05786_ _00166_ _00167_ vssd1 vssd1 vccd1 vccd1 _00168_ sky130_fd_sc_hd__or2_1
XPHY_27 vssd1 vssd1 vccd1 vccd1 sky130_fd_sc_hd__decap_3
XPHY_38 vssd1 vssd1 vccd1 vccd1 sky130_fd_sc_hd__decap_3
X_07525_ _01895_ _01896_ _01892_ vssd1 vssd1 vccd1 vccd1 _01898_ sky130_fd_sc_hd__a21o_1
XPHY_49 vssd1 vssd1 vccd1 vccd1 sky130_fd_sc_hd__decap_3
XFILLER_0_49_546 vssd1 vssd1 vccd1 vccd1 sky130_ef_sc_hd__decap_12
XFILLER_0_91_335 vssd1 vssd1 vccd1 vccd1 sky130_fd_sc_hd__fill_1
XFILLER_0_29_281 vssd1 vssd1 vccd1 vccd1 sky130_fd_sc_hd__decap_3
X_07456_ _01823_ _01812_ vssd1 vssd1 vccd1 vccd1 _01824_ sky130_fd_sc_hd__nand2b_1
X_07387_ _01605_ _01607_ _01606_ vssd1 vssd1 vccd1 vccd1 _01756_ sky130_fd_sc_hd__a21bo_1
XFILLER_0_8_197 vssd1 vssd1 vccd1 vccd1 sky130_fd_sc_hd__decap_6
X_06407_ net338 net343 net478 net487 vssd1 vssd1 vccd1 vccd1 _00783_ sky130_fd_sc_hd__and4_1
X_09126_ _03578_ _03579_ _03580_ vssd1 vssd1 vccd1 vccd1 _03582_ sky130_fd_sc_hd__a21oi_2
XFILLER_0_17_476 vssd1 vssd1 vccd1 vccd1 sky130_fd_sc_hd__fill_2
X_06338_ _00594_ _00602_ vssd1 vssd1 vccd1 vccd1 _00715_ sky130_fd_sc_hd__nand2_1
X_09057_ net147 net588 _03359_ net138 net153 vssd1 vssd1 vccd1 vccd1 _03507_ sky130_fd_sc_hd__a32o_1
X_06269_ _00536_ _00643_ _00644_ vssd1 vssd1 vccd1 vccd1 _00646_ sky130_fd_sc_hd__or3_1
X_08008_ _02241_ _02243_ vssd1 vssd1 vccd1 vccd1 _02381_ sky130_fd_sc_hd__nand2_1
X_09959_ net216 net411 vssd1 vssd1 vccd1 vccd1 _04493_ sky130_fd_sc_hd__nand2_1
XFILLER_0_99_457 vssd1 vssd1 vccd1 vccd1 sky130_fd_sc_hd__fill_2
XFILLER_0_79_181 vssd1 vssd1 vccd1 vccd1 sky130_fd_sc_hd__decap_8
XFILLER_0_67_332 vssd1 vssd1 vccd1 vccd1 sky130_fd_sc_hd__decap_4
XFILLER_0_55_505 vssd1 vssd1 vccd1 vccd1 sky130_fd_sc_hd__fill_1
XFILLER_0_90_390 vssd1 vssd1 vccd1 vccd1 sky130_fd_sc_hd__fill_1
XFILLER_0_50_287 vssd1 vssd1 vccd1 vccd1 sky130_fd_sc_hd__decap_3
Xoutput70 net70 vssd1 vssd1 vccd1 vccd1 wbs_dat_o[8] sky130_fd_sc_hd__clkbuf_4
XFILLER_0_77_107 vssd1 vssd1 vccd1 vccd1 sky130_fd_sc_hd__decap_4
X_05640_ _04852_ _04854_ _04909_ vssd1 vssd1 vccd1 vccd1 _04910_ sky130_fd_sc_hd__a21oi_1
X_05571_ _04766_ _04840_ vssd1 vssd1 vccd1 vccd1 _04841_ sky130_fd_sc_hd__or2_1
X_07310_ _01546_ _01677_ vssd1 vssd1 vccd1 vccd1 _01679_ sky130_fd_sc_hd__xor2_1
X_08290_ net169 net565 vssd1 vssd1 vccd1 vccd1 _02669_ sky130_fd_sc_hd__nand2_1
X_07241_ _01608_ _01609_ _01610_ vssd1 vssd1 vccd1 vccd1 _01611_ sky130_fd_sc_hd__nand3_1
X_07172_ _01273_ _01412_ _01414_ _01405_ vssd1 vssd1 vccd1 vccd1 _01542_ sky130_fd_sc_hd__a2bb2oi_1
XFILLER_0_5_156 vssd1 vssd1 vccd1 vccd1 sky130_ef_sc_hd__decap_12
X_06123_ _00394_ _00499_ vssd1 vssd1 vccd1 vccd1 _00501_ sky130_fd_sc_hd__nand2_1
XFILLER_0_78_85 vssd1 vssd1 vccd1 vccd1 sky130_fd_sc_hd__decap_4
X_06054_ _00426_ _00431_ vssd1 vssd1 vccd1 vccd1 _00433_ sky130_fd_sc_hd__xnor2_2
XFILLER_0_22_490 vssd1 vssd1 vccd1 vccd1 sky130_fd_sc_hd__decap_4
Xfanout304 net309 vssd1 vssd1 vccd1 vccd1 net304 sky130_fd_sc_hd__clkbuf_4
Xfanout315 net318 vssd1 vssd1 vccd1 vccd1 net315 sky130_fd_sc_hd__clkbuf_2
Xfanout326 mul.a\[8\] vssd1 vssd1 vccd1 vccd1 net326 sky130_fd_sc_hd__clkbuf_4
Xfanout348 net349 vssd1 vssd1 vccd1 vccd1 net348 sky130_fd_sc_hd__buf_2
Xfanout337 net338 vssd1 vssd1 vccd1 vccd1 net337 sky130_fd_sc_hd__buf_2
X_09813_ _04331_ _04332_ vssd1 vssd1 vccd1 vccd1 _04333_ sky130_fd_sc_hd__nor2_1
Xfanout359 net360 vssd1 vssd1 vccd1 vccd1 net359 sky130_fd_sc_hd__buf_4
X_09744_ _04256_ _04257_ vssd1 vssd1 vccd1 vccd1 _04258_ sky130_fd_sc_hd__nand2_1
X_06956_ _01325_ _01326_ _01327_ vssd1 vssd1 vccd1 vccd1 _01328_ sky130_fd_sc_hd__and3_2
X_05907_ net280 net591 _00285_ _00286_ vssd1 vssd1 vccd1 vccd1 _00287_ sky130_fd_sc_hd__nand4_2
X_06887_ _01126_ _01257_ vssd1 vssd1 vccd1 vccd1 _01259_ sky130_fd_sc_hd__xnor2_1
X_09675_ _04181_ vssd1 vssd1 vccd1 vccd1 _04182_ sky130_fd_sc_hd__inv_2
XFILLER_0_96_438 vssd1 vssd1 vccd1 vccd1 sky130_fd_sc_hd__fill_2
X_08626_ _03033_ _03034_ _02823_ _02825_ vssd1 vssd1 vccd1 vccd1 _03036_ sky130_fd_sc_hd__a211oi_2
X_05838_ _05002_ _00218_ vssd1 vssd1 vccd1 vccd1 _00219_ sky130_fd_sc_hd__xnor2_1
XTAP_1339 vssd1 vccd1 sky130_fd_sc_hd__tapvpwrvgnd_1
XTAP_1328 vssd1 vccd1 sky130_fd_sc_hd__tapvpwrvgnd_1
XTAP_1306 vssd1 vccd1 sky130_fd_sc_hd__tapvpwrvgnd_1
XTAP_1317 vssd1 vccd1 sky130_fd_sc_hd__tapvpwrvgnd_1
X_08557_ net214 net215 net482 net491 vssd1 vssd1 vccd1 vccd1 _02960_ sky130_fd_sc_hd__nand4_1
X_05769_ _00148_ _00149_ _00150_ vssd1 vssd1 vccd1 vccd1 _00151_ sky130_fd_sc_hd__nand3_2
XFILLER_0_37_505 vssd1 vssd1 vccd1 vccd1 sky130_fd_sc_hd__decap_6
XFILLER_0_49_376 vssd1 vssd1 vccd1 vccd1 sky130_fd_sc_hd__decap_6
X_08488_ net147 net588 vssd1 vssd1 vccd1 vccd1 _02885_ sky130_fd_sc_hd__nand2_8
XFILLER_0_76_195 vssd1 vssd1 vccd1 vccd1 sky130_fd_sc_hd__fill_1
X_07508_ _01877_ _01878_ _01879_ vssd1 vssd1 vccd1 vccd1 _01880_ sky130_fd_sc_hd__a21oi_1
XFILLER_0_37_549 vssd1 vssd1 vccd1 vccd1 sky130_fd_sc_hd__decap_6
X_07439_ _01656_ _01662_ _01806_ vssd1 vssd1 vccd1 vccd1 _01807_ sky130_fd_sc_hd__a21o_1
XFILLER_0_91_187 vssd1 vssd1 vccd1 vccd1 sky130_fd_sc_hd__fill_1
XFILLER_0_17_251 vssd1 vssd1 vccd1 vccd1 sky130_fd_sc_hd__fill_1
XFILLER_0_17_262 vssd1 vssd1 vccd1 vccd1 sky130_ef_sc_hd__decap_12
XFILLER_0_72_390 vssd1 vssd1 vccd1 vccd1 sky130_fd_sc_hd__decap_4
X_09109_ net152 net700 net545 net148 vssd1 vssd1 vccd1 vccd1 _03564_ sky130_fd_sc_hd__a22o_1
XFILLER_0_2_3 vssd1 vssd1 vccd1 vccd1 sky130_ef_sc_hd__decap_12
XFILLER_0_13_490 vssd1 vssd1 vccd1 vccd1 sky130_fd_sc_hd__fill_1
XFILLER_0_87_449 vssd1 vssd1 vccd1 vccd1 sky130_ef_sc_hd__decap_12
XFILLER_0_67_140 vssd1 vssd1 vccd1 vccd1 sky130_ef_sc_hd__decap_12
XFILLER_0_67_173 vssd1 vssd1 vccd1 vccd1 sky130_fd_sc_hd__fill_1
XFILLER_0_28_527 vssd1 vssd1 vccd1 vccd1 sky130_fd_sc_hd__decap_4
XFILLER_0_82_132 vssd1 vssd1 vccd1 vccd1 sky130_fd_sc_hd__decap_8
Xrebuffer3 _01928_ vssd1 vssd1 vccd1 vccd1 net648 sky130_fd_sc_hd__clkbuf_1
XFILLER_0_3_605 vssd1 vssd1 vccd1 vccd1 sky130_fd_sc_hd__fill_2
XFILLER_0_51_552 vssd1 vssd1 vccd1 vccd1 sky130_fd_sc_hd__decap_3
XFILLER_0_23_243 vssd1 vssd1 vccd1 vccd1 sky130_fd_sc_hd__decap_6
XFILLER_0_11_427 vssd1 vssd1 vccd1 vccd1 sky130_fd_sc_hd__fill_1
XFILLER_0_11_416 vssd1 vssd1 vccd1 vccd1 sky130_fd_sc_hd__decap_4
XFILLER_0_2_159 vssd1 vssd1 vccd1 vccd1 sky130_ef_sc_hd__decap_12
XFILLER_0_48_11 vssd1 vssd1 vccd1 vccd1 sky130_ef_sc_hd__decap_12
X_07790_ net384 net393 vssd1 vssd1 vccd1 vccd1 _02161_ sky130_fd_sc_hd__and2b_1
XFILLER_0_3_24 vssd1 vssd1 vccd1 vccd1 sky130_fd_sc_hd__decap_8
X_06810_ net277 net526 vssd1 vssd1 vccd1 vccd1 _01183_ sky130_fd_sc_hd__and2_1
XFILLER_0_3_57 vssd1 vssd1 vccd1 vccd1 sky130_ef_sc_hd__decap_12
X_06741_ _01112_ _01113_ vssd1 vssd1 vccd1 vccd1 _01114_ sky130_fd_sc_hd__and2b_1
X_09460_ _03947_ _03940_ vssd1 vssd1 vccd1 vccd1 _03948_ sky130_fd_sc_hd__nand2b_1
X_08411_ _02791_ _02800_ vssd1 vssd1 vccd1 vccd1 _02801_ sky130_fd_sc_hd__xnor2_1
X_06672_ _01044_ _01045_ vssd1 vssd1 vccd1 vccd1 _01046_ sky130_fd_sc_hd__and2b_1
X_09391_ _03868_ _03870_ vssd1 vssd1 vccd1 vccd1 _03872_ sky130_fd_sc_hd__xor2_1
XFILLER_0_58_151 vssd1 vssd1 vccd1 vccd1 sky130_ef_sc_hd__decap_12
X_05623_ _04891_ _04892_ vssd1 vssd1 vccd1 vccd1 _04893_ sky130_fd_sc_hd__or2_1
X_08342_ _02547_ _02555_ _02554_ vssd1 vssd1 vccd1 vccd1 _02726_ sky130_fd_sc_hd__o21bai_2
X_05554_ _04754_ _04756_ _04755_ vssd1 vssd1 vccd1 vccd1 _04824_ sky130_fd_sc_hd__a21bo_1
X_08273_ net274 net453 _02647_ _02648_ vssd1 vssd1 vccd1 vccd1 _02650_ sky130_fd_sc_hd__a22oi_2
XFILLER_0_73_143 vssd1 vssd1 vccd1 vccd1 sky130_fd_sc_hd__decap_4
X_05485_ net364 net371 net530 net543 vssd1 vssd1 vccd1 vccd1 _04755_ sky130_fd_sc_hd__nand4_1
XFILLER_0_46_335 vssd1 vssd1 vccd1 vccd1 sky130_fd_sc_hd__decap_6
XFILLER_0_61_327 vssd1 vssd1 vccd1 vccd1 sky130_fd_sc_hd__fill_2
X_07224_ net304 net473 _01591_ _01592_ vssd1 vssd1 vccd1 vccd1 _01594_ sky130_fd_sc_hd__and4_1
XFILLER_0_6_443 vssd1 vssd1 vccd1 vccd1 sky130_fd_sc_hd__fill_1
XFILLER_0_6_421 vssd1 vssd1 vccd1 vccd1 sky130_fd_sc_hd__decap_6
XFILLER_0_13_80 vssd1 vssd1 vccd1 vccd1 sky130_fd_sc_hd__fill_2
XFILLER_0_80_3 vssd1 vssd1 vccd1 vccd1 sky130_fd_sc_hd__decap_6
XFILLER_0_42_541 vssd1 vssd1 vccd1 vccd1 sky130_fd_sc_hd__fill_2
XFILLER_0_14_265 vssd1 vssd1 vccd1 vccd1 sky130_fd_sc_hd__fill_1
XFILLER_0_42_552 vssd1 vssd1 vccd1 vccd1 sky130_fd_sc_hd__decap_4
X_07155_ net197 net591 _01522_ _01523_ vssd1 vssd1 vccd1 vccd1 _01525_ sky130_fd_sc_hd__nand4_2
X_07086_ _01454_ _01455_ _01456_ vssd1 vssd1 vccd1 vccd1 _01457_ sky130_fd_sc_hd__nand3_1
X_06106_ net607 net142 net128 net368 _00484_ vssd1 vssd1 vccd1 vccd1 net65 sky130_fd_sc_hd__a221o_1
XFILLER_0_14_298 vssd1 vssd1 vccd1 vccd1 sky130_fd_sc_hd__decap_4
X_06037_ _00397_ _00414_ vssd1 vssd1 vccd1 vccd1 _00416_ sky130_fd_sc_hd__nand2_1
Xfanout123 _03513_ vssd1 vssd1 vccd1 vccd1 net123 sky130_fd_sc_hd__clkbuf_4
Xfanout145 _02210_ vssd1 vssd1 vccd1 vccd1 net145 sky130_fd_sc_hd__clkbuf_2
Xfanout156 net158 vssd1 vssd1 vccd1 vccd1 net156 sky130_fd_sc_hd__clkbuf_4
Xfanout134 _01881_ vssd1 vssd1 vccd1 vccd1 net134 sky130_fd_sc_hd__buf_4
Xfanout178 mul.a\[25\] vssd1 vssd1 vccd1 vccd1 net178 sky130_fd_sc_hd__clkbuf_4
X_07988_ _02187_ _02190_ _02359_ _02360_ vssd1 vssd1 vccd1 vccd1 _02361_ sky130_fd_sc_hd__a211oi_2
Xfanout167 net168 vssd1 vssd1 vccd1 vccd1 net167 sky130_fd_sc_hd__clkbuf_2
Xfanout189 net190 vssd1 vssd1 vccd1 vccd1 net189 sky130_fd_sc_hd__clkbuf_2
X_09727_ _04237_ _04238_ vssd1 vssd1 vccd1 vccd1 _04239_ sky130_fd_sc_hd__or2_1
X_06939_ _01302_ _01310_ vssd1 vssd1 vccd1 vccd1 _01311_ sky130_fd_sc_hd__xnor2_1
XFILLER_0_69_405 vssd1 vssd1 vccd1 vccd1 sky130_fd_sc_hd__decap_4
X_09658_ net410 net145 net131 mul.a\[28\] vssd1 vssd1 vccd1 vccd1 _04164_ sky130_fd_sc_hd__a22o_1
XFILLER_0_96_224 vssd1 vssd1 vccd1 vccd1 sky130_fd_sc_hd__fill_1
XTAP_1114 vssd1 vccd1 sky130_fd_sc_hd__tapvpwrvgnd_1
XTAP_1103 vssd1 vccd1 sky130_fd_sc_hd__tapvpwrvgnd_1
X_08609_ _03007_ _03016_ vssd1 vssd1 vccd1 vccd1 _03018_ sky130_fd_sc_hd__xnor2_1
XTAP_1147 vssd1 vccd1 sky130_fd_sc_hd__tapvpwrvgnd_1
XTAP_1136 vssd1 vccd1 sky130_fd_sc_hd__tapvpwrvgnd_1
XTAP_1125 vssd1 vccd1 sky130_fd_sc_hd__tapvpwrvgnd_1
X_09589_ _03943_ _03945_ vssd1 vssd1 vccd1 vccd1 _04089_ sky130_fd_sc_hd__or2_1
XTAP_1158 vssd1 vccd1 sky130_fd_sc_hd__tapvpwrvgnd_1
XTAP_1169 vssd1 vccd1 sky130_fd_sc_hd__tapvpwrvgnd_1
XFILLER_0_37_302 vssd1 vssd1 vccd1 vccd1 sky130_fd_sc_hd__decap_6
XFILLER_0_64_121 vssd1 vssd1 vccd1 vccd1 sky130_fd_sc_hd__fill_2
XFILLER_0_37_335 vssd1 vssd1 vccd1 vccd1 sky130_fd_sc_hd__fill_1
XFILLER_0_64_165 vssd1 vssd1 vccd1 vccd1 sky130_fd_sc_hd__decap_4
XFILLER_0_9_281 vssd1 vssd1 vccd1 vccd1 sky130_fd_sc_hd__decap_4
XFILLER_0_100_29 vssd1 vssd1 vccd1 vccd1 sky130_ef_sc_hd__decap_12
XFILLER_0_33_552 vssd1 vssd1 vccd1 vccd1 sky130_fd_sc_hd__decap_8
XTAP_909 vssd1 vccd1 sky130_fd_sc_hd__tapvpwrvgnd_1
XFILLER_0_28_324 vssd1 vssd1 vccd1 vccd1 sky130_fd_sc_hd__fill_1
XFILLER_0_28_335 vssd1 vssd1 vccd1 vccd1 sky130_fd_sc_hd__fill_1
X_05270_ _04328_ _04339_ _04481_ _04492_ vssd1 vssd1 vccd1 vccd1 _04503_ sky130_fd_sc_hd__and4bb_1
XFILLER_0_24_530 vssd1 vssd1 vccd1 vccd1 sky130_fd_sc_hd__fill_2
XFILLER_0_43_349 vssd1 vssd1 vccd1 vccd1 sky130_fd_sc_hd__fill_1
XFILLER_0_3_457 vssd1 vssd1 vccd1 vccd1 sky130_fd_sc_hd__fill_1
XFILLER_0_24_596 vssd1 vssd1 vccd1 vccd1 sky130_fd_sc_hd__fill_2
X_08960_ net152 net157 net697 net545 vssd1 vssd1 vccd1 vccd1 _03401_ sky130_fd_sc_hd__nand4_2
XFILLER_0_59_98 vssd1 vssd1 vccd1 vccd1 sky130_fd_sc_hd__fill_1
X_08891_ _03315_ _03325_ vssd1 vssd1 vccd1 vccd1 _03326_ sky130_fd_sc_hd__xor2_1
X_07911_ net494 net144 net130 net256 vssd1 vssd1 vccd1 vccd1 _02285_ sky130_fd_sc_hd__a22o_1
X_07842_ _02209_ _02211_ _02196_ vssd1 vssd1 vccd1 vccd1 _02214_ sky130_fd_sc_hd__a21oi_1
X_09512_ _04002_ _04003_ vssd1 vssd1 vccd1 vccd1 _04005_ sky130_fd_sc_hd__xor2_2
X_07773_ _02142_ _02143_ vssd1 vssd1 vccd1 vccd1 _02144_ sky130_fd_sc_hd__nor2_1
XFILLER_0_78_224 vssd1 vssd1 vccd1 vccd1 sky130_ef_sc_hd__decap_12
X_06724_ net564 net143 net128 mul.a\[8\] _01097_ vssd1 vssd1 vccd1 vccd1 net70 sky130_fd_sc_hd__a221o_1
XFILLER_0_91_85 vssd1 vssd1 vccd1 vccd1 sky130_ef_sc_hd__decap_12
X_09443_ net276 net395 _03926_ _03928_ vssd1 vssd1 vccd1 vccd1 _03929_ sky130_fd_sc_hd__a22o_1
X_06655_ _01026_ _01027_ _01028_ vssd1 vssd1 vccd1 vccd1 _01029_ sky130_fd_sc_hd__and3_1
X_09374_ _03850_ _03853_ vssd1 vssd1 vccd1 vccd1 _03854_ sky130_fd_sc_hd__or2_1
X_05606_ _04859_ _04874_ vssd1 vssd1 vccd1 vccd1 _04876_ sky130_fd_sc_hd__nand2_1
X_08325_ _02664_ _02665_ _02705_ _02706_ vssd1 vssd1 vccd1 vccd1 _02707_ sky130_fd_sc_hd__and4bb_2
X_06586_ _00182_ _00960_ vssd1 vssd1 vccd1 vccd1 _00961_ sky130_fd_sc_hd__nor2_1
X_05537_ _04804_ _04805_ _04733_ _04736_ vssd1 vssd1 vccd1 vccd1 _04807_ sky130_fd_sc_hd__o211a_1
XFILLER_0_34_316 vssd1 vssd1 vccd1 vccd1 sky130_ef_sc_hd__decap_12
X_08256_ _02628_ _02629_ _02625_ vssd1 vssd1 vccd1 vccd1 _02631_ sky130_fd_sc_hd__a21o_1
XFILLER_0_61_135 vssd1 vssd1 vccd1 vccd1 sky130_fd_sc_hd__fill_2
XFILLER_0_61_113 vssd1 vssd1 vccd1 vccd1 sky130_fd_sc_hd__fill_2
X_05468_ _04121_ _04545_ _04736_ _04737_ vssd1 vssd1 vccd1 vccd1 _04738_ sky130_fd_sc_hd__o211a_1
X_08187_ net316 net432 _02397_ _02398_ net445 vssd1 vssd1 vccd1 vccd1 _02559_ sky130_fd_sc_hd__a32o_1
X_07207_ net334 net449 _01575_ _01576_ vssd1 vssd1 vccd1 vccd1 _01577_ sky130_fd_sc_hd__o2bb2a_1
XFILLER_0_6_295 vssd1 vssd1 vccd1 vccd1 sky130_fd_sc_hd__fill_1
XFILLER_0_15_541 vssd1 vssd1 vccd1 vccd1 sky130_fd_sc_hd__fill_1
XFILLER_0_15_552 vssd1 vssd1 vccd1 vccd1 sky130_fd_sc_hd__decap_8
XFILLER_0_61_179 vssd1 vssd1 vccd1 vccd1 sky130_fd_sc_hd__decap_4
XFILLER_0_15_574 vssd1 vssd1 vccd1 vccd1 sky130_fd_sc_hd__fill_1
X_05399_ _04654_ _04668_ vssd1 vssd1 vccd1 vccd1 _04669_ sky130_fd_sc_hd__nand2_1
X_07138_ _01506_ _01507_ vssd1 vssd1 vccd1 vccd1 _01508_ sky130_fd_sc_hd__xnor2_1
XFILLER_0_100_421 vssd1 vssd1 vccd1 vccd1 sky130_fd_sc_hd__fill_1
X_07069_ net304 net481 net490 net295 vssd1 vssd1 vccd1 vccd1 _01440_ sky130_fd_sc_hd__a22o_1
X_10080_ clknet_3_0_0_wb_clk_i _00076_ _00012_ vssd1 vssd1 vccd1 vccd1 mul.b\[9\]
+ sky130_fd_sc_hd__dfrtp_1
XFILLER_0_38_600 vssd1 vssd1 vccd1 vccd1 sky130_fd_sc_hd__fill_1
XFILLER_0_37_143 vssd1 vssd1 vccd1 vccd1 sky130_fd_sc_hd__fill_1
XFILLER_0_20_15 vssd1 vssd1 vccd1 vccd1 sky130_fd_sc_hd__decap_3
XFILLER_0_20_26 vssd1 vssd1 vccd1 vccd1 sky130_fd_sc_hd__fill_2
Xmax_cap109 _02969_ vssd1 vssd1 vccd1 vccd1 net109 sky130_fd_sc_hd__buf_1
XFILLER_0_21_555 vssd1 vssd1 vccd1 vccd1 sky130_fd_sc_hd__fill_2
XFILLER_0_33_393 vssd1 vssd1 vccd1 vccd1 sky130_fd_sc_hd__decap_6
XTAP_706 vssd1 vccd1 sky130_fd_sc_hd__tapvpwrvgnd_1
XTAP_717 vssd1 vccd1 sky130_fd_sc_hd__tapvpwrvgnd_1
XTAP_728 vssd1 vccd1 sky130_fd_sc_hd__tapvpwrvgnd_1
XTAP_739 vssd1 vccd1 sky130_fd_sc_hd__tapvpwrvgnd_1
XFILLER_0_45_23 vssd1 vssd1 vccd1 vccd1 sky130_fd_sc_hd__decap_8
Xmax_cap1 _03832_ vssd1 vssd1 vccd1 vccd1 net711 sky130_fd_sc_hd__clkbuf_1
X_06440_ _00690_ _00693_ _00814_ _00815_ vssd1 vssd1 vccd1 vccd1 _00816_ sky130_fd_sc_hd__a211oi_4
XFILLER_0_48_419 vssd1 vssd1 vccd1 vccd1 sky130_fd_sc_hd__fill_1
XFILLER_0_61_88 vssd1 vssd1 vccd1 vccd1 sky130_fd_sc_hd__fill_1
X_06371_ _00626_ _00630_ _00745_ vssd1 vssd1 vccd1 vccd1 _00747_ sky130_fd_sc_hd__nand3_1
X_09090_ _03540_ _03541_ _03543_ vssd1 vssd1 vccd1 vccd1 _03544_ sky130_fd_sc_hd__or3_4
X_08110_ _02444_ _02480_ vssd1 vssd1 vccd1 vccd1 _02482_ sky130_fd_sc_hd__xnor2_2
XFILLER_0_56_485 vssd1 vssd1 vccd1 vccd1 sky130_fd_sc_hd__fill_2
X_05322_ _04033_ _04589_ _04588_ vssd1 vssd1 vccd1 vccd1 _04592_ sky130_fd_sc_hd__a21oi_1
XFILLER_0_28_187 vssd1 vssd1 vccd1 vccd1 sky130_fd_sc_hd__decap_8
X_08041_ _02411_ _02412_ _02207_ _02209_ vssd1 vssd1 vccd1 vccd1 _02414_ sky130_fd_sc_hd__o211a_1
XFILLER_0_71_455 vssd1 vssd1 vccd1 vccd1 sky130_fd_sc_hd__fill_1
X_05253_ _04274_ _04285_ _04296_ vssd1 vssd1 vccd1 vccd1 _04317_ sky130_fd_sc_hd__a21o_1
XFILLER_0_3_254 vssd1 vssd1 vccd1 vccd1 sky130_fd_sc_hd__decap_4
XFILLER_0_12_522 vssd1 vssd1 vccd1 vccd1 sky130_fd_sc_hd__fill_2
XFILLER_0_12_533 vssd1 vssd1 vccd1 vccd1 sky130_fd_sc_hd__decap_6
X_05184_ _02919_ _03421_ _03553_ vssd1 vssd1 vccd1 vccd1 _03563_ sky130_fd_sc_hd__nand3_1
XFILLER_0_24_393 vssd1 vssd1 vccd1 vccd1 sky130_fd_sc_hd__decap_4
X_09992_ _04360_ _04390_ _04391_ _04395_ vssd1 vssd1 vccd1 vccd1 _04529_ sky130_fd_sc_hd__o31ai_1
X_08943_ _03380_ _03381_ _03382_ vssd1 vssd1 vccd1 vccd1 _03383_ sky130_fd_sc_hd__or3_1
XFILLER_0_86_85 vssd1 vssd1 vccd1 vccd1 sky130_fd_sc_hd__decap_8
XFILLER_0_43_3 vssd1 vssd1 vccd1 vccd1 sky130_fd_sc_hd__decap_6
X_08874_ _03281_ _03282_ _03303_ _03304_ vssd1 vssd1 vccd1 vccd1 _03307_ sky130_fd_sc_hd__a22oi_4
XFILLER_0_19_90 vssd1 vssd1 vccd1 vccd1 sky130_fd_sc_hd__fill_1
XFILLER_0_98_319 vssd1 vssd1 vccd1 vccd1 sky130_fd_sc_hd__fill_2
X_07825_ _02057_ _02063_ _02062_ vssd1 vssd1 vccd1 vccd1 _02196_ sky130_fd_sc_hd__a21o_1
XFILLER_0_79_544 vssd1 vssd1 vccd1 vccd1 sky130_fd_sc_hd__decap_3
X_07756_ _01956_ _01958_ vssd1 vssd1 vccd1 vccd1 _02127_ sky130_fd_sc_hd__nor2_1
X_06707_ _01005_ _01006_ _01079_ _01080_ vssd1 vssd1 vccd1 vccd1 _01081_ sky130_fd_sc_hd__nand4_4
XFILLER_0_94_525 vssd1 vssd1 vccd1 vccd1 sky130_fd_sc_hd__decap_6
X_09426_ _03893_ _03909_ vssd1 vssd1 vccd1 vccd1 _03910_ sky130_fd_sc_hd__nand2_1
X_07687_ net254 net265 net494 net502 vssd1 vssd1 vccd1 vccd1 _02059_ sky130_fd_sc_hd__nand4_2
XFILLER_0_94_547 vssd1 vssd1 vccd1 vccd1 sky130_fd_sc_hd__fill_1
X_06638_ _01008_ _01010_ _00888_ vssd1 vssd1 vccd1 vccd1 _01012_ sky130_fd_sc_hd__a21oi_1
X_09357_ net79 _03833_ _03666_ _03691_ vssd1 vssd1 vccd1 vccd1 _03835_ sky130_fd_sc_hd__o211a_1
X_06569_ _00941_ _00942_ _00816_ _00818_ vssd1 vssd1 vccd1 vccd1 _00944_ sky130_fd_sc_hd__a211oi_4
XFILLER_0_47_463 vssd1 vssd1 vccd1 vccd1 sky130_fd_sc_hd__decap_8
X_08308_ _02687_ vssd1 vssd1 vccd1 vccd1 _02688_ sky130_fd_sc_hd__inv_2
X_09288_ _03757_ _03758_ vssd1 vssd1 vccd1 vccd1 _03759_ sky130_fd_sc_hd__and2b_1
X_08239_ net207 net508 net518 net201 vssd1 vssd1 vccd1 vccd1 _02613_ sky130_fd_sc_hd__a22o_1
XFILLER_0_15_382 vssd1 vssd1 vccd1 vccd1 sky130_fd_sc_hd__decap_4
XFILLER_0_30_341 vssd1 vssd1 vccd1 vccd1 sky130_fd_sc_hd__fill_2
XFILLER_0_42_190 vssd1 vssd1 vccd1 vccd1 sky130_fd_sc_hd__fill_1
X_10132_ clknet_3_5_0_wb_clk_i _00126_ _00062_ vssd1 vssd1 vccd1 vccd1 mul.a\[27\]
+ sky130_fd_sc_hd__dfrtp_1
X_10063_ net644 vssd1 vssd1 vccd1 vccd1 _00059_ sky130_fd_sc_hd__inv_2
XFILLER_0_57_216 vssd1 vssd1 vccd1 vccd1 sky130_fd_sc_hd__fill_1
XFILLER_0_85_569 vssd1 vssd1 vccd1 vccd1 sky130_fd_sc_hd__fill_1
XFILLER_0_85_558 vssd1 vssd1 vccd1 vccd1 sky130_fd_sc_hd__fill_2
XFILLER_0_38_452 vssd1 vssd1 vccd1 vccd1 sky130_fd_sc_hd__decap_8
XFILLER_0_38_474 vssd1 vssd1 vccd1 vccd1 sky130_fd_sc_hd__fill_2
XFILLER_0_53_455 vssd1 vssd1 vccd1 vccd1 sky130_fd_sc_hd__fill_1
XFILLER_0_31_69 vssd1 vssd1 vccd1 vccd1 sky130_fd_sc_hd__decap_8
XFILLER_0_21_330 vssd1 vssd1 vccd1 vccd1 sky130_fd_sc_hd__fill_1
XFILLER_0_40_138 vssd1 vssd1 vccd1 vccd1 sky130_fd_sc_hd__fill_2
XFILLER_0_21_396 vssd1 vssd1 vccd1 vccd1 sky130_fd_sc_hd__fill_2
XTAP_503 vssd1 vccd1 sky130_fd_sc_hd__tapvpwrvgnd_1
XTAP_514 vssd1 vccd1 sky130_fd_sc_hd__tapvpwrvgnd_1
XTAP_525 vssd1 vccd1 sky130_fd_sc_hd__tapvpwrvgnd_1
XTAP_536 vssd1 vccd1 sky130_fd_sc_hd__tapvpwrvgnd_1
XTAP_547 vssd1 vccd1 sky130_fd_sc_hd__tapvpwrvgnd_1
XTAP_558 vssd1 vccd1 sky130_fd_sc_hd__tapvpwrvgnd_1
XFILLER_0_56_55 vssd1 vssd1 vccd1 vccd1 sky130_fd_sc_hd__decap_3
X_05940_ _00300_ _00318_ vssd1 vssd1 vccd1 vccd1 _00320_ sky130_fd_sc_hd__and2_1
XTAP_569 vssd1 vccd1 sky130_fd_sc_hd__tapvpwrvgnd_1
X_05871_ _00233_ _00250_ _00251_ vssd1 vssd1 vccd1 vccd1 _00252_ sky130_fd_sc_hd__and3_1
X_08590_ _02972_ _02974_ _02994_ vssd1 vssd1 vccd1 vccd1 _02997_ sky130_fd_sc_hd__nand3_2
X_07610_ net205 net555 _01979_ _01980_ vssd1 vssd1 vccd1 vccd1 _01982_ sky130_fd_sc_hd__nand4_2
X_07541_ _01911_ _01912_ _01750_ _01753_ vssd1 vssd1 vccd1 vccd1 _01914_ sky130_fd_sc_hd__a211o_1
XFILLER_0_88_363 vssd1 vssd1 vccd1 vccd1 sky130_fd_sc_hd__fill_1
X_07472_ net376 net383 net402 net409 vssd1 vssd1 vccd1 vccd1 _01842_ sky130_fd_sc_hd__nand4_2
X_09211_ _03668_ _03675_ vssd1 vssd1 vccd1 vccd1 _03676_ sky130_fd_sc_hd__and2_1
X_06423_ _00796_ _00797_ _00798_ vssd1 vssd1 vccd1 vccd1 _00799_ sky130_fd_sc_hd__nand3_1
X_09142_ _03597_ _03598_ _03416_ _03430_ vssd1 vssd1 vccd1 vccd1 _03600_ sky130_fd_sc_hd__a211o_1
XFILLER_0_8_368 vssd1 vssd1 vccd1 vccd1 sky130_fd_sc_hd__decap_4
X_06354_ _00725_ _00728_ vssd1 vssd1 vccd1 vccd1 _00730_ sky130_fd_sc_hd__xnor2_1
XFILLER_0_71_252 vssd1 vssd1 vccd1 vccd1 sky130_fd_sc_hd__decap_4
X_05305_ _04559_ _04573_ _04574_ vssd1 vssd1 vccd1 vccd1 _04575_ sky130_fd_sc_hd__nand3_1
X_09073_ _03523_ _03524_ vssd1 vssd1 vccd1 vccd1 _03525_ sky130_fd_sc_hd__nand2_1
XFILLER_0_71_263 vssd1 vssd1 vccd1 vccd1 sky130_ef_sc_hd__decap_12
X_06285_ net352 net478 net487 net343 vssd1 vssd1 vccd1 vccd1 _00662_ sky130_fd_sc_hd__a22o_1
XFILLER_0_44_477 vssd1 vssd1 vccd1 vccd1 sky130_fd_sc_hd__decap_4
X_08024_ net307 net438 net445 net299 vssd1 vssd1 vccd1 vccd1 _02397_ sky130_fd_sc_hd__a22o_1
X_05236_ _03684_ _04110_ vssd1 vssd1 vccd1 vccd1 _04132_ sky130_fd_sc_hd__and2_1
XFILLER_0_4_574 vssd1 vssd1 vccd1 vccd1 sky130_fd_sc_hd__fill_1
XFILLER_0_12_352 vssd1 vssd1 vccd1 vccd1 sky130_fd_sc_hd__fill_1
X_05167_ _03181_ _03236_ vssd1 vssd1 vccd1 vccd1 _03378_ sky130_fd_sc_hd__and2b_1
X_09975_ _04508_ _04509_ vssd1 vssd1 vccd1 vccd1 _04510_ sky130_fd_sc_hd__xnor2_1
X_05098_ net310 net622 net630 net301 vssd1 vssd1 vccd1 vccd1 _02623_ sky130_fd_sc_hd__a22oi_1
X_08926_ _03357_ _03363_ vssd1 vssd1 vccd1 vccd1 _03364_ sky130_fd_sc_hd__xnor2_1
XFILLER_0_98_105 vssd1 vssd1 vccd1 vccd1 sky130_fd_sc_hd__decap_3
X_08857_ net223 net458 net465 net215 vssd1 vssd1 vccd1 vccd1 _03288_ sky130_fd_sc_hd__a22oi_1
X_07808_ net350 net414 _02177_ _02178_ vssd1 vssd1 vccd1 vccd1 _02179_ sky130_fd_sc_hd__a22o_1
X_08788_ _03212_ _03204_ vssd1 vssd1 vccd1 vccd1 _03213_ sky130_fd_sc_hd__and2b_1
X_07739_ _01948_ _01952_ _02109_ _00182_ vssd1 vssd1 vccd1 vccd1 _02111_ sky130_fd_sc_hd__a31o_1
X_09409_ _03889_ _03890_ vssd1 vssd1 vccd1 vccd1 _03892_ sky130_fd_sc_hd__nand2_2
XFILLER_0_47_260 vssd1 vssd1 vccd1 vccd1 sky130_fd_sc_hd__decap_3
XFILLER_0_35_444 vssd1 vssd1 vccd1 vccd1 sky130_fd_sc_hd__decap_4
XFILLER_0_23_617 vssd1 vssd1 vccd1 vccd1 sky130_fd_sc_hd__fill_1
X_10115_ clknet_3_1_0_wb_clk_i _00109_ _00045_ vssd1 vssd1 vccd1 vccd1 mul.a\[10\]
+ sky130_fd_sc_hd__dfrtp_1
X_10046_ net639 vssd1 vssd1 vccd1 vccd1 _00042_ sky130_fd_sc_hd__inv_2
XFILLER_0_97_160 vssd1 vssd1 vccd1 vccd1 sky130_fd_sc_hd__decap_8
XFILLER_0_97_182 vssd1 vssd1 vccd1 vccd1 sky130_fd_sc_hd__decap_3
XFILLER_0_42_57 vssd1 vssd1 vccd1 vccd1 sky130_fd_sc_hd__fill_1
XFILLER_0_42_68 vssd1 vssd1 vccd1 vccd1 sky130_fd_sc_hd__decap_8
XFILLER_0_73_539 vssd1 vssd1 vccd1 vccd1 sky130_fd_sc_hd__decap_4
XFILLER_0_66_580 vssd1 vssd1 vccd1 vccd1 sky130_fd_sc_hd__fill_1
XFILLER_0_26_400 vssd1 vssd1 vccd1 vccd1 sky130_fd_sc_hd__fill_2
XFILLER_0_38_260 vssd1 vssd1 vccd1 vccd1 sky130_fd_sc_hd__fill_1
XFILLER_0_53_230 vssd1 vssd1 vccd1 vccd1 sky130_ef_sc_hd__decap_12
XFILLER_0_5_305 vssd1 vssd1 vccd1 vccd1 sky130_ef_sc_hd__decap_12
XFILLER_0_5_349 vssd1 vssd1 vccd1 vccd1 sky130_fd_sc_hd__decap_8
XFILLER_0_101_3 vssd1 vssd1 vccd1 vccd1 sky130_ef_sc_hd__decap_12
XANTENNA_1 mul.a\[25\] vssd1 vssd1 vccd1 vccd1 sky130_fd_sc_hd__diode_2
X_06070_ _00440_ _00447_ _00448_ vssd1 vssd1 vccd1 vccd1 _00449_ sky130_fd_sc_hd__nand3_2
XFILLER_0_41_447 vssd1 vssd1 vccd1 vccd1 sky130_fd_sc_hd__fill_1
X_05021_ net3 vssd1 vssd1 vccd1 vccd1 _01849_ sky130_fd_sc_hd__inv_2
Xfanout519 net520 vssd1 vssd1 vccd1 vccd1 net519 sky130_fd_sc_hd__clkbuf_2
XFILLER_0_67_65 vssd1 vssd1 vccd1 vccd1 sky130_ef_sc_hd__decap_12
XFILLER_0_67_54 vssd1 vssd1 vccd1 vccd1 sky130_fd_sc_hd__fill_2
Xfanout508 net509 vssd1 vssd1 vccd1 vccd1 net508 sky130_fd_sc_hd__clkbuf_4
XTAP_333 vssd1 vccd1 sky130_fd_sc_hd__tapvpwrvgnd_1
XTAP_322 vssd1 vccd1 sky130_fd_sc_hd__tapvpwrvgnd_1
XTAP_311 vssd1 vccd1 sky130_fd_sc_hd__tapvpwrvgnd_1
XTAP_300 vssd1 vccd1 sky130_fd_sc_hd__tapvpwrvgnd_1
X_09760_ _04082_ _04085_ _04273_ vssd1 vssd1 vccd1 vccd1 _04276_ sky130_fd_sc_hd__nor3_1
XFILLER_0_67_98 vssd1 vssd1 vccd1 vccd1 sky130_fd_sc_hd__decap_4
XFILLER_0_67_87 vssd1 vssd1 vccd1 vccd1 sky130_fd_sc_hd__decap_4
XTAP_344 vssd1 vccd1 sky130_fd_sc_hd__tapvpwrvgnd_1
XTAP_355 vssd1 vccd1 sky130_fd_sc_hd__tapvpwrvgnd_1
XTAP_366 vssd1 vccd1 sky130_fd_sc_hd__tapvpwrvgnd_1
X_06972_ _01264_ _01341_ _01342_ vssd1 vssd1 vccd1 vccd1 _01344_ sky130_fd_sc_hd__or3_4
X_08711_ _02955_ net109 _03127_ _03128_ vssd1 vssd1 vccd1 vccd1 _03129_ sky130_fd_sc_hd__o211ai_4
XTAP_377 vssd1 vccd1 sky130_fd_sc_hd__tapvpwrvgnd_1
X_05923_ _00301_ _00302_ vssd1 vssd1 vccd1 vccd1 _00303_ sky130_fd_sc_hd__nand2b_1
XTAP_388 vssd1 vccd1 sky130_fd_sc_hd__tapvpwrvgnd_1
XTAP_399 vssd1 vccd1 sky130_fd_sc_hd__tapvpwrvgnd_1
X_09691_ _04198_ _04199_ vssd1 vssd1 vccd1 vccd1 _04200_ sky130_fd_sc_hd__or2_1
X_08642_ net163 net138 _03052_ vssd1 vssd1 vccd1 vccd1 _03054_ sky130_fd_sc_hd__a21bo_1
XFILLER_0_83_20 vssd1 vssd1 vccd1 vccd1 sky130_fd_sc_hd__fill_1
Xrebuffer35 net679 vssd1 vssd1 vccd1 vccd1 net680 sky130_fd_sc_hd__clkbuf_1
XFILLER_0_83_64 vssd1 vssd1 vccd1 vccd1 sky130_ef_sc_hd__decap_12
Xrebuffer24 _01914_ vssd1 vssd1 vccd1 vccd1 net669 sky130_fd_sc_hd__clkbuf_1
Xrebuffer13 _01773_ vssd1 vssd1 vccd1 vccd1 net658 sky130_fd_sc_hd__clkbuf_1
Xrebuffer46 net690 vssd1 vssd1 vccd1 vccd1 net691 sky130_fd_sc_hd__clkbuf_1
X_05854_ net364 net509 net513 net356 vssd1 vssd1 vccd1 vccd1 _00235_ sky130_fd_sc_hd__a22oi_1
Xrebuffer57 _03305_ vssd1 vssd1 vccd1 vccd1 net702 sky130_fd_sc_hd__buf_1
X_08573_ _02976_ _02977_ vssd1 vssd1 vccd1 vccd1 _02978_ sky130_fd_sc_hd__nand2_1
XPHY_17 vssd1 vssd1 vccd1 vccd1 sky130_fd_sc_hd__decap_3
X_05785_ _04839_ _04959_ _04961_ vssd1 vssd1 vccd1 vccd1 _00167_ sky130_fd_sc_hd__a21oi_1
XPHY_28 vssd1 vssd1 vccd1 vccd1 sky130_fd_sc_hd__decap_3
Xrebuffer68 _01198_ vssd1 vssd1 vccd1 vccd1 net724 sky130_fd_sc_hd__dlymetal6s2s_1
X_07524_ _01892_ _01895_ _01896_ vssd1 vssd1 vccd1 vccd1 _01897_ sky130_fd_sc_hd__and3_1
XPHY_39 vssd1 vssd1 vccd1 vccd1 sky130_fd_sc_hd__decap_3
XFILLER_0_49_558 vssd1 vssd1 vccd1 vccd1 sky130_fd_sc_hd__fill_2
X_07455_ _01695_ _01821_ vssd1 vssd1 vccd1 vccd1 _01823_ sky130_fd_sc_hd__xor2_2
X_06406_ net352 net469 vssd1 vssd1 vccd1 vccd1 _00782_ sky130_fd_sc_hd__nand2_1
X_07386_ net240 net527 _01751_ _01752_ vssd1 vssd1 vccd1 vccd1 _01755_ sky130_fd_sc_hd__a22o_1
X_09125_ _03578_ _03579_ _03580_ vssd1 vssd1 vccd1 vccd1 _03581_ sky130_fd_sc_hd__and3_2
X_06337_ _00712_ _00713_ vssd1 vssd1 vccd1 vccd1 _00714_ sky130_fd_sc_hd__and2_1
X_09056_ _03315_ _03324_ _03322_ vssd1 vssd1 vccd1 vccd1 _03506_ sky130_fd_sc_hd__a21o_1
X_06268_ _00643_ _00644_ vssd1 vssd1 vccd1 vccd1 _00645_ sky130_fd_sc_hd__nor2_1
X_08007_ _02376_ _02377_ _02378_ vssd1 vssd1 vccd1 vccd1 _02380_ sky130_fd_sc_hd__a21oi_2
X_05219_ _03323_ _03356_ vssd1 vssd1 vccd1 vccd1 _03946_ sky130_fd_sc_hd__xor2_1
X_06199_ _00573_ _00575_ _00456_ _00458_ vssd1 vssd1 vccd1 vccd1 _00577_ sky130_fd_sc_hd__o211a_1
X_09958_ net222 net407 vssd1 vssd1 vccd1 vccd1 _04491_ sky130_fd_sc_hd__nand2_1
X_08909_ _03187_ _03189_ _03343_ _03344_ vssd1 vssd1 vccd1 vccd1 _03346_ sky130_fd_sc_hd__a211oi_2
X_09889_ _04413_ _04414_ vssd1 vssd1 vccd1 vccd1 _04417_ sky130_fd_sc_hd__and2_1
XFILLER_0_86_108 vssd1 vssd1 vccd1 vccd1 sky130_fd_sc_hd__fill_1
XFILLER_0_94_141 vssd1 vssd1 vccd1 vccd1 sky130_ef_sc_hd__decap_12
XFILLER_0_94_174 vssd1 vssd1 vccd1 vccd1 sky130_fd_sc_hd__decap_8
XFILLER_0_27_219 vssd1 vssd1 vccd1 vccd1 sky130_fd_sc_hd__decap_4
XFILLER_0_63_561 vssd1 vssd1 vccd1 vccd1 sky130_fd_sc_hd__fill_1
XFILLER_0_50_211 vssd1 vssd1 vccd1 vccd1 sky130_fd_sc_hd__decap_3
XFILLER_0_23_436 vssd1 vssd1 vccd1 vccd1 sky130_fd_sc_hd__fill_1
Xoutput60 net60 vssd1 vssd1 vccd1 vccd1 wbs_dat_o[28] sky130_fd_sc_hd__clkbuf_4
Xoutput71 net71 vssd1 vssd1 vccd1 vccd1 wbs_dat_o[9] sky130_fd_sc_hd__clkbuf_4
X_10029_ net644 vssd1 vssd1 vccd1 vccd1 _00025_ sky130_fd_sc_hd__inv_2
XFILLER_0_98_491 vssd1 vssd1 vccd1 vccd1 sky130_fd_sc_hd__fill_2
X_05570_ _04820_ _04838_ vssd1 vssd1 vccd1 vccd1 _04840_ sky130_fd_sc_hd__xnor2_2
XFILLER_0_73_325 vssd1 vssd1 vccd1 vccd1 sky130_fd_sc_hd__decap_8
XFILLER_0_73_314 vssd1 vssd1 vccd1 vccd1 sky130_fd_sc_hd__fill_1
XFILLER_0_18_219 vssd1 vssd1 vccd1 vccd1 sky130_fd_sc_hd__decap_3
X_07240_ _01454_ _01456_ _01455_ vssd1 vssd1 vccd1 vccd1 _01610_ sky130_fd_sc_hd__a21bo_1
XFILLER_0_54_583 vssd1 vssd1 vccd1 vccd1 sky130_fd_sc_hd__fill_2
XFILLER_0_26_274 vssd1 vssd1 vccd1 vccd1 sky130_fd_sc_hd__fill_1
X_07171_ _01502_ _01539_ vssd1 vssd1 vccd1 vccd1 _01541_ sky130_fd_sc_hd__xor2_1
XFILLER_0_81_391 vssd1 vssd1 vccd1 vccd1 sky130_fd_sc_hd__fill_1
X_06122_ _00394_ _00499_ vssd1 vssd1 vccd1 vccd1 _00500_ sky130_fd_sc_hd__or2_2
XFILLER_0_1_330 vssd1 vssd1 vccd1 vccd1 sky130_fd_sc_hd__fill_1
X_06053_ _00426_ _00431_ vssd1 vssd1 vccd1 vccd1 _00432_ sky130_fd_sc_hd__and2b_1
Xfanout305 net306 vssd1 vssd1 vccd1 vccd1 net305 sky130_fd_sc_hd__clkbuf_4
Xfanout316 net318 vssd1 vssd1 vccd1 vccd1 net316 sky130_fd_sc_hd__buf_4
Xfanout327 net329 vssd1 vssd1 vccd1 vccd1 net327 sky130_fd_sc_hd__clkbuf_4
Xfanout338 net339 vssd1 vssd1 vccd1 vccd1 net338 sky130_fd_sc_hd__buf_4
X_09812_ _04173_ _04189_ _04330_ vssd1 vssd1 vccd1 vccd1 _04332_ sky130_fd_sc_hd__nor3_1
XFILLER_0_94_41 vssd1 vssd1 vccd1 vccd1 sky130_ef_sc_hd__decap_12
Xfanout349 mul.a\[5\] vssd1 vssd1 vccd1 vccd1 net349 sky130_fd_sc_hd__buf_6
X_09743_ _04254_ _04255_ _04239_ vssd1 vssd1 vccd1 vccd1 _04257_ sky130_fd_sc_hd__o21ai_1
X_06955_ _01182_ _01190_ _01189_ vssd1 vssd1 vccd1 vccd1 _01327_ sky130_fd_sc_hd__a21bo_1
X_05906_ net312 net554 net581 net289 vssd1 vssd1 vccd1 vccd1 _00286_ sky130_fd_sc_hd__a22o_1
XFILLER_0_27_90 vssd1 vssd1 vccd1 vccd1 sky130_fd_sc_hd__decap_8
X_06886_ _01126_ _01257_ vssd1 vssd1 vccd1 vccd1 _01258_ sky130_fd_sc_hd__or2_1
X_09674_ net166 net468 _04178_ _04179_ vssd1 vssd1 vccd1 vccd1 _04181_ sky130_fd_sc_hd__and4_1
XFILLER_0_96_406 vssd1 vssd1 vccd1 vccd1 sky130_ef_sc_hd__decap_12
X_08625_ _02823_ _02825_ _03033_ _03034_ vssd1 vssd1 vccd1 vccd1 _03035_ sky130_fd_sc_hd__o211a_1
X_05837_ _00216_ _00217_ vssd1 vssd1 vccd1 vccd1 _00218_ sky130_fd_sc_hd__and2b_1
XTAP_1329 vssd1 vccd1 sky130_fd_sc_hd__tapvpwrvgnd_1
XTAP_1307 vssd1 vccd1 sky130_fd_sc_hd__tapvpwrvgnd_1
XTAP_1318 vssd1 vccd1 sky130_fd_sc_hd__tapvpwrvgnd_1
X_08556_ net215 net482 net491 net207 vssd1 vssd1 vccd1 vccd1 _02959_ sky130_fd_sc_hd__a22o_1
XFILLER_0_76_141 vssd1 vssd1 vccd1 vccd1 sky130_ef_sc_hd__decap_12
X_07507_ net316 net452 vssd1 vssd1 vccd1 vccd1 _01879_ sky130_fd_sc_hd__and2_1
X_05768_ _04944_ _04950_ _04943_ vssd1 vssd1 vccd1 vccd1 _00150_ sky130_fd_sc_hd__a21bo_1
X_08487_ net155 net169 net558 net584 vssd1 vssd1 vccd1 vccd1 _02884_ sky130_fd_sc_hd__nand4_2
X_05699_ _04965_ _04966_ _04968_ vssd1 vssd1 vccd1 vccd1 _04969_ sky130_fd_sc_hd__and3_1
X_07438_ _01801_ _01804_ vssd1 vssd1 vccd1 vccd1 _01806_ sky130_fd_sc_hd__xor2_1
X_07369_ net277 net285 net480 net491 vssd1 vssd1 vccd1 vccd1 _01738_ sky130_fd_sc_hd__nand4_2
XFILLER_0_17_274 vssd1 vssd1 vccd1 vccd1 sky130_fd_sc_hd__decap_6
XFILLER_0_45_550 vssd1 vssd1 vccd1 vccd1 sky130_fd_sc_hd__decap_8
XFILLER_0_45_561 vssd1 vssd1 vccd1 vccd1 sky130_fd_sc_hd__decap_3
X_09108_ net433 net144 net130 net190 _03562_ vssd1 vssd1 vccd1 vccd1 net56 sky130_fd_sc_hd__a221o_1
XFILLER_0_17_296 vssd1 vssd1 vccd1 vccd1 sky130_fd_sc_hd__decap_8
X_09039_ _03478_ _03485_ vssd1 vssd1 vccd1 vccd1 _03488_ sky130_fd_sc_hd__xnor2_1
XFILLER_0_20_439 vssd1 vssd1 vccd1 vccd1 sky130_fd_sc_hd__fill_1
XFILLER_0_99_222 vssd1 vssd1 vccd1 vccd1 sky130_fd_sc_hd__fill_2
XFILLER_0_59_119 vssd1 vssd1 vccd1 vccd1 sky130_fd_sc_hd__decap_8
XFILLER_0_67_152 vssd1 vssd1 vccd1 vccd1 sky130_fd_sc_hd__decap_4
XFILLER_0_83_623 vssd1 vssd1 vccd1 vccd1 sky130_fd_sc_hd__fill_2
XFILLER_0_83_612 vssd1 vssd1 vccd1 vccd1 sky130_fd_sc_hd__decap_4
XFILLER_0_82_111 vssd1 vssd1 vccd1 vccd1 sky130_fd_sc_hd__fill_1
XFILLER_0_67_163 vssd1 vssd1 vccd1 vccd1 sky130_fd_sc_hd__fill_2
XFILLER_0_82_155 vssd1 vssd1 vccd1 vccd1 sky130_ef_sc_hd__decap_12
Xrebuffer4 _01928_ vssd1 vssd1 vccd1 vccd1 net649 sky130_fd_sc_hd__buf_1
XFILLER_0_2_116 vssd1 vssd1 vccd1 vccd1 sky130_fd_sc_hd__decap_8
XFILLER_0_2_149 vssd1 vssd1 vccd1 vccd1 sky130_fd_sc_hd__decap_3
XFILLER_0_48_23 vssd1 vssd1 vccd1 vccd1 sky130_fd_sc_hd__decap_4
XFILLER_0_48_89 vssd1 vssd1 vccd1 vccd1 sky130_fd_sc_hd__fill_1
X_06740_ _00974_ _00979_ _01111_ vssd1 vssd1 vccd1 vccd1 _01113_ sky130_fd_sc_hd__or3_1
XFILLER_0_78_406 vssd1 vssd1 vccd1 vccd1 sky130_ef_sc_hd__decap_12
X_06671_ _01042_ _01043_ _01039_ vssd1 vssd1 vccd1 vccd1 _01045_ sky130_fd_sc_hd__a21o_1
X_08410_ _02797_ _02799_ vssd1 vssd1 vccd1 vccd1 _02800_ sky130_fd_sc_hd__and2b_1
X_05622_ _04809_ _04810_ _04812_ vssd1 vssd1 vccd1 vccd1 _04892_ sky130_fd_sc_hd__o21a_1
X_09390_ _03868_ _03870_ vssd1 vssd1 vccd1 vccd1 _03871_ sky130_fd_sc_hd__and2_1
X_08341_ _02464_ _02468_ _02470_ _02472_ _02463_ vssd1 vssd1 vccd1 vccd1 _02725_ sky130_fd_sc_hd__a32o_1
XFILLER_0_80_65 vssd1 vssd1 vccd1 vccd1 sky130_ef_sc_hd__decap_12
XFILLER_0_80_54 vssd1 vssd1 vccd1 vccd1 sky130_fd_sc_hd__fill_1
XFILLER_0_74_623 vssd1 vssd1 vccd1 vccd1 sky130_fd_sc_hd__fill_2
XFILLER_0_73_111 vssd1 vssd1 vccd1 vccd1 sky130_fd_sc_hd__fill_1
XFILLER_0_58_163 vssd1 vssd1 vccd1 vccd1 sky130_fd_sc_hd__decap_8
X_05553_ _04821_ _04822_ vssd1 vssd1 vccd1 vccd1 _04823_ sky130_fd_sc_hd__nor2_1
X_08272_ _02648_ vssd1 vssd1 vccd1 vccd1 _02649_ sky130_fd_sc_hd__inv_2
X_05484_ net381 net522 vssd1 vssd1 vccd1 vccd1 _04754_ sky130_fd_sc_hd__and2_1
XFILLER_0_6_400 vssd1 vssd1 vccd1 vccd1 sky130_fd_sc_hd__fill_1
X_07223_ net304 net473 _01591_ _01592_ vssd1 vssd1 vccd1 vccd1 _01593_ sky130_fd_sc_hd__a22oi_1
XFILLER_0_13_92 vssd1 vssd1 vccd1 vccd1 sky130_fd_sc_hd__decap_4
XFILLER_0_27_572 vssd1 vssd1 vccd1 vccd1 sky130_ef_sc_hd__decap_12
XFILLER_0_6_477 vssd1 vssd1 vccd1 vccd1 sky130_fd_sc_hd__decap_8
X_07154_ net197 net591 _01522_ _01523_ vssd1 vssd1 vccd1 vccd1 _01524_ sky130_fd_sc_hd__a22o_1
XFILLER_0_73_3 vssd1 vssd1 vccd1 vccd1 sky130_fd_sc_hd__fill_2
X_07085_ net250 net690 net546 net240 vssd1 vssd1 vccd1 vccd1 _01456_ sky130_fd_sc_hd__a22o_1
X_06105_ _00182_ _00483_ vssd1 vssd1 vccd1 vccd1 _00484_ sky130_fd_sc_hd__nor2_1
XFILLER_0_42_586 vssd1 vssd1 vccd1 vccd1 sky130_fd_sc_hd__fill_2
X_06036_ _00397_ _00414_ vssd1 vssd1 vccd1 vccd1 _00415_ sky130_fd_sc_hd__or2_1
Xfanout135 _01881_ vssd1 vssd1 vccd1 vccd1 net135 sky130_fd_sc_hd__buf_2
Xfanout146 net148 vssd1 vssd1 vccd1 vccd1 net146 sky130_fd_sc_hd__buf_2
Xfanout124 _02232_ vssd1 vssd1 vccd1 vccd1 net124 sky130_fd_sc_hd__buf_4
Xfanout179 net180 vssd1 vssd1 vccd1 vccd1 net179 sky130_fd_sc_hd__buf_2
X_07987_ _02356_ _02358_ _02213_ _02215_ vssd1 vssd1 vccd1 vccd1 _02360_ sky130_fd_sc_hd__o211a_1
Xfanout168 net171 vssd1 vssd1 vccd1 vccd1 net168 sky130_fd_sc_hd__clkbuf_2
Xfanout157 net158 vssd1 vssd1 vccd1 vccd1 net157 sky130_fd_sc_hd__clkbuf_2
X_09726_ _04227_ _04236_ vssd1 vssd1 vccd1 vccd1 _04238_ sky130_fd_sc_hd__and2_1
X_06938_ _01308_ _01309_ vssd1 vssd1 vccd1 vccd1 _01310_ sky130_fd_sc_hd__and2b_1
X_09657_ _04155_ _04161_ vssd1 vssd1 vccd1 vccd1 _04163_ sky130_fd_sc_hd__or2_1
XTAP_1104 vssd1 vccd1 sky130_fd_sc_hd__tapvpwrvgnd_1
X_06869_ _01105_ _01110_ _01239_ vssd1 vssd1 vccd1 vccd1 _01241_ sky130_fd_sc_hd__or3_1
X_08608_ _03012_ _03013_ vssd1 vssd1 vccd1 vccd1 _03016_ sky130_fd_sc_hd__xnor2_1
XTAP_1137 vssd1 vccd1 sky130_fd_sc_hd__tapvpwrvgnd_1
XTAP_1126 vssd1 vccd1 sky130_fd_sc_hd__tapvpwrvgnd_1
XTAP_1115 vssd1 vccd1 sky130_fd_sc_hd__tapvpwrvgnd_1
X_09588_ _04085_ _04086_ vssd1 vssd1 vccd1 vccd1 _04087_ sky130_fd_sc_hd__or2_1
XTAP_1159 vssd1 vccd1 sky130_fd_sc_hd__tapvpwrvgnd_1
XTAP_1148 vssd1 vccd1 sky130_fd_sc_hd__tapvpwrvgnd_1
X_08539_ net179 net525 _02937_ _02939_ vssd1 vssd1 vccd1 vccd1 _02941_ sky130_fd_sc_hd__a22o_1
XFILLER_0_65_623 vssd1 vssd1 vccd1 vccd1 sky130_fd_sc_hd__fill_2
XFILLER_0_52_317 vssd1 vssd1 vccd1 vccd1 sky130_fd_sc_hd__fill_1
XFILLER_0_45_380 vssd1 vssd1 vccd1 vccd1 sky130_fd_sc_hd__fill_1
XFILLER_0_60_383 vssd1 vssd1 vccd1 vccd1 sky130_fd_sc_hd__decap_3
XFILLER_0_18_37 vssd1 vssd1 vccd1 vccd1 sky130_ef_sc_hd__decap_12
XFILLER_0_18_59 vssd1 vssd1 vccd1 vccd1 sky130_fd_sc_hd__decap_8
XFILLER_0_87_203 vssd1 vssd1 vccd1 vccd1 sky130_fd_sc_hd__decap_4
XFILLER_0_83_475 vssd1 vssd1 vccd1 vccd1 sky130_fd_sc_hd__decap_3
XFILLER_0_55_166 vssd1 vssd1 vccd1 vccd1 sky130_fd_sc_hd__fill_2
XFILLER_0_43_306 vssd1 vssd1 vccd1 vccd1 sky130_fd_sc_hd__decap_4
XFILLER_0_55_188 vssd1 vssd1 vccd1 vccd1 sky130_fd_sc_hd__decap_4
XFILLER_0_24_553 vssd1 vssd1 vccd1 vccd1 sky130_fd_sc_hd__decap_4
XFILLER_0_11_225 vssd1 vssd1 vccd1 vccd1 sky130_fd_sc_hd__decap_8
X_08890_ _03322_ _03324_ vssd1 vssd1 vccd1 vccd1 _03325_ sky130_fd_sc_hd__nand2b_1
XFILLER_0_75_21 vssd1 vssd1 vccd1 vccd1 sky130_ef_sc_hd__decap_12
X_07910_ _02275_ _02282_ vssd1 vssd1 vccd1 vccd1 _02284_ sky130_fd_sc_hd__nand2_1
X_07841_ _02212_ vssd1 vssd1 vccd1 vccd1 _02213_ sky130_fd_sc_hd__inv_2
X_07772_ net169 net593 _02140_ _02141_ vssd1 vssd1 vccd1 vccd1 _02143_ sky130_fd_sc_hd__and4_1
X_09511_ _04002_ _04003_ vssd1 vssd1 vccd1 vccd1 _04004_ sky130_fd_sc_hd__nand2b_1
X_06723_ _00966_ _01095_ _01096_ vssd1 vssd1 vccd1 vccd1 _01097_ sky130_fd_sc_hd__a21oi_1
XFILLER_0_78_236 vssd1 vssd1 vccd1 vccd1 sky130_fd_sc_hd__decap_3
XFILLER_0_91_53 vssd1 vssd1 vccd1 vccd1 sky130_fd_sc_hd__decap_3
X_09442_ net257 net267 net399 net405 vssd1 vssd1 vccd1 vccd1 _03928_ sky130_fd_sc_hd__nand4_1
XFILLER_0_78_247 vssd1 vssd1 vccd1 vccd1 sky130_fd_sc_hd__decap_4
X_06654_ _00890_ _00892_ _00891_ vssd1 vssd1 vccd1 vccd1 _01028_ sky130_fd_sc_hd__a21bo_1
X_09373_ _03559_ _03852_ _03851_ vssd1 vssd1 vccd1 vccd1 _03853_ sky130_fd_sc_hd__o21ba_1
XFILLER_0_91_97 vssd1 vssd1 vccd1 vccd1 sky130_fd_sc_hd__decap_4
XFILLER_0_59_461 vssd1 vssd1 vccd1 vccd1 sky130_fd_sc_hd__decap_3
X_05605_ _04859_ _04874_ vssd1 vssd1 vccd1 vccd1 _04875_ sky130_fd_sc_hd__or2_2
X_06585_ _00958_ _00959_ vssd1 vssd1 vccd1 vccd1 _00960_ sky130_fd_sc_hd__xnor2_1
XFILLER_0_46_100 vssd1 vssd1 vccd1 vccd1 sky130_fd_sc_hd__fill_1
XFILLER_0_47_623 vssd1 vssd1 vccd1 vccd1 sky130_fd_sc_hd__fill_2
X_08324_ _02703_ _02704_ _02666_ vssd1 vssd1 vccd1 vccd1 _02706_ sky130_fd_sc_hd__a21o_1
X_05536_ _04733_ _04736_ _04804_ _04805_ vssd1 vssd1 vccd1 vccd1 _04806_ sky130_fd_sc_hd__a211oi_1
XFILLER_0_19_325 vssd1 vssd1 vccd1 vccd1 sky130_fd_sc_hd__decap_3
XFILLER_0_46_155 vssd1 vssd1 vccd1 vccd1 sky130_fd_sc_hd__decap_4
X_08255_ _02625_ _02628_ _02629_ vssd1 vssd1 vccd1 vccd1 _02630_ sky130_fd_sc_hd__and3_1
X_05467_ _04718_ _04719_ _04735_ vssd1 vssd1 vccd1 vccd1 _04737_ sky130_fd_sc_hd__o21ai_1
XFILLER_0_34_328 vssd1 vssd1 vccd1 vccd1 sky130_fd_sc_hd__fill_1
X_08186_ _02346_ _02348_ vssd1 vssd1 vccd1 vccd1 _02558_ sky130_fd_sc_hd__or2_1
X_07206_ net314 net323 net457 net464 vssd1 vssd1 vccd1 vccd1 _01576_ sky130_fd_sc_hd__and4_1
X_05398_ _04660_ _04661_ _04666_ _04667_ vssd1 vssd1 vccd1 vccd1 _04668_ sky130_fd_sc_hd__o22a_1
X_07137_ net175 net619 vssd1 vssd1 vccd1 vccd1 _01507_ sky130_fd_sc_hd__nand2_1
XFILLER_0_30_556 vssd1 vssd1 vccd1 vccd1 sky130_fd_sc_hd__fill_2
X_07068_ net295 net498 _01313_ _01312_ vssd1 vssd1 vccd1 vccd1 _01439_ sky130_fd_sc_hd__a31o_1
XFILLER_0_30_578 vssd1 vssd1 vccd1 vccd1 sky130_fd_sc_hd__fill_2
XFILLER_0_30_589 vssd1 vssd1 vccd1 vccd1 sky130_fd_sc_hd__fill_2
X_06019_ net253 net263 net597 net608 vssd1 vssd1 vccd1 vccd1 _00398_ sky130_fd_sc_hd__and4_1
XFILLER_0_69_225 vssd1 vssd1 vccd1 vccd1 sky130_fd_sc_hd__decap_3
XFILLER_0_69_214 vssd1 vssd1 vccd1 vccd1 sky130_fd_sc_hd__decap_8
X_09709_ _04217_ _04218_ vssd1 vssd1 vccd1 vccd1 _04220_ sky130_fd_sc_hd__or2_1
XFILLER_0_69_269 vssd1 vssd1 vccd1 vccd1 sky130_fd_sc_hd__decap_4
XFILLER_0_84_228 vssd1 vssd1 vccd1 vccd1 sky130_fd_sc_hd__fill_2
XFILLER_0_37_111 vssd1 vssd1 vccd1 vccd1 sky130_fd_sc_hd__fill_1
XFILLER_0_21_578 vssd1 vssd1 vccd1 vccd1 sky130_fd_sc_hd__fill_1
XFILLER_0_21_589 vssd1 vssd1 vccd1 vccd1 sky130_fd_sc_hd__fill_2
XTAP_707 vssd1 vccd1 sky130_fd_sc_hd__tapvpwrvgnd_1
XTAP_718 vssd1 vccd1 sky130_fd_sc_hd__tapvpwrvgnd_1
XTAP_729 vssd1 vccd1 sky130_fd_sc_hd__tapvpwrvgnd_1
Xmax_cap2 _00466_ vssd1 vssd1 vccd1 vccd1 net712 sky130_fd_sc_hd__buf_1
XFILLER_0_0_15 vssd1 vssd1 vccd1 vccd1 sky130_ef_sc_hd__decap_12
XFILLER_0_88_589 vssd1 vssd1 vccd1 vccd1 sky130_fd_sc_hd__fill_2
XFILLER_0_29_623 vssd1 vssd1 vccd1 vccd1 sky130_fd_sc_hd__fill_2
X_06370_ _00626_ _00630_ _00745_ vssd1 vssd1 vccd1 vccd1 _00746_ sky130_fd_sc_hd__a21o_1
X_05321_ _03563_ _03585_ vssd1 vssd1 vccd1 vccd1 _04591_ sky130_fd_sc_hd__nand2_1
X_08040_ _02207_ _02209_ _02411_ _02412_ vssd1 vssd1 vccd1 vccd1 _02413_ sky130_fd_sc_hd__a211oi_2
XFILLER_0_9_57 vssd1 vssd1 vccd1 vccd1 sky130_ef_sc_hd__decap_12
X_05252_ _04274_ _04285_ _04296_ vssd1 vssd1 vccd1 vccd1 _04307_ sky130_fd_sc_hd__nand3_1
XFILLER_0_9_79 vssd1 vssd1 vccd1 vccd1 sky130_ef_sc_hd__decap_12
XFILLER_0_3_244 vssd1 vssd1 vccd1 vccd1 sky130_fd_sc_hd__decap_3
XFILLER_0_3_222 vssd1 vssd1 vccd1 vccd1 sky130_fd_sc_hd__fill_2
XFILLER_0_43_169 vssd1 vssd1 vccd1 vccd1 sky130_fd_sc_hd__fill_1
X_05183_ _03520_ _03531_ _03498_ vssd1 vssd1 vccd1 vccd1 _03553_ sky130_fd_sc_hd__a21bo_1
X_09991_ _04402_ _04422_ _04420_ vssd1 vssd1 vccd1 vccd1 _04528_ sky130_fd_sc_hd__a21oi_2
XFILLER_0_12_578 vssd1 vssd1 vccd1 vccd1 sky130_fd_sc_hd__decap_8
X_08942_ _03201_ _03223_ _03222_ vssd1 vssd1 vccd1 vccd1 _03382_ sky130_fd_sc_hd__a21oi_1
XFILLER_0_86_75 vssd1 vssd1 vccd1 vccd1 sky130_fd_sc_hd__decap_8
X_08873_ _03281_ _03282_ _03303_ _03304_ vssd1 vssd1 vccd1 vccd1 _03306_ sky130_fd_sc_hd__nand4_2
XFILLER_0_36_3 vssd1 vssd1 vccd1 vccd1 sky130_ef_sc_hd__decap_12
XFILLER_0_98_309 vssd1 vssd1 vccd1 vccd1 sky130_fd_sc_hd__fill_1
X_07824_ _02192_ _02193_ _02028_ _02030_ vssd1 vssd1 vccd1 vccd1 _02195_ sky130_fd_sc_hd__o211a_1
XFILLER_0_79_523 vssd1 vssd1 vccd1 vccd1 sky130_fd_sc_hd__decap_8
X_07755_ _02122_ _02125_ vssd1 vssd1 vccd1 vccd1 _02126_ sky130_fd_sc_hd__xor2_1
X_07686_ net264 net494 net502 net254 vssd1 vssd1 vccd1 vccd1 _02058_ sky130_fd_sc_hd__a22o_1
X_06706_ _01076_ _01078_ _00939_ _00941_ vssd1 vssd1 vccd1 vccd1 _01080_ sky130_fd_sc_hd__o211ai_4
X_09425_ _03898_ _03908_ vssd1 vssd1 vccd1 vccd1 _03909_ sky130_fd_sc_hd__xor2_1
X_06637_ _00888_ _01008_ _01010_ vssd1 vssd1 vccd1 vccd1 _01011_ sky130_fd_sc_hd__and3_1
XFILLER_0_59_291 vssd1 vssd1 vccd1 vccd1 sky130_fd_sc_hd__fill_2
X_09356_ _03666_ _03691_ net78 _03833_ vssd1 vssd1 vccd1 vccd1 _03834_ sky130_fd_sc_hd__a211oi_2
X_06568_ _00816_ _00818_ _00941_ _00942_ vssd1 vssd1 vccd1 vccd1 _00943_ sky130_fd_sc_hd__o211a_2
X_08307_ net308 net317 net420 net426 vssd1 vssd1 vccd1 vccd1 _02687_ sky130_fd_sc_hd__nand4_2
X_09287_ _03608_ _03610_ vssd1 vssd1 vccd1 vccd1 _03758_ sky130_fd_sc_hd__or2_1
X_05519_ net293 net614 _04786_ _04787_ vssd1 vssd1 vccd1 vccd1 _04789_ sky130_fd_sc_hd__a22o_1
X_06499_ _00746_ _00872_ vssd1 vssd1 vccd1 vccd1 _00874_ sky130_fd_sc_hd__xnor2_1
X_08238_ _02607_ _02609_ _02486_ _02489_ vssd1 vssd1 vccd1 vccd1 _02611_ sky130_fd_sc_hd__a211o_1
XFILLER_0_7_561 vssd1 vssd1 vccd1 vccd1 sky130_ef_sc_hd__decap_12
XFILLER_0_22_309 vssd1 vssd1 vccd1 vccd1 sky130_fd_sc_hd__fill_1
X_08169_ _02537_ _02538_ _02394_ _02416_ vssd1 vssd1 vccd1 vccd1 _02541_ sky130_fd_sc_hd__o211a_1
XFILLER_0_42_180 vssd1 vssd1 vccd1 vccd1 sky130_fd_sc_hd__decap_6
X_10131_ clknet_3_5_0_wb_clk_i _00125_ _00061_ vssd1 vssd1 vccd1 vccd1 mul.a\[26\]
+ sky130_fd_sc_hd__dfrtp_4
X_10062_ net644 vssd1 vssd1 vccd1 vccd1 _00058_ sky130_fd_sc_hd__inv_2
XFILLER_0_80_253 vssd1 vssd1 vccd1 vccd1 sky130_fd_sc_hd__fill_2
XFILLER_0_80_286 vssd1 vssd1 vccd1 vccd1 sky130_fd_sc_hd__decap_3
XFILLER_0_80_275 vssd1 vssd1 vccd1 vccd1 sky130_fd_sc_hd__fill_1
XFILLER_0_25_169 vssd1 vssd1 vccd1 vccd1 sky130_fd_sc_hd__decap_4
XFILLER_0_0_203 vssd1 vssd1 vccd1 vccd1 sky130_fd_sc_hd__decap_8
XFILLER_0_0_214 vssd1 vssd1 vccd1 vccd1 sky130_fd_sc_hd__decap_8
XFILLER_0_0_225 vssd1 vssd1 vccd1 vccd1 sky130_fd_sc_hd__fill_1
XFILLER_0_0_236 vssd1 vssd1 vccd1 vccd1 sky130_fd_sc_hd__decap_8
XFILLER_0_21_375 vssd1 vssd1 vccd1 vccd1 sky130_fd_sc_hd__fill_1
XTAP_504 vssd1 vccd1 sky130_fd_sc_hd__tapvpwrvgnd_1
XTAP_515 vssd1 vccd1 sky130_fd_sc_hd__tapvpwrvgnd_1
XTAP_526 vssd1 vccd1 sky130_fd_sc_hd__tapvpwrvgnd_1
XTAP_537 vssd1 vccd1 sky130_fd_sc_hd__tapvpwrvgnd_1
XTAP_548 vssd1 vccd1 sky130_fd_sc_hd__tapvpwrvgnd_1
XTAP_559 vssd1 vccd1 sky130_fd_sc_hd__tapvpwrvgnd_1
XFILLER_0_56_67 vssd1 vssd1 vccd1 vccd1 sky130_fd_sc_hd__decap_8
X_05870_ _00247_ _00248_ _00249_ vssd1 vssd1 vccd1 vccd1 _00251_ sky130_fd_sc_hd__a21o_1
X_07540_ _01750_ net670 _01911_ _01912_ vssd1 vssd1 vccd1 vccd1 _01913_ sky130_fd_sc_hd__o211ai_2
XFILLER_0_76_515 vssd1 vssd1 vccd1 vccd1 sky130_fd_sc_hd__decap_3
XFILLER_0_76_559 vssd1 vssd1 vccd1 vccd1 sky130_ef_sc_hd__decap_12
XFILLER_0_76_537 vssd1 vssd1 vccd1 vccd1 sky130_fd_sc_hd__fill_1
X_07471_ net383 net402 net409 net376 vssd1 vssd1 vccd1 vccd1 _01841_ sky130_fd_sc_hd__a22o_1
XFILLER_0_29_420 vssd1 vssd1 vccd1 vccd1 sky130_fd_sc_hd__fill_1
X_09210_ _03669_ _03674_ vssd1 vssd1 vccd1 vccd1 _03675_ sky130_fd_sc_hd__xnor2_1
XFILLER_0_63_209 vssd1 vssd1 vccd1 vccd1 sky130_fd_sc_hd__fill_1
X_06422_ net292 net532 net542 net287 vssd1 vssd1 vccd1 vccd1 _00798_ sky130_fd_sc_hd__a22o_1
X_09141_ _03416_ net106 _03597_ _03598_ vssd1 vssd1 vccd1 vccd1 _03599_ sky130_fd_sc_hd__o211ai_4
X_06353_ _00725_ _00728_ vssd1 vssd1 vccd1 vccd1 _00729_ sky130_fd_sc_hd__and2b_1
XFILLER_0_44_412 vssd1 vssd1 vccd1 vccd1 sky130_fd_sc_hd__fill_1
X_09072_ _03366_ _03368_ _03365_ vssd1 vssd1 vccd1 vccd1 _03524_ sky130_fd_sc_hd__o21ai_1
XFILLER_0_71_220 vssd1 vssd1 vccd1 vccd1 sky130_fd_sc_hd__decap_4
X_05304_ _03880_ _04560_ _04572_ vssd1 vssd1 vccd1 vccd1 _04574_ sky130_fd_sc_hd__a21o_1
XFILLER_0_71_275 vssd1 vssd1 vccd1 vccd1 sky130_fd_sc_hd__fill_1
X_08023_ _02238_ _02245_ _02244_ vssd1 vssd1 vccd1 vccd1 _02396_ sky130_fd_sc_hd__a21o_1
XFILLER_0_4_531 vssd1 vssd1 vccd1 vccd1 sky130_fd_sc_hd__fill_1
X_06284_ net343 net352 net478 net487 vssd1 vssd1 vccd1 vccd1 _00661_ sky130_fd_sc_hd__nand4_1
X_05235_ _03684_ _04110_ vssd1 vssd1 vccd1 vccd1 _04121_ sky130_fd_sc_hd__nor2_1
X_05166_ _03323_ _03356_ vssd1 vssd1 vccd1 vccd1 _03367_ sky130_fd_sc_hd__or2_1
X_09974_ net146 net490 vssd1 vssd1 vccd1 vccd1 _04509_ sky130_fd_sc_hd__nand2_1
X_05097_ net301 net310 net622 net630 vssd1 vssd1 vccd1 vccd1 _02612_ sky130_fd_sc_hd__and4_1
X_08925_ _03358_ _03361_ vssd1 vssd1 vccd1 vccd1 _03363_ sky130_fd_sc_hd__xor2_2
X_08856_ _03285_ _03286_ vssd1 vssd1 vccd1 vccd1 _03287_ sky130_fd_sc_hd__nand2_1
X_07807_ net332 net340 net421 net426 vssd1 vssd1 vccd1 vccd1 _02178_ sky130_fd_sc_hd__nand4_2
X_08787_ _03205_ _03211_ vssd1 vssd1 vccd1 vccd1 _03212_ sky130_fd_sc_hd__xnor2_1
X_05999_ _00183_ _00280_ _00378_ vssd1 vssd1 vccd1 vccd1 _00379_ sky130_fd_sc_hd__o21a_1
XFILLER_0_94_301 vssd1 vssd1 vccd1 vccd1 sky130_fd_sc_hd__decap_6
X_07738_ _01948_ _01952_ _02109_ vssd1 vssd1 vccd1 vccd1 _02110_ sky130_fd_sc_hd__a21oi_1
XFILLER_0_79_397 vssd1 vssd1 vccd1 vccd1 sky130_fd_sc_hd__fill_1
XFILLER_0_67_537 vssd1 vssd1 vccd1 vccd1 sky130_fd_sc_hd__decap_6
X_07669_ _02037_ _02040_ vssd1 vssd1 vccd1 vccd1 _02041_ sky130_fd_sc_hd__xor2_1
XFILLER_0_82_518 vssd1 vssd1 vccd1 vccd1 sky130_fd_sc_hd__fill_1
X_09408_ _03887_ _03888_ vssd1 vssd1 vccd1 vccd1 _03890_ sky130_fd_sc_hd__nand2_1
XFILLER_0_54_209 vssd1 vssd1 vccd1 vccd1 sky130_fd_sc_hd__fill_1
XFILLER_0_47_250 vssd1 vssd1 vccd1 vccd1 sky130_fd_sc_hd__decap_4
X_09339_ net123 _03813_ vssd1 vssd1 vccd1 vccd1 _03816_ sky130_fd_sc_hd__xnor2_1
XFILLER_0_35_401 vssd1 vssd1 vccd1 vccd1 sky130_fd_sc_hd__decap_6
XFILLER_0_62_253 vssd1 vssd1 vccd1 vccd1 sky130_fd_sc_hd__fill_1
XFILLER_0_7_391 vssd1 vssd1 vccd1 vccd1 sky130_fd_sc_hd__fill_1
XFILLER_0_22_106 vssd1 vssd1 vccd1 vccd1 sky130_fd_sc_hd__decap_4
XFILLER_0_22_117 vssd1 vssd1 vccd1 vccd1 sky130_ef_sc_hd__decap_12
X_10114_ clknet_3_0_0_wb_clk_i _00108_ _00044_ vssd1 vssd1 vccd1 vccd1 mul.a\[9\]
+ sky130_fd_sc_hd__dfrtp_1
XFILLER_0_26_15 vssd1 vssd1 vccd1 vccd1 sky130_fd_sc_hd__decap_8
X_10045_ net639 vssd1 vssd1 vccd1 vccd1 _00041_ sky130_fd_sc_hd__inv_2
XFILLER_0_85_389 vssd1 vssd1 vccd1 vccd1 sky130_fd_sc_hd__decap_3
XFILLER_0_5_317 vssd1 vssd1 vccd1 vccd1 sky130_fd_sc_hd__fill_2
XANTENNA_2 mul.a\[25\] vssd1 vssd1 vccd1 vccd1 sky130_fd_sc_hd__diode_2
XFILLER_0_13_117 vssd1 vssd1 vccd1 vccd1 sky130_fd_sc_hd__fill_1
X_05020_ net267 vssd1 vssd1 vccd1 vccd1 _01838_ sky130_fd_sc_hd__inv_2
XFILLER_0_67_22 vssd1 vssd1 vccd1 vccd1 sky130_fd_sc_hd__decap_3
Xfanout509 net510 vssd1 vssd1 vccd1 vccd1 net509 sky130_fd_sc_hd__buf_6
XTAP_323 vssd1 vccd1 sky130_fd_sc_hd__tapvpwrvgnd_1
XTAP_312 vssd1 vccd1 sky130_fd_sc_hd__tapvpwrvgnd_1
XTAP_301 vssd1 vccd1 sky130_fd_sc_hd__tapvpwrvgnd_1
XFILLER_0_67_77 vssd1 vssd1 vccd1 vccd1 sky130_fd_sc_hd__decap_4
XTAP_345 vssd1 vccd1 sky130_fd_sc_hd__tapvpwrvgnd_1
XTAP_334 vssd1 vccd1 sky130_fd_sc_hd__tapvpwrvgnd_1
XTAP_356 vssd1 vccd1 sky130_fd_sc_hd__tapvpwrvgnd_1
XTAP_367 vssd1 vccd1 sky130_fd_sc_hd__tapvpwrvgnd_1
X_06971_ _01264_ _01341_ _01342_ vssd1 vssd1 vccd1 vccd1 _01343_ sky130_fd_sc_hd__nor3_1
X_08710_ _03111_ _03112_ _03124_ vssd1 vssd1 vccd1 vccd1 _03128_ sky130_fd_sc_hd__o21ai_2
X_05922_ net273 net598 net607 net263 vssd1 vssd1 vccd1 vccd1 _00302_ sky130_fd_sc_hd__a22o_1
XTAP_378 vssd1 vccd1 sky130_fd_sc_hd__tapvpwrvgnd_1
XTAP_389 vssd1 vccd1 sky130_fd_sc_hd__tapvpwrvgnd_1
X_09690_ net209 net428 _04194_ _04196_ vssd1 vssd1 vccd1 vccd1 _04199_ sky130_fd_sc_hd__and4_1
X_08641_ net147 net558 net579 vssd1 vssd1 vccd1 vccd1 _03053_ sky130_fd_sc_hd__and3_1
X_05853_ net371 net496 vssd1 vssd1 vccd1 vccd1 _00234_ sky130_fd_sc_hd__nand2_1
XFILLER_0_83_76 vssd1 vssd1 vccd1 vccd1 sky130_ef_sc_hd__decap_12
Xrebuffer25 _01753_ vssd1 vssd1 vccd1 vccd1 net670 sky130_fd_sc_hd__clkbuf_1
Xrebuffer36 _01752_ vssd1 vssd1 vccd1 vccd1 net681 sky130_fd_sc_hd__clkbuf_1
Xrebuffer14 _01937_ vssd1 vssd1 vccd1 vccd1 net659 sky130_fd_sc_hd__buf_1
X_08572_ net260 net270 net437 net443 vssd1 vssd1 vccd1 vccd1 _02977_ sky130_fd_sc_hd__nand4_1
Xrebuffer69 _02101_ vssd1 vssd1 vccd1 vccd1 net725 sky130_fd_sc_hd__buf_4
XPHY_18 vssd1 vssd1 vccd1 vccd1 sky130_fd_sc_hd__decap_3
X_05784_ _05015_ _00164_ vssd1 vssd1 vccd1 vccd1 _00166_ sky130_fd_sc_hd__xnor2_1
Xrebuffer58 _00365_ vssd1 vssd1 vccd1 vccd1 net703 sky130_fd_sc_hd__buf_6
XPHY_29 vssd1 vssd1 vccd1 vccd1 sky130_fd_sc_hd__decap_3
Xrebuffer47 _01081_ vssd1 vssd1 vccd1 vccd1 net692 sky130_fd_sc_hd__clkbuf_1
XFILLER_0_76_312 vssd1 vssd1 vccd1 vccd1 sky130_fd_sc_hd__fill_1
X_07523_ net286 net473 _01893_ _01894_ vssd1 vssd1 vccd1 vccd1 _01896_ sky130_fd_sc_hd__nand4_2
XFILLER_0_9_623 vssd1 vssd1 vccd1 vccd1 sky130_fd_sc_hd__fill_2
X_07454_ _01695_ _01821_ vssd1 vssd1 vccd1 vccd1 _01822_ sky130_fd_sc_hd__nand2b_1
XFILLER_0_91_337 vssd1 vssd1 vccd1 vccd1 sky130_fd_sc_hd__fill_2
XFILLER_0_8_122 vssd1 vssd1 vccd1 vccd1 sky130_fd_sc_hd__decap_6
XFILLER_0_17_412 vssd1 vssd1 vccd1 vccd1 sky130_fd_sc_hd__decap_8
X_06405_ _00669_ _00670_ _00671_ vssd1 vssd1 vccd1 vccd1 _00781_ sky130_fd_sc_hd__o21ba_1
X_07385_ net240 net527 _01751_ net681 vssd1 vssd1 vccd1 vccd1 _01754_ sky130_fd_sc_hd__nand4_1
X_09124_ _03406_ _03412_ _03405_ vssd1 vssd1 vccd1 vccd1 _03580_ sky130_fd_sc_hd__a21bo_1
X_06336_ _00710_ _00711_ _00590_ net75 vssd1 vssd1 vccd1 vccd1 _00713_ sky130_fd_sc_hd__a211o_1
XFILLER_0_44_242 vssd1 vssd1 vccd1 vccd1 sky130_fd_sc_hd__fill_2
X_09055_ _03343_ _03346_ vssd1 vssd1 vccd1 vccd1 _03505_ sky130_fd_sc_hd__nor2_1
XFILLER_0_72_595 vssd1 vssd1 vccd1 vccd1 sky130_fd_sc_hd__fill_2
X_06267_ net272 net280 net563 net571 vssd1 vssd1 vccd1 vccd1 _00644_ sky130_fd_sc_hd__and4_1
X_08006_ _02376_ _02377_ _02378_ vssd1 vssd1 vccd1 vccd1 _02379_ sky130_fd_sc_hd__and3_2
XFILLER_0_4_372 vssd1 vssd1 vccd1 vccd1 sky130_ef_sc_hd__decap_12
X_05218_ _03902_ _03913_ _03749_ vssd1 vssd1 vccd1 vccd1 _03935_ sky130_fd_sc_hd__a21o_1
X_06198_ _00456_ _00458_ net666 _00575_ vssd1 vssd1 vccd1 vccd1 _00576_ sky130_fd_sc_hd__a211oi_4
X_05149_ net361 net369 net575 net585 vssd1 vssd1 vccd1 vccd1 _03181_ sky130_fd_sc_hd__and4_1
X_09957_ _04466_ _04489_ vssd1 vssd1 vccd1 vccd1 _04490_ sky130_fd_sc_hd__xnor2_1
X_08908_ _03341_ _03342_ _03147_ _03150_ vssd1 vssd1 vccd1 vccd1 _03344_ sky130_fd_sc_hd__a211oi_2
XFILLER_0_99_437 vssd1 vssd1 vccd1 vccd1 sky130_fd_sc_hd__decap_8
XFILLER_0_99_415 vssd1 vssd1 vccd1 vccd1 sky130_fd_sc_hd__decap_8
X_09888_ _04413_ _04414_ vssd1 vssd1 vccd1 vccd1 _04415_ sky130_fd_sc_hd__nor2_1
XTAP_890 vssd1 vccd1 sky130_fd_sc_hd__tapvpwrvgnd_1
X_08839_ net193 net201 net484 net493 vssd1 vssd1 vccd1 vccd1 _03269_ sky130_fd_sc_hd__nand4_1
XFILLER_0_94_153 vssd1 vssd1 vccd1 vccd1 sky130_ef_sc_hd__decap_12
XFILLER_0_63_551 vssd1 vssd1 vccd1 vccd1 sky130_fd_sc_hd__decap_8
XFILLER_0_2_309 vssd1 vssd1 vccd1 vccd1 sky130_fd_sc_hd__decap_4
XFILLER_0_31_470 vssd1 vssd1 vccd1 vccd1 sky130_fd_sc_hd__decap_6
Xoutput61 net61 vssd1 vssd1 vccd1 vccd1 wbs_dat_o[29] sky130_fd_sc_hd__clkbuf_4
Xoutput50 net50 vssd1 vssd1 vccd1 vccd1 wbs_dat_o[19] sky130_fd_sc_hd__buf_4
X_10028_ net642 vssd1 vssd1 vccd1 vccd1 _00024_ sky130_fd_sc_hd__inv_2
XFILLER_0_58_334 vssd1 vssd1 vccd1 vccd1 sky130_fd_sc_hd__decap_3
XFILLER_0_53_68 vssd1 vssd1 vccd1 vccd1 sky130_ef_sc_hd__decap_12
XFILLER_0_53_57 vssd1 vssd1 vccd1 vccd1 sky130_fd_sc_hd__decap_8
XFILLER_0_85_164 vssd1 vssd1 vccd1 vccd1 sky130_fd_sc_hd__decap_4
XFILLER_0_54_551 vssd1 vssd1 vccd1 vccd1 sky130_ef_sc_hd__decap_12
XFILLER_0_26_253 vssd1 vssd1 vccd1 vccd1 sky130_fd_sc_hd__decap_4
X_07170_ _01539_ _01502_ vssd1 vssd1 vccd1 vccd1 _01540_ sky130_fd_sc_hd__nand2b_1
XFILLER_0_5_169 vssd1 vssd1 vccd1 vccd1 sky130_fd_sc_hd__decap_3
X_06121_ _00497_ _00498_ vssd1 vssd1 vccd1 vccd1 _00499_ sky130_fd_sc_hd__nand2_1
XFILLER_0_41_223 vssd1 vssd1 vccd1 vccd1 sky130_fd_sc_hd__fill_1
X_06052_ _00427_ _00430_ vssd1 vssd1 vccd1 vccd1 _00431_ sky130_fd_sc_hd__xnor2_2
XFILLER_0_41_256 vssd1 vssd1 vccd1 vccd1 sky130_fd_sc_hd__decap_8
XFILLER_0_78_76 vssd1 vssd1 vccd1 vccd1 sky130_fd_sc_hd__fill_1
XFILLER_0_94_20 vssd1 vssd1 vccd1 vccd1 sky130_fd_sc_hd__decap_8
Xfanout317 net318 vssd1 vssd1 vccd1 vccd1 net317 sky130_fd_sc_hd__clkbuf_2
Xfanout328 net329 vssd1 vssd1 vccd1 vccd1 net328 sky130_fd_sc_hd__buf_2
Xfanout339 mul.a\[6\] vssd1 vssd1 vccd1 vccd1 net339 sky130_fd_sc_hd__buf_4
Xfanout306 net309 vssd1 vssd1 vccd1 vccd1 net306 sky130_fd_sc_hd__buf_2
X_09811_ _04173_ _04189_ _04330_ vssd1 vssd1 vccd1 vccd1 _04331_ sky130_fd_sc_hd__o21a_1
XFILLER_0_94_53 vssd1 vssd1 vccd1 vccd1 sky130_ef_sc_hd__decap_12
X_09742_ _04239_ _04254_ _04255_ vssd1 vssd1 vccd1 vccd1 _04256_ sky130_fd_sc_hd__or3_1
X_06954_ _01323_ _01324_ _01316_ vssd1 vssd1 vccd1 vccd1 _01326_ sky130_fd_sc_hd__a21o_1
X_05905_ net289 net312 net554 net581 vssd1 vssd1 vccd1 vccd1 _00285_ sky130_fd_sc_hd__nand4_2
X_06885_ _01255_ _01256_ vssd1 vssd1 vccd1 vccd1 _01257_ sky130_fd_sc_hd__nand2_1
X_09673_ net166 net468 _04178_ _04179_ vssd1 vssd1 vccd1 vccd1 _04180_ sky130_fd_sc_hd__a22o_1
XFILLER_0_96_418 vssd1 vssd1 vccd1 vccd1 sky130_fd_sc_hd__fill_2
X_08624_ _03031_ _03032_ _03018_ vssd1 vssd1 vccd1 vccd1 _03034_ sky130_fd_sc_hd__a21o_1
X_05836_ _04999_ _05004_ _00215_ vssd1 vssd1 vccd1 vccd1 _00217_ sky130_fd_sc_hd__or3_1
XTAP_1308 vssd1 vccd1 sky130_fd_sc_hd__tapvpwrvgnd_1
XTAP_1319 vssd1 vccd1 sky130_fd_sc_hd__tapvpwrvgnd_1
X_08555_ net214 net500 _02780_ _02781_ net518 vssd1 vssd1 vccd1 vccd1 _02958_ sky130_fd_sc_hd__a32o_1
X_05767_ _00146_ _00147_ _00139_ vssd1 vssd1 vccd1 vccd1 _00149_ sky130_fd_sc_hd__a21o_1
XFILLER_0_49_334 vssd1 vssd1 vccd1 vccd1 sky130_fd_sc_hd__fill_2
X_07506_ net300 net307 net459 net466 vssd1 vssd1 vccd1 vccd1 _01878_ sky130_fd_sc_hd__nand4_1
X_08486_ net169 net557 net584 net155 vssd1 vssd1 vccd1 vccd1 _02883_ sky130_fd_sc_hd__a22o_1
XFILLER_0_76_153 vssd1 vssd1 vccd1 vccd1 sky130_fd_sc_hd__decap_8
X_05698_ _04882_ _04883_ net77 vssd1 vssd1 vccd1 vccd1 _04968_ sky130_fd_sc_hd__a21o_1
XFILLER_0_76_197 vssd1 vssd1 vccd1 vccd1 sky130_ef_sc_hd__decap_12
X_07437_ _01801_ _01802_ _01803_ vssd1 vssd1 vccd1 vccd1 _01805_ sky130_fd_sc_hd__nand3_1
XFILLER_0_91_156 vssd1 vssd1 vccd1 vccd1 sky130_ef_sc_hd__decap_12
X_07368_ net285 net482 net491 net277 vssd1 vssd1 vccd1 vccd1 _01737_ sky130_fd_sc_hd__a22o_1
X_09107_ _03552_ _03559_ _03561_ vssd1 vssd1 vccd1 vccd1 _03562_ sky130_fd_sc_hd__a21oi_1
X_06319_ _00692_ _00694_ net709 _00574_ vssd1 vssd1 vccd1 vccd1 _00696_ sky130_fd_sc_hd__o211ai_2
XFILLER_0_32_201 vssd1 vssd1 vccd1 vccd1 sky130_fd_sc_hd__fill_1
XFILLER_0_60_565 vssd1 vssd1 vccd1 vccd1 sky130_fd_sc_hd__fill_2
X_07299_ _01513_ _01666_ vssd1 vssd1 vccd1 vccd1 _01668_ sky130_fd_sc_hd__xnor2_1
X_09038_ _03478_ _03485_ vssd1 vssd1 vccd1 vccd1 _03486_ sky130_fd_sc_hd__nand2_1
XFILLER_0_20_418 vssd1 vssd1 vccd1 vccd1 sky130_fd_sc_hd__fill_2
XFILLER_0_99_212 vssd1 vssd1 vccd1 vccd1 sky130_fd_sc_hd__decap_4
XFILLER_0_99_245 vssd1 vssd1 vccd1 vccd1 sky130_fd_sc_hd__fill_1
XFILLER_0_95_473 vssd1 vssd1 vccd1 vccd1 sky130_ef_sc_hd__decap_12
XFILLER_0_55_326 vssd1 vssd1 vccd1 vccd1 sky130_fd_sc_hd__decap_8
XFILLER_0_67_197 vssd1 vssd1 vccd1 vccd1 sky130_fd_sc_hd__fill_2
XFILLER_0_55_359 vssd1 vssd1 vccd1 vccd1 sky130_fd_sc_hd__decap_8
XFILLER_0_55_337 vssd1 vssd1 vccd1 vccd1 sky130_fd_sc_hd__fill_1
XFILLER_0_82_167 vssd1 vssd1 vccd1 vccd1 sky130_fd_sc_hd__fill_1
Xrebuffer5 net649 vssd1 vssd1 vccd1 vccd1 net650 sky130_fd_sc_hd__clkbuf_1
XFILLER_0_48_46 vssd1 vssd1 vccd1 vccd1 sky130_ef_sc_hd__decap_12
XFILLER_0_3_15 vssd1 vssd1 vccd1 vccd1 sky130_fd_sc_hd__fill_1
XFILLER_0_78_418 vssd1 vssd1 vccd1 vccd1 sky130_fd_sc_hd__fill_2
X_06670_ _01039_ _01042_ _01043_ vssd1 vssd1 vccd1 vccd1 _01044_ sky130_fd_sc_hd__and3_1
X_05621_ _04817_ _04889_ vssd1 vssd1 vccd1 vccd1 _04891_ sky130_fd_sc_hd__xnor2_1
X_08340_ _02119_ _02723_ vssd1 vssd1 vccd1 vccd1 _02724_ sky130_fd_sc_hd__xnor2_2
X_05552_ net381 net390 net504 net513 vssd1 vssd1 vccd1 vccd1 _04822_ sky130_fd_sc_hd__and4_1
X_08271_ net254 net264 net457 net464 vssd1 vssd1 vccd1 vccd1 _02648_ sky130_fd_sc_hd__nand4_2
XFILLER_0_80_77 vssd1 vssd1 vccd1 vccd1 sky130_fd_sc_hd__fill_2
XFILLER_0_58_197 vssd1 vssd1 vccd1 vccd1 sky130_fd_sc_hd__decap_3
XFILLER_0_58_186 vssd1 vssd1 vccd1 vccd1 sky130_fd_sc_hd__decap_4
X_05483_ net387 net513 vssd1 vssd1 vccd1 vccd1 _04753_ sky130_fd_sc_hd__nand2_1
X_07222_ net285 net295 net481 net490 vssd1 vssd1 vccd1 vccd1 _01592_ sky130_fd_sc_hd__nand4_1
XFILLER_0_27_584 vssd1 vssd1 vccd1 vccd1 sky130_fd_sc_hd__decap_8
X_07153_ net202 net226 net556 net578 vssd1 vssd1 vccd1 vccd1 _01523_ sky130_fd_sc_hd__nand4_2
XFILLER_0_54_392 vssd1 vssd1 vccd1 vccd1 sky130_fd_sc_hd__fill_1
X_06104_ _00481_ _00482_ vssd1 vssd1 vccd1 vccd1 _00483_ sky130_fd_sc_hd__xnor2_1
X_07084_ net240 net250 net697 net545 vssd1 vssd1 vccd1 vccd1 _01455_ sky130_fd_sc_hd__nand4_2
XFILLER_0_66_3 vssd1 vssd1 vccd1 vccd1 sky130_fd_sc_hd__fill_2
XFILLER_0_1_161 vssd1 vssd1 vccd1 vccd1 sky130_fd_sc_hd__fill_1
X_06035_ _00310_ _00413_ vssd1 vssd1 vccd1 vccd1 _00414_ sky130_fd_sc_hd__xnor2_1
Xfanout147 net148 vssd1 vssd1 vccd1 vccd1 net147 sky130_fd_sc_hd__clkbuf_8
Xfanout136 net137 vssd1 vssd1 vccd1 vccd1 net136 sky130_fd_sc_hd__buf_2
Xfanout125 _02232_ vssd1 vssd1 vccd1 vccd1 net125 sky130_fd_sc_hd__clkbuf_2
Xfanout158 mul.a\[29\] vssd1 vssd1 vccd1 vccd1 net158 sky130_fd_sc_hd__buf_2
Xfanout169 net171 vssd1 vssd1 vccd1 vccd1 net169 sky130_fd_sc_hd__clkbuf_4
X_07986_ _02213_ _02215_ _02356_ _02358_ vssd1 vssd1 vccd1 vccd1 _02359_ sky130_fd_sc_hd__a211oi_2
X_09725_ _04227_ _04236_ vssd1 vssd1 vccd1 vccd1 _04237_ sky130_fd_sc_hd__nor2_1
X_06937_ _01306_ _01307_ _01303_ vssd1 vssd1 vccd1 vccd1 _01309_ sky130_fd_sc_hd__a21o_1
X_09656_ _04155_ _04161_ vssd1 vssd1 vccd1 vccd1 _04162_ sky130_fd_sc_hd__nand2_1
X_08607_ _03012_ _03013_ vssd1 vssd1 vccd1 vccd1 _03015_ sky130_fd_sc_hd__or2_1
XTAP_1105 vssd1 vccd1 sky130_fd_sc_hd__tapvpwrvgnd_1
XFILLER_0_69_429 vssd1 vssd1 vccd1 vccd1 sky130_fd_sc_hd__decap_3
X_06868_ _01105_ _01110_ _01239_ vssd1 vssd1 vccd1 vccd1 _01240_ sky130_fd_sc_hd__o21ai_2
XTAP_1138 vssd1 vccd1 sky130_fd_sc_hd__tapvpwrvgnd_1
XTAP_1127 vssd1 vccd1 sky130_fd_sc_hd__tapvpwrvgnd_1
XTAP_1116 vssd1 vccd1 sky130_fd_sc_hd__tapvpwrvgnd_1
X_09587_ _04074_ _04084_ vssd1 vssd1 vccd1 vccd1 _04086_ sky130_fd_sc_hd__and2_1
X_05819_ _04987_ _00198_ vssd1 vssd1 vccd1 vccd1 _00200_ sky130_fd_sc_hd__nand2_1
X_06799_ net330 net468 _01170_ _01171_ vssd1 vssd1 vccd1 vccd1 _01172_ sky130_fd_sc_hd__nand4_1
XFILLER_0_92_410 vssd1 vssd1 vccd1 vccd1 sky130_fd_sc_hd__decap_4
XTAP_1149 vssd1 vccd1 sky130_fd_sc_hd__tapvpwrvgnd_1
X_08538_ net168 net173 net534 net547 vssd1 vssd1 vccd1 vccd1 _02939_ sky130_fd_sc_hd__nand4_2
XFILLER_0_37_315 vssd1 vssd1 vccd1 vccd1 sky130_ef_sc_hd__decap_12
XFILLER_0_92_421 vssd1 vssd1 vccd1 vccd1 sky130_ef_sc_hd__decap_12
X_08469_ _02849_ _02862_ _02863_ vssd1 vssd1 vccd1 vccd1 _02865_ sky130_fd_sc_hd__nand3_4
XFILLER_0_64_112 vssd1 vssd1 vccd1 vccd1 sky130_fd_sc_hd__fill_2
XFILLER_0_18_595 vssd1 vssd1 vccd1 vccd1 sky130_fd_sc_hd__fill_1
XFILLER_0_33_532 vssd1 vssd1 vccd1 vccd1 sky130_ef_sc_hd__decap_12
XFILLER_0_20_248 vssd1 vssd1 vccd1 vccd1 sky130_fd_sc_hd__decap_4
XFILLER_0_20_259 vssd1 vssd1 vccd1 vccd1 sky130_fd_sc_hd__decap_8
XFILLER_0_18_27 vssd1 vssd1 vccd1 vccd1 sky130_fd_sc_hd__fill_1
XFILLER_0_18_49 vssd1 vssd1 vccd1 vccd1 sky130_fd_sc_hd__decap_4
XFILLER_0_34_15 vssd1 vssd1 vccd1 vccd1 sky130_ef_sc_hd__decap_12
XFILLER_0_56_624 vssd1 vssd1 vccd1 vccd1 sky130_fd_sc_hd__fill_1
XFILLER_0_95_281 vssd1 vssd1 vccd1 vccd1 sky130_fd_sc_hd__decap_4
XFILLER_0_50_47 vssd1 vssd1 vccd1 vccd1 sky130_fd_sc_hd__fill_1
XFILLER_0_70_126 vssd1 vssd1 vccd1 vccd1 sky130_fd_sc_hd__fill_1
XFILLER_0_36_381 vssd1 vssd1 vccd1 vccd1 sky130_fd_sc_hd__fill_1
XFILLER_0_51_384 vssd1 vssd1 vccd1 vccd1 sky130_fd_sc_hd__decap_8
XFILLER_0_75_55 vssd1 vssd1 vccd1 vccd1 sky130_fd_sc_hd__fill_1
XFILLER_0_75_33 vssd1 vssd1 vccd1 vccd1 sky130_fd_sc_hd__fill_2
X_07840_ _02196_ _02209_ _02211_ vssd1 vssd1 vccd1 vccd1 _02212_ sky130_fd_sc_hd__and3_1
XFILLER_0_45_8 vssd1 vssd1 vccd1 vccd1 sky130_fd_sc_hd__decap_8
X_07771_ net169 net593 _02140_ _02141_ vssd1 vssd1 vccd1 vccd1 _02142_ sky130_fd_sc_hd__a22oi_1
X_09510_ _03842_ _03844_ vssd1 vssd1 vccd1 vccd1 _04003_ sky130_fd_sc_hd__nand2_1
X_06722_ _00966_ _01095_ net139 vssd1 vssd1 vccd1 vccd1 _01096_ sky130_fd_sc_hd__o21ai_1
XFILLER_0_91_76 vssd1 vssd1 vccd1 vccd1 sky130_fd_sc_hd__fill_2
X_09441_ net257 net267 net399 net405 vssd1 vssd1 vccd1 vccd1 _03927_ sky130_fd_sc_hd__and4_1
X_06653_ net365 net448 _01024_ _01025_ vssd1 vssd1 vccd1 vccd1 _01027_ sky130_fd_sc_hd__a22o_1
X_09372_ _03552_ _03704_ _03705_ vssd1 vssd1 vccd1 vccd1 _03852_ sky130_fd_sc_hd__or3_4
X_05604_ _04779_ _04872_ vssd1 vssd1 vccd1 vccd1 _04874_ sky130_fd_sc_hd__xor2_1
X_06584_ _00836_ _00839_ _00835_ vssd1 vssd1 vccd1 vccd1 _00959_ sky130_fd_sc_hd__a21o_1
X_08323_ _02666_ _02703_ _02704_ vssd1 vssd1 vccd1 vccd1 _02705_ sky130_fd_sc_hd__nand3_1
X_05535_ _04802_ _04803_ _04768_ vssd1 vssd1 vccd1 vccd1 _04805_ sky130_fd_sc_hd__o21a_1
XFILLER_0_19_337 vssd1 vssd1 vccd1 vccd1 sky130_fd_sc_hd__fill_1
XFILLER_0_24_70 vssd1 vssd1 vccd1 vccd1 sky130_fd_sc_hd__fill_2
X_08254_ net245 net474 _02626_ _02627_ vssd1 vssd1 vccd1 vccd1 _02629_ sky130_fd_sc_hd__nand4_1
XFILLER_0_6_253 vssd1 vssd1 vccd1 vccd1 sky130_fd_sc_hd__decap_8
X_05466_ _04718_ _04719_ _04735_ vssd1 vssd1 vccd1 vccd1 _04736_ sky130_fd_sc_hd__or3_4
XFILLER_0_15_521 vssd1 vssd1 vccd1 vccd1 sky130_ef_sc_hd__decap_12
X_08185_ _02547_ _02556_ vssd1 vssd1 vccd1 vccd1 _02557_ sky130_fd_sc_hd__xor2_2
X_07205_ net323 net457 net464 net314 vssd1 vssd1 vccd1 vccd1 _01575_ sky130_fd_sc_hd__a22oi_1
X_05397_ net386 net615 _04663_ _04661_ _04660_ vssd1 vssd1 vccd1 vccd1 _04667_ sky130_fd_sc_hd__a32o_1
X_07136_ _01504_ _01505_ vssd1 vssd1 vccd1 vccd1 _01506_ sky130_fd_sc_hd__nand2b_1
X_07067_ _01305_ _01307_ vssd1 vssd1 vccd1 vccd1 _01438_ sky130_fd_sc_hd__nand2_1
X_06018_ _00295_ _00396_ vssd1 vssd1 vccd1 vccd1 _00397_ sky130_fd_sc_hd__xnor2_1
XFILLER_0_97_502 vssd1 vssd1 vccd1 vccd1 sky130_fd_sc_hd__fill_2
X_07969_ _02332_ _02341_ vssd1 vssd1 vccd1 vccd1 _02342_ sky130_fd_sc_hd__xor2_2
X_09708_ _04039_ _04064_ _04038_ vssd1 vssd1 vccd1 vccd1 _04218_ sky130_fd_sc_hd__a21oi_1
X_09639_ _03986_ _03988_ vssd1 vssd1 vccd1 vccd1 _04144_ sky130_fd_sc_hd__or2_1
XFILLER_0_77_281 vssd1 vssd1 vccd1 vccd1 sky130_fd_sc_hd__decap_8
XFILLER_0_65_443 vssd1 vssd1 vccd1 vccd1 sky130_fd_sc_hd__decap_4
XFILLER_0_37_156 vssd1 vssd1 vccd1 vccd1 sky130_fd_sc_hd__decap_8
XFILLER_0_52_104 vssd1 vssd1 vccd1 vccd1 sky130_ef_sc_hd__decap_12
XFILLER_0_25_329 vssd1 vssd1 vccd1 vccd1 sky130_fd_sc_hd__decap_6
XFILLER_0_18_392 vssd1 vssd1 vccd1 vccd1 sky130_fd_sc_hd__fill_2
XFILLER_0_0_418 vssd1 vssd1 vccd1 vccd1 sky130_fd_sc_hd__fill_2
XFILLER_0_21_535 vssd1 vssd1 vccd1 vccd1 sky130_fd_sc_hd__fill_2
XTAP_708 vssd1 vccd1 sky130_fd_sc_hd__tapvpwrvgnd_1
XTAP_719 vssd1 vccd1 sky130_fd_sc_hd__tapvpwrvgnd_1
Xmax_cap3 _01208_ vssd1 vssd1 vccd1 vccd1 net713 sky130_fd_sc_hd__clkbuf_2
XFILLER_0_0_27 vssd1 vssd1 vccd1 vccd1 sky130_fd_sc_hd__fill_1
XFILLER_0_75_229 vssd1 vssd1 vccd1 vccd1 sky130_fd_sc_hd__fill_1
XFILLER_0_61_57 vssd1 vssd1 vccd1 vccd1 sky130_fd_sc_hd__decap_4
XFILLER_0_56_421 vssd1 vssd1 vccd1 vccd1 sky130_fd_sc_hd__decap_4
XFILLER_0_28_123 vssd1 vssd1 vccd1 vccd1 sky130_ef_sc_hd__decap_12
X_05320_ _04033_ _04588_ _04589_ vssd1 vssd1 vccd1 vccd1 _04590_ sky130_fd_sc_hd__and3_1
XFILLER_0_28_167 vssd1 vssd1 vccd1 vccd1 sky130_fd_sc_hd__decap_6
XFILLER_0_43_104 vssd1 vssd1 vccd1 vccd1 sky130_fd_sc_hd__fill_1
XFILLER_0_9_69 vssd1 vssd1 vccd1 vccd1 sky130_fd_sc_hd__decap_4
X_05251_ _02634_ _02766_ _02755_ vssd1 vssd1 vccd1 vccd1 _04296_ sky130_fd_sc_hd__a21bo_1
XFILLER_0_101_41 vssd1 vssd1 vccd1 vccd1 sky130_ef_sc_hd__decap_12
X_05182_ _03498_ _03520_ _03531_ vssd1 vssd1 vccd1 vccd1 _03542_ sky130_fd_sc_hd__nand3_1
XFILLER_0_24_362 vssd1 vssd1 vccd1 vccd1 sky130_fd_sc_hd__fill_2
XFILLER_0_101_209 vssd1 vssd1 vccd1 vccd1 sky130_ef_sc_hd__decap_12
XFILLER_0_101_85 vssd1 vssd1 vccd1 vccd1 sky130_fd_sc_hd__decap_8
XFILLER_0_12_546 vssd1 vssd1 vccd1 vccd1 sky130_fd_sc_hd__decap_8
X_09990_ net180 net448 _04343_ _04342_ vssd1 vssd1 vccd1 vccd1 _04527_ sky130_fd_sc_hd__a31o_1
X_08941_ _03377_ _03379_ _03199_ _03226_ vssd1 vssd1 vccd1 vccd1 _03381_ sky130_fd_sc_hd__a211oi_1
XFILLER_0_86_65 vssd1 vssd1 vccd1 vccd1 sky130_fd_sc_hd__decap_6
X_08872_ _03281_ _03282_ _03303_ _03304_ vssd1 vssd1 vccd1 vccd1 _03305_ sky130_fd_sc_hd__and4_1
X_07823_ _02028_ _02030_ _02192_ _02193_ vssd1 vssd1 vccd1 vccd1 _02194_ sky130_fd_sc_hd__a211oi_2
XFILLER_0_29_3 vssd1 vssd1 vccd1 vccd1 sky130_fd_sc_hd__decap_8
X_07754_ _02123_ _02124_ vssd1 vssd1 vccd1 vccd1 _02125_ sky130_fd_sc_hd__nand2_1
X_07685_ _01894_ _01896_ vssd1 vssd1 vccd1 vccd1 _02057_ sky130_fd_sc_hd__nand2_2
X_06705_ _00939_ _00941_ _01076_ _01078_ vssd1 vssd1 vccd1 vccd1 _01079_ sky130_fd_sc_hd__a211o_4
XFILLER_0_94_505 vssd1 vssd1 vccd1 vccd1 sky130_fd_sc_hd__fill_2
X_09424_ _03905_ _03906_ vssd1 vssd1 vccd1 vccd1 _03908_ sky130_fd_sc_hd__xor2_1
X_06636_ net242 mul.a\[16\] net560 net567 vssd1 vssd1 vccd1 vccd1 _01010_ sky130_fd_sc_hd__nand4_1
XFILLER_0_66_229 vssd1 vssd1 vccd1 vccd1 sky130_fd_sc_hd__fill_1
XFILLER_0_59_281 vssd1 vssd1 vccd1 vccd1 sky130_fd_sc_hd__decap_4
XFILLER_0_47_421 vssd1 vssd1 vccd1 vccd1 sky130_fd_sc_hd__fill_1
X_09355_ _03810_ _03811_ _03830_ _03831_ vssd1 vssd1 vccd1 vccd1 _03833_ sky130_fd_sc_hd__o22a_1
X_06567_ _00939_ _00940_ _00886_ vssd1 vssd1 vccd1 vccd1 _00942_ sky130_fd_sc_hd__a21o_1
XFILLER_0_47_454 vssd1 vssd1 vccd1 vccd1 sky130_fd_sc_hd__decap_4
X_08306_ net317 net420 net426 net307 vssd1 vssd1 vccd1 vccd1 _02686_ sky130_fd_sc_hd__a22o_1
X_09286_ _03755_ _03756_ vssd1 vssd1 vccd1 vccd1 _03757_ sky130_fd_sc_hd__or2_1
XFILLER_0_51_90 vssd1 vssd1 vccd1 vccd1 sky130_fd_sc_hd__decap_6
X_05518_ net293 net614 _04786_ _04787_ vssd1 vssd1 vccd1 vccd1 _04788_ sky130_fd_sc_hd__nand4_2
XFILLER_0_19_167 vssd1 vssd1 vccd1 vccd1 sky130_fd_sc_hd__fill_1
XFILLER_0_19_178 vssd1 vssd1 vccd1 vccd1 sky130_fd_sc_hd__decap_4
X_06498_ _00746_ _00872_ vssd1 vssd1 vccd1 vccd1 _00873_ sky130_fd_sc_hd__or2_1
XFILLER_0_47_476 vssd1 vssd1 vccd1 vccd1 sky130_fd_sc_hd__decap_4
X_08237_ _02486_ _02489_ _02607_ _02609_ vssd1 vssd1 vccd1 vccd1 _02610_ sky130_fd_sc_hd__o211ai_2
XFILLER_0_7_573 vssd1 vssd1 vccd1 vccd1 sky130_fd_sc_hd__decap_8
X_05449_ _04715_ _04717_ _04481_ _04514_ vssd1 vssd1 vccd1 vccd1 _04719_ sky130_fd_sc_hd__o211a_1
XFILLER_0_15_351 vssd1 vssd1 vccd1 vccd1 sky130_fd_sc_hd__decap_6
X_08168_ _02394_ _02416_ _02537_ _02538_ vssd1 vssd1 vccd1 vccd1 _02540_ sky130_fd_sc_hd__a211o_1
X_08099_ _02467_ _02469_ vssd1 vssd1 vccd1 vccd1 _02471_ sky130_fd_sc_hd__or2_1
X_07119_ _01487_ _01488_ _01240_ _01243_ vssd1 vssd1 vccd1 vccd1 _01490_ sky130_fd_sc_hd__o211a_1
X_10130_ clknet_3_5_0_wb_clk_i _00124_ _00060_ vssd1 vssd1 vccd1 vccd1 mul.a\[25\]
+ sky130_fd_sc_hd__dfrtp_4
X_10061_ net644 vssd1 vssd1 vccd1 vccd1 _00057_ sky130_fd_sc_hd__inv_2
XFILLER_0_85_505 vssd1 vssd1 vccd1 vccd1 sky130_ef_sc_hd__decap_12
XFILLER_0_85_538 vssd1 vssd1 vccd1 vccd1 sky130_fd_sc_hd__fill_1
XFILLER_0_53_424 vssd1 vssd1 vccd1 vccd1 sky130_fd_sc_hd__decap_6
XFILLER_0_53_402 vssd1 vssd1 vccd1 vccd1 sky130_fd_sc_hd__decap_8
XFILLER_0_40_129 vssd1 vssd1 vccd1 vccd1 sky130_fd_sc_hd__fill_2
XTAP_505 vssd1 vccd1 sky130_fd_sc_hd__tapvpwrvgnd_1
XTAP_516 vssd1 vccd1 sky130_fd_sc_hd__tapvpwrvgnd_1
XTAP_527 vssd1 vccd1 sky130_fd_sc_hd__tapvpwrvgnd_1
XTAP_538 vssd1 vccd1 sky130_fd_sc_hd__tapvpwrvgnd_1
XTAP_549 vssd1 vccd1 sky130_fd_sc_hd__tapvpwrvgnd_1
XFILLER_0_56_46 vssd1 vssd1 vccd1 vccd1 sky130_fd_sc_hd__decap_6
XFILLER_0_56_79 vssd1 vssd1 vccd1 vccd1 sky130_fd_sc_hd__decap_4
XFILLER_0_88_365 vssd1 vssd1 vccd1 vccd1 sky130_fd_sc_hd__decap_8
X_07470_ _01837_ _01839_ vssd1 vssd1 vccd1 vccd1 _01840_ sky130_fd_sc_hd__nor2_1
XFILLER_0_56_240 vssd1 vssd1 vccd1 vccd1 sky130_fd_sc_hd__fill_1
XFILLER_0_8_304 vssd1 vssd1 vccd1 vccd1 sky130_fd_sc_hd__decap_4
XFILLER_0_17_605 vssd1 vssd1 vccd1 vccd1 sky130_fd_sc_hd__fill_2
X_06421_ net287 net292 net532 net542 vssd1 vssd1 vccd1 vccd1 _00797_ sky130_fd_sc_hd__nand4_1
X_09140_ _03581_ _03582_ _03594_ vssd1 vssd1 vccd1 vccd1 _03598_ sky130_fd_sc_hd__o21ai_2
XFILLER_0_16_104 vssd1 vssd1 vccd1 vccd1 sky130_fd_sc_hd__decap_3
X_06352_ _00726_ _00727_ vssd1 vssd1 vccd1 vccd1 _00728_ sky130_fd_sc_hd__nor2_1
XFILLER_0_29_487 vssd1 vssd1 vccd1 vccd1 sky130_ef_sc_hd__decap_12
X_09071_ _03519_ _03521_ vssd1 vssd1 vccd1 vccd1 _03523_ sky130_fd_sc_hd__xnor2_2
XFILLER_0_71_243 vssd1 vssd1 vccd1 vccd1 sky130_fd_sc_hd__decap_3
X_06283_ net343 net495 _00552_ _00551_ vssd1 vssd1 vccd1 vccd1 _00660_ sky130_fd_sc_hd__a31o_1
X_05303_ _03880_ _04560_ _04572_ vssd1 vssd1 vccd1 vccd1 _04573_ sky130_fd_sc_hd__nand3_1
X_08022_ _02392_ _02393_ _02236_ net113 vssd1 vssd1 vccd1 vccd1 _02395_ sky130_fd_sc_hd__a211o_1
X_05234_ _04066_ _04099_ vssd1 vssd1 vccd1 vccd1 _04110_ sky130_fd_sc_hd__xnor2_1
XFILLER_0_12_321 vssd1 vssd1 vccd1 vccd1 sky130_ef_sc_hd__decap_12
XFILLER_0_4_587 vssd1 vssd1 vccd1 vccd1 sky130_fd_sc_hd__fill_1
X_05165_ _03246_ _03334_ _03345_ vssd1 vssd1 vccd1 vccd1 _03356_ sky130_fd_sc_hd__or3b_1
X_09973_ net173 net449 vssd1 vssd1 vccd1 vccd1 _04508_ sky130_fd_sc_hd__nand2_1
X_05096_ net2 net37 _02592_ vssd1 vssd1 vccd1 vccd1 _00002_ sky130_fd_sc_hd__and3b_1
XFILLER_0_12_387 vssd1 vssd1 vccd1 vccd1 sky130_fd_sc_hd__decap_3
X_08924_ _03358_ _03361_ vssd1 vssd1 vccd1 vccd1 _03362_ sky130_fd_sc_hd__and2_1
X_08855_ net260 net430 _03283_ _03284_ vssd1 vssd1 vccd1 vccd1 _03286_ sky130_fd_sc_hd__nand4_2
X_08786_ _03206_ _03209_ vssd1 vssd1 vccd1 vccd1 _03211_ sky130_fd_sc_hd__xor2_1
XFILLER_0_98_129 vssd1 vssd1 vccd1 vccd1 sky130_fd_sc_hd__fill_2
X_07806_ net340 net421 net426 net332 vssd1 vssd1 vccd1 vccd1 _02177_ sky130_fd_sc_hd__a22o_1
X_05998_ _00178_ _00279_ _00278_ vssd1 vssd1 vccd1 vccd1 _00378_ sky130_fd_sc_hd__a21o_1
X_07737_ _02107_ _02108_ vssd1 vssd1 vccd1 vccd1 _02109_ sky130_fd_sc_hd__or2_1
XFILLER_0_94_335 vssd1 vssd1 vccd1 vccd1 sky130_fd_sc_hd__fill_1
X_07668_ net446 _02039_ _02038_ vssd1 vssd1 vccd1 vccd1 _02040_ sky130_fd_sc_hd__a21bo_1
XFILLER_0_39_229 vssd1 vssd1 vccd1 vccd1 sky130_fd_sc_hd__fill_1
X_09407_ _03887_ _03888_ vssd1 vssd1 vccd1 vccd1 _03889_ sky130_fd_sc_hd__or2_1
X_06619_ _00860_ _00862_ vssd1 vssd1 vccd1 vccd1 _00993_ sky130_fd_sc_hd__nand2_1
X_07599_ _01969_ _01970_ vssd1 vssd1 vccd1 vccd1 _01971_ sky130_fd_sc_hd__or2_1
X_09338_ _03813_ net123 vssd1 vssd1 vccd1 vccd1 _03814_ sky130_fd_sc_hd__and2b_1
XFILLER_0_47_295 vssd1 vssd1 vccd1 vccd1 sky130_fd_sc_hd__fill_1
X_09269_ _03737_ vssd1 vssd1 vccd1 vccd1 _03739_ sky130_fd_sc_hd__inv_2
XFILLER_0_15_181 vssd1 vssd1 vccd1 vccd1 sky130_fd_sc_hd__fill_2
XFILLER_0_22_129 vssd1 vssd1 vccd1 vccd1 sky130_fd_sc_hd__decap_8
X_10113_ clknet_3_0_0_wb_clk_i _00107_ _00043_ vssd1 vssd1 vccd1 vccd1 mul.a\[8\]
+ sky130_fd_sc_hd__dfrtp_4
X_10044_ net641 vssd1 vssd1 vccd1 vccd1 _00040_ sky130_fd_sc_hd__inv_2
XFILLER_0_89_107 vssd1 vssd1 vccd1 vccd1 sky130_fd_sc_hd__decap_4
XFILLER_0_26_27 vssd1 vssd1 vccd1 vccd1 sky130_fd_sc_hd__fill_1
XFILLER_0_58_527 vssd1 vssd1 vccd1 vccd1 sky130_fd_sc_hd__decap_4
XFILLER_0_85_368 vssd1 vssd1 vccd1 vccd1 sky130_fd_sc_hd__decap_6
XANTENNA_3 mul.a\[26\] vssd1 vssd1 vccd1 vccd1 sky130_fd_sc_hd__diode_2
XFILLER_0_41_449 vssd1 vssd1 vccd1 vccd1 sky130_ef_sc_hd__decap_12
XFILLER_0_34_490 vssd1 vssd1 vccd1 vccd1 sky130_fd_sc_hd__decap_6
XTAP_324 vssd1 vccd1 sky130_fd_sc_hd__tapvpwrvgnd_1
XTAP_313 vssd1 vccd1 sky130_fd_sc_hd__tapvpwrvgnd_1
XTAP_302 vssd1 vccd1 sky130_fd_sc_hd__tapvpwrvgnd_1
XTAP_346 vssd1 vccd1 sky130_fd_sc_hd__tapvpwrvgnd_1
XTAP_335 vssd1 vccd1 sky130_fd_sc_hd__tapvpwrvgnd_1
XTAP_357 vssd1 vccd1 sky130_fd_sc_hd__tapvpwrvgnd_1
X_06970_ _01339_ _01340_ _01202_ _01204_ vssd1 vssd1 vccd1 vccd1 _01342_ sky130_fd_sc_hd__a211oi_2
XTAP_379 vssd1 vccd1 sky130_fd_sc_hd__tapvpwrvgnd_1
X_05921_ net263 net273 net598 net607 vssd1 vssd1 vccd1 vccd1 _00301_ sky130_fd_sc_hd__and4_1
XTAP_368 vssd1 vccd1 sky130_fd_sc_hd__tapvpwrvgnd_1
X_08640_ net163 net558 net579 net148 vssd1 vssd1 vccd1 vccd1 _03052_ sky130_fd_sc_hd__a22o_1
XFILLER_0_83_33 vssd1 vssd1 vccd1 vccd1 sky130_fd_sc_hd__fill_1
X_05852_ _00231_ _00232_ vssd1 vssd1 vccd1 vccd1 _00233_ sky130_fd_sc_hd__and2_1
Xrebuffer15 _01762_ vssd1 vssd1 vccd1 vccd1 net660 sky130_fd_sc_hd__clkbuf_1
Xrebuffer26 _00812_ vssd1 vssd1 vccd1 vccd1 net671 sky130_fd_sc_hd__dlygate4sd2_1
X_08571_ net270 net437 net443 net259 vssd1 vssd1 vccd1 vccd1 _02976_ sky130_fd_sc_hd__a22o_1
XFILLER_0_83_88 vssd1 vssd1 vccd1 vccd1 sky130_ef_sc_hd__decap_12
Xrebuffer37 _02282_ vssd1 vssd1 vccd1 vccd1 net682 sky130_fd_sc_hd__dlygate4sd3_1
XPHY_19 vssd1 vssd1 vccd1 vccd1 sky130_fd_sc_hd__decap_3
X_05783_ _05015_ _00164_ vssd1 vssd1 vccd1 vccd1 _00165_ sky130_fd_sc_hd__nand2_1
Xrebuffer59 _00703_ vssd1 vssd1 vccd1 vccd1 net704 sky130_fd_sc_hd__clkbuf_1
Xrebuffer48 net692 vssd1 vssd1 vccd1 vccd1 net693 sky130_fd_sc_hd__buf_1
X_07522_ net285 net473 _01893_ _01894_ vssd1 vssd1 vccd1 vccd1 _01895_ sky130_fd_sc_hd__a22o_1
XFILLER_0_16_82 vssd1 vssd1 vccd1 vccd1 sky130_fd_sc_hd__fill_2
XFILLER_0_49_538 vssd1 vssd1 vccd1 vccd1 sky130_fd_sc_hd__decap_3
XFILLER_0_8_112 vssd1 vssd1 vccd1 vccd1 sky130_fd_sc_hd__decap_4
X_07453_ _01813_ _01820_ vssd1 vssd1 vccd1 vccd1 _01821_ sky130_fd_sc_hd__xnor2_2
X_06404_ _00661_ _00663_ vssd1 vssd1 vccd1 vccd1 _00780_ sky130_fd_sc_hd__and2_1
XFILLER_0_72_530 vssd1 vssd1 vccd1 vccd1 sky130_fd_sc_hd__fill_2
X_09123_ _03570_ _03571_ _03577_ vssd1 vssd1 vccd1 vccd1 _03579_ sky130_fd_sc_hd__a21o_1
X_07384_ net240 net525 _01751_ _01752_ vssd1 vssd1 vccd1 vccd1 _01753_ sky130_fd_sc_hd__and4_1
XFILLER_0_32_70 vssd1 vssd1 vccd1 vccd1 sky130_fd_sc_hd__fill_1
XFILLER_0_96_3 vssd1 vssd1 vccd1 vccd1 sky130_ef_sc_hd__decap_12
X_06335_ _00590_ net75 _00710_ _00711_ vssd1 vssd1 vccd1 vccd1 _00712_ sky130_fd_sc_hd__o211ai_1
X_09054_ net119 _03372_ _03371_ vssd1 vssd1 vccd1 vccd1 _03504_ sky130_fd_sc_hd__o21ai_2
X_06266_ net280 net563 net571 net272 vssd1 vssd1 vccd1 vccd1 _00643_ sky130_fd_sc_hd__a22oi_1
X_08005_ _02226_ _02231_ _02225_ vssd1 vssd1 vccd1 vccd1 _02378_ sky130_fd_sc_hd__a21bo_1
XFILLER_0_4_384 vssd1 vssd1 vccd1 vccd1 sky130_ef_sc_hd__decap_12
X_05217_ _03749_ _03902_ _03913_ vssd1 vssd1 vccd1 vccd1 _03924_ sky130_fd_sc_hd__nand3_1
XFILLER_0_25_490 vssd1 vssd1 vccd1 vccd1 sky130_ef_sc_hd__decap_12
XFILLER_0_12_173 vssd1 vssd1 vccd1 vccd1 sky130_fd_sc_hd__decap_3
X_06197_ _00571_ _00572_ _00538_ vssd1 vssd1 vccd1 vccd1 _00575_ sky130_fd_sc_hd__a21oi_2
X_05148_ _03017_ _03137_ _03148_ vssd1 vssd1 vccd1 vccd1 _03170_ sky130_fd_sc_hd__a21o_1
X_09956_ _04474_ _04488_ vssd1 vssd1 vccd1 vccd1 _04489_ sky130_fd_sc_hd__xnor2_1
X_05079_ net8 net529 net124 vssd1 vssd1 vccd1 vccd1 _00079_ sky130_fd_sc_hd__mux2_1
X_08907_ _03147_ _03150_ _03341_ _03342_ vssd1 vssd1 vccd1 vccd1 _03343_ sky130_fd_sc_hd__o211a_1
X_09887_ _04277_ _04279_ _04275_ vssd1 vssd1 vccd1 vccd1 _04414_ sky130_fd_sc_hd__a21oi_1
XTAP_880 vssd1 vccd1 sky130_fd_sc_hd__tapvpwrvgnd_1
X_08838_ net199 net484 net493 net192 vssd1 vssd1 vccd1 vccd1 _03267_ sky130_fd_sc_hd__a22o_1
XTAP_891 vssd1 vccd1 sky130_fd_sc_hd__tapvpwrvgnd_1
XFILLER_0_99_449 vssd1 vssd1 vccd1 vccd1 sky130_fd_sc_hd__decap_8
X_08769_ _03189_ _03190_ _02990_ _02992_ vssd1 vssd1 vccd1 vccd1 _03193_ sky130_fd_sc_hd__a211oi_2
XFILLER_0_79_140 vssd1 vssd1 vccd1 vccd1 sky130_fd_sc_hd__fill_2
XFILLER_0_94_165 vssd1 vssd1 vccd1 vccd1 sky130_fd_sc_hd__decap_4
XFILLER_0_35_221 vssd1 vssd1 vccd1 vccd1 sky130_fd_sc_hd__decap_3
XFILLER_0_23_405 vssd1 vssd1 vccd1 vccd1 sky130_ef_sc_hd__decap_12
XFILLER_0_90_382 vssd1 vssd1 vccd1 vccd1 sky130_fd_sc_hd__decap_8
XFILLER_0_50_235 vssd1 vssd1 vccd1 vccd1 sky130_fd_sc_hd__decap_4
Xoutput51 net51 vssd1 vssd1 vccd1 vccd1 wbs_dat_o[1] sky130_fd_sc_hd__clkbuf_4
Xoutput40 net40 vssd1 vssd1 vccd1 vccd1 wbs_dat_o[0] sky130_fd_sc_hd__clkbuf_4
XFILLER_0_31_482 vssd1 vssd1 vccd1 vccd1 sky130_fd_sc_hd__fill_2
Xoutput62 net62 vssd1 vssd1 vccd1 vccd1 wbs_dat_o[2] sky130_fd_sc_hd__clkbuf_4
XFILLER_0_37_15 vssd1 vssd1 vccd1 vccd1 sky130_ef_sc_hd__decap_12
XFILLER_0_37_48 vssd1 vssd1 vccd1 vccd1 sky130_fd_sc_hd__decap_8
X_10027_ net642 vssd1 vssd1 vccd1 vccd1 _00023_ sky130_fd_sc_hd__inv_2
XFILLER_0_53_14 vssd1 vssd1 vccd1 vccd1 sky130_fd_sc_hd__fill_1
XPHY_190 vssd1 vssd1 vccd1 vccd1 sky130_fd_sc_hd__decap_3
XFILLER_0_54_563 vssd1 vssd1 vccd1 vccd1 sky130_fd_sc_hd__fill_1
XFILLER_0_54_541 vssd1 vssd1 vccd1 vccd1 sky130_fd_sc_hd__fill_2
XFILLER_0_14_416 vssd1 vssd1 vccd1 vccd1 sky130_fd_sc_hd__decap_4
X_06120_ _00388_ _00392_ _00496_ vssd1 vssd1 vccd1 vccd1 _00498_ sky130_fd_sc_hd__nand3_1
X_06051_ _00428_ _00429_ vssd1 vssd1 vccd1 vccd1 _00430_ sky130_fd_sc_hd__and2b_1
Xfanout307 net308 vssd1 vssd1 vccd1 vccd1 net307 sky130_fd_sc_hd__buf_4
Xfanout329 net330 vssd1 vssd1 vccd1 vccd1 net329 sky130_fd_sc_hd__buf_2
Xfanout318 mul.a\[9\] vssd1 vssd1 vccd1 vccd1 net318 sky130_fd_sc_hd__buf_4
X_09810_ _04327_ _04329_ vssd1 vssd1 vccd1 vccd1 _04330_ sky130_fd_sc_hd__and2_1
X_09741_ _04097_ _04100_ _04253_ vssd1 vssd1 vccd1 vccd1 _04255_ sky130_fd_sc_hd__and3_1
X_06953_ _01316_ _01323_ _01324_ vssd1 vssd1 vccd1 vccd1 _01325_ sky130_fd_sc_hd__nand3_1
XFILLER_0_94_65 vssd1 vssd1 vccd1 vccd1 sky130_ef_sc_hd__decap_12
X_05904_ _05002_ _00217_ _00216_ vssd1 vssd1 vccd1 vccd1 _00284_ sky130_fd_sc_hd__a21oi_2
X_06884_ _01120_ _01124_ _01254_ vssd1 vssd1 vccd1 vccd1 _01256_ sky130_fd_sc_hd__nand3_1
X_09672_ net156 net162 net477 net486 vssd1 vssd1 vccd1 vccd1 _04179_ sky130_fd_sc_hd__nand4_1
X_08623_ _03018_ _03031_ _03032_ vssd1 vssd1 vccd1 vccd1 _03033_ sky130_fd_sc_hd__nand3_2
XFILLER_0_89_460 vssd1 vssd1 vccd1 vccd1 sky130_fd_sc_hd__decap_4
X_05835_ _04999_ _05004_ _00215_ vssd1 vssd1 vccd1 vccd1 _00216_ sky130_fd_sc_hd__o21a_1
XTAP_1309 vssd1 vccd1 sky130_fd_sc_hd__tapvpwrvgnd_1
X_08554_ _02794_ _02796_ vssd1 vssd1 vccd1 vccd1 _02957_ sky130_fd_sc_hd__nand2_1
X_05766_ _00139_ _00146_ _00147_ vssd1 vssd1 vccd1 vccd1 _00148_ sky130_fd_sc_hd__nand3_1
X_07505_ net307 net459 net466 net300 vssd1 vssd1 vccd1 vccd1 _01877_ sky130_fd_sc_hd__a22o_1
X_08485_ net164 net574 _02671_ _02670_ vssd1 vssd1 vccd1 vccd1 _02882_ sky130_fd_sc_hd__a31o_1
X_05697_ _04965_ _04966_ vssd1 vssd1 vccd1 vccd1 _04967_ sky130_fd_sc_hd__nand2_1
XFILLER_0_91_124 vssd1 vssd1 vccd1 vccd1 sky130_fd_sc_hd__decap_4
XFILLER_0_91_113 vssd1 vssd1 vccd1 vccd1 sky130_fd_sc_hd__decap_4
X_07436_ _01802_ _01803_ vssd1 vssd1 vccd1 vccd1 _01804_ sky130_fd_sc_hd__nand2_1
XFILLER_0_91_146 vssd1 vssd1 vccd1 vccd1 sky130_fd_sc_hd__decap_3
X_07367_ net277 net499 _01601_ _01600_ vssd1 vssd1 vccd1 vccd1 _01736_ sky130_fd_sc_hd__a31o_1
X_09106_ _00182_ _03560_ vssd1 vssd1 vccd1 vccd1 _03561_ sky130_fd_sc_hd__or2_1
XFILLER_0_60_533 vssd1 vssd1 vccd1 vccd1 sky130_fd_sc_hd__fill_1
X_06318_ _00571_ _00574_ _00692_ _00694_ vssd1 vssd1 vccd1 vccd1 _00695_ sky130_fd_sc_hd__a211o_2
X_09037_ _03483_ _03484_ vssd1 vssd1 vccd1 vccd1 _03485_ sky130_fd_sc_hd__and2_1
X_07298_ _01513_ _01666_ vssd1 vssd1 vccd1 vccd1 _01667_ sky130_fd_sc_hd__and2_1
X_06249_ _00528_ _00624_ _00625_ vssd1 vssd1 vccd1 vccd1 _00626_ sky130_fd_sc_hd__nand3_1
X_09939_ net166 net455 vssd1 vssd1 vccd1 vccd1 _04471_ sky130_fd_sc_hd__nand2_1
XFILLER_0_99_279 vssd1 vssd1 vccd1 vccd1 sky130_fd_sc_hd__fill_1
XFILLER_0_95_485 vssd1 vssd1 vccd1 vccd1 sky130_fd_sc_hd__decap_6
XFILLER_0_95_496 vssd1 vssd1 vccd1 vccd1 sky130_fd_sc_hd__decap_8
XFILLER_0_63_393 vssd1 vssd1 vccd1 vccd1 sky130_fd_sc_hd__fill_2
Xrebuffer6 _02095_ vssd1 vssd1 vccd1 vccd1 net651 sky130_fd_sc_hd__dlygate4sd1_1
XFILLER_0_48_58 vssd1 vssd1 vccd1 vccd1 sky130_fd_sc_hd__decap_4
XFILLER_0_64_13 vssd1 vssd1 vccd1 vccd1 sky130_fd_sc_hd__fill_2
X_05620_ _04817_ _04889_ vssd1 vssd1 vccd1 vccd1 _04890_ sky130_fd_sc_hd__nand2_1
X_05551_ net390 net504 net513 net381 vssd1 vssd1 vccd1 vccd1 _04821_ sky130_fd_sc_hd__a22oi_1
XFILLER_0_19_508 vssd1 vssd1 vccd1 vccd1 sky130_fd_sc_hd__decap_8
X_08270_ net264 net460 net467 net254 vssd1 vssd1 vccd1 vccd1 _02647_ sky130_fd_sc_hd__a22o_1
XFILLER_0_80_89 vssd1 vssd1 vccd1 vccd1 sky130_ef_sc_hd__decap_12
X_05482_ _04750_ _04751_ vssd1 vssd1 vccd1 vccd1 _04752_ sky130_fd_sc_hd__or2_1
XFILLER_0_46_349 vssd1 vssd1 vccd1 vccd1 sky130_fd_sc_hd__decap_8
X_07221_ net295 net481 net492 net285 vssd1 vssd1 vccd1 vccd1 _01591_ sky130_fd_sc_hd__a22o_1
XFILLER_0_27_596 vssd1 vssd1 vccd1 vccd1 sky130_fd_sc_hd__fill_2
X_07152_ net226 net556 net578 net202 vssd1 vssd1 vccd1 vccd1 _01522_ sky130_fd_sc_hd__a22o_1
XFILLER_0_89_76 vssd1 vssd1 vccd1 vccd1 sky130_fd_sc_hd__fill_1
X_06103_ _00375_ _00376_ _00381_ vssd1 vssd1 vccd1 vccd1 _00482_ sky130_fd_sc_hd__o21a_1
XFILLER_0_14_224 vssd1 vssd1 vccd1 vccd1 sky130_fd_sc_hd__fill_1
XFILLER_0_14_235 vssd1 vssd1 vccd1 vccd1 sky130_fd_sc_hd__fill_1
XFILLER_0_14_246 vssd1 vssd1 vccd1 vccd1 sky130_fd_sc_hd__decap_6
XFILLER_0_42_533 vssd1 vssd1 vccd1 vccd1 sky130_fd_sc_hd__decap_8
X_07083_ net259 net524 vssd1 vssd1 vccd1 vccd1 _01454_ sky130_fd_sc_hd__and2_1
X_06034_ _00411_ _00412_ vssd1 vssd1 vccd1 vccd1 _00413_ sky130_fd_sc_hd__and2b_1
Xfanout137 _03313_ vssd1 vssd1 vccd1 vccd1 net137 sky130_fd_sc_hd__clkbuf_2
Xfanout126 _02232_ vssd1 vssd1 vccd1 vccd1 net126 sky130_fd_sc_hd__buf_4
XFILLER_0_1_195 vssd1 vssd1 vccd1 vccd1 sky130_fd_sc_hd__fill_1
Xfanout148 mul.a\[31\] vssd1 vssd1 vccd1 vccd1 net148 sky130_fd_sc_hd__clkbuf_4
X_07985_ _02354_ _02355_ _02342_ vssd1 vssd1 vccd1 vccd1 _02358_ sky130_fd_sc_hd__a21oi_1
Xfanout159 mul.a\[29\] vssd1 vssd1 vccd1 vccd1 net159 sky130_fd_sc_hd__clkbuf_4
X_09724_ _04234_ _04235_ vssd1 vssd1 vccd1 vccd1 _04236_ sky130_fd_sc_hd__or2_1
X_06936_ _01303_ _01306_ _01307_ vssd1 vssd1 vccd1 vccd1 _01308_ sky130_fd_sc_hd__and3_1
X_09655_ _03559_ _03852_ _04157_ _04160_ vssd1 vssd1 vccd1 vccd1 _04161_ sky130_fd_sc_hd__o31ai_4
X_06867_ _01234_ _01237_ vssd1 vssd1 vccd1 vccd1 _01239_ sky130_fd_sc_hd__xnor2_1
X_08606_ _03012_ _03013_ vssd1 vssd1 vccd1 vccd1 _03014_ sky130_fd_sc_hd__and2_1
X_05818_ _04987_ _00198_ vssd1 vssd1 vccd1 vccd1 _00199_ sky130_fd_sc_hd__or2_1
XTAP_1128 vssd1 vccd1 sky130_fd_sc_hd__tapvpwrvgnd_1
XTAP_1117 vssd1 vccd1 sky130_fd_sc_hd__tapvpwrvgnd_1
XTAP_1106 vssd1 vccd1 sky130_fd_sc_hd__tapvpwrvgnd_1
X_09586_ _04074_ _04084_ vssd1 vssd1 vccd1 vccd1 _04085_ sky130_fd_sc_hd__nor2_1
X_06798_ net322 net477 net486 net313 vssd1 vssd1 vccd1 vccd1 _01171_ sky130_fd_sc_hd__a22o_1
XFILLER_0_92_400 vssd1 vssd1 vccd1 vccd1 sky130_fd_sc_hd__decap_6
XTAP_1139 vssd1 vccd1 sky130_fd_sc_hd__tapvpwrvgnd_1
X_08537_ net171 net174 net701 net544 vssd1 vssd1 vccd1 vccd1 _02938_ sky130_fd_sc_hd__and4_1
XFILLER_0_65_614 vssd1 vssd1 vccd1 vccd1 sky130_fd_sc_hd__fill_2
X_05749_ _04822_ _04954_ _04953_ vssd1 vssd1 vccd1 vccd1 _00131_ sky130_fd_sc_hd__a21o_1
XFILLER_0_49_165 vssd1 vssd1 vccd1 vccd1 sky130_fd_sc_hd__decap_3
XFILLER_0_92_433 vssd1 vssd1 vccd1 vccd1 sky130_fd_sc_hd__fill_2
X_08468_ _02859_ _02860_ _02861_ vssd1 vssd1 vccd1 vccd1 _02863_ sky130_fd_sc_hd__a21o_1
XFILLER_0_37_327 vssd1 vssd1 vccd1 vccd1 sky130_fd_sc_hd__decap_8
XFILLER_0_9_262 vssd1 vssd1 vccd1 vccd1 sky130_fd_sc_hd__decap_6
XFILLER_0_18_530 vssd1 vssd1 vccd1 vccd1 sky130_fd_sc_hd__fill_2
X_07419_ _01786_ _01787_ _01641_ _01643_ vssd1 vssd1 vccd1 vccd1 _01788_ sky130_fd_sc_hd__o211a_1
X_08399_ _02611_ _02617_ _02610_ vssd1 vssd1 vccd1 vccd1 _02788_ sky130_fd_sc_hd__a21bo_1
XFILLER_0_18_574 vssd1 vssd1 vccd1 vccd1 sky130_fd_sc_hd__decap_4
XFILLER_0_18_585 vssd1 vssd1 vccd1 vccd1 sky130_fd_sc_hd__decap_3
XFILLER_0_33_544 vssd1 vssd1 vccd1 vccd1 sky130_fd_sc_hd__fill_1
XFILLER_0_45_393 vssd1 vssd1 vccd1 vccd1 sky130_ef_sc_hd__decap_12
XFILLER_0_60_363 vssd1 vssd1 vccd1 vccd1 sky130_fd_sc_hd__fill_1
XFILLER_0_0_3 vssd1 vssd1 vccd1 vccd1 sky130_ef_sc_hd__decap_12
XFILLER_0_34_27 vssd1 vssd1 vccd1 vccd1 sky130_fd_sc_hd__fill_1
XFILLER_0_68_474 vssd1 vssd1 vccd1 vccd1 sky130_fd_sc_hd__fill_2
XFILLER_0_56_603 vssd1 vssd1 vccd1 vccd1 sky130_fd_sc_hd__fill_1
XFILLER_0_50_15 vssd1 vssd1 vccd1 vccd1 sky130_ef_sc_hd__decap_12
XFILLER_0_71_617 vssd1 vssd1 vccd1 vccd1 sky130_fd_sc_hd__fill_2
XFILLER_0_55_146 vssd1 vssd1 vccd1 vccd1 sky130_fd_sc_hd__fill_2
XFILLER_0_83_488 vssd1 vssd1 vccd1 vccd1 sky130_fd_sc_hd__decap_3
XFILLER_0_24_533 vssd1 vssd1 vccd1 vccd1 sky130_fd_sc_hd__decap_8
XFILLER_0_59_24 vssd1 vssd1 vccd1 vccd1 sky130_ef_sc_hd__decap_12
XFILLER_0_3_449 vssd1 vssd1 vccd1 vccd1 sky130_fd_sc_hd__decap_8
XFILLER_0_59_57 vssd1 vssd1 vccd1 vccd1 sky130_ef_sc_hd__decap_12
XFILLER_0_11_238 vssd1 vssd1 vccd1 vccd1 sky130_fd_sc_hd__decap_6
X_07770_ net176 net196 net557 net584 vssd1 vssd1 vccd1 vccd1 _02141_ sky130_fd_sc_hd__nand4_1
X_06721_ _01093_ _01094_ vssd1 vssd1 vccd1 vccd1 _01095_ sky130_fd_sc_hd__and2_1
XFILLER_0_91_11 vssd1 vssd1 vccd1 vccd1 sky130_fd_sc_hd__fill_1
XFILLER_0_78_216 vssd1 vssd1 vccd1 vccd1 sky130_fd_sc_hd__decap_3
X_09440_ net267 net399 net405 net257 vssd1 vssd1 vccd1 vccd1 _03926_ sky130_fd_sc_hd__a22o_1
X_06652_ net365 net448 _01024_ _01025_ vssd1 vssd1 vccd1 vccd1 _01026_ sky130_fd_sc_hd__nand4_2
X_09371_ _03550_ _03704_ _03705_ vssd1 vssd1 vccd1 vccd1 _03851_ sky130_fd_sc_hd__o21ba_1
X_05603_ _04779_ _04872_ vssd1 vssd1 vccd1 vccd1 _04873_ sky130_fd_sc_hd__nand2b_1
X_06583_ _00842_ _00955_ vssd1 vssd1 vccd1 vccd1 _00958_ sky130_fd_sc_hd__xnor2_1
X_08322_ _02701_ _02702_ _02533_ _02535_ vssd1 vssd1 vccd1 vccd1 _02704_ sky130_fd_sc_hd__o211ai_2
X_05534_ _04768_ _04802_ _04803_ vssd1 vssd1 vccd1 vccd1 _04804_ sky130_fd_sc_hd__nor3_1
XFILLER_0_24_82 vssd1 vssd1 vccd1 vccd1 sky130_fd_sc_hd__fill_2
X_08253_ net245 net473 _02626_ _02627_ vssd1 vssd1 vccd1 vccd1 _02628_ sky130_fd_sc_hd__a22o_1
XFILLER_0_74_466 vssd1 vssd1 vccd1 vccd1 sky130_fd_sc_hd__fill_2
XFILLER_0_74_477 vssd1 vssd1 vccd1 vccd1 sky130_fd_sc_hd__decap_6
XFILLER_0_61_127 vssd1 vssd1 vccd1 vccd1 sky130_fd_sc_hd__decap_8
X_07204_ _01572_ _01573_ vssd1 vssd1 vccd1 vccd1 _01574_ sky130_fd_sc_hd__nand2_1
X_05465_ _04733_ _04734_ vssd1 vssd1 vccd1 vccd1 _04735_ sky130_fd_sc_hd__nand2_1
X_08184_ _02554_ _02555_ vssd1 vssd1 vccd1 vccd1 _02556_ sky130_fd_sc_hd__or2_1
XFILLER_0_15_533 vssd1 vssd1 vccd1 vccd1 sky130_fd_sc_hd__decap_8
X_05396_ _04663_ _04665_ net378 net624 vssd1 vssd1 vccd1 vccd1 _04666_ sky130_fd_sc_hd__o211a_1
XFILLER_0_15_588 vssd1 vssd1 vccd1 vccd1 sky130_fd_sc_hd__fill_1
X_07135_ net188 net602 net612 net181 vssd1 vssd1 vccd1 vccd1 _01505_ sky130_fd_sc_hd__a22o_1
X_07066_ _01434_ _01435_ _01293_ _01295_ vssd1 vssd1 vccd1 vccd1 _01437_ sky130_fd_sc_hd__o211a_1
X_06017_ _00394_ _00395_ vssd1 vssd1 vccd1 vccd1 _00396_ sky130_fd_sc_hd__nand2_1
X_07968_ _02339_ _02340_ vssd1 vssd1 vccd1 vccd1 _02341_ sky130_fd_sc_hd__or2_1
X_09707_ _04193_ _04216_ vssd1 vssd1 vccd1 vccd1 _04217_ sky130_fd_sc_hd__xnor2_1
X_06919_ net348 net448 _01289_ _01290_ vssd1 vssd1 vccd1 vccd1 _01291_ sky130_fd_sc_hd__nand4_4
X_07899_ net663 _02105_ _02271_ _02272_ vssd1 vssd1 vccd1 vccd1 _02273_ sky130_fd_sc_hd__o211ai_2
X_09638_ _04140_ _04141_ vssd1 vssd1 vccd1 vccd1 _04142_ sky130_fd_sc_hd__nor2_1
XFILLER_0_69_238 vssd1 vssd1 vccd1 vccd1 sky130_fd_sc_hd__decap_4
X_09569_ _03890_ _03915_ _03889_ vssd1 vssd1 vccd1 vccd1 _04067_ sky130_fd_sc_hd__a21boi_2
XFILLER_0_37_113 vssd1 vssd1 vccd1 vccd1 sky130_fd_sc_hd__fill_1
XFILLER_0_92_241 vssd1 vssd1 vccd1 vccd1 sky130_fd_sc_hd__decap_8
XFILLER_0_92_263 vssd1 vssd1 vccd1 vccd1 sky130_fd_sc_hd__decap_6
XFILLER_0_25_319 vssd1 vssd1 vccd1 vccd1 sky130_fd_sc_hd__decap_3
XFILLER_0_80_469 vssd1 vssd1 vccd1 vccd1 sky130_fd_sc_hd__decap_6
XFILLER_0_80_458 vssd1 vssd1 vccd1 vccd1 sky130_fd_sc_hd__decap_3
XFILLER_0_20_29 vssd1 vssd1 vccd1 vccd1 sky130_fd_sc_hd__decap_4
XFILLER_0_21_503 vssd1 vssd1 vccd1 vccd1 sky130_fd_sc_hd__fill_1
XTAP_709 vssd1 vccd1 sky130_fd_sc_hd__tapvpwrvgnd_1
Xfanout490 net493 vssd1 vssd1 vccd1 vccd1 net490 sky130_fd_sc_hd__clkbuf_4
XFILLER_0_88_514 vssd1 vssd1 vccd1 vccd1 sky130_fd_sc_hd__decap_3
Xmax_cap4 _00945_ vssd1 vssd1 vccd1 vccd1 net714 sky130_fd_sc_hd__clkbuf_2
XFILLER_0_96_580 vssd1 vssd1 vccd1 vccd1 sky130_fd_sc_hd__fill_2
XFILLER_0_61_47 vssd1 vssd1 vccd1 vccd1 sky130_fd_sc_hd__decap_6
XFILLER_0_83_252 vssd1 vssd1 vccd1 vccd1 sky130_ef_sc_hd__decap_12
XFILLER_0_68_293 vssd1 vssd1 vccd1 vccd1 sky130_fd_sc_hd__fill_1
XFILLER_0_28_135 vssd1 vssd1 vccd1 vccd1 sky130_fd_sc_hd__fill_1
XFILLER_0_83_285 vssd1 vssd1 vccd1 vccd1 sky130_fd_sc_hd__fill_1
XFILLER_0_9_15 vssd1 vssd1 vccd1 vccd1 sky130_ef_sc_hd__decap_12
X_05250_ _04252_ _04263_ _04175_ vssd1 vssd1 vccd1 vccd1 _04285_ sky130_fd_sc_hd__a21o_1
XFILLER_0_71_469 vssd1 vssd1 vccd1 vccd1 sky130_fd_sc_hd__fill_2
X_05181_ _02842_ _03432_ _03487_ vssd1 vssd1 vccd1 vccd1 _03531_ sky130_fd_sc_hd__a21o_1
XFILLER_0_101_53 vssd1 vssd1 vccd1 vccd1 sky130_fd_sc_hd__decap_3
XFILLER_0_10_95 vssd1 vssd1 vccd1 vccd1 sky130_fd_sc_hd__fill_2
XFILLER_0_12_569 vssd1 vssd1 vccd1 vccd1 sky130_fd_sc_hd__decap_3
X_08940_ _03199_ _03226_ _03377_ _03379_ vssd1 vssd1 vccd1 vccd1 _03380_ sky130_fd_sc_hd__o211a_1
X_08871_ _03299_ _03300_ _03143_ _03145_ vssd1 vssd1 vccd1 vccd1 _03304_ sky130_fd_sc_hd__o211ai_4
X_07822_ _02189_ _02191_ _02052_ _02054_ vssd1 vssd1 vccd1 vccd1 _02193_ sky130_fd_sc_hd__o211a_1
XFILLER_0_19_82 vssd1 vssd1 vccd1 vccd1 sky130_fd_sc_hd__decap_8
X_07753_ net159 net165 net600 net610 vssd1 vssd1 vccd1 vccd1 _02124_ sky130_fd_sc_hd__nand4_1
X_07684_ _02054_ _02055_ vssd1 vssd1 vccd1 vccd1 _02056_ sky130_fd_sc_hd__and2_1
X_06704_ _01074_ _01075_ _01015_ vssd1 vssd1 vccd1 vccd1 _01078_ sky130_fd_sc_hd__a21oi_2
X_09423_ _03905_ _03906_ vssd1 vssd1 vccd1 vccd1 _03907_ sky130_fd_sc_hd__and2b_1
X_06635_ net243 net252 net561 net572 vssd1 vssd1 vccd1 vccd1 _01009_ sky130_fd_sc_hd__and4_1
X_09354_ _03810_ _03811_ _03830_ _03831_ vssd1 vssd1 vccd1 vccd1 _03832_ sky130_fd_sc_hd__nor4_1
XFILLER_0_59_260 vssd1 vssd1 vccd1 vccd1 sky130_fd_sc_hd__decap_4
XFILLER_0_19_113 vssd1 vssd1 vccd1 vccd1 sky130_fd_sc_hd__decap_3
X_08305_ _02562_ _02564_ vssd1 vssd1 vccd1 vccd1 _02685_ sky130_fd_sc_hd__nand2_1
XFILLER_0_74_241 vssd1 vssd1 vccd1 vccd1 sky130_fd_sc_hd__decap_8
X_06566_ _00886_ _00939_ _00940_ vssd1 vssd1 vccd1 vccd1 _00941_ sky130_fd_sc_hd__nand3_4
X_09285_ _03753_ _03754_ net208 net449 vssd1 vssd1 vccd1 vccd1 _03756_ sky130_fd_sc_hd__and4bb_1
XFILLER_0_7_541 vssd1 vssd1 vccd1 vccd1 sky130_fd_sc_hd__fill_1
X_05517_ net311 net595 net605 net302 vssd1 vssd1 vccd1 vccd1 _04787_ sky130_fd_sc_hd__a22o_1
X_06497_ _00870_ _00871_ vssd1 vssd1 vccd1 vccd1 _00872_ sky130_fd_sc_hd__nand2_1
XFILLER_0_35_617 vssd1 vssd1 vccd1 vccd1 sky130_fd_sc_hd__fill_1
X_08236_ net194 net527 _02604_ _02606_ vssd1 vssd1 vccd1 vccd1 _02609_ sky130_fd_sc_hd__nand4_1
X_05448_ _04481_ _04514_ net104 _04717_ vssd1 vssd1 vccd1 vccd1 _04718_ sky130_fd_sc_hd__a211oi_4
X_08167_ _02394_ _02416_ _02537_ _02538_ vssd1 vssd1 vccd1 vccd1 _02539_ sky130_fd_sc_hd__a211oi_2
XFILLER_0_70_491 vssd1 vssd1 vccd1 vccd1 sky130_fd_sc_hd__fill_1
X_05379_ _04611_ _04638_ _04647_ _04648_ _04642_ vssd1 vssd1 vccd1 vccd1 _04649_ sky130_fd_sc_hd__o32a_1
X_07118_ _01240_ _01243_ _01487_ _01488_ vssd1 vssd1 vccd1 vccd1 _01489_ sky130_fd_sc_hd__a211oi_2
X_08098_ _02469_ vssd1 vssd1 vccd1 vccd1 _02470_ sky130_fd_sc_hd__inv_2
X_07049_ _01302_ _01309_ _01308_ vssd1 vssd1 vccd1 vccd1 _01420_ sky130_fd_sc_hd__a21o_1
X_10060_ net645 vssd1 vssd1 vccd1 vccd1 _00056_ sky130_fd_sc_hd__inv_2
XFILLER_0_97_300 vssd1 vssd1 vccd1 vccd1 sky130_fd_sc_hd__decap_8
XFILLER_0_85_517 vssd1 vssd1 vccd1 vccd1 sky130_fd_sc_hd__decap_3
XFILLER_0_57_208 vssd1 vssd1 vccd1 vccd1 sky130_fd_sc_hd__decap_8
XFILLER_0_25_116 vssd1 vssd1 vccd1 vccd1 sky130_ef_sc_hd__decap_12
XFILLER_0_38_477 vssd1 vssd1 vccd1 vccd1 sky130_fd_sc_hd__fill_1
XFILLER_0_21_355 vssd1 vssd1 vccd1 vccd1 sky130_ef_sc_hd__decap_12
XFILLER_0_33_193 vssd1 vssd1 vccd1 vccd1 sky130_fd_sc_hd__decap_3
XTAP_506 vssd1 vccd1 sky130_fd_sc_hd__tapvpwrvgnd_1
XTAP_517 vssd1 vccd1 sky130_fd_sc_hd__tapvpwrvgnd_1
XTAP_528 vssd1 vccd1 sky130_fd_sc_hd__tapvpwrvgnd_1
XTAP_539 vssd1 vccd1 sky130_fd_sc_hd__tapvpwrvgnd_1
X_06420_ net301 net522 vssd1 vssd1 vccd1 vccd1 _00796_ sky130_fd_sc_hd__and2_1
XFILLER_0_8_349 vssd1 vssd1 vccd1 vccd1 sky130_fd_sc_hd__fill_2
XFILLER_0_8_338 vssd1 vssd1 vccd1 vccd1 sky130_fd_sc_hd__fill_1
X_06351_ net211 net627 net635 net204 vssd1 vssd1 vccd1 vccd1 _00727_ sky130_fd_sc_hd__a22oi_1
XFILLER_0_29_477 vssd1 vssd1 vccd1 vccd1 sky130_fd_sc_hd__decap_4
X_09070_ _03521_ vssd1 vssd1 vccd1 vccd1 _03522_ sky130_fd_sc_hd__inv_2
XFILLER_0_56_285 vssd1 vssd1 vccd1 vccd1 sky130_fd_sc_hd__fill_2
XFILLER_0_16_116 vssd1 vssd1 vccd1 vccd1 sky130_fd_sc_hd__fill_2
X_06282_ net370 net469 _00543_ _00542_ net487 vssd1 vssd1 vccd1 vccd1 _00659_ sky130_fd_sc_hd__a32o_1
X_05302_ _04569_ _04570_ _04567_ vssd1 vssd1 vccd1 vccd1 _04572_ sky130_fd_sc_hd__a21bo_1
XFILLER_0_29_499 vssd1 vssd1 vccd1 vccd1 sky130_fd_sc_hd__decap_4
XFILLER_0_44_436 vssd1 vssd1 vccd1 vccd1 sky130_ef_sc_hd__decap_12
X_08021_ _02236_ net113 _02392_ _02393_ vssd1 vssd1 vccd1 vccd1 _02394_ sky130_fd_sc_hd__o211ai_4
X_05233_ _04077_ _04088_ vssd1 vssd1 vccd1 vccd1 _04099_ sky130_fd_sc_hd__or2_1
XFILLER_0_12_333 vssd1 vssd1 vccd1 vccd1 sky130_fd_sc_hd__decap_4
X_05164_ net369 net575 net585 net361 vssd1 vssd1 vccd1 vccd1 _03345_ sky130_fd_sc_hd__a22o_1
XFILLER_0_24_182 vssd1 vssd1 vccd1 vccd1 sky130_fd_sc_hd__decap_4
X_09972_ _04497_ _04506_ vssd1 vssd1 vccd1 vccd1 _04507_ sky130_fd_sc_hd__xnor2_1
X_05095_ val_y_reg.wb_helper.wbs_ack_o net4 net3 vssd1 vssd1 vccd1 vccd1 _02592_ sky130_fd_sc_hd__and3b_1
X_08923_ _02885_ _03360_ vssd1 vssd1 vccd1 vccd1 _03361_ sky130_fd_sc_hd__xor2_2
XFILLER_0_41_3 vssd1 vssd1 vccd1 vccd1 sky130_ef_sc_hd__decap_12
X_08854_ net260 net430 _03283_ _03284_ vssd1 vssd1 vccd1 vccd1 _03285_ sky130_fd_sc_hd__a22o_1
X_08785_ _03206_ _03209_ vssd1 vssd1 vccd1 vccd1 _03210_ sky130_fd_sc_hd__and2_1
X_07805_ net324 net439 _02038_ _02039_ net446 vssd1 vssd1 vccd1 vccd1 _02176_ sky130_fd_sc_hd__a32o_1
X_05997_ _00375_ _00376_ vssd1 vssd1 vccd1 vccd1 _00377_ sky130_fd_sc_hd__xnor2_2
X_07736_ _01942_ _01944_ _02105_ _02106_ vssd1 vssd1 vccd1 vccd1 _02108_ sky130_fd_sc_hd__a211oi_2
XFILLER_0_79_377 vssd1 vssd1 vccd1 vccd1 sky130_ef_sc_hd__decap_12
XFILLER_0_79_344 vssd1 vssd1 vccd1 vccd1 sky130_ef_sc_hd__decap_12
X_07667_ net308 net316 net452 vssd1 vssd1 vccd1 vccd1 _02039_ sky130_fd_sc_hd__and3_1
XFILLER_0_94_347 vssd1 vssd1 vccd1 vccd1 sky130_ef_sc_hd__decap_12
X_09406_ _03729_ _03743_ vssd1 vssd1 vccd1 vccd1 _03888_ sky130_fd_sc_hd__and2b_1
X_06618_ _00990_ _00991_ vssd1 vssd1 vccd1 vccd1 _00992_ sky130_fd_sc_hd__nand2_1
XFILLER_0_47_241 vssd1 vssd1 vccd1 vccd1 sky130_fd_sc_hd__decap_3
X_07598_ _01962_ _01968_ vssd1 vssd1 vccd1 vccd1 _01970_ sky130_fd_sc_hd__nor2_1
X_09337_ _03163_ _03630_ net137 net303 vssd1 vssd1 vccd1 vccd1 _03813_ sky130_fd_sc_hd__o2bb2a_1
XFILLER_0_75_561 vssd1 vssd1 vccd1 vccd1 sky130_fd_sc_hd__decap_4
X_06549_ _00921_ _00922_ _00923_ vssd1 vssd1 vccd1 vccd1 _00924_ sky130_fd_sc_hd__nand3_1
XFILLER_0_90_542 vssd1 vssd1 vccd1 vccd1 sky130_ef_sc_hd__decap_12
XFILLER_0_90_520 vssd1 vssd1 vccd1 vccd1 sky130_fd_sc_hd__decap_4
X_09268_ net185 net471 _03733_ _03734_ vssd1 vssd1 vccd1 vccd1 _03737_ sky130_fd_sc_hd__and4_1
XFILLER_0_35_436 vssd1 vssd1 vccd1 vccd1 sky130_fd_sc_hd__fill_2
X_08219_ _02442_ _02589_ _02591_ vssd1 vssd1 vccd1 vccd1 _02593_ sky130_fd_sc_hd__or3_4
XFILLER_0_7_371 vssd1 vssd1 vccd1 vccd1 sky130_fd_sc_hd__decap_8
X_09199_ _03626_ _03627_ _03659_ _03660_ vssd1 vssd1 vccd1 vccd1 _03663_ sky130_fd_sc_hd__or4_1
XFILLER_0_30_141 vssd1 vssd1 vccd1 vccd1 sky130_fd_sc_hd__fill_1
X_10112_ clknet_3_0_0_wb_clk_i _00106_ _00042_ vssd1 vssd1 vccd1 vccd1 mul.a\[7\]
+ sky130_fd_sc_hd__dfrtp_2
X_10043_ net641 vssd1 vssd1 vccd1 vccd1 _00039_ sky130_fd_sc_hd__inv_2
XFILLER_0_85_325 vssd1 vssd1 vccd1 vccd1 sky130_fd_sc_hd__fill_1
XFILLER_0_26_447 vssd1 vssd1 vccd1 vccd1 sky130_fd_sc_hd__fill_2
XFILLER_0_26_458 vssd1 vssd1 vccd1 vccd1 sky130_fd_sc_hd__decap_8
XFILLER_0_81_586 vssd1 vssd1 vccd1 vccd1 sky130_fd_sc_hd__decap_3
XFILLER_0_53_288 vssd1 vssd1 vccd1 vccd1 sky130_fd_sc_hd__decap_4
XANTENNA_4 mul.b\[4\] vssd1 vssd1 vccd1 vccd1 sky130_fd_sc_hd__diode_2
XFILLER_0_67_57 vssd1 vssd1 vccd1 vccd1 sky130_fd_sc_hd__decap_4
XTAP_314 vssd1 vccd1 sky130_fd_sc_hd__tapvpwrvgnd_1
XTAP_303 vssd1 vccd1 sky130_fd_sc_hd__tapvpwrvgnd_1
XTAP_347 vssd1 vccd1 sky130_fd_sc_hd__tapvpwrvgnd_1
XTAP_336 vssd1 vccd1 sky130_fd_sc_hd__tapvpwrvgnd_1
XTAP_325 vssd1 vccd1 sky130_fd_sc_hd__tapvpwrvgnd_1
XTAP_358 vssd1 vccd1 sky130_fd_sc_hd__tapvpwrvgnd_1
X_05920_ _00298_ _00299_ vssd1 vssd1 vccd1 vccd1 _00300_ sky130_fd_sc_hd__or2_1
XTAP_369 vssd1 vccd1 sky130_fd_sc_hd__tapvpwrvgnd_1
X_05851_ _00226_ _00230_ vssd1 vssd1 vccd1 vccd1 _00232_ sky130_fd_sc_hd__or2_1
X_08570_ _02791_ _02799_ _02797_ vssd1 vssd1 vccd1 vccd1 _02975_ sky130_fd_sc_hd__a21o_1
Xrebuffer16 _01762_ vssd1 vssd1 vccd1 vccd1 net661 sky130_fd_sc_hd__buf_1
Xrebuffer27 _00947_ vssd1 vssd1 vccd1 vccd1 net672 sky130_fd_sc_hd__clkbuf_1
XFILLER_0_88_141 vssd1 vssd1 vccd1 vccd1 sky130_ef_sc_hd__decap_12
X_07521_ net270 net278 net482 net491 vssd1 vssd1 vccd1 vccd1 _01894_ sky130_fd_sc_hd__nand4_2
Xrebuffer49 net521 vssd1 vssd1 vccd1 vccd1 net694 sky130_fd_sc_hd__dlygate4sd1_1
X_05782_ _00160_ _00162_ vssd1 vssd1 vccd1 vccd1 _00164_ sky130_fd_sc_hd__xnor2_1
Xrebuffer38 _00355_ vssd1 vssd1 vccd1 vccd1 net683 sky130_fd_sc_hd__clkbuf_1
XFILLER_0_88_185 vssd1 vssd1 vccd1 vccd1 sky130_fd_sc_hd__decap_6
XFILLER_0_88_174 vssd1 vssd1 vccd1 vccd1 sky130_fd_sc_hd__fill_1
XFILLER_0_76_369 vssd1 vssd1 vccd1 vccd1 sky130_ef_sc_hd__decap_12
X_07452_ _01818_ _01819_ vssd1 vssd1 vccd1 vccd1 _01820_ sky130_fd_sc_hd__nand2b_1
XFILLER_0_91_317 vssd1 vssd1 vccd1 vccd1 sky130_ef_sc_hd__decap_12
X_07383_ net231 net534 net547 net224 vssd1 vssd1 vccd1 vccd1 _01752_ sky130_fd_sc_hd__a22o_1
X_06403_ _00654_ _00777_ vssd1 vssd1 vccd1 vccd1 _00779_ sky130_fd_sc_hd__xnor2_2
X_09122_ _03570_ _03571_ _03577_ vssd1 vssd1 vccd1 vccd1 _03578_ sky130_fd_sc_hd__nand3_1
XFILLER_0_8_146 vssd1 vssd1 vccd1 vccd1 sky130_fd_sc_hd__decap_4
X_06334_ _00708_ _00709_ _00516_ _00519_ vssd1 vssd1 vccd1 vccd1 _00711_ sky130_fd_sc_hd__o211ai_1
X_09053_ _03308_ _03348_ _03501_ vssd1 vssd1 vccd1 vccd1 _03503_ sky130_fd_sc_hd__nor3_1
XFILLER_0_89_3 vssd1 vssd1 vccd1 vccd1 sky130_fd_sc_hd__fill_2
X_06265_ _00500_ _00522_ _00640_ vssd1 vssd1 vccd1 vccd1 _00642_ sky130_fd_sc_hd__and3_1
X_08004_ _02369_ _02370_ _02375_ vssd1 vssd1 vccd1 vccd1 _02377_ sky130_fd_sc_hd__a21o_1
X_05216_ _03542_ _03760_ _03891_ vssd1 vssd1 vccd1 vccd1 _03913_ sky130_fd_sc_hd__a21o_1
X_06196_ _00538_ net708 _00572_ vssd1 vssd1 vccd1 vccd1 _00574_ sky130_fd_sc_hd__nand3_1
XFILLER_0_12_163 vssd1 vssd1 vccd1 vccd1 sky130_fd_sc_hd__decap_3
XFILLER_0_12_141 vssd1 vssd1 vccd1 vccd1 sky130_fd_sc_hd__decap_4
XFILLER_0_4_396 vssd1 vssd1 vccd1 vccd1 sky130_fd_sc_hd__decap_8
X_05147_ _03017_ _03137_ _03148_ vssd1 vssd1 vccd1 vccd1 _03159_ sky130_fd_sc_hd__and3_1
X_09955_ _04482_ _04487_ vssd1 vssd1 vccd1 vccd1 _04488_ sky130_fd_sc_hd__xnor2_1
X_05078_ net9 net521 net124 vssd1 vssd1 vccd1 vccd1 _00080_ sky130_fd_sc_hd__mux2_1
X_08906_ _03338_ _03340_ _03326_ vssd1 vssd1 vccd1 vccd1 _03342_ sky130_fd_sc_hd__o21ai_1
X_09886_ _04410_ _04412_ vssd1 vssd1 vccd1 vccd1 _04413_ sky130_fd_sc_hd__xnor2_1
XTAP_870 vssd1 vccd1 sky130_fd_sc_hd__tapvpwrvgnd_1
X_08837_ net193 net499 _03102_ _03103_ net515 vssd1 vssd1 vccd1 vccd1 _03266_ sky130_fd_sc_hd__a32o_1
XTAP_892 vssd1 vccd1 sky130_fd_sc_hd__tapvpwrvgnd_1
XTAP_881 vssd1 vccd1 sky130_fd_sc_hd__tapvpwrvgnd_1
X_08768_ _02990_ _02992_ _03189_ _03190_ vssd1 vssd1 vccd1 vccd1 _03191_ sky130_fd_sc_hd__o211a_1
XFILLER_0_95_623 vssd1 vssd1 vccd1 vccd1 sky130_fd_sc_hd__fill_2
XFILLER_0_94_111 vssd1 vssd1 vccd1 vccd1 sky130_fd_sc_hd__decap_4
XFILLER_0_94_100 vssd1 vssd1 vccd1 vccd1 sky130_fd_sc_hd__decap_4
X_08699_ net207 net480 net489 net201 vssd1 vssd1 vccd1 vccd1 _03116_ sky130_fd_sc_hd__a22o_1
X_07719_ net675 _01926_ _02089_ _02090_ vssd1 vssd1 vccd1 vccd1 _02091_ sky130_fd_sc_hd__a211o_4
XFILLER_0_94_122 vssd1 vssd1 vccd1 vccd1 sky130_ef_sc_hd__decap_12
XFILLER_0_48_594 vssd1 vssd1 vccd1 vccd1 sky130_fd_sc_hd__fill_2
XFILLER_0_63_542 vssd1 vssd1 vccd1 vccd1 sky130_fd_sc_hd__fill_1
XFILLER_0_23_417 vssd1 vssd1 vccd1 vccd1 sky130_fd_sc_hd__fill_2
Xoutput52 net52 vssd1 vssd1 vccd1 vccd1 wbs_dat_o[20] sky130_fd_sc_hd__clkbuf_4
Xoutput41 net41 vssd1 vssd1 vccd1 vccd1 wbs_dat_o[10] sky130_fd_sc_hd__clkbuf_4
Xoutput63 net63 vssd1 vssd1 vccd1 vccd1 wbs_dat_o[30] sky130_fd_sc_hd__buf_6
XFILLER_0_101_393 vssd1 vssd1 vccd1 vccd1 sky130_ef_sc_hd__decap_12
XFILLER_0_37_27 vssd1 vssd1 vccd1 vccd1 sky130_fd_sc_hd__decap_3
X_10026_ net642 vssd1 vssd1 vccd1 vccd1 _00022_ sky130_fd_sc_hd__inv_2
XFILLER_0_53_26 vssd1 vssd1 vccd1 vccd1 sky130_ef_sc_hd__decap_12
XFILLER_0_98_483 vssd1 vssd1 vccd1 vccd1 sky130_fd_sc_hd__decap_8
XFILLER_0_58_314 vssd1 vssd1 vccd1 vccd1 sky130_fd_sc_hd__decap_6
XFILLER_0_85_111 vssd1 vssd1 vccd1 vccd1 sky130_fd_sc_hd__fill_1
XFILLER_0_39_561 vssd1 vssd1 vccd1 vccd1 sky130_fd_sc_hd__decap_4
XFILLER_0_85_188 vssd1 vssd1 vccd1 vccd1 sky130_fd_sc_hd__fill_1
XFILLER_0_54_531 vssd1 vssd1 vccd1 vccd1 sky130_fd_sc_hd__fill_1
XPHY_191 vssd1 vssd1 vccd1 vccd1 sky130_fd_sc_hd__decap_3
XPHY_180 vssd1 vssd1 vccd1 vccd1 sky130_fd_sc_hd__decap_3
XFILLER_0_54_575 vssd1 vssd1 vccd1 vccd1 sky130_fd_sc_hd__decap_8
XFILLER_0_14_428 vssd1 vssd1 vccd1 vccd1 sky130_fd_sc_hd__fill_1
XFILLER_0_26_288 vssd1 vssd1 vccd1 vccd1 sky130_fd_sc_hd__decap_4
XFILLER_0_78_12 vssd1 vssd1 vccd1 vccd1 sky130_ef_sc_hd__decap_12
X_06050_ net371 net478 net487 net364 vssd1 vssd1 vccd1 vccd1 _00429_ sky130_fd_sc_hd__a22o_1
XFILLER_0_41_225 vssd1 vssd1 vccd1 vccd1 sky130_ef_sc_hd__decap_12
XFILLER_0_10_601 vssd1 vssd1 vccd1 vccd1 sky130_fd_sc_hd__fill_1
XFILLER_0_78_89 vssd1 vssd1 vccd1 vccd1 sky130_fd_sc_hd__fill_1
XFILLER_0_10_623 vssd1 vssd1 vccd1 vccd1 sky130_fd_sc_hd__fill_2
XFILLER_0_22_494 vssd1 vssd1 vccd1 vccd1 sky130_fd_sc_hd__fill_1
XFILLER_0_94_11 vssd1 vssd1 vccd1 vccd1 sky130_fd_sc_hd__fill_2
Xfanout308 net309 vssd1 vssd1 vccd1 vccd1 net308 sky130_fd_sc_hd__clkbuf_4
Xfanout319 net320 vssd1 vssd1 vccd1 vccd1 net319 sky130_fd_sc_hd__clkbuf_4
X_09740_ _04097_ _04100_ _04253_ vssd1 vssd1 vccd1 vccd1 _04254_ sky130_fd_sc_hd__a21oi_1
X_06952_ _01320_ _01321_ _01322_ vssd1 vssd1 vccd1 vccd1 _01324_ sky130_fd_sc_hd__a21o_1
.ends
