* NGSPICE file created from spi_block_m.ext - technology: sky130A

* Black-box entry subcircuit for sky130_fd_sc_hd__dfrtp_1 abstract view
.subckt sky130_fd_sc_hd__dfrtp_1 CLK D RESET_B VGND VNB VPB VPWR Q
.ends

* Black-box entry subcircuit for sky130_fd_sc_hd__tapvpwrvgnd_1 abstract view
.subckt sky130_fd_sc_hd__tapvpwrvgnd_1 VGND VPWR
.ends

* Black-box entry subcircuit for sky130_ef_sc_hd__decap_12 abstract view
.subckt sky130_ef_sc_hd__decap_12 VGND VNB VPB VPWR
.ends

* Black-box entry subcircuit for sky130_fd_sc_hd__fill_1 abstract view
.subckt sky130_fd_sc_hd__fill_1 VGND VNB VPB VPWR
.ends

* Black-box entry subcircuit for sky130_fd_sc_hd__decap_6 abstract view
.subckt sky130_fd_sc_hd__decap_6 VGND VNB VPB VPWR
.ends

* Black-box entry subcircuit for sky130_fd_sc_hd__a211o_1 abstract view
.subckt sky130_fd_sc_hd__a211o_1 A1 A2 B1 C1 VGND VNB VPB VPWR X
.ends

* Black-box entry subcircuit for sky130_fd_sc_hd__decap_4 abstract view
.subckt sky130_fd_sc_hd__decap_4 VGND VNB VPB VPWR
.ends

* Black-box entry subcircuit for sky130_fd_sc_hd__o211a_1 abstract view
.subckt sky130_fd_sc_hd__o211a_1 A1 A2 B1 C1 VGND VNB VPB VPWR X
.ends

* Black-box entry subcircuit for sky130_fd_sc_hd__decap_3 abstract view
.subckt sky130_fd_sc_hd__decap_3 VGND VNB VPB VPWR
.ends

* Black-box entry subcircuit for sky130_fd_sc_hd__mux2_1 abstract view
.subckt sky130_fd_sc_hd__mux2_1 A0 A1 S VGND VNB VPB VPWR X
.ends

* Black-box entry subcircuit for sky130_fd_sc_hd__nand2_1 abstract view
.subckt sky130_fd_sc_hd__nand2_1 A B VGND VNB VPB VPWR Y
.ends

* Black-box entry subcircuit for sky130_fd_sc_hd__dlygate4sd3_1 abstract view
.subckt sky130_fd_sc_hd__dlygate4sd3_1 A VGND VNB VPB VPWR X
.ends

* Black-box entry subcircuit for sky130_fd_sc_hd__fill_2 abstract view
.subckt sky130_fd_sc_hd__fill_2 VGND VNB VPB VPWR
.ends

* Black-box entry subcircuit for sky130_fd_sc_hd__decap_8 abstract view
.subckt sky130_fd_sc_hd__decap_8 VGND VNB VPB VPWR
.ends

* Black-box entry subcircuit for sky130_fd_sc_hd__a22o_1 abstract view
.subckt sky130_fd_sc_hd__a22o_1 A1 A2 B1 B2 VGND VNB VPB VPWR X
.ends

* Black-box entry subcircuit for sky130_fd_sc_hd__a221o_1 abstract view
.subckt sky130_fd_sc_hd__a221o_1 A1 A2 B1 B2 C1 VGND VNB VPB VPWR X
.ends

* Black-box entry subcircuit for sky130_fd_sc_hd__clkbuf_4 abstract view
.subckt sky130_fd_sc_hd__clkbuf_4 A VGND VNB VPB VPWR X
.ends

* Black-box entry subcircuit for sky130_fd_sc_hd__clkbuf_2 abstract view
.subckt sky130_fd_sc_hd__clkbuf_2 A VGND VNB VPB VPWR X
.ends

* Black-box entry subcircuit for sky130_fd_sc_hd__o21ai_2 abstract view
.subckt sky130_fd_sc_hd__o21ai_2 A1 A2 B1 VGND VNB VPB VPWR Y
.ends

* Black-box entry subcircuit for sky130_fd_sc_hd__o21ai_1 abstract view
.subckt sky130_fd_sc_hd__o21ai_1 A1 A2 B1 VGND VNB VPB VPWR Y
.ends

* Black-box entry subcircuit for sky130_fd_sc_hd__dfrtp_2 abstract view
.subckt sky130_fd_sc_hd__dfrtp_2 CLK D RESET_B VGND VNB VPB VPWR Q
.ends

* Black-box entry subcircuit for sky130_fd_sc_hd__or2_2 abstract view
.subckt sky130_fd_sc_hd__or2_2 A B VGND VNB VPB VPWR X
.ends

* Black-box entry subcircuit for sky130_fd_sc_hd__a21o_1 abstract view
.subckt sky130_fd_sc_hd__a21o_1 A1 A2 B1 VGND VNB VPB VPWR X
.ends

* Black-box entry subcircuit for sky130_fd_sc_hd__clkbuf_1 abstract view
.subckt sky130_fd_sc_hd__clkbuf_1 A VGND VNB VPB VPWR X
.ends

* Black-box entry subcircuit for sky130_fd_sc_hd__diode_2 abstract view
.subckt sky130_fd_sc_hd__diode_2 DIODE VGND VNB VPB VPWR
.ends

* Black-box entry subcircuit for sky130_fd_sc_hd__inv_2 abstract view
.subckt sky130_fd_sc_hd__inv_2 A VGND VNB VPB VPWR Y
.ends

* Black-box entry subcircuit for sky130_fd_sc_hd__a211o_2 abstract view
.subckt sky130_fd_sc_hd__a211o_2 A1 A2 B1 C1 VGND VNB VPB VPWR X
.ends

* Black-box entry subcircuit for sky130_fd_sc_hd__dlymetal6s2s_1 abstract view
.subckt sky130_fd_sc_hd__dlymetal6s2s_1 A VGND VNB VPB VPWR X
.ends

* Black-box entry subcircuit for sky130_fd_sc_hd__buf_1 abstract view
.subckt sky130_fd_sc_hd__buf_1 A VGND VNB VPB VPWR X
.ends

* Black-box entry subcircuit for sky130_fd_sc_hd__nor2_2 abstract view
.subckt sky130_fd_sc_hd__nor2_2 A B VGND VNB VPB VPWR Y
.ends

* Black-box entry subcircuit for sky130_fd_sc_hd__or2_1 abstract view
.subckt sky130_fd_sc_hd__or2_1 A B VGND VNB VPB VPWR X
.ends

* Black-box entry subcircuit for sky130_fd_sc_hd__o2bb2a_1 abstract view
.subckt sky130_fd_sc_hd__o2bb2a_1 A1_N A2_N B1 B2 VGND VNB VPB VPWR X
.ends

* Black-box entry subcircuit for sky130_fd_sc_hd__buf_2 abstract view
.subckt sky130_fd_sc_hd__buf_2 A VGND VNB VPB VPWR X
.ends

* Black-box entry subcircuit for sky130_fd_sc_hd__buf_4 abstract view
.subckt sky130_fd_sc_hd__buf_4 A VGND VNB VPB VPWR X
.ends

* Black-box entry subcircuit for sky130_fd_sc_hd__and2_2 abstract view
.subckt sky130_fd_sc_hd__and2_2 A B VGND VNB VPB VPWR X
.ends

* Black-box entry subcircuit for sky130_fd_sc_hd__and3_1 abstract view
.subckt sky130_fd_sc_hd__and3_1 A B C VGND VNB VPB VPWR X
.ends

* Black-box entry subcircuit for sky130_fd_sc_hd__a22oi_4 abstract view
.subckt sky130_fd_sc_hd__a22oi_4 A1 A2 B1 B2 VGND VNB VPB VPWR Y
.ends

* Black-box entry subcircuit for sky130_fd_sc_hd__a21oi_2 abstract view
.subckt sky130_fd_sc_hd__a21oi_2 A1 A2 B1 VGND VNB VPB VPWR Y
.ends

* Black-box entry subcircuit for sky130_fd_sc_hd__and2b_2 abstract view
.subckt sky130_fd_sc_hd__and2b_2 A_N B VGND VNB VPB VPWR X
.ends

* Black-box entry subcircuit for sky130_fd_sc_hd__nand2_2 abstract view
.subckt sky130_fd_sc_hd__nand2_2 A B VGND VNB VPB VPWR Y
.ends

* Black-box entry subcircuit for sky130_fd_sc_hd__a21oi_1 abstract view
.subckt sky130_fd_sc_hd__a21oi_1 A1 A2 B1 VGND VNB VPB VPWR Y
.ends

* Black-box entry subcircuit for sky130_fd_sc_hd__xnor2_1 abstract view
.subckt sky130_fd_sc_hd__xnor2_1 A B VGND VNB VPB VPWR Y
.ends

* Black-box entry subcircuit for sky130_fd_sc_hd__a21boi_1 abstract view
.subckt sky130_fd_sc_hd__a21boi_1 A1 A2 B1_N VGND VNB VPB VPWR Y
.ends

* Black-box entry subcircuit for sky130_fd_sc_hd__nor2_1 abstract view
.subckt sky130_fd_sc_hd__nor2_1 A B VGND VNB VPB VPWR Y
.ends

* Black-box entry subcircuit for sky130_fd_sc_hd__or4_4 abstract view
.subckt sky130_fd_sc_hd__or4_4 A B C D VGND VNB VPB VPWR X
.ends

* Black-box entry subcircuit for sky130_fd_sc_hd__o21a_1 abstract view
.subckt sky130_fd_sc_hd__o21a_1 A1 A2 B1 VGND VNB VPB VPWR X
.ends

* Black-box entry subcircuit for sky130_fd_sc_hd__o21ai_4 abstract view
.subckt sky130_fd_sc_hd__o21ai_4 A1 A2 B1 VGND VNB VPB VPWR Y
.ends

* Black-box entry subcircuit for sky130_fd_sc_hd__a31oi_1 abstract view
.subckt sky130_fd_sc_hd__a31oi_1 A1 A2 A3 B1 VGND VNB VPB VPWR Y
.ends

* Black-box entry subcircuit for sky130_fd_sc_hd__clkbuf_16 abstract view
.subckt sky130_fd_sc_hd__clkbuf_16 A VGND VNB VPB VPWR X
.ends

* Black-box entry subcircuit for sky130_fd_sc_hd__dfstp_2 abstract view
.subckt sky130_fd_sc_hd__dfstp_2 CLK D SET_B VGND VNB VPB VPWR Q
.ends

* Black-box entry subcircuit for sky130_fd_sc_hd__and2_4 abstract view
.subckt sky130_fd_sc_hd__and2_4 A B VGND VNB VPB VPWR X
.ends

* Black-box entry subcircuit for sky130_fd_sc_hd__a2111o_2 abstract view
.subckt sky130_fd_sc_hd__a2111o_2 A1 A2 B1 C1 D1 VGND VNB VPB VPWR X
.ends

* Black-box entry subcircuit for sky130_fd_sc_hd__nand3_1 abstract view
.subckt sky130_fd_sc_hd__nand3_1 A B C VGND VNB VPB VPWR Y
.ends

* Black-box entry subcircuit for sky130_fd_sc_hd__a21bo_1 abstract view
.subckt sky130_fd_sc_hd__a21bo_1 A1 A2 B1_N VGND VNB VPB VPWR X
.ends

* Black-box entry subcircuit for sky130_fd_sc_hd__nor3_1 abstract view
.subckt sky130_fd_sc_hd__nor3_1 A B C VGND VNB VPB VPWR Y
.ends

* Black-box entry subcircuit for sky130_fd_sc_hd__or4_1 abstract view
.subckt sky130_fd_sc_hd__or4_1 A B C D VGND VNB VPB VPWR X
.ends

* Black-box entry subcircuit for sky130_fd_sc_hd__and3b_2 abstract view
.subckt sky130_fd_sc_hd__and3b_2 A_N B C VGND VNB VPB VPWR X
.ends

* Black-box entry subcircuit for sky130_fd_sc_hd__o21ba_1 abstract view
.subckt sky130_fd_sc_hd__o21ba_1 A1 A2 B1_N VGND VNB VPB VPWR X
.ends

* Black-box entry subcircuit for sky130_fd_sc_hd__nor4_1 abstract view
.subckt sky130_fd_sc_hd__nor4_1 A B C D VGND VNB VPB VPWR Y
.ends

* Black-box entry subcircuit for sky130_fd_sc_hd__a31o_1 abstract view
.subckt sky130_fd_sc_hd__a31o_1 A1 A2 A3 B1 VGND VNB VPB VPWR X
.ends

* Black-box entry subcircuit for sky130_fd_sc_hd__or3_2 abstract view
.subckt sky130_fd_sc_hd__or3_2 A B C VGND VNB VPB VPWR X
.ends

* Black-box entry subcircuit for sky130_fd_sc_hd__o31a_1 abstract view
.subckt sky130_fd_sc_hd__o31a_1 A1 A2 A3 B1 VGND VNB VPB VPWR X
.ends

* Black-box entry subcircuit for sky130_fd_sc_hd__a2111oi_2 abstract view
.subckt sky130_fd_sc_hd__a2111oi_2 A1 A2 B1 C1 D1 VGND VNB VPB VPWR Y
.ends

* Black-box entry subcircuit for sky130_fd_sc_hd__nor3b_1 abstract view
.subckt sky130_fd_sc_hd__nor3b_1 A B C_N VGND VNB VPB VPWR Y
.ends

* Black-box entry subcircuit for sky130_fd_sc_hd__a2bb2o_1 abstract view
.subckt sky130_fd_sc_hd__a2bb2o_1 A1_N A2_N B1 B2 VGND VNB VPB VPWR X
.ends

* Black-box entry subcircuit for sky130_fd_sc_hd__nand2b_1 abstract view
.subckt sky130_fd_sc_hd__nand2b_1 A_N B VGND VNB VPB VPWR Y
.ends

* Black-box entry subcircuit for sky130_fd_sc_hd__a32o_1 abstract view
.subckt sky130_fd_sc_hd__a32o_1 A1 A2 A3 B1 B2 VGND VNB VPB VPWR X
.ends

* Black-box entry subcircuit for sky130_fd_sc_hd__or3_1 abstract view
.subckt sky130_fd_sc_hd__or3_1 A B C VGND VNB VPB VPWR X
.ends

* Black-box entry subcircuit for sky130_fd_sc_hd__xor2_1 abstract view
.subckt sky130_fd_sc_hd__xor2_1 A B VGND VNB VPB VPWR X
.ends

* Black-box entry subcircuit for sky130_fd_sc_hd__o41a_4 abstract view
.subckt sky130_fd_sc_hd__o41a_4 A1 A2 A3 A4 B1 VGND VNB VPB VPWR X
.ends

* Black-box entry subcircuit for sky130_fd_sc_hd__o22a_1 abstract view
.subckt sky130_fd_sc_hd__o22a_1 A1 A2 B1 B2 VGND VNB VPB VPWR X
.ends

* Black-box entry subcircuit for sky130_fd_sc_hd__o2111a_2 abstract view
.subckt sky130_fd_sc_hd__o2111a_2 A1 A2 B1 C1 D1 VGND VNB VPB VPWR X
.ends

* Black-box entry subcircuit for sky130_fd_sc_hd__o2111a_1 abstract view
.subckt sky130_fd_sc_hd__o2111a_1 A1 A2 B1 C1 D1 VGND VNB VPB VPWR X
.ends

* Black-box entry subcircuit for sky130_fd_sc_hd__and2_1 abstract view
.subckt sky130_fd_sc_hd__and2_1 A B VGND VNB VPB VPWR X
.ends

* Black-box entry subcircuit for sky130_fd_sc_hd__and2b_1 abstract view
.subckt sky130_fd_sc_hd__and2b_1 A_N B VGND VNB VPB VPWR X
.ends

* Black-box entry subcircuit for sky130_fd_sc_hd__or3b_1 abstract view
.subckt sky130_fd_sc_hd__or3b_1 A B C_N VGND VNB VPB VPWR X
.ends

* Black-box entry subcircuit for sky130_fd_sc_hd__nor3_4 abstract view
.subckt sky130_fd_sc_hd__nor3_4 A B C VGND VNB VPB VPWR Y
.ends

* Black-box entry subcircuit for sky130_fd_sc_hd__nor2_4 abstract view
.subckt sky130_fd_sc_hd__nor2_4 A B VGND VNB VPB VPWR Y
.ends

* Black-box entry subcircuit for sky130_fd_sc_hd__o31a_2 abstract view
.subckt sky130_fd_sc_hd__o31a_2 A1 A2 A3 B1 VGND VNB VPB VPWR X
.ends

* Black-box entry subcircuit for sky130_fd_sc_hd__o22a_4 abstract view
.subckt sky130_fd_sc_hd__o22a_4 A1 A2 B1 B2 VGND VNB VPB VPWR X
.ends

* Black-box entry subcircuit for sky130_fd_sc_hd__a31o_2 abstract view
.subckt sky130_fd_sc_hd__a31o_2 A1 A2 A3 B1 VGND VNB VPB VPWR X
.ends

* Black-box entry subcircuit for sky130_fd_sc_hd__a31oi_4 abstract view
.subckt sky130_fd_sc_hd__a31oi_4 A1 A2 A3 B1 VGND VNB VPB VPWR Y
.ends

* Black-box entry subcircuit for sky130_fd_sc_hd__nand2_4 abstract view
.subckt sky130_fd_sc_hd__nand2_4 A B VGND VNB VPB VPWR Y
.ends

* Black-box entry subcircuit for sky130_fd_sc_hd__mux4_1 abstract view
.subckt sky130_fd_sc_hd__mux4_1 A0 A1 A2 A3 S0 S1 VGND VNB VPB VPWR X
.ends

* Black-box entry subcircuit for sky130_fd_sc_hd__nand2b_2 abstract view
.subckt sky130_fd_sc_hd__nand2b_2 A_N B VGND VNB VPB VPWR Y
.ends

* Black-box entry subcircuit for sky130_fd_sc_hd__or2_4 abstract view
.subckt sky130_fd_sc_hd__or2_4 A B VGND VNB VPB VPWR X
.ends

* Black-box entry subcircuit for sky130_fd_sc_hd__a311o_1 abstract view
.subckt sky130_fd_sc_hd__a311o_1 A1 A2 A3 B1 C1 VGND VNB VPB VPWR X
.ends

* Black-box entry subcircuit for sky130_fd_sc_hd__or3b_4 abstract view
.subckt sky130_fd_sc_hd__or3b_4 A B C_N VGND VNB VPB VPWR X
.ends

* Black-box entry subcircuit for sky130_fd_sc_hd__nor3b_2 abstract view
.subckt sky130_fd_sc_hd__nor3b_2 A B C_N VGND VNB VPB VPWR Y
.ends

* Black-box entry subcircuit for sky130_fd_sc_hd__mux4_2 abstract view
.subckt sky130_fd_sc_hd__mux4_2 A0 A1 A2 A3 S0 S1 VGND VNB VPB VPWR X
.ends

* Black-box entry subcircuit for sky130_fd_sc_hd__a2111o_1 abstract view
.subckt sky130_fd_sc_hd__a2111o_1 A1 A2 B1 C1 D1 VGND VNB VPB VPWR X
.ends

* Black-box entry subcircuit for sky130_fd_sc_hd__and3_2 abstract view
.subckt sky130_fd_sc_hd__and3_2 A B C VGND VNB VPB VPWR X
.ends

* Black-box entry subcircuit for sky130_fd_sc_hd__a21oi_4 abstract view
.subckt sky130_fd_sc_hd__a21oi_4 A1 A2 B1 VGND VNB VPB VPWR Y
.ends

* Black-box entry subcircuit for sky130_fd_sc_hd__o2111ai_4 abstract view
.subckt sky130_fd_sc_hd__o2111ai_4 A1 A2 B1 C1 D1 VGND VNB VPB VPWR Y
.ends

* Black-box entry subcircuit for sky130_fd_sc_hd__dfrtp_4 abstract view
.subckt sky130_fd_sc_hd__dfrtp_4 CLK D RESET_B VGND VNB VPB VPWR Q
.ends

* Black-box entry subcircuit for sky130_fd_sc_hd__or4_2 abstract view
.subckt sky130_fd_sc_hd__or4_2 A B C D VGND VNB VPB VPWR X
.ends

* Black-box entry subcircuit for sky130_fd_sc_hd__a21o_2 abstract view
.subckt sky130_fd_sc_hd__a21o_2 A1 A2 B1 VGND VNB VPB VPWR X
.ends

* Black-box entry subcircuit for sky130_fd_sc_hd__a41o_1 abstract view
.subckt sky130_fd_sc_hd__a41o_1 A1 A2 A3 A4 B1 VGND VNB VPB VPWR X
.ends

* Black-box entry subcircuit for sky130_fd_sc_hd__and4b_1 abstract view
.subckt sky130_fd_sc_hd__and4b_1 A_N B C D VGND VNB VPB VPWR X
.ends

* Black-box entry subcircuit for sky130_fd_sc_hd__o21bai_4 abstract view
.subckt sky130_fd_sc_hd__o21bai_4 A1 A2 B1_N VGND VNB VPB VPWR Y
.ends

* Black-box entry subcircuit for sky130_fd_sc_hd__or3b_2 abstract view
.subckt sky130_fd_sc_hd__or3b_2 A B C_N VGND VNB VPB VPWR X
.ends

* Black-box entry subcircuit for sky130_fd_sc_hd__dfstp_1 abstract view
.subckt sky130_fd_sc_hd__dfstp_1 CLK D SET_B VGND VNB VPB VPWR Q
.ends

* Black-box entry subcircuit for sky130_fd_sc_hd__o41a_1 abstract view
.subckt sky130_fd_sc_hd__o41a_1 A1 A2 A3 A4 B1 VGND VNB VPB VPWR X
.ends

* Black-box entry subcircuit for sky130_fd_sc_hd__and4_1 abstract view
.subckt sky130_fd_sc_hd__and4_1 A B C D VGND VNB VPB VPWR X
.ends

* Black-box entry subcircuit for sky130_fd_sc_hd__or4b_1 abstract view
.subckt sky130_fd_sc_hd__or4b_1 A B C D_N VGND VNB VPB VPWR X
.ends

* Black-box entry subcircuit for sky130_fd_sc_hd__dfstp_4 abstract view
.subckt sky130_fd_sc_hd__dfstp_4 CLK D SET_B VGND VNB VPB VPWR Q
.ends

* Black-box entry subcircuit for sky130_fd_sc_hd__o31ai_1 abstract view
.subckt sky130_fd_sc_hd__o31ai_1 A1 A2 A3 B1 VGND VNB VPB VPWR Y
.ends

* Black-box entry subcircuit for sky130_fd_sc_hd__and3b_1 abstract view
.subckt sky130_fd_sc_hd__and3b_1 A_N B C VGND VNB VPB VPWR X
.ends

* Black-box entry subcircuit for sky130_fd_sc_hd__o21a_2 abstract view
.subckt sky130_fd_sc_hd__o21a_2 A1 A2 B1 VGND VNB VPB VPWR X
.ends

* Black-box entry subcircuit for sky130_fd_sc_hd__o21bai_2 abstract view
.subckt sky130_fd_sc_hd__o21bai_2 A1 A2 B1_N VGND VNB VPB VPWR Y
.ends

* Black-box entry subcircuit for sky130_fd_sc_hd__a221o_4 abstract view
.subckt sky130_fd_sc_hd__a221o_4 A1 A2 B1 B2 C1 VGND VNB VPB VPWR X
.ends

* Black-box entry subcircuit for sky130_fd_sc_hd__mux2_2 abstract view
.subckt sky130_fd_sc_hd__mux2_2 A0 A1 S VGND VNB VPB VPWR X
.ends

* Black-box entry subcircuit for sky130_fd_sc_hd__nand4b_2 abstract view
.subckt sky130_fd_sc_hd__nand4b_2 A_N B C D VGND VNB VPB VPWR Y
.ends

.subckt spi_block_m clk_i nrst_i spi0_clk_o spi0_cs_o spi0_dqsm_en_o spi0_dqsm_i spi0_dqsm_o
+ spi0_miso_i[0] spi0_miso_i[1] spi0_miso_i[2] spi0_miso_i[3] spi0_mosi_o[0] spi0_mosi_o[1]
+ spi0_mosi_o[2] spi0_mosi_o[3] spi0_sio_en_o[0] spi0_sio_en_o[1] spi0_sio_en_o[2]
+ spi0_sio_en_o[3] spi1_clk_o spi1_cs_o spi1_dqsm_en_o spi1_dqsm_i spi1_dqsm_o spi1_miso_i[0]
+ spi1_miso_i[1] spi1_miso_i[2] spi1_miso_i[3] spi1_mosi_o[0] spi1_mosi_o[1] spi1_mosi_o[2]
+ spi1_mosi_o[3] spi1_sio_en_o[0] spi1_sio_en_o[1] spi1_sio_en_o[2] spi1_sio_en_o[3]
+ spi2_clk_o spi2_cs_o spi2_dqsm_en_o spi2_dqsm_i spi2_dqsm_o spi2_miso_i[0] spi2_miso_i[1]
+ spi2_miso_i[2] spi2_miso_i[3] spi2_mosi_o[0] spi2_mosi_o[1] spi2_mosi_o[2] spi2_mosi_o[3]
+ spi2_sio_en_o[0] spi2_sio_en_o[1] spi2_sio_en_o[2] spi2_sio_en_o[3] sport0_i[0]
+ sport0_i[10] sport0_i[11] sport0_i[12] sport0_i[13] sport0_i[14] sport0_i[15] sport0_i[16]
+ sport0_i[17] sport0_i[18] sport0_i[19] sport0_i[1] sport0_i[20] sport0_i[21] sport0_i[22]
+ sport0_i[23] sport0_i[24] sport0_i[25] sport0_i[26] sport0_i[27] sport0_i[28] sport0_i[29]
+ sport0_i[2] sport0_i[30] sport0_i[31] sport0_i[32] sport0_i[33] sport0_i[34] sport0_i[35]
+ sport0_i[36] sport0_i[37] sport0_i[38] sport0_i[39] sport0_i[3] sport0_i[40] sport0_i[41]
+ sport0_i[42] sport0_i[43] sport0_i[44] sport0_i[45] sport0_i[46] sport0_i[47] sport0_i[48]
+ sport0_i[49] sport0_i[4] sport0_i[50] sport0_i[51] sport0_i[52] sport0_i[53] sport0_i[54]
+ sport0_i[55] sport0_i[56] sport0_i[57] sport0_i[58] sport0_i[59] sport0_i[5] sport0_i[60]
+ sport0_i[61] sport0_i[62] sport0_i[63] sport0_i[64] sport0_i[65] sport0_i[66] sport0_i[67]
+ sport0_i[68] sport0_i[6] sport0_i[7] sport0_i[8] sport0_i[9] sport0_o[0] sport0_o[10]
+ sport0_o[11] sport0_o[12] sport0_o[13] sport0_o[14] sport0_o[15] sport0_o[16] sport0_o[17]
+ sport0_o[18] sport0_o[19] sport0_o[1] sport0_o[20] sport0_o[21] sport0_o[22] sport0_o[23]
+ sport0_o[24] sport0_o[25] sport0_o[26] sport0_o[27] sport0_o[28] sport0_o[29] sport0_o[2]
+ sport0_o[30] sport0_o[31] sport0_o[32] sport0_o[33] sport0_o[3] sport0_o[4] sport0_o[5]
+ sport0_o[6] sport0_o[7] sport0_o[8] sport0_o[9] sport1_i[0] sport1_i[10] sport1_i[11]
+ sport1_i[12] sport1_i[13] sport1_i[14] sport1_i[15] sport1_i[16] sport1_i[17] sport1_i[18]
+ sport1_i[19] sport1_i[1] sport1_i[20] sport1_i[21] sport1_i[22] sport1_i[23] sport1_i[24]
+ sport1_i[25] sport1_i[26] sport1_i[27] sport1_i[28] sport1_i[29] sport1_i[2] sport1_i[30]
+ sport1_i[31] sport1_i[32] sport1_i[33] sport1_i[34] sport1_i[35] sport1_i[36] sport1_i[37]
+ sport1_i[38] sport1_i[39] sport1_i[3] sport1_i[40] sport1_i[41] sport1_i[42] sport1_i[43]
+ sport1_i[44] sport1_i[45] sport1_i[46] sport1_i[47] sport1_i[48] sport1_i[49] sport1_i[4]
+ sport1_i[50] sport1_i[51] sport1_i[52] sport1_i[53] sport1_i[54] sport1_i[55] sport1_i[56]
+ sport1_i[57] sport1_i[58] sport1_i[59] sport1_i[5] sport1_i[60] sport1_i[61] sport1_i[62]
+ sport1_i[63] sport1_i[64] sport1_i[65] sport1_i[66] sport1_i[67] sport1_i[68] sport1_i[6]
+ sport1_i[7] sport1_i[8] sport1_i[9] sport1_o[0] sport1_o[10] sport1_o[11] sport1_o[12]
+ sport1_o[13] sport1_o[14] sport1_o[15] sport1_o[16] sport1_o[17] sport1_o[18] sport1_o[19]
+ sport1_o[1] sport1_o[20] sport1_o[21] sport1_o[22] sport1_o[23] sport1_o[24] sport1_o[25]
+ sport1_o[26] sport1_o[27] sport1_o[28] sport1_o[29] sport1_o[2] sport1_o[30] sport1_o[31]
+ sport1_o[32] sport1_o[33] sport1_o[3] sport1_o[4] sport1_o[5] sport1_o[6] sport1_o[7]
+ sport1_o[8] sport1_o[9] sport2_i[0] sport2_i[10] sport2_i[11] sport2_i[12] sport2_i[13]
+ sport2_i[14] sport2_i[15] sport2_i[16] sport2_i[17] sport2_i[18] sport2_i[19] sport2_i[1]
+ sport2_i[20] sport2_i[21] sport2_i[22] sport2_i[23] sport2_i[24] sport2_i[25] sport2_i[26]
+ sport2_i[27] sport2_i[28] sport2_i[29] sport2_i[2] sport2_i[30] sport2_i[31] sport2_i[32]
+ sport2_i[33] sport2_i[34] sport2_i[35] sport2_i[36] sport2_i[37] sport2_i[38] sport2_i[39]
+ sport2_i[3] sport2_i[40] sport2_i[41] sport2_i[42] sport2_i[43] sport2_i[44] sport2_i[45]
+ sport2_i[46] sport2_i[47] sport2_i[48] sport2_i[49] sport2_i[4] sport2_i[50] sport2_i[51]
+ sport2_i[52] sport2_i[53] sport2_i[54] sport2_i[55] sport2_i[56] sport2_i[57] sport2_i[58]
+ sport2_i[59] sport2_i[5] sport2_i[60] sport2_i[61] sport2_i[62] sport2_i[63] sport2_i[64]
+ sport2_i[65] sport2_i[66] sport2_i[67] sport2_i[68] sport2_i[6] sport2_i[7] sport2_i[8]
+ sport2_i[9] sport2_o[0] sport2_o[10] sport2_o[11] sport2_o[12] sport2_o[13] sport2_o[14]
+ sport2_o[15] sport2_o[16] sport2_o[17] sport2_o[18] sport2_o[19] sport2_o[1] sport2_o[20]
+ sport2_o[21] sport2_o[22] sport2_o[23] sport2_o[24] sport2_o[25] sport2_o[26] sport2_o[27]
+ sport2_o[28] sport2_o[29] sport2_o[2] sport2_o[30] sport2_o[31] sport2_o[32] sport2_o[33]
+ sport2_o[3] sport2_o[4] sport2_o[5] sport2_o[6] sport2_o[7] sport2_o[8] sport2_o[9]
+ vccd1 vssd1
X_2106_ clknet_leaf_11_clk_i _0126_ net475 vssd1 vssd1 vccd1 vccd1 spi_mem1.has_2lc
+ sky130_fd_sc_hd__dfrtp_1
X_2037_ clknet_leaf_1_clk_i net521 net451 vssd1 vssd1 vccd1 vccd1 net292 sky130_fd_sc_hd__dfrtp_1
XTAP_199 vssd1 vccd1 sky130_fd_sc_hd__tapvpwrvgnd_1
XTAP_188 vssd1 vccd1 sky130_fd_sc_hd__tapvpwrvgnd_1
XTAP_177 vssd1 vccd1 sky130_fd_sc_hd__tapvpwrvgnd_1
XFILLER_0_72_350 vssd1 vssd1 vccd1 vccd1 sky130_ef_sc_hd__decap_12
XFILLER_0_49_369 vssd1 vssd1 vccd1 vccd1 sky130_ef_sc_hd__decap_12
XFILLER_0_32_269 vssd1 vssd1 vccd1 vccd1 sky130_fd_sc_hd__fill_1
XFILLER_0_2_7 vssd1 vssd1 vccd1 vccd1 sky130_fd_sc_hd__fill_1
XFILLER_0_67_177 vssd1 vssd1 vccd1 vccd1 sky130_fd_sc_hd__fill_1
XFILLER_0_67_155 vssd1 vssd1 vccd1 vccd1 sky130_fd_sc_hd__decap_6
XFILLER_0_63_350 vssd1 vssd1 vccd1 vccd1 sky130_fd_sc_hd__fill_1
XFILLER_0_48_15 vssd1 vssd1 vccd1 vccd1 sky130_ef_sc_hd__decap_12
X_1270_ spi_mem0.data_buf\[3\] _0349_ _0462_ net435 vssd1 vssd1 vccd1 vccd1 _0463_
+ sky130_fd_sc_hd__a211o_1
XFILLER_0_73_158 vssd1 vssd1 vccd1 vccd1 sky130_fd_sc_hd__decap_4
X_1606_ _0977_ _0982_ _0608_ _0687_ vssd1 vssd1 vccd1 vccd1 _0688_ sky130_fd_sc_hd__o211a_1
XFILLER_0_54_361 vssd1 vssd1 vccd1 vccd1 sky130_fd_sc_hd__decap_3
X_1399_ net810 _0553_ _0548_ vssd1 vssd1 vccd1 vccd1 _0128_ sky130_fd_sc_hd__mux2_1
X_1468_ _0545_ _0592_ vssd1 vssd1 vccd1 vccd1 _0594_ sky130_fd_sc_hd__nand2_1
X_1537_ net696 net314 net387 vssd1 vssd1 vccd1 vccd1 _0190_ sky130_fd_sc_hd__mux2_1
XFILLER_0_49_122 vssd1 vssd1 vccd1 vccd1 sky130_ef_sc_hd__decap_12
XFILLER_0_60_320 vssd1 vssd1 vccd1 vccd1 sky130_ef_sc_hd__decap_12
XFILLER_0_52_309 vssd1 vssd1 vccd1 vccd1 sky130_ef_sc_hd__decap_12
Xhold181 spi_mem1.address\[15\] vssd1 vssd1 vccd1 vccd1 net685 sky130_fd_sc_hd__dlygate4sd3_1
Xhold192 spi_mem1.data_buf\[28\] vssd1 vssd1 vccd1 vccd1 net696 sky130_fd_sc_hd__dlygate4sd3_1
Xhold170 _0279_ vssd1 vssd1 vccd1 vccd1 net674 sky130_fd_sc_hd__dlygate4sd3_1
XFILLER_0_55_136 vssd1 vssd1 vccd1 vccd1 sky130_fd_sc_hd__fill_2
XFILLER_0_50_49 vssd1 vssd1 vccd1 vccd1 sky130_fd_sc_hd__decap_8
XFILLER_0_50_27 vssd1 vssd1 vccd1 vccd1 sky130_fd_sc_hd__fill_1
XFILLER_0_70_117 vssd1 vssd1 vccd1 vccd1 sky130_fd_sc_hd__decap_4
XFILLER_0_55_169 vssd1 vssd1 vccd1 vccd1 sky130_fd_sc_hd__decap_8
XFILLER_0_3_406 vssd1 vssd1 vccd1 vccd1 sky130_fd_sc_hd__fill_1
X_1322_ net559 _0499_ _0501_ net373 vssd1 vssd1 vccd1 vccd1 _0103_ sky130_fd_sc_hd__a22o_1
X_1253_ spi_mem0.address\[0\] _0392_ _0447_ spi_mem0.address_nibble\[1\] net443 vssd1
+ vssd1 vccd1 vccd1 _0448_ sky130_fd_sc_hd__a221o_1
X_1184_ spi_mem0.state\[0\] net377 _0413_ _0415_ vssd1 vssd1 vccd1 vccd1 _0051_ sky130_fd_sc_hd__o211a_1
XFILLER_0_54_180 vssd1 vssd1 vccd1 vccd1 sky130_fd_sc_hd__decap_3
XFILLER_0_40_60 vssd1 vssd1 vccd1 vccd1 sky130_ef_sc_hd__decap_12
Xoutput231 net231 vssd1 vssd1 vccd1 vccd1 spi0_mosi_o[3] sky130_fd_sc_hd__clkbuf_4
Xoutput242 net242 vssd1 vssd1 vccd1 vccd1 spi1_mosi_o[2] sky130_fd_sc_hd__clkbuf_4
Xoutput253 net253 vssd1 vssd1 vccd1 vccd1 spi2_mosi_o[1] sky130_fd_sc_hd__clkbuf_4
XFILLER_0_71_3 vssd1 vssd1 vccd1 vccd1 sky130_ef_sc_hd__decap_12
Xoutput286 net286 vssd1 vssd1 vccd1 vccd1 sport0_o[33] sky130_fd_sc_hd__clkbuf_4
Xoutput275 net275 vssd1 vssd1 vccd1 vccd1 sport0_o[23] sky130_fd_sc_hd__clkbuf_4
Xoutput264 net264 vssd1 vssd1 vccd1 vccd1 sport0_o[13] sky130_fd_sc_hd__clkbuf_4
Xoutput297 net297 vssd1 vssd1 vccd1 vccd1 sport1_o[12] sky130_fd_sc_hd__clkbuf_4
XFILLER_0_37_103 vssd1 vssd1 vccd1 vccd1 sky130_fd_sc_hd__decap_8
XFILLER_0_52_106 vssd1 vssd1 vccd1 vccd1 sky130_fd_sc_hd__decap_6
XFILLER_0_33_320 vssd1 vssd1 vccd1 vccd1 sky130_ef_sc_hd__decap_12
XFILLER_0_61_15 vssd1 vssd1 vccd1 vccd1 sky130_ef_sc_hd__decap_12
Xfanout480 net482 vssd1 vssd1 vccd1 vccd1 net480 sky130_fd_sc_hd__clkbuf_2
XFILLER_0_0_29 vssd1 vssd1 vccd1 vccd1 sky130_fd_sc_hd__decap_4
X_1871_ spi_mem2.address\[19\] _0742_ _0849_ _0926_ vssd1 vssd1 vccd1 vccd1 _0850_
+ sky130_fd_sc_hd__a211o_1
X_1940_ _0968_ _0972_ net364 vssd1 vssd1 vccd1 vccd1 _0897_ sky130_fd_sc_hd__o21ai_2
XFILLER_0_36_191 vssd1 vssd1 vccd1 vccd1 sky130_fd_sc_hd__decap_4
XFILLER_0_43_7 vssd1 vssd1 vccd1 vccd1 sky130_fd_sc_hd__fill_1
X_1305_ net50 net414 _0482_ _0490_ vssd1 vssd1 vccd1 vccd1 _0491_ sky130_fd_sc_hd__a22o_1
X_2285_ clknet_leaf_36_clk_i net678 net448 vssd1 vssd1 vccd1 vccd1 net349 sky130_fd_sc_hd__dfrtp_1
X_1236_ spi_mem0.address\[3\] spi_mem0.address\[7\] spi_mem0.address_nibble\[0\] vssd1
+ vssd1 vccd1 vccd1 _0432_ sky130_fd_sc_hd__mux2_1
XFILLER_0_66_209 vssd1 vssd1 vccd1 vccd1 sky130_ef_sc_hd__decap_12
X_1098_ _0967_ net392 _0362_ vssd1 vssd1 vccd1 vccd1 _0363_ sky130_fd_sc_hd__o21ai_1
X_1167_ net60 _0397_ _0398_ net62 vssd1 vssd1 vccd1 vccd1 _0399_ sky130_fd_sc_hd__o211a_1
XFILLER_0_74_264 vssd1 vssd1 vccd1 vccd1 sky130_fd_sc_hd__fill_1
XFILLER_0_74_253 vssd1 vssd1 vccd1 vccd1 sky130_fd_sc_hd__decap_8
XFILLER_0_34_106 vssd1 vssd1 vccd1 vccd1 sky130_fd_sc_hd__fill_2
XFILLER_0_65_231 vssd1 vssd1 vccd1 vccd1 sky130_fd_sc_hd__decap_8
XTAP_507 vssd1 vccd1 sky130_fd_sc_hd__tapvpwrvgnd_1
XTAP_529 vssd1 vccd1 sky130_fd_sc_hd__tapvpwrvgnd_1
XTAP_518 vssd1 vccd1 sky130_fd_sc_hd__tapvpwrvgnd_1
X_2070_ net494 _0000_ net481 vssd1 vssd1 vccd1 vccd1 spi_mem0.spi_clk sky130_fd_sc_hd__dfrtp_2
XFILLER_0_56_231 vssd1 vssd1 vccd1 vccd1 sky130_ef_sc_hd__decap_12
X_1021_ spi_mem0.state\[1\] net442 vssd1 vssd1 vccd1 vccd1 _0946_ sky130_fd_sc_hd__or2_2
XFILLER_0_29_401 vssd1 vssd1 vccd1 vccd1 sky130_fd_sc_hd__decap_6
XFILLER_0_71_256 vssd1 vssd1 vccd1 vccd1 sky130_fd_sc_hd__fill_2
XFILLER_0_56_297 vssd1 vssd1 vccd1 vccd1 sky130_fd_sc_hd__decap_3
XFILLER_0_56_253 vssd1 vssd1 vccd1 vccd1 sky130_fd_sc_hd__fill_1
X_1785_ _0973_ _0801_ _0800_ net425 vssd1 vssd1 vccd1 vccd1 _0802_ sky130_fd_sc_hd__a211o_1
X_1923_ net601 _0886_ _0887_ net362 vssd1 vssd1 vccd1 vccd1 _0318_ sky130_fd_sc_hd__a22o_1
XFILLER_0_16_139 vssd1 vssd1 vccd1 vccd1 sky130_fd_sc_hd__fill_1
X_1854_ spi_mem2.data_buf\[9\] _0819_ spi_mem2.data_byte\[1\] vssd1 vssd1 vccd1 vccd1
+ _0834_ sky130_fd_sc_hd__a21o_1
X_2337_ net247 vssd1 vssd1 vccd1 vccd1 net244 sky130_fd_sc_hd__clkbuf_1
X_2199_ clknet_leaf_8_clk_i _0213_ net470 vssd1 vssd1 vccd1 vccd1 spi_mem1.data_buf\[11\]
+ sky130_fd_sc_hd__dfrtp_1
X_1219_ net568 net278 net391 vssd1 vssd1 vccd1 vccd1 _0081_ sky130_fd_sc_hd__mux2_1
XFILLER_0_34_3 vssd1 vssd1 vccd1 vccd1 sky130_fd_sc_hd__decap_6
X_2268_ clknet_leaf_39_clk_i net651 net445 vssd1 vssd1 vccd1 vccd1 net331 sky130_fd_sc_hd__dfrtp_1
XFILLER_0_79_389 vssd1 vssd1 vccd1 vccd1 sky130_fd_sc_hd__decap_3
XFILLER_0_62_212 vssd1 vssd1 vccd1 vccd1 sky130_fd_sc_hd__fill_2
XFILLER_0_30_153 vssd1 vssd1 vccd1 vccd1 sky130_fd_sc_hd__decap_8
Xhold63 net228 vssd1 vssd1 vccd1 vccd1 net567 sky130_fd_sc_hd__dlygate4sd3_1
Xhold30 spi_mem1.data_buf\[31\] vssd1 vssd1 vccd1 vccd1 net534 sky130_fd_sc_hd__dlygate4sd3_1
Xhold74 spi_mem0.address\[6\] vssd1 vssd1 vccd1 vccd1 net578 sky130_fd_sc_hd__dlygate4sd3_1
XFILLER_0_30_197 vssd1 vssd1 vccd1 vccd1 sky130_ef_sc_hd__decap_12
Xhold52 spi_mem2.address\[18\] vssd1 vssd1 vccd1 vccd1 net556 sky130_fd_sc_hd__dlygate4sd3_1
XFILLER_0_26_29 vssd1 vssd1 vccd1 vccd1 sky130_fd_sc_hd__decap_6
Xhold41 spi_mem2.address\[3\] vssd1 vssd1 vccd1 vccd1 net545 sky130_fd_sc_hd__dlygate4sd3_1
Xhold96 spi_mem0.address\[14\] vssd1 vssd1 vccd1 vccd1 net600 sky130_fd_sc_hd__dlygate4sd3_1
Xhold85 _0298_ vssd1 vssd1 vccd1 vccd1 net589 sky130_fd_sc_hd__dlygate4sd3_1
XFILLER_0_53_245 vssd1 vssd1 vccd1 vccd1 sky130_ef_sc_hd__decap_12
XFILLER_0_53_212 vssd1 vssd1 vccd1 vccd1 sky130_fd_sc_hd__decap_4
XFILLER_0_38_253 vssd1 vssd1 vccd1 vccd1 sky130_ef_sc_hd__decap_12
X_1570_ spi_mem1.address\[0\] _0641_ _0657_ spi_mem1.address_nibble\[1\] spi_mem1.address_nibble\[2\]
+ vssd1 vssd1 vccd1 vccd1 _0658_ sky130_fd_sc_hd__a221o_1
XANTENNA_5 net103 vssd1 vssd1 vccd1 vccd1 sky130_fd_sc_hd__diode_2
XTAP_348 vssd1 vccd1 sky130_fd_sc_hd__tapvpwrvgnd_1
XTAP_337 vssd1 vccd1 sky130_fd_sc_hd__tapvpwrvgnd_1
XTAP_304 vssd1 vccd1 sky130_fd_sc_hd__tapvpwrvgnd_1
XTAP_315 vssd1 vccd1 sky130_fd_sc_hd__tapvpwrvgnd_1
XTAP_326 vssd1 vccd1 sky130_fd_sc_hd__tapvpwrvgnd_1
X_2122_ clknet_leaf_20_clk_i _0142_ net485 vssd1 vssd1 vccd1 vccd1 spi_mem1.address\[9\]
+ sky130_fd_sc_hd__dfrtp_1
X_2053_ clknet_leaf_4_clk_i net544 net454 vssd1 vssd1 vccd1 vccd1 net276 sky130_fd_sc_hd__dfrtp_1
XTAP_359 vssd1 vccd1 sky130_fd_sc_hd__tapvpwrvgnd_1
X_1004_ net150 vssd1 vssd1 vccd1 vccd1 _0933_ sky130_fd_sc_hd__inv_2
X_1837_ net405 _0817_ _0816_ _0804_ vssd1 vssd1 vccd1 vccd1 _0818_ sky130_fd_sc_hd__a211o_2
X_1768_ _0787_ _0741_ spi_mem2.address_nibble\[0\] vssd1 vssd1 vccd1 vccd1 _0263_
+ sky130_fd_sc_hd__mux2_1
XFILLER_0_4_386 vssd1 vssd1 vccd1 vccd1 sky130_fd_sc_hd__fill_1
X_1906_ net644 _0870_ _0876_ net362 vssd1 vssd1 vccd1 vccd1 _0312_ sky130_fd_sc_hd__a22o_1
XFILLER_0_12_164 vssd1 vssd1 vccd1 vccd1 sky130_fd_sc_hd__decap_6
X_1699_ _0926_ _0746_ _0741_ vssd1 vssd1 vccd1 vccd1 _0747_ sky130_fd_sc_hd__a21o_1
XFILLER_0_12_197 vssd1 vssd1 vccd1 vccd1 sky130_fd_sc_hd__fill_2
XFILLER_0_35_278 vssd1 vssd1 vccd1 vccd1 sky130_fd_sc_hd__fill_2
XFILLER_0_53_27 vssd1 vssd1 vccd1 vccd1 sky130_fd_sc_hd__decap_4
Xinput131 sport1_i[50] vssd1 vssd1 vccd1 vccd1 net131 sky130_fd_sc_hd__clkbuf_2
Xinput120 sport1_i[40] vssd1 vssd1 vccd1 vccd1 net120 sky130_fd_sc_hd__clkbuf_4
Xinput153 sport1_i[8] vssd1 vssd1 vccd1 vccd1 net153 sky130_fd_sc_hd__dlymetal6s2s_1
Xinput197 sport2_i[48] vssd1 vssd1 vccd1 vccd1 net197 sky130_fd_sc_hd__dlymetal6s2s_1
Xinput142 sport1_i[60] vssd1 vssd1 vccd1 vccd1 net142 sky130_fd_sc_hd__clkbuf_1
Xinput164 sport2_i[18] vssd1 vssd1 vccd1 vccd1 net164 sky130_fd_sc_hd__clkbuf_1
Xinput186 sport2_i[38] vssd1 vssd1 vccd1 vccd1 net186 sky130_fd_sc_hd__buf_1
Xinput175 sport2_i[28] vssd1 vssd1 vccd1 vccd1 net175 sky130_fd_sc_hd__clkbuf_1
XFILLER_0_66_381 vssd1 vssd1 vccd1 vccd1 sky130_fd_sc_hd__decap_6
XFILLER_0_58_315 vssd1 vssd1 vccd1 vccd1 sky130_fd_sc_hd__decap_8
X_1622_ net726 _0691_ _0699_ net368 vssd1 vssd1 vccd1 vccd1 _0205_ sky130_fd_sc_hd__a22o_1
XFILLER_0_41_237 vssd1 vssd1 vccd1 vccd1 sky130_ef_sc_hd__decap_12
X_1484_ net430 _0608_ vssd1 vssd1 vccd1 vccd1 _0609_ sky130_fd_sc_hd__nor2_2
X_1553_ spi_mem1.address\[3\] spi_mem1.address\[7\] spi_mem1.address_nibble\[0\] vssd1
+ vssd1 vccd1 vccd1 _0642_ sky130_fd_sc_hd__mux2_1
XTAP_189 vssd1 vccd1 sky130_fd_sc_hd__tapvpwrvgnd_1
XTAP_178 vssd1 vccd1 sky130_fd_sc_hd__tapvpwrvgnd_1
XTAP_167 vssd1 vccd1 sky130_fd_sc_hd__tapvpwrvgnd_1
X_2036_ clknet_leaf_2_clk_i net666 net453 vssd1 vssd1 vccd1 vccd1 net291 sky130_fd_sc_hd__dfrtp_1
X_2105_ clknet_leaf_33_clk_i _0125_ net463 vssd1 vssd1 vccd1 vccd1 spi_mem0.data_buf\[31\]
+ sky130_fd_sc_hd__dfrtp_1
XFILLER_0_9_401 vssd1 vssd1 vccd1 vccd1 sky130_fd_sc_hd__decap_3
XFILLER_0_72_362 vssd1 vssd1 vccd1 vccd1 sky130_fd_sc_hd__fill_2
XFILLER_0_64_307 vssd1 vssd1 vccd1 vccd1 sky130_fd_sc_hd__fill_1
XFILLER_0_49_359 vssd1 vssd1 vccd1 vccd1 sky130_fd_sc_hd__decap_4
XTAP_690 vssd1 vccd1 sky130_fd_sc_hd__tapvpwrvgnd_1
XFILLER_0_82_148 vssd1 vssd1 vccd1 vccd1 sky130_fd_sc_hd__fill_2
XFILLER_0_48_27 vssd1 vssd1 vccd1 vccd1 sky130_fd_sc_hd__fill_1
XFILLER_0_64_37 vssd1 vssd1 vccd1 vccd1 sky130_fd_sc_hd__fill_1
XFILLER_0_64_26 vssd1 vssd1 vccd1 vccd1 sky130_fd_sc_hd__fill_2
XFILLER_0_64_15 vssd1 vssd1 vccd1 vccd1 sky130_fd_sc_hd__decap_4
XFILLER_0_13_52 vssd1 vssd1 vccd1 vccd1 sky130_fd_sc_hd__decap_4
XFILLER_0_14_204 vssd1 vssd1 vccd1 vccd1 sky130_fd_sc_hd__decap_4
X_1605_ spi_mem1.data_byte\[1\] net429 vssd1 vssd1 vccd1 vccd1 _0687_ sky130_fd_sc_hd__or2_1
X_1536_ net771 net313 net385 vssd1 vssd1 vccd1 vccd1 _0189_ sky130_fd_sc_hd__mux2_1
X_1398_ _0537_ _0552_ _0549_ vssd1 vssd1 vccd1 vccd1 _0553_ sky130_fd_sc_hd__a21o_1
X_1467_ net395 _0534_ _0593_ spi_mem1.address_nibble\[1\] vssd1 vssd1 vccd1 vccd1
+ _0156_ sky130_fd_sc_hd__o2bb2a_1
XFILLER_0_49_134 vssd1 vssd1 vccd1 vccd1 sky130_ef_sc_hd__decap_12
XFILLER_0_49_101 vssd1 vssd1 vccd1 vccd1 sky130_fd_sc_hd__decap_3
X_2019_ clknet_leaf_30_clk_i _0045_ net460 vssd1 vssd1 vccd1 vccd1 spi_mem0.address\[19\]
+ sky130_fd_sc_hd__dfrtp_1
XFILLER_0_64_137 vssd1 vssd1 vccd1 vccd1 sky130_fd_sc_hd__decap_3
XFILLER_0_60_365 vssd1 vssd1 vccd1 vccd1 sky130_fd_sc_hd__decap_4
XFILLER_0_60_354 vssd1 vssd1 vccd1 vccd1 sky130_fd_sc_hd__decap_3
XFILLER_0_60_332 vssd1 vssd1 vccd1 vccd1 sky130_ef_sc_hd__decap_12
Xhold193 _0190_ vssd1 vssd1 vccd1 vccd1 net697 sky130_fd_sc_hd__dlygate4sd3_1
Xhold171 spi_mem0.data_buf\[15\] vssd1 vssd1 vccd1 vccd1 net675 sky130_fd_sc_hd__dlygate4sd3_1
Xhold182 spi_mem0.data_buf\[18\] vssd1 vssd1 vccd1 vccd1 net686 sky130_fd_sc_hd__dlygate4sd3_1
XFILLER_0_13_281 vssd1 vssd1 vccd1 vccd1 sky130_fd_sc_hd__fill_2
XFILLER_0_13_292 vssd1 vssd1 vccd1 vccd1 sky130_fd_sc_hd__decap_4
Xhold160 spi_mem2.address\[14\] vssd1 vssd1 vccd1 vccd1 net664 sky130_fd_sc_hd__dlygate4sd3_1
XFILLER_0_34_29 vssd1 vssd1 vccd1 vccd1 sky130_fd_sc_hd__fill_2
XFILLER_0_28_329 vssd1 vssd1 vccd1 vccd1 sky130_ef_sc_hd__decap_12
XFILLER_0_28_307 vssd1 vssd1 vccd1 vccd1 sky130_fd_sc_hd__fill_1
X_1321_ net85 net414 _0486_ _0498_ vssd1 vssd1 vccd1 vccd1 _0501_ sky130_fd_sc_hd__a22o_1
X_1252_ spi_mem0.address\[4\] spi_mem0.address\[8\] spi_mem0.address_nibble\[0\] vssd1
+ vssd1 vccd1 vccd1 _0447_ sky130_fd_sc_hd__mux2_1
X_1183_ net377 _0414_ vssd1 vssd1 vccd1 vccd1 _0415_ sky130_fd_sc_hd__nand2_1
XFILLER_0_42_332 vssd1 vssd1 vccd1 vccd1 sky130_ef_sc_hd__decap_12
XFILLER_0_40_72 vssd1 vssd1 vccd1 vccd1 sky130_fd_sc_hd__decap_4
Xoutput243 net243 vssd1 vssd1 vccd1 vccd1 spi1_mosi_o[3] sky130_fd_sc_hd__clkbuf_4
Xoutput254 net254 vssd1 vssd1 vccd1 vccd1 spi2_mosi_o[2] sky130_fd_sc_hd__clkbuf_4
Xoutput232 net232 vssd1 vssd1 vccd1 vccd1 spi0_sio_en_o[0] sky130_fd_sc_hd__clkbuf_4
X_1519_ net718 net722 _0629_ vssd1 vssd1 vccd1 vccd1 _0172_ sky130_fd_sc_hd__mux2_1
XFILLER_0_64_3 vssd1 vssd1 vccd1 vccd1 sky130_ef_sc_hd__decap_12
Xoutput265 net265 vssd1 vssd1 vccd1 vccd1 sport0_o[14] sky130_fd_sc_hd__clkbuf_4
XFILLER_0_10_273 vssd1 vssd1 vccd1 vccd1 sky130_fd_sc_hd__decap_4
Xoutput287 net287 vssd1 vssd1 vccd1 vccd1 sport0_o[3] sky130_fd_sc_hd__clkbuf_4
Xoutput276 net276 vssd1 vssd1 vccd1 vccd1 sport0_o[24] sky130_fd_sc_hd__clkbuf_4
Xoutput298 net298 vssd1 vssd1 vccd1 vccd1 sport1_o[13] sky130_fd_sc_hd__clkbuf_4
XFILLER_0_65_402 vssd1 vssd1 vccd1 vccd1 sky130_fd_sc_hd__decap_4
XFILLER_0_60_162 vssd1 vssd1 vccd1 vccd1 sky130_fd_sc_hd__decap_8
XFILLER_0_45_181 vssd1 vssd1 vccd1 vccd1 sky130_fd_sc_hd__fill_1
XFILLER_0_33_332 vssd1 vssd1 vccd1 vccd1 sky130_fd_sc_hd__decap_4
Xfanout470 net473 vssd1 vssd1 vccd1 vccd1 net470 sky130_fd_sc_hd__buf_2
Xfanout481 net482 vssd1 vssd1 vccd1 vccd1 net481 sky130_fd_sc_hd__buf_4
XFILLER_0_68_251 vssd1 vssd1 vccd1 vccd1 sky130_fd_sc_hd__fill_1
XFILLER_0_61_27 vssd1 vssd1 vccd1 vccd1 sky130_fd_sc_hd__decap_3
X_1870_ spi_mem2.address\[11\] _0746_ _0824_ spi_mem2.address\[15\] vssd1 vssd1 vccd1
+ vccd1 _0849_ sky130_fd_sc_hd__a22o_1
XFILLER_0_24_365 vssd1 vssd1 vccd1 vccd1 sky130_fd_sc_hd__decap_8
X_1304_ spi_mem0.delayed_miso\[3\] _0344_ vssd1 vssd1 vccd1 vccd1 _0490_ sky130_fd_sc_hd__and2_2
X_1235_ spi_mem0.data_buf\[12\] _0426_ _0429_ _0430_ vssd1 vssd1 vccd1 vccd1 _0431_
+ sky130_fd_sc_hd__a211o_1
X_1166_ net65 net64 net63 vssd1 vssd1 vccd1 vccd1 _0398_ sky130_fd_sc_hd__and3_1
X_2284_ clknet_leaf_36_clk_i net589 net448 vssd1 vssd1 vccd1 vccd1 net348 sky130_fd_sc_hd__dfrtp_1
XFILLER_0_47_402 vssd1 vssd1 vccd1 vccd1 sky130_fd_sc_hd__decap_4
X_1097_ _0960_ net392 _0361_ _0953_ vssd1 vssd1 vccd1 vccd1 _0362_ sky130_fd_sc_hd__a22oi_4
XFILLER_0_74_298 vssd1 vssd1 vccd1 vccd1 sky130_fd_sc_hd__fill_1
X_1999_ clknet_leaf_8_clk_i _0025_ net469 vssd1 vssd1 vccd1 vccd1 spi_mem0.latency\[5\]
+ sky130_fd_sc_hd__dfrtp_2
XFILLER_0_42_173 vssd1 vssd1 vccd1 vccd1 sky130_fd_sc_hd__decap_3
XFILLER_0_27_181 vssd1 vssd1 vccd1 vccd1 sky130_fd_sc_hd__fill_2
XFILLER_0_15_321 vssd1 vssd1 vccd1 vccd1 sky130_fd_sc_hd__decap_4
XTAP_519 vssd1 vccd1 sky130_fd_sc_hd__tapvpwrvgnd_1
XTAP_508 vssd1 vccd1 sky130_fd_sc_hd__tapvpwrvgnd_1
XFILLER_0_21_335 vssd1 vssd1 vccd1 vccd1 sky130_fd_sc_hd__fill_1
XFILLER_0_21_357 vssd1 vssd1 vccd1 vccd1 sky130_fd_sc_hd__decap_6
XFILLER_0_72_15 vssd1 vssd1 vccd1 vccd1 sky130_ef_sc_hd__decap_12
XFILLER_0_56_27 vssd1 vssd1 vccd1 vccd1 sky130_fd_sc_hd__fill_1
X_1020_ spi_mem0.state\[1\] net442 vssd1 vssd1 vccd1 vccd1 _0945_ sky130_fd_sc_hd__nor2_2
XFILLER_0_56_243 vssd1 vssd1 vccd1 vccd1 sky130_fd_sc_hd__decap_8
X_1922_ net222 net400 _0871_ _0885_ vssd1 vssd1 vccd1 vccd1 _0887_ sky130_fd_sc_hd__a22o_1
X_1784_ net217 _0352_ net218 vssd1 vssd1 vccd1 vccd1 _0801_ sky130_fd_sc_hd__a21o_1
XFILLER_0_12_335 vssd1 vssd1 vccd1 vccd1 sky130_fd_sc_hd__fill_1
XFILLER_0_16_107 vssd1 vssd1 vccd1 vccd1 sky130_ef_sc_hd__decap_12
X_1853_ spi_mem2.data_buf\[25\] _0819_ _0832_ _0927_ vssd1 vssd1 vccd1 vccd1 _0833_
+ sky130_fd_sc_hd__a211o_1
X_2336_ net235 vssd1 vssd1 vccd1 vccd1 net234 sky130_fd_sc_hd__clkbuf_1
XFILLER_0_79_313 vssd1 vssd1 vccd1 vccd1 sky130_ef_sc_hd__decap_12
X_2198_ clknet_leaf_12_clk_i _0212_ net478 vssd1 vssd1 vccd1 vccd1 spi_mem1.data_buf\[10\]
+ sky130_fd_sc_hd__dfrtp_1
X_1218_ net637 net277 net391 vssd1 vssd1 vccd1 vccd1 _0080_ sky130_fd_sc_hd__mux2_1
XFILLER_0_27_3 vssd1 vssd1 vccd1 vccd1 sky130_fd_sc_hd__fill_1
X_1149_ net59 net592 net408 vssd1 vssd1 vccd1 vccd1 _0042_ sky130_fd_sc_hd__mux2_1
X_2267_ clknet_leaf_39_clk_i net640 net445 vssd1 vssd1 vccd1 vccd1 net330 sky130_fd_sc_hd__dfrtp_1
XFILLER_0_62_81 vssd1 vssd1 vccd1 vccd1 sky130_fd_sc_hd__decap_3
XFILLER_0_35_405 vssd1 vssd1 vccd1 vccd1 sky130_fd_sc_hd__fill_2
XFILLER_0_7_351 vssd1 vssd1 vccd1 vccd1 sky130_fd_sc_hd__fill_2
XFILLER_0_15_151 vssd1 vssd1 vccd1 vccd1 sky130_fd_sc_hd__decap_4
Xhold20 spi_mem1.data_buf\[20\] vssd1 vssd1 vccd1 vccd1 net524 sky130_fd_sc_hd__dlygate4sd3_1
Xhold31 _0193_ vssd1 vssd1 vccd1 vccd1 net535 sky130_fd_sc_hd__dlygate4sd3_1
Xhold53 spi_mem0.data_buf\[27\] vssd1 vssd1 vccd1 vccd1 net557 sky130_fd_sc_hd__dlygate4sd3_1
Xhold64 spi_mem0.data_buf\[26\] vssd1 vssd1 vccd1 vccd1 net568 sky130_fd_sc_hd__dlygate4sd3_1
Xhold75 spi_mem0.address\[10\] vssd1 vssd1 vccd1 vccd1 net579 sky130_fd_sc_hd__dlygate4sd3_1
Xhold42 spi_mem2.address\[15\] vssd1 vssd1 vccd1 vccd1 net546 sky130_fd_sc_hd__dlygate4sd3_1
Xhold97 spi_mem2.data_buf\[8\] vssd1 vssd1 vccd1 vccd1 net601 sky130_fd_sc_hd__dlygate4sd3_1
Xhold86 spi_mem0.address\[17\] vssd1 vssd1 vccd1 vccd1 net590 sky130_fd_sc_hd__dlygate4sd3_1
XFILLER_0_42_29 vssd1 vssd1 vccd1 vccd1 sky130_fd_sc_hd__decap_6
XFILLER_0_38_265 vssd1 vssd1 vccd1 vccd1 sky130_ef_sc_hd__decap_12
XFILLER_0_38_210 vssd1 vssd1 vccd1 vccd1 sky130_fd_sc_hd__fill_2
XANTENNA_6 net113 vssd1 vssd1 vccd1 vccd1 sky130_fd_sc_hd__diode_2
XFILLER_0_61_290 vssd1 vssd1 vccd1 vccd1 sky130_fd_sc_hd__decap_4
XFILLER_0_53_257 vssd1 vssd1 vccd1 vccd1 sky130_ef_sc_hd__decap_12
XFILLER_0_21_110 vssd1 vssd1 vccd1 vccd1 sky130_fd_sc_hd__fill_2
XFILLER_0_67_37 vssd1 vssd1 vccd1 vccd1 sky130_ef_sc_hd__decap_12
XTAP_349 vssd1 vccd1 sky130_fd_sc_hd__tapvpwrvgnd_1
XTAP_338 vssd1 vccd1 sky130_fd_sc_hd__tapvpwrvgnd_1
XTAP_305 vssd1 vccd1 sky130_fd_sc_hd__tapvpwrvgnd_1
XTAP_316 vssd1 vccd1 sky130_fd_sc_hd__tapvpwrvgnd_1
XFILLER_0_21_154 vssd1 vssd1 vccd1 vccd1 sky130_ef_sc_hd__decap_12
XTAP_327 vssd1 vccd1 sky130_fd_sc_hd__tapvpwrvgnd_1
X_2121_ clknet_leaf_16_clk_i _0141_ net479 vssd1 vssd1 vccd1 vccd1 spi_mem1.address\[8\]
+ sky130_fd_sc_hd__dfrtp_1
X_1003_ net219 vssd1 vssd1 vccd1 vccd1 _0932_ sky130_fd_sc_hd__inv_2
X_2052_ clknet_leaf_4_clk_i net682 net454 vssd1 vssd1 vccd1 vccd1 net275 sky130_fd_sc_hd__dfrtp_1
X_1905_ net177 net401 _0869_ _0875_ vssd1 vssd1 vccd1 vccd1 _0876_ sky130_fd_sc_hd__a22o_1
X_1836_ net427 _0955_ _0969_ vssd1 vssd1 vccd1 vccd1 _0817_ sky130_fd_sc_hd__a21oi_2
X_1767_ net405 _0741_ vssd1 vssd1 vccd1 vccd1 _0787_ sky130_fd_sc_hd__nand2_1
X_1698_ spi_mem2.address_nibble\[1\] spi_mem2.address_nibble\[0\] vssd1 vssd1 vccd1
+ vccd1 _0746_ sky130_fd_sc_hd__nor2_2
X_2319_ clknet_leaf_36_clk_i _0327_ net448 vssd1 vssd1 vccd1 vccd1 spi_mem2.data_buf\[17\]
+ sky130_fd_sc_hd__dfrtp_1
XFILLER_0_79_198 vssd1 vssd1 vccd1 vccd1 sky130_ef_sc_hd__decap_12
XFILLER_0_67_305 vssd1 vssd1 vccd1 vccd1 sky130_fd_sc_hd__fill_1
XFILLER_0_75_393 vssd1 vssd1 vccd1 vccd1 sky130_ef_sc_hd__decap_12
Xinput110 sport1_i[31] vssd1 vssd1 vccd1 vccd1 net110 sky130_fd_sc_hd__buf_1
Xinput198 sport2_i[49] vssd1 vssd1 vccd1 vccd1 net198 sky130_fd_sc_hd__buf_1
Xinput121 sport1_i[41] vssd1 vssd1 vccd1 vccd1 net121 sky130_fd_sc_hd__buf_2
Xinput132 sport1_i[51] vssd1 vssd1 vccd1 vccd1 net132 sky130_fd_sc_hd__clkbuf_2
Xinput154 sport1_i[9] vssd1 vssd1 vccd1 vccd1 net154 sky130_fd_sc_hd__dlymetal6s2s_1
Xinput143 sport1_i[61] vssd1 vssd1 vccd1 vccd1 net143 sky130_fd_sc_hd__clkbuf_1
Xinput165 sport2_i[19] vssd1 vssd1 vccd1 vccd1 net165 sky130_fd_sc_hd__clkbuf_1
Xinput176 sport2_i[29] vssd1 vssd1 vccd1 vccd1 net176 sky130_fd_sc_hd__clkbuf_1
Xinput187 sport2_i[39] vssd1 vssd1 vccd1 vccd1 net187 sky130_fd_sc_hd__clkbuf_1
XPHY_160 vssd1 vssd1 vccd1 vccd1 sky130_fd_sc_hd__decap_3
XFILLER_0_73_319 vssd1 vssd1 vccd1 vccd1 sky130_ef_sc_hd__decap_12
XFILLER_0_73_308 vssd1 vssd1 vccd1 vccd1 sky130_fd_sc_hd__decap_6
XFILLER_0_66_360 vssd1 vssd1 vccd1 vccd1 sky130_fd_sc_hd__decap_4
XFILLER_0_5_107 vssd1 vssd1 vccd1 vccd1 sky130_fd_sc_hd__decap_4
X_1552_ spi_mem1.address_nibble\[1\] spi_mem1.address_nibble\[0\] vssd1 vssd1 vccd1
+ vccd1 _0641_ sky130_fd_sc_hd__and2b_2
X_1621_ net119 net397 _0690_ _0698_ vssd1 vssd1 vccd1 vccd1 _0699_ sky130_fd_sc_hd__a22o_1
XFILLER_0_41_249 vssd1 vssd1 vccd1 vccd1 sky130_fd_sc_hd__fill_1
XFILLER_0_34_290 vssd1 vssd1 vccd1 vccd1 sky130_fd_sc_hd__decap_6
X_1483_ spi_mem1.data_byte\[1\] net429 vssd1 vssd1 vccd1 vccd1 _0608_ sky130_fd_sc_hd__nand2_2
X_2104_ clknet_leaf_33_clk_i _0124_ net463 vssd1 vssd1 vccd1 vccd1 spi_mem0.data_buf\[30\]
+ sky130_fd_sc_hd__dfrtp_1
XTAP_179 vssd1 vccd1 sky130_fd_sc_hd__tapvpwrvgnd_1
XFILLER_0_1_379 vssd1 vssd1 vccd1 vccd1 sky130_fd_sc_hd__fill_1
XTAP_168 vssd1 vccd1 sky130_fd_sc_hd__tapvpwrvgnd_1
X_2035_ clknet_leaf_7_clk_i net742 net467 vssd1 vssd1 vccd1 vccd1 net290 sky130_fd_sc_hd__dfrtp_1
XFILLER_0_57_393 vssd1 vssd1 vccd1 vccd1 sky130_ef_sc_hd__decap_12
X_1819_ spi_mem2.data_buf\[16\] net624 net380 vssd1 vssd1 vccd1 vccd1 _0286_ sky130_fd_sc_hd__mux2_1
XTAP_691 vssd1 vccd1 sky130_fd_sc_hd__tapvpwrvgnd_1
XTAP_680 vssd1 vccd1 sky130_fd_sc_hd__tapvpwrvgnd_1
XFILLER_0_67_113 vssd1 vssd1 vccd1 vccd1 sky130_fd_sc_hd__decap_8
XFILLER_0_67_102 vssd1 vssd1 vccd1 vccd1 sky130_fd_sc_hd__decap_8
XFILLER_0_80_15 vssd1 vssd1 vccd1 vccd1 sky130_ef_sc_hd__decap_12
XFILLER_0_58_157 vssd1 vssd1 vccd1 vccd1 sky130_fd_sc_hd__fill_2
XFILLER_0_54_374 vssd1 vssd1 vccd1 vccd1 sky130_ef_sc_hd__decap_12
XFILLER_0_54_330 vssd1 vssd1 vccd1 vccd1 sky130_fd_sc_hd__decap_3
XFILLER_0_39_393 vssd1 vssd1 vccd1 vccd1 sky130_ef_sc_hd__decap_12
X_1604_ net429 _0685_ _0686_ vssd1 vssd1 vccd1 vccd1 _0200_ sky130_fd_sc_hd__a21oi_1
X_1535_ net619 net312 net385 vssd1 vssd1 vccd1 vccd1 _0188_ sky130_fd_sc_hd__mux2_1
X_1397_ spi_mem1.latency\[0\] spi_mem1.latency\[1\] vssd1 vssd1 vccd1 vccd1 _0552_
+ sky130_fd_sc_hd__xnor2_1
X_1466_ spi_mem1.address_nibble\[0\] net395 _0592_ vssd1 vssd1 vccd1 vccd1 _0593_
+ sky130_fd_sc_hd__a21boi_1
XFILLER_0_38_83 vssd1 vssd1 vccd1 vccd1 sky130_fd_sc_hd__fill_1
XFILLER_0_49_146 vssd1 vssd1 vccd1 vccd1 sky130_fd_sc_hd__fill_1
XFILLER_0_9_243 vssd1 vssd1 vccd1 vccd1 sky130_fd_sc_hd__fill_1
X_2018_ clknet_leaf_33_clk_i _0044_ net460 vssd1 vssd1 vccd1 vccd1 spi_mem0.address\[18\]
+ sky130_fd_sc_hd__dfrtp_1
XFILLER_0_60_377 vssd1 vssd1 vccd1 vccd1 sky130_fd_sc_hd__decap_4
XFILLER_0_60_344 vssd1 vssd1 vccd1 vccd1 sky130_fd_sc_hd__fill_1
XFILLER_0_13_260 vssd1 vssd1 vccd1 vccd1 sky130_ef_sc_hd__decap_12
Xhold161 spi_mem0.data_buf\[7\] vssd1 vssd1 vccd1 vccd1 net665 sky130_fd_sc_hd__dlygate4sd3_1
Xhold172 spi_mem2.data_buf\[3\] vssd1 vssd1 vccd1 vccd1 net676 sky130_fd_sc_hd__dlygate4sd3_1
Xhold194 spi_mem2.data_buf\[14\] vssd1 vssd1 vccd1 vccd1 net698 sky130_fd_sc_hd__dlygate4sd3_1
Xhold150 _0271_ vssd1 vssd1 vccd1 vccd1 net654 sky130_fd_sc_hd__dlygate4sd3_1
Xhold183 _0073_ vssd1 vssd1 vccd1 vccd1 net687 sky130_fd_sc_hd__dlygate4sd3_1
XFILLER_0_36_363 vssd1 vssd1 vccd1 vccd1 sky130_fd_sc_hd__fill_1
X_1320_ net520 _0499_ _0500_ net372 vssd1 vssd1 vccd1 vccd1 _0102_ sky130_fd_sc_hd__a22o_1
XFILLER_0_75_15 vssd1 vssd1 vccd1 vccd1 sky130_fd_sc_hd__decap_8
X_1182_ _0949_ net226 vssd1 vssd1 vccd1 vccd1 _0414_ sky130_fd_sc_hd__nor2_1
X_1251_ spi_mem0.address\[10\] _0375_ _0392_ spi_mem0.address\[14\] _0445_ vssd1 vssd1
+ vccd1 vccd1 _0446_ sky130_fd_sc_hd__a221o_1
XFILLER_0_42_377 vssd1 vssd1 vccd1 vccd1 sky130_ef_sc_hd__decap_12
XFILLER_0_42_344 vssd1 vssd1 vccd1 vccd1 sky130_fd_sc_hd__decap_6
XFILLER_0_42_300 vssd1 vssd1 vccd1 vccd1 sky130_fd_sc_hd__decap_8
Xoutput255 net255 vssd1 vssd1 vccd1 vccd1 spi2_mosi_o[3] sky130_fd_sc_hd__clkbuf_4
Xoutput233 net233 vssd1 vssd1 vccd1 vccd1 spi0_sio_en_o[1] sky130_fd_sc_hd__clkbuf_4
Xoutput244 net244 vssd1 vssd1 vccd1 vccd1 spi1_sio_en_o[0] sky130_fd_sc_hd__clkbuf_4
X_1518_ net711 net736 _0629_ vssd1 vssd1 vccd1 vccd1 _0171_ sky130_fd_sc_hd__mux2_1
XFILLER_0_57_3 vssd1 vssd1 vccd1 vccd1 sky130_fd_sc_hd__decap_8
X_1449_ net574 _0581_ net412 vssd1 vssd1 vccd1 vccd1 _0150_ sky130_fd_sc_hd__mux2_1
Xoutput277 net277 vssd1 vssd1 vccd1 vccd1 sport0_o[25] sky130_fd_sc_hd__clkbuf_4
Xoutput266 net266 vssd1 vssd1 vccd1 vccd1 sport0_o[15] sky130_fd_sc_hd__clkbuf_4
Xoutput299 net299 vssd1 vssd1 vccd1 vccd1 sport1_o[14] sky130_fd_sc_hd__clkbuf_4
Xoutput288 net288 vssd1 vssd1 vccd1 vccd1 sport0_o[4] sky130_fd_sc_hd__clkbuf_4
XFILLER_0_69_219 vssd1 vssd1 vccd1 vccd1 sky130_fd_sc_hd__decap_4
XFILLER_0_60_185 vssd1 vssd1 vccd1 vccd1 sky130_fd_sc_hd__decap_8
XFILLER_0_60_141 vssd1 vssd1 vccd1 vccd1 sky130_fd_sc_hd__decap_6
XFILLER_0_5_290 vssd1 vssd1 vccd1 vccd1 sky130_fd_sc_hd__fill_1
Xfanout482 net488 vssd1 vssd1 vccd1 vccd1 net482 sky130_fd_sc_hd__clkbuf_4
Xfanout471 net473 vssd1 vssd1 vccd1 vccd1 net471 sky130_fd_sc_hd__clkbuf_4
Xfanout460 net461 vssd1 vssd1 vccd1 vccd1 net460 sky130_fd_sc_hd__clkbuf_4
XFILLER_0_28_138 vssd1 vssd1 vccd1 vccd1 sky130_fd_sc_hd__fill_2
XFILLER_0_36_160 vssd1 vssd1 vccd1 vccd1 sky130_fd_sc_hd__fill_2
X_1303_ net750 _0483_ _0489_ net372 vssd1 vssd1 vccd1 vccd1 _0096_ sky130_fd_sc_hd__a22o_1
X_2283_ clknet_leaf_36_clk_i net707 net448 vssd1 vssd1 vccd1 vccd1 net347 sky130_fd_sc_hd__dfrtp_1
XFILLER_0_19_52 vssd1 vssd1 vccd1 vccd1 sky130_fd_sc_hd__decap_4
X_1096_ spi_mem2.latency\[3\] spi_mem2.latency\[5\] spi_mem2.latency\[4\] _0359_ vssd1
+ vssd1 vccd1 vccd1 _0361_ sky130_fd_sc_hd__or4_4
XFILLER_0_35_51 vssd1 vssd1 vccd1 vccd1 sky130_fd_sc_hd__decap_4
X_1234_ spi_mem0.data_buf\[0\] _0349_ _0425_ spi_mem0.data_buf\[4\] vssd1 vssd1 vccd1
+ vccd1 _0430_ sky130_fd_sc_hd__a22o_1
X_1165_ _0395_ _0396_ net59 vssd1 vssd1 vccd1 vccd1 _0397_ sky130_fd_sc_hd__o21a_1
XFILLER_0_19_85 vssd1 vssd1 vccd1 vccd1 sky130_fd_sc_hd__fill_2
X_1998_ clknet_leaf_8_clk_i _0024_ net469 vssd1 vssd1 vccd1 vccd1 spi_mem0.latency\[4\]
+ sky130_fd_sc_hd__dfrtp_1
XFILLER_0_42_141 vssd1 vssd1 vccd1 vccd1 sky130_ef_sc_hd__decap_12
XFILLER_0_33_130 vssd1 vssd1 vccd1 vccd1 sky130_fd_sc_hd__fill_1
XTAP_509 vssd1 vccd1 sky130_fd_sc_hd__tapvpwrvgnd_1
XFILLER_0_72_38 vssd1 vssd1 vccd1 vccd1 sky130_fd_sc_hd__decap_6
XFILLER_0_72_27 vssd1 vssd1 vccd1 vccd1 sky130_fd_sc_hd__fill_1
X_1921_ _0968_ _0885_ net366 vssd1 vssd1 vccd1 vccd1 _0886_ sky130_fd_sc_hd__o21ai_4
X_1852_ spi_mem2.data_buf\[17\] _0971_ _0820_ spi_mem2.data_buf\[21\] _0831_ vssd1
+ vssd1 vccd1 vccd1 _0832_ sky130_fd_sc_hd__a221o_1
XFILLER_0_16_119 vssd1 vssd1 vccd1 vccd1 sky130_ef_sc_hd__decap_12
X_1783_ net216 spi_mem2.data_byte\[1\] net422 _0973_ vssd1 vssd1 vccd1 vccd1 _0800_
+ sky130_fd_sc_hd__a31oi_1
X_2335_ net235 vssd1 vssd1 vccd1 vccd1 net233 sky130_fd_sc_hd__clkbuf_1
X_2266_ clknet_leaf_0_clk_i net672 net444 vssd1 vssd1 vccd1 vccd1 net329 sky130_fd_sc_hd__dfrtp_1
Xclkbuf_2_0__f_clk_i clknet_0_clk_i vssd1 vssd1 vccd1 vccd1 clknet_2_0__leaf_clk_i
+ sky130_fd_sc_hd__clkbuf_16
XFILLER_0_79_325 vssd1 vssd1 vccd1 vccd1 sky130_fd_sc_hd__decap_4
X_2197_ clknet_leaf_6_clk_i _0211_ net470 vssd1 vssd1 vccd1 vccd1 spi_mem1.data_buf\[9\]
+ sky130_fd_sc_hd__dfrtp_1
XFILLER_0_47_211 vssd1 vssd1 vccd1 vccd1 sky130_ef_sc_hd__decap_12
XFILLER_0_46_83 vssd1 vssd1 vccd1 vccd1 sky130_fd_sc_hd__fill_1
X_1079_ _0347_ vssd1 vssd1 vccd1 vccd1 _0348_ sky130_fd_sc_hd__inv_2
X_1217_ net543 net276 net391 vssd1 vssd1 vccd1 vccd1 _0079_ sky130_fd_sc_hd__mux2_1
X_1148_ net58 net645 net407 vssd1 vssd1 vccd1 vccd1 _0041_ sky130_fd_sc_hd__mux2_1
XFILLER_0_62_93 vssd1 vssd1 vccd1 vccd1 sky130_fd_sc_hd__fill_1
XFILLER_0_47_299 vssd1 vssd1 vccd1 vccd1 sky130_ef_sc_hd__decap_12
XFILLER_0_7_374 vssd1 vssd1 vccd1 vccd1 sky130_fd_sc_hd__decap_8
XFILLER_0_15_141 vssd1 vssd1 vccd1 vccd1 sky130_fd_sc_hd__decap_4
XFILLER_0_15_163 vssd1 vssd1 vccd1 vccd1 sky130_fd_sc_hd__decap_4
XFILLER_0_30_122 vssd1 vssd1 vccd1 vccd1 sky130_fd_sc_hd__decap_4
Xhold21 _0182_ vssd1 vssd1 vccd1 vccd1 net525 sky130_fd_sc_hd__dlygate4sd3_1
Xhold32 spi_mem1.data_buf\[23\] vssd1 vssd1 vccd1 vccd1 net536 sky130_fd_sc_hd__dlygate4sd3_1
Xhold10 spi_mem0.data_buf\[12\] vssd1 vssd1 vccd1 vccd1 net514 sky130_fd_sc_hd__dlygate4sd3_1
Xhold54 _0082_ vssd1 vssd1 vccd1 vccd1 net558 sky130_fd_sc_hd__dlygate4sd3_1
Xhold87 spi_mem0.address\[2\] vssd1 vssd1 vccd1 vccd1 net591 sky130_fd_sc_hd__dlygate4sd3_1
Xhold43 spi_mem2.address\[6\] vssd1 vssd1 vccd1 vccd1 net547 sky130_fd_sc_hd__dlygate4sd3_1
Xhold76 spi_mem0.data_buf\[19\] vssd1 vssd1 vccd1 vccd1 net580 sky130_fd_sc_hd__dlygate4sd3_1
Xhold65 net344 vssd1 vssd1 vccd1 vccd1 net569 sky130_fd_sc_hd__dlygate4sd3_1
Xhold98 _0278_ vssd1 vssd1 vccd1 vccd1 net602 sky130_fd_sc_hd__dlygate4sd3_1
XFILLER_0_38_277 vssd1 vssd1 vccd1 vccd1 sky130_fd_sc_hd__decap_8
XANTENNA_7 net119 vssd1 vssd1 vccd1 vccd1 sky130_fd_sc_hd__diode_2
XFILLER_0_53_269 vssd1 vssd1 vccd1 vccd1 sky130_fd_sc_hd__decap_8
XFILLER_0_53_225 vssd1 vssd1 vccd1 vccd1 sky130_fd_sc_hd__fill_1
XFILLER_0_67_49 vssd1 vssd1 vccd1 vccd1 sky130_fd_sc_hd__decap_6
X_2120_ clknet_leaf_16_clk_i _0140_ net479 vssd1 vssd1 vccd1 vccd1 spi_mem1.address\[7\]
+ sky130_fd_sc_hd__dfrtp_1
XTAP_339 vssd1 vccd1 sky130_fd_sc_hd__tapvpwrvgnd_1
XTAP_306 vssd1 vccd1 sky130_fd_sc_hd__tapvpwrvgnd_1
XTAP_317 vssd1 vccd1 sky130_fd_sc_hd__tapvpwrvgnd_1
XFILLER_0_21_166 vssd1 vssd1 vccd1 vccd1 sky130_fd_sc_hd__fill_2
XFILLER_0_21_177 vssd1 vssd1 vccd1 vccd1 sky130_ef_sc_hd__decap_12
XTAP_328 vssd1 vccd1 sky130_fd_sc_hd__tapvpwrvgnd_1
X_1002_ spi_mem1.data_byte\[1\] vssd1 vssd1 vccd1 vccd1 _0931_ sky130_fd_sc_hd__inv_2
X_2051_ clknet_leaf_35_clk_i net725 net449 vssd1 vssd1 vccd1 vccd1 net274 sky130_fd_sc_hd__dfrtp_1
XFILLER_0_69_391 vssd1 vssd1 vccd1 vccd1 sky130_fd_sc_hd__fill_1
X_1835_ net248 _0361_ _0355_ vssd1 vssd1 vccd1 vccd1 _0816_ sky130_fd_sc_hd__o21a_1
X_1904_ spi_mem2.delayed_miso\[2\] _0967_ vssd1 vssd1 vccd1 vccd1 _0875_ sky130_fd_sc_hd__and2_2
XFILLER_0_32_85 vssd1 vssd1 vccd1 vccd1 sky130_fd_sc_hd__decap_4
XFILLER_0_29_233 vssd1 vssd1 vccd1 vccd1 sky130_fd_sc_hd__fill_1
XFILLER_0_8_127 vssd1 vssd1 vccd1 vccd1 sky130_fd_sc_hd__fill_1
XFILLER_0_8_149 vssd1 vssd1 vccd1 vccd1 sky130_fd_sc_hd__fill_2
X_1697_ net392 _0744_ _0362_ vssd1 vssd1 vccd1 vccd1 _0745_ sky130_fd_sc_hd__o21ai_4
X_1766_ net643 net404 _0785_ _0786_ vssd1 vssd1 vccd1 vccd1 _0262_ sky130_fd_sc_hd__a22o_1
X_2249_ clknet_leaf_26_clk_i _0263_ net465 vssd1 vssd1 vccd1 vccd1 spi_mem2.address_nibble\[0\]
+ sky130_fd_sc_hd__dfstp_2
X_2318_ clknet_leaf_36_clk_i _0326_ net448 vssd1 vssd1 vccd1 vccd1 spi_mem2.data_buf\[16\]
+ sky130_fd_sc_hd__dfrtp_1
XFILLER_0_82_309 vssd1 vssd1 vccd1 vccd1 sky130_fd_sc_hd__fill_1
XFILLER_0_79_155 vssd1 vssd1 vccd1 vccd1 sky130_fd_sc_hd__decap_6
XFILLER_0_75_383 vssd1 vssd1 vccd1 vccd1 sky130_fd_sc_hd__decap_8
Xinput133 sport1_i[52] vssd1 vssd1 vccd1 vccd1 net133 sky130_fd_sc_hd__clkbuf_2
Xinput122 sport1_i[42] vssd1 vssd1 vccd1 vccd1 net122 sky130_fd_sc_hd__buf_2
Xinput111 sport1_i[32] vssd1 vssd1 vccd1 vccd1 net111 sky130_fd_sc_hd__dlymetal6s2s_1
Xinput144 sport1_i[62] vssd1 vssd1 vccd1 vccd1 net144 sky130_fd_sc_hd__clkbuf_1
Xinput100 sport1_i[22] vssd1 vssd1 vccd1 vccd1 net100 sky130_fd_sc_hd__buf_1
XFILLER_0_9_3 vssd1 vssd1 vccd1 vccd1 sky130_fd_sc_hd__fill_2
XFILLER_0_58_306 vssd1 vssd1 vccd1 vccd1 sky130_fd_sc_hd__fill_2
Xinput177 sport2_i[2] vssd1 vssd1 vccd1 vccd1 net177 sky130_fd_sc_hd__clkbuf_1
Xinput188 sport2_i[3] vssd1 vssd1 vccd1 vccd1 net188 sky130_fd_sc_hd__clkbuf_1
Xinput199 sport2_i[4] vssd1 vssd1 vccd1 vccd1 net199 sky130_fd_sc_hd__clkbuf_2
Xinput155 sport2_i[0] vssd1 vssd1 vccd1 vccd1 net155 sky130_fd_sc_hd__clkbuf_1
Xinput166 sport2_i[1] vssd1 vssd1 vccd1 vccd1 net166 sky130_fd_sc_hd__clkbuf_1
XPHY_161 vssd1 vssd1 vccd1 vccd1 sky130_fd_sc_hd__decap_3
XPHY_150 vssd1 vssd1 vccd1 vccd1 sky130_fd_sc_hd__decap_3
XFILLER_0_66_350 vssd1 vssd1 vccd1 vccd1 sky130_fd_sc_hd__fill_1
X_1620_ spi_mem1.delayed_miso\[3\] _0982_ vssd1 vssd1 vccd1 vccd1 _0698_ sky130_fd_sc_hd__and2_4
X_1551_ spi_mem1.data_buf\[0\] _0978_ _0639_ spi_mem1.data_byte\[1\] vssd1 vssd1 vccd1
+ vccd1 _0640_ sky130_fd_sc_hd__a211o_1
XFILLER_0_1_369 vssd1 vssd1 vccd1 vccd1 sky130_fd_sc_hd__fill_2
X_1482_ net135 _0590_ _0597_ _0602_ _0606_ vssd1 vssd1 vccd1 vccd1 _0607_ sky130_fd_sc_hd__a2111o_2
X_2103_ clknet_leaf_33_clk_i _0123_ net462 vssd1 vssd1 vccd1 vccd1 spi_mem0.data_buf\[29\]
+ sky130_fd_sc_hd__dfrtp_1
XTAP_169 vssd1 vccd1 sky130_fd_sc_hd__tapvpwrvgnd_1
XFILLER_0_64_309 vssd1 vssd1 vccd1 vccd1 sky130_ef_sc_hd__decap_12
X_2034_ clknet_leaf_2_clk_i net731 net453 vssd1 vssd1 vccd1 vccd1 net289 sky130_fd_sc_hd__dfrtp_1
XFILLER_0_11_7 vssd1 vssd1 vccd1 vccd1 sky130_fd_sc_hd__fill_1
XFILLER_0_17_203 vssd1 vssd1 vccd1 vccd1 sky130_ef_sc_hd__decap_12
Xhold310 spi_mem2.address_nibble\[2\] vssd1 vssd1 vccd1 vccd1 net814 sky130_fd_sc_hd__dlygate4sd3_1
X_1818_ net576 net334 net380 vssd1 vssd1 vccd1 vccd1 _0285_ sky130_fd_sc_hd__mux2_1
XFILLER_0_17_225 vssd1 vssd1 vccd1 vccd1 sky130_fd_sc_hd__decap_6
XTAP_670 vssd1 vccd1 sky130_fd_sc_hd__tapvpwrvgnd_1
XFILLER_0_0_391 vssd1 vssd1 vccd1 vccd1 sky130_fd_sc_hd__fill_1
X_1749_ net546 _0775_ _0962_ vssd1 vssd1 vccd1 vccd1 _0256_ sky130_fd_sc_hd__mux2_1
XTAP_692 vssd1 vccd1 sky130_fd_sc_hd__tapvpwrvgnd_1
XTAP_681 vssd1 vccd1 sky130_fd_sc_hd__tapvpwrvgnd_1
XFILLER_0_67_169 vssd1 vssd1 vccd1 vccd1 sky130_fd_sc_hd__decap_8
XFILLER_0_48_29 vssd1 vssd1 vccd1 vccd1 sky130_fd_sc_hd__fill_1
XFILLER_0_23_206 vssd1 vssd1 vccd1 vccd1 sky130_fd_sc_hd__decap_3
XFILLER_0_80_27 vssd1 vssd1 vccd1 vccd1 sky130_fd_sc_hd__fill_1
XFILLER_0_46_309 vssd1 vssd1 vccd1 vccd1 sky130_fd_sc_hd__fill_1
XFILLER_0_39_372 vssd1 vssd1 vccd1 vccd1 sky130_fd_sc_hd__decap_3
XFILLER_0_54_386 vssd1 vssd1 vccd1 vccd1 sky130_ef_sc_hd__decap_12
XFILLER_0_14_228 vssd1 vssd1 vccd1 vccd1 sky130_fd_sc_hd__decap_4
X_1603_ net429 _0683_ vssd1 vssd1 vccd1 vccd1 _0686_ sky130_fd_sc_hd__nor2_1
X_1465_ _0592_ _0533_ spi_mem1.address_nibble\[0\] vssd1 vssd1 vccd1 vccd1 _0155_
+ sky130_fd_sc_hd__mux2_1
X_1534_ net703 net311 _0629_ vssd1 vssd1 vccd1 vccd1 _0187_ sky130_fd_sc_hd__mux2_1
XFILLER_0_38_51 vssd1 vssd1 vccd1 vccd1 sky130_fd_sc_hd__decap_8
X_1396_ net819 _0551_ _0548_ vssd1 vssd1 vccd1 vccd1 _0127_ sky130_fd_sc_hd__mux2_1
XFILLER_0_54_72 vssd1 vssd1 vccd1 vccd1 sky130_ef_sc_hd__decap_12
X_2017_ clknet_leaf_30_clk_i _0043_ net461 vssd1 vssd1 vccd1 vccd1 spi_mem0.address\[17\]
+ sky130_fd_sc_hd__dfrtp_1
XFILLER_0_70_93 vssd1 vssd1 vccd1 vccd1 sky130_fd_sc_hd__decap_4
XFILLER_0_45_364 vssd1 vssd1 vccd1 vccd1 sky130_ef_sc_hd__decap_12
XFILLER_0_9_211 vssd1 vssd1 vccd1 vccd1 sky130_fd_sc_hd__fill_1
XFILLER_0_9_266 vssd1 vssd1 vccd1 vccd1 sky130_ef_sc_hd__decap_12
XFILLER_0_79_91 vssd1 vssd1 vccd1 vccd1 sky130_fd_sc_hd__fill_1
XFILLER_0_72_183 vssd1 vssd1 vccd1 vccd1 sky130_ef_sc_hd__decap_12
Xhold151 spi_mem0.latency\[2\] vssd1 vssd1 vccd1 vccd1 net655 sky130_fd_sc_hd__dlygate4sd3_1
Xhold162 _0062_ vssd1 vssd1 vccd1 vccd1 net666 sky130_fd_sc_hd__dlygate4sd3_1
Xhold140 spi_mem2.data_buf\[2\] vssd1 vssd1 vccd1 vccd1 net644 sky130_fd_sc_hd__dlygate4sd3_1
Xhold195 spi_mem0.data_buf\[10\] vssd1 vssd1 vccd1 vccd1 net699 sky130_fd_sc_hd__dlygate4sd3_1
Xhold173 net349 vssd1 vssd1 vccd1 vccd1 net677 sky130_fd_sc_hd__dlygate4sd3_1
Xhold184 spi_mem0.address\[19\] vssd1 vssd1 vccd1 vccd1 net688 sky130_fd_sc_hd__dlygate4sd3_1
X_1986__10 clknet_leaf_18_clk_i vssd1 vssd1 vccd1 vccd1 net499 sky130_fd_sc_hd__inv_2
XFILLER_0_51_312 vssd1 vssd1 vccd1 vccd1 sky130_ef_sc_hd__decap_12
XFILLER_0_78_209 vssd1 vssd1 vccd1 vccd1 sky130_ef_sc_hd__decap_12
X_1181_ spi_mem0.state\[0\] _0343_ net377 vssd1 vssd1 vccd1 vccd1 _0413_ sky130_fd_sc_hd__nand3_1
X_1250_ spi_mem0.address\[18\] _0366_ net443 vssd1 vssd1 vccd1 vccd1 _0445_ sky130_fd_sc_hd__a21bo_1
XFILLER_0_39_191 vssd1 vssd1 vccd1 vccd1 sky130_fd_sc_hd__decap_4
XFILLER_0_6_214 vssd1 vssd1 vccd1 vccd1 sky130_fd_sc_hd__fill_1
Xoutput234 net234 vssd1 vssd1 vccd1 vccd1 spi0_sio_en_o[2] sky130_fd_sc_hd__clkbuf_4
XFILLER_0_54_150 vssd1 vssd1 vccd1 vccd1 sky130_fd_sc_hd__fill_1
XFILLER_0_42_389 vssd1 vssd1 vccd1 vccd1 sky130_ef_sc_hd__decap_12
XFILLER_0_40_85 vssd1 vssd1 vccd1 vccd1 sky130_fd_sc_hd__decap_3
XFILLER_0_6_236 vssd1 vssd1 vccd1 vccd1 sky130_fd_sc_hd__fill_2
Xoutput245 net245 vssd1 vssd1 vccd1 vccd1 spi1_sio_en_o[1] sky130_fd_sc_hd__clkbuf_4
Xoutput256 net256 vssd1 vssd1 vccd1 vccd1 spi2_sio_en_o[0] sky130_fd_sc_hd__clkbuf_4
X_1517_ net702 net720 net387 vssd1 vssd1 vccd1 vccd1 _0170_ sky130_fd_sc_hd__mux2_1
X_1448_ net129 _0579_ vssd1 vssd1 vccd1 vccd1 _0581_ sky130_fd_sc_hd__xnor2_1
XFILLER_0_4_85 vssd1 vssd1 vccd1 vccd1 sky130_fd_sc_hd__fill_2
Xoutput267 net267 vssd1 vssd1 vccd1 vccd1 sport0_o[16] sky130_fd_sc_hd__clkbuf_4
Xoutput289 net289 vssd1 vssd1 vccd1 vccd1 sport0_o[5] sky130_fd_sc_hd__clkbuf_4
XFILLER_0_10_286 vssd1 vssd1 vccd1 vccd1 sky130_ef_sc_hd__decap_12
Xoutput278 net278 vssd1 vssd1 vccd1 vccd1 sport0_o[26] sky130_fd_sc_hd__clkbuf_4
X_1379_ net541 net7 _0535_ vssd1 vssd1 vccd1 vccd1 _0126_ sky130_fd_sc_hd__mux2_1
XFILLER_0_4_96 vssd1 vssd1 vccd1 vccd1 sky130_fd_sc_hd__decap_4
XFILLER_0_33_345 vssd1 vssd1 vccd1 vccd1 sky130_fd_sc_hd__fill_1
XFILLER_0_60_197 vssd1 vssd1 vccd1 vccd1 sky130_ef_sc_hd__decap_12
Xfanout483 net484 vssd1 vssd1 vccd1 vccd1 net483 sky130_fd_sc_hd__clkbuf_4
Xfanout472 net473 vssd1 vssd1 vccd1 vccd1 net472 sky130_fd_sc_hd__clkbuf_4
Xfanout461 net466 vssd1 vssd1 vccd1 vccd1 net461 sky130_fd_sc_hd__clkbuf_4
Xfanout450 net489 vssd1 vssd1 vccd1 vccd1 net450 sky130_fd_sc_hd__buf_2
XFILLER_0_68_253 vssd1 vssd1 vccd1 vccd1 sky130_ef_sc_hd__decap_12
XFILLER_0_68_231 vssd1 vssd1 vccd1 vccd1 sky130_fd_sc_hd__fill_1
XFILLER_0_51_197 vssd1 vssd1 vccd1 vccd1 sky130_fd_sc_hd__fill_1
X_1233_ spi_mem0.data_buf\[8\] _0423_ net435 vssd1 vssd1 vccd1 vccd1 _0429_ sky130_fd_sc_hd__a21o_1
X_1302_ net39 net414 _0482_ _0488_ vssd1 vssd1 vccd1 vccd1 _0489_ sky130_fd_sc_hd__a22o_1
X_2282_ clknet_leaf_35_clk_i net512 net458 vssd1 vssd1 vccd1 vccd1 net346 sky130_fd_sc_hd__dfrtp_1
X_1095_ spi_mem2.latency\[3\] spi_mem2.latency\[4\] _0359_ vssd1 vssd1 vccd1 vccd1
+ _0360_ sky130_fd_sc_hd__nor3_1
XFILLER_0_35_30 vssd1 vssd1 vccd1 vccd1 sky130_fd_sc_hd__fill_2
X_1164_ net58 net57 net56 net55 vssd1 vssd1 vccd1 vccd1 _0396_ sky130_fd_sc_hd__or4_1
X_1997_ clknet_leaf_8_clk_i _0023_ net469 vssd1 vssd1 vccd1 vccd1 spi_mem0.latency\[3\]
+ sky130_fd_sc_hd__dfrtp_1
XFILLER_0_15_334 vssd1 vssd1 vccd1 vccd1 sky130_fd_sc_hd__fill_2
XFILLER_0_42_197 vssd1 vssd1 vccd1 vccd1 sky130_ef_sc_hd__decap_12
XFILLER_0_42_153 vssd1 vssd1 vccd1 vccd1 sky130_ef_sc_hd__decap_12
XFILLER_0_65_223 vssd1 vssd1 vccd1 vccd1 sky130_fd_sc_hd__fill_1
XFILLER_0_18_161 vssd1 vssd1 vccd1 vccd1 sky130_fd_sc_hd__fill_2
XFILLER_0_56_29 vssd1 vssd1 vccd1 vccd1 sky130_fd_sc_hd__decap_4
XFILLER_0_71_248 vssd1 vssd1 vccd1 vccd1 sky130_fd_sc_hd__decap_8
XFILLER_0_71_204 vssd1 vssd1 vccd1 vccd1 sky130_ef_sc_hd__decap_12
X_1920_ net423 _0927_ net420 vssd1 vssd1 vccd1 vccd1 _0885_ sky130_fd_sc_hd__and3b_2
X_1851_ net423 net420 spi_mem2.data_buf\[29\] vssd1 vssd1 vccd1 vccd1 _0831_ sky130_fd_sc_hd__and3_1
XFILLER_0_21_54 vssd1 vssd1 vccd1 vccd1 sky130_fd_sc_hd__fill_2
X_1782_ _0794_ net384 _0954_ _0956_ vssd1 vssd1 vccd1 vccd1 _0799_ sky130_fd_sc_hd__a211o_1
XFILLER_0_24_131 vssd1 vssd1 vccd1 vccd1 sky130_fd_sc_hd__fill_1
XFILLER_0_12_304 vssd1 vssd1 vccd1 vccd1 sky130_fd_sc_hd__decap_4
X_2334_ net235 vssd1 vssd1 vccd1 vccd1 net232 sky130_fd_sc_hd__clkbuf_1
X_2196_ clknet_leaf_9_clk_i _0210_ net476 vssd1 vssd1 vccd1 vccd1 spi_mem1.data_buf\[8\]
+ sky130_fd_sc_hd__dfrtp_1
X_2265_ clknet_leaf_38_clk_i net674 net446 vssd1 vssd1 vccd1 vccd1 net361 sky130_fd_sc_hd__dfrtp_1
X_1216_ net681 net275 net388 vssd1 vssd1 vccd1 vccd1 _0078_ sky130_fd_sc_hd__mux2_1
XFILLER_0_47_223 vssd1 vssd1 vccd1 vccd1 sky130_fd_sc_hd__fill_1
X_1078_ net442 net416 vssd1 vssd1 vccd1 vccd1 _0347_ sky130_fd_sc_hd__and2_2
X_1147_ net57 net600 net408 vssd1 vssd1 vccd1 vccd1 _0040_ sky130_fd_sc_hd__mux2_1
XFILLER_0_1_86 vssd1 vssd1 vccd1 vccd1 sky130_fd_sc_hd__fill_2
Xhold11 spi_mem1.data_buf\[11\] vssd1 vssd1 vccd1 vccd1 net515 sky130_fd_sc_hd__dlygate4sd3_1
Xhold22 spi_mem1.data_buf\[18\] vssd1 vssd1 vccd1 vccd1 net526 sky130_fd_sc_hd__dlygate4sd3_1
Xhold99 spi_mem1.data_buf\[17\] vssd1 vssd1 vccd1 vccd1 net603 sky130_fd_sc_hd__dlygate4sd3_1
Xhold77 _0074_ vssd1 vssd1 vccd1 vccd1 net581 sky130_fd_sc_hd__dlygate4sd3_1
Xhold55 spi_mem0.data_buf\[9\] vssd1 vssd1 vccd1 vccd1 net559 sky130_fd_sc_hd__dlygate4sd3_1
Xhold88 spi_mem0.address\[16\] vssd1 vssd1 vccd1 vccd1 net592 sky130_fd_sc_hd__dlygate4sd3_1
Xhold66 _0294_ vssd1 vssd1 vccd1 vccd1 net570 sky130_fd_sc_hd__dlygate4sd3_1
Xhold44 spi_mem0.address\[4\] vssd1 vssd1 vccd1 vccd1 net548 sky130_fd_sc_hd__dlygate4sd3_1
Xhold33 spi_mem2.address\[8\] vssd1 vssd1 vccd1 vccd1 net537 sky130_fd_sc_hd__dlygate4sd3_1
XANTENNA_8 net352 vssd1 vssd1 vccd1 vccd1 sky130_fd_sc_hd__diode_2
XFILLER_0_21_189 vssd1 vssd1 vccd1 vccd1 sky130_ef_sc_hd__decap_12
X_2050_ clknet_leaf_4_clk_i net714 net454 vssd1 vssd1 vccd1 vccd1 net273 sky130_fd_sc_hd__dfrtp_1
XTAP_329 vssd1 vccd1 sky130_fd_sc_hd__tapvpwrvgnd_1
XTAP_307 vssd1 vccd1 sky130_fd_sc_hd__tapvpwrvgnd_1
XTAP_318 vssd1 vccd1 sky130_fd_sc_hd__tapvpwrvgnd_1
XFILLER_0_76_329 vssd1 vssd1 vccd1 vccd1 sky130_ef_sc_hd__decap_12
XFILLER_0_76_307 vssd1 vssd1 vccd1 vccd1 sky130_fd_sc_hd__fill_1
X_1001_ spi_mem1.address_nibble\[2\] vssd1 vssd1 vccd1 vccd1 _0930_ sky130_fd_sc_hd__inv_2
XFILLER_0_29_212 vssd1 vssd1 vccd1 vccd1 sky130_ef_sc_hd__decap_12
XFILLER_0_44_259 vssd1 vssd1 vccd1 vccd1 sky130_ef_sc_hd__decap_12
XFILLER_0_32_53 vssd1 vssd1 vccd1 vccd1 sky130_fd_sc_hd__decap_4
XFILLER_0_4_323 vssd1 vssd1 vccd1 vccd1 sky130_fd_sc_hd__fill_1
X_1834_ net717 net740 net383 vssd1 vssd1 vccd1 vccd1 _0301_ sky130_fd_sc_hd__mux2_1
X_1765_ net203 _0783_ net406 vssd1 vssd1 vccd1 vccd1 _0786_ sky130_fd_sc_hd__o21a_1
X_1903_ net797 _0870_ _0874_ net366 vssd1 vssd1 vccd1 vccd1 _0311_ sky130_fd_sc_hd__a22o_1
X_1696_ _0967_ _0970_ vssd1 vssd1 vccd1 vccd1 _0744_ sky130_fd_sc_hd__or2_2
XFILLER_0_79_145 vssd1 vssd1 vccd1 vccd1 sky130_fd_sc_hd__fill_1
X_2179_ clknet_leaf_24_clk_i _0198_ net479 vssd1 vssd1 vccd1 vccd1 spi_mem0.data_ready
+ sky130_fd_sc_hd__dfrtp_1
X_2248_ clknet_leaf_29_clk_i _0262_ net461 vssd1 vssd1 vccd1 vccd1 spi_mem2.address\[21\]
+ sky130_fd_sc_hd__dfrtp_1
X_2317_ clknet_leaf_37_clk_i _0325_ net445 vssd1 vssd1 vccd1 vccd1 spi_mem2.data_buf\[15\]
+ sky130_fd_sc_hd__dfrtp_1
XFILLER_0_75_373 vssd1 vssd1 vccd1 vccd1 sky130_fd_sc_hd__fill_1
XFILLER_0_35_248 vssd1 vssd1 vccd1 vccd1 sky130_fd_sc_hd__fill_2
Xinput178 sport2_i[30] vssd1 vssd1 vccd1 vccd1 net178 sky130_fd_sc_hd__clkbuf_1
Xinput134 sport1_i[53] vssd1 vssd1 vccd1 vccd1 net134 sky130_fd_sc_hd__clkbuf_2
Xinput156 sport2_i[10] vssd1 vssd1 vccd1 vccd1 net156 sky130_fd_sc_hd__clkbuf_1
Xinput112 sport1_i[33] vssd1 vssd1 vccd1 vccd1 net112 sky130_fd_sc_hd__clkbuf_2
Xinput123 sport1_i[43] vssd1 vssd1 vccd1 vccd1 net123 sky130_fd_sc_hd__dlymetal6s2s_1
Xinput167 sport2_i[20] vssd1 vssd1 vccd1 vccd1 net167 sky130_fd_sc_hd__buf_1
Xinput145 sport1_i[63] vssd1 vssd1 vccd1 vccd1 net145 sky130_fd_sc_hd__clkbuf_1
Xinput101 sport1_i[23] vssd1 vssd1 vccd1 vccd1 net101 sky130_fd_sc_hd__buf_1
Xinput189 sport2_i[40] vssd1 vssd1 vccd1 vccd1 net189 sky130_fd_sc_hd__buf_1
XFILLER_0_81_310 vssd1 vssd1 vccd1 vccd1 sky130_fd_sc_hd__fill_1
XPHY_162 vssd1 vssd1 vccd1 vccd1 sky130_fd_sc_hd__decap_3
XPHY_151 vssd1 vssd1 vccd1 vccd1 sky130_fd_sc_hd__decap_3
XPHY_140 vssd1 vssd1 vccd1 vccd1 sky130_fd_sc_hd__decap_3
XFILLER_0_66_373 vssd1 vssd1 vccd1 vccd1 sky130_fd_sc_hd__decap_4
XFILLER_0_78_49 vssd1 vssd1 vccd1 vccd1 sky130_ef_sc_hd__decap_12
X_1550_ spi_mem1.data_buf\[8\] _0633_ _0634_ spi_mem1.data_buf\[4\] _0638_ vssd1 vssd1
+ vccd1 vccd1 _0639_ sky130_fd_sc_hd__a221o_1
X_1481_ _0595_ _0603_ _0604_ _0605_ vssd1 vssd1 vccd1 vccd1 _0606_ sky130_fd_sc_hd__or4_1
X_2033_ clknet_leaf_2_clk_i net733 net453 vssd1 vssd1 vccd1 vccd1 net288 sky130_fd_sc_hd__dfrtp_1
X_2102_ clknet_leaf_33_clk_i _0122_ net462 vssd1 vssd1 vccd1 vccd1 spi_mem0.data_buf\[28\]
+ sky130_fd_sc_hd__dfrtp_1
XFILLER_0_27_53 vssd1 vssd1 vccd1 vccd1 sky130_fd_sc_hd__decap_3
XFILLER_0_72_321 vssd1 vssd1 vccd1 vccd1 sky130_fd_sc_hd__fill_1
XFILLER_0_49_318 vssd1 vssd1 vccd1 vccd1 sky130_fd_sc_hd__decap_3
XFILLER_0_72_365 vssd1 vssd1 vccd1 vccd1 sky130_ef_sc_hd__decap_12
Xhold311 spi_mem1.data_ready vssd1 vssd1 vccd1 vccd1 net815 sky130_fd_sc_hd__dlygate4sd3_1
XFILLER_0_40_251 vssd1 vssd1 vccd1 vccd1 sky130_fd_sc_hd__fill_1
Xhold300 spi_mem0.address_nibble\[1\] vssd1 vssd1 vccd1 vccd1 net804 sky130_fd_sc_hd__dlygate4sd3_1
XFILLER_0_25_270 vssd1 vssd1 vccd1 vccd1 sky130_fd_sc_hd__decap_4
XFILLER_0_4_175 vssd1 vssd1 vccd1 vccd1 sky130_fd_sc_hd__fill_1
X_1748_ net196 _0771_ _0774_ vssd1 vssd1 vccd1 vccd1 _0775_ sky130_fd_sc_hd__a21bo_1
X_1817_ spi_mem2.data_buf\[14\] net610 net381 vssd1 vssd1 vccd1 vccd1 _0284_ sky130_fd_sc_hd__mux2_1
XTAP_693 vssd1 vccd1 sky130_fd_sc_hd__tapvpwrvgnd_1
XTAP_682 vssd1 vccd1 sky130_fd_sc_hd__tapvpwrvgnd_1
XTAP_671 vssd1 vccd1 sky130_fd_sc_hd__tapvpwrvgnd_1
XTAP_660 vssd1 vccd1 sky130_fd_sc_hd__tapvpwrvgnd_1
X_1679_ net105 net399 _0609_ _0698_ vssd1 vssd1 vccd1 vccd1 _0733_ sky130_fd_sc_hd__a22o_1
XFILLER_0_40_273 vssd1 vssd1 vccd1 vccd1 sky130_fd_sc_hd__decap_3
XFILLER_0_82_129 vssd1 vssd1 vccd1 vccd1 sky130_fd_sc_hd__decap_4
XFILLER_0_64_29 vssd1 vssd1 vccd1 vccd1 sky130_fd_sc_hd__decap_8
XFILLER_0_73_107 vssd1 vssd1 vccd1 vccd1 sky130_fd_sc_hd__decap_4
XFILLER_0_54_321 vssd1 vssd1 vccd1 vccd1 sky130_fd_sc_hd__fill_1
X_1602_ _0537_ _0683_ _0542_ vssd1 vssd1 vccd1 vccd1 _0685_ sky130_fd_sc_hd__o21ba_1
XFILLER_0_54_398 vssd1 vssd1 vccd1 vccd1 sky130_fd_sc_hd__decap_8
XFILLER_0_54_365 vssd1 vssd1 vccd1 vccd1 sky130_fd_sc_hd__decap_4
X_1395_ _0550_ vssd1 vssd1 vccd1 vccd1 _0551_ sky130_fd_sc_hd__inv_2
X_1464_ net411 _0533_ vssd1 vssd1 vccd1 vccd1 _0592_ sky130_fd_sc_hd__nand2_1
X_1533_ net743 net310 _0629_ vssd1 vssd1 vccd1 vccd1 _0186_ sky130_fd_sc_hd__mux2_1
XFILLER_0_38_85 vssd1 vssd1 vccd1 vccd1 sky130_ef_sc_hd__decap_12
XFILLER_0_54_51 vssd1 vssd1 vccd1 vccd1 sky130_fd_sc_hd__fill_1
X_2016_ clknet_leaf_25_clk_i _0042_ net464 vssd1 vssd1 vccd1 vccd1 spi_mem0.address\[16\]
+ sky130_fd_sc_hd__dfrtp_1
XFILLER_0_45_376 vssd1 vssd1 vccd1 vccd1 sky130_fd_sc_hd__decap_3
XFILLER_0_9_223 vssd1 vssd1 vccd1 vccd1 sky130_fd_sc_hd__fill_1
XFILLER_0_9_278 vssd1 vssd1 vccd1 vccd1 sky130_fd_sc_hd__fill_2
XFILLER_0_72_195 vssd1 vssd1 vccd1 vccd1 sky130_fd_sc_hd__fill_1
Xhold152 spi_mem2.latency\[2\] vssd1 vssd1 vccd1 vccd1 net656 sky130_fd_sc_hd__dlygate4sd3_1
Xhold163 spi_mem1.address\[0\] vssd1 vssd1 vccd1 vccd1 net667 sky130_fd_sc_hd__dlygate4sd3_1
XFILLER_0_45_398 vssd1 vssd1 vccd1 vccd1 sky130_fd_sc_hd__decap_8
Xhold174 _0299_ vssd1 vssd1 vccd1 vccd1 net678 sky130_fd_sc_hd__dlygate4sd3_1
Xhold130 net355 vssd1 vssd1 vccd1 vccd1 net634 sky130_fd_sc_hd__dlygate4sd3_1
Xhold141 spi_mem0.address\[15\] vssd1 vssd1 vccd1 vccd1 net645 sky130_fd_sc_hd__dlygate4sd3_1
Xhold185 spi_mem2.address\[12\] vssd1 vssd1 vccd1 vccd1 net689 sky130_fd_sc_hd__dlygate4sd3_1
XTAP_490 vssd1 vccd1 sky130_fd_sc_hd__tapvpwrvgnd_1
Xhold196 spi_mem0.data_buf\[13\] vssd1 vssd1 vccd1 vccd1 net700 sky130_fd_sc_hd__dlygate4sd3_1
XFILLER_0_55_107 vssd1 vssd1 vccd1 vccd1 sky130_fd_sc_hd__decap_4
XFILLER_0_36_321 vssd1 vssd1 vccd1 vccd1 sky130_ef_sc_hd__decap_12
XFILLER_0_63_195 vssd1 vssd1 vccd1 vccd1 sky130_fd_sc_hd__fill_2
XFILLER_0_51_324 vssd1 vssd1 vccd1 vccd1 sky130_ef_sc_hd__decap_12
XFILLER_0_36_365 vssd1 vssd1 vccd1 vccd1 sky130_ef_sc_hd__decap_12
X_1180_ _0403_ _0405_ _0410_ _0411_ vssd1 vssd1 vccd1 vccd1 _0412_ sky130_fd_sc_hd__nor4_1
XFILLER_0_27_376 vssd1 vssd1 vccd1 vccd1 sky130_ef_sc_hd__decap_12
Xoutput235 net235 vssd1 vssd1 vccd1 vccd1 spi0_sio_en_o[3] sky130_fd_sc_hd__clkbuf_4
Xoutput246 net246 vssd1 vssd1 vccd1 vccd1 spi1_sio_en_o[2] sky130_fd_sc_hd__clkbuf_4
Xoutput257 net257 vssd1 vssd1 vccd1 vccd1 spi2_sio_en_o[1] sky130_fd_sc_hd__clkbuf_4
Xoutput224 net224 vssd1 vssd1 vccd1 vccd1 spi0_clk_o sky130_fd_sc_hd__clkbuf_4
X_1516_ net690 net325 net386 vssd1 vssd1 vccd1 vccd1 _0169_ sky130_fd_sc_hd__mux2_1
Xoutput268 net268 vssd1 vssd1 vccd1 vccd1 sport0_o[17] sky130_fd_sc_hd__clkbuf_4
X_1378_ _0930_ net395 _0534_ vssd1 vssd1 vccd1 vccd1 _0535_ sky130_fd_sc_hd__and3_1
XFILLER_0_65_94 vssd1 vssd1 vccd1 vccd1 sky130_fd_sc_hd__decap_3
X_1447_ net412 _0578_ _0580_ _0577_ vssd1 vssd1 vccd1 vccd1 _0149_ sky130_fd_sc_hd__a31o_1
Xoutput279 net279 vssd1 vssd1 vccd1 vccd1 sport0_o[27] sky130_fd_sc_hd__clkbuf_4
XFILLER_0_10_298 vssd1 vssd1 vccd1 vccd1 sky130_fd_sc_hd__decap_8
XFILLER_0_18_321 vssd1 vssd1 vccd1 vccd1 sky130_fd_sc_hd__decap_4
Xfanout440 spi_mem0.data_nibble vssd1 vssd1 vccd1 vccd1 net440 sky130_fd_sc_hd__clkbuf_2
XFILLER_0_68_210 vssd1 vssd1 vccd1 vccd1 sky130_fd_sc_hd__fill_1
Xfanout484 net488 vssd1 vssd1 vccd1 vccd1 net484 sky130_fd_sc_hd__clkbuf_4
Xfanout473 net489 vssd1 vssd1 vccd1 vccd1 net473 sky130_fd_sc_hd__buf_2
Xfanout451 net456 vssd1 vssd1 vccd1 vccd1 net451 sky130_fd_sc_hd__clkbuf_4
Xfanout462 net463 vssd1 vssd1 vccd1 vccd1 net462 sky130_fd_sc_hd__clkbuf_4
XFILLER_0_68_265 vssd1 vssd1 vccd1 vccd1 sky130_ef_sc_hd__decap_12
XFILLER_0_68_243 vssd1 vssd1 vccd1 vccd1 sky130_fd_sc_hd__fill_1
XFILLER_0_51_165 vssd1 vssd1 vccd1 vccd1 sky130_fd_sc_hd__decap_3
XFILLER_0_51_143 vssd1 vssd1 vccd1 vccd1 sky130_fd_sc_hd__decap_6
XFILLER_0_51_121 vssd1 vssd1 vccd1 vccd1 sky130_fd_sc_hd__fill_2
XFILLER_0_36_195 vssd1 vssd1 vccd1 vccd1 sky130_fd_sc_hd__fill_1
X_1301_ spi_mem0.delayed_miso\[2\] _0344_ vssd1 vssd1 vccd1 vccd1 _0488_ sky130_fd_sc_hd__and2_2
X_1232_ spi_mem0.data_buf\[20\] _0425_ _0427_ _0424_ vssd1 vssd1 vccd1 vccd1 _0428_
+ sky130_fd_sc_hd__a211o_1
X_2281_ clknet_leaf_35_clk_i net554 net449 vssd1 vssd1 vccd1 vccd1 net345 sky130_fd_sc_hd__dfrtp_1
X_1094_ spi_mem2.latency\[1\] spi_mem2.latency\[0\] spi_mem2.latency\[2\] vssd1 vssd1
+ vccd1 vccd1 _0359_ sky130_fd_sc_hd__or3_2
XFILLER_0_59_298 vssd1 vssd1 vccd1 vccd1 sky130_fd_sc_hd__decap_6
X_1163_ net53 net52 net51 net54 vssd1 vssd1 vccd1 vccd1 _0395_ sky130_fd_sc_hd__o31a_1
XFILLER_0_19_107 vssd1 vssd1 vccd1 vccd1 sky130_fd_sc_hd__decap_4
X_1996_ clknet_leaf_10_clk_i _0022_ net474 vssd1 vssd1 vccd1 vccd1 spi_mem0.latency\[2\]
+ sky130_fd_sc_hd__dfrtp_1
XFILLER_0_42_132 vssd1 vssd1 vccd1 vccd1 sky130_fd_sc_hd__decap_8
XFILLER_0_27_151 vssd1 vssd1 vccd1 vccd1 sky130_fd_sc_hd__fill_1
XFILLER_0_62_3 vssd1 vssd1 vccd1 vccd1 sky130_fd_sc_hd__decap_8
XFILLER_0_42_165 vssd1 vssd1 vccd1 vccd1 sky130_fd_sc_hd__decap_8
XFILLER_0_2_251 vssd1 vssd1 vccd1 vccd1 sky130_fd_sc_hd__fill_1
XFILLER_0_76_82 vssd1 vssd1 vccd1 vccd1 sky130_fd_sc_hd__fill_2
XFILLER_0_80_205 vssd1 vssd1 vccd1 vccd1 sky130_fd_sc_hd__fill_2
XFILLER_0_65_279 vssd1 vssd1 vccd1 vccd1 sky130_fd_sc_hd__fill_1
X_1850_ _0830_ net605 _0818_ vssd1 vssd1 vccd1 vccd1 _0302_ sky130_fd_sc_hd__mux2_1
XFILLER_0_71_216 vssd1 vssd1 vccd1 vccd1 sky130_fd_sc_hd__decap_8
X_1781_ net205 net204 _0795_ _0796_ _0797_ vssd1 vssd1 vccd1 vccd1 _0798_ sky130_fd_sc_hd__a2111oi_2
XFILLER_0_21_11 vssd1 vssd1 vccd1 vccd1 sky130_fd_sc_hd__decap_3
X_2333_ clknet_leaf_31_clk_i _0341_ net459 vssd1 vssd1 vccd1 vccd1 spi_mem2.data_buf\[31\]
+ sky130_fd_sc_hd__dfrtp_1
X_2195_ clknet_leaf_11_clk_i _0209_ net476 vssd1 vssd1 vccd1 vccd1 spi_mem1.data_buf\[7\]
+ sky130_fd_sc_hd__dfrtp_1
XFILLER_0_46_85 vssd1 vssd1 vccd1 vccd1 sky130_ef_sc_hd__decap_12
X_2264_ clknet_leaf_39_clk_i net602 net444 vssd1 vssd1 vccd1 vccd1 net360 sky130_fd_sc_hd__dfrtp_1
X_1146_ net56 net539 net407 vssd1 vssd1 vccd1 vccd1 _0039_ sky130_fd_sc_hd__mux2_1
X_1215_ net724 net274 net388 vssd1 vssd1 vccd1 vccd1 _0077_ sky130_fd_sc_hd__mux2_1
XFILLER_0_47_268 vssd1 vssd1 vccd1 vccd1 sky130_fd_sc_hd__fill_2
X_1077_ spi_mem0.state\[1\] net441 spi_mem0.state\[3\] vssd1 vssd1 vccd1 vccd1 _0346_
+ sky130_fd_sc_hd__nor3b_1
XFILLER_0_47_202 vssd1 vssd1 vccd1 vccd1 sky130_fd_sc_hd__fill_2
XFILLER_0_1_65 vssd1 vssd1 vccd1 vccd1 sky130_fd_sc_hd__fill_1
XFILLER_0_70_293 vssd1 vssd1 vccd1 vccd1 sky130_fd_sc_hd__decap_6
XFILLER_0_7_343 vssd1 vssd1 vccd1 vccd1 sky130_fd_sc_hd__decap_8
Xhold34 spi_mem1.address\[11\] vssd1 vssd1 vccd1 vccd1 net538 sky130_fd_sc_hd__dlygate4sd3_1
Xhold45 spi_mem1.address\[12\] vssd1 vssd1 vccd1 vccd1 net549 sky130_fd_sc_hd__dlygate4sd3_1
Xhold12 _0173_ vssd1 vssd1 vccd1 vccd1 net516 sky130_fd_sc_hd__dlygate4sd3_1
XFILLER_0_30_179 vssd1 vssd1 vccd1 vccd1 sky130_fd_sc_hd__fill_2
XFILLER_0_11_393 vssd1 vssd1 vccd1 vccd1 sky130_fd_sc_hd__decap_4
Xhold23 spi_mem2.address\[9\] vssd1 vssd1 vccd1 vccd1 net527 sky130_fd_sc_hd__dlygate4sd3_1
Xhold56 _0064_ vssd1 vssd1 vccd1 vccd1 net560 sky130_fd_sc_hd__dlygate4sd3_1
Xhold89 spi_mem1.address\[20\] vssd1 vssd1 vccd1 vccd1 net593 sky130_fd_sc_hd__dlygate4sd3_1
Xhold67 spi_mem1.data_buf\[21\] vssd1 vssd1 vccd1 vccd1 net571 sky130_fd_sc_hd__dlygate4sd3_1
Xhold78 spi_mem2.address\[17\] vssd1 vssd1 vccd1 vccd1 net582 sky130_fd_sc_hd__dlygate4sd3_1
XFILLER_0_53_216 vssd1 vssd1 vccd1 vccd1 sky130_fd_sc_hd__fill_1
XTAP_308 vssd1 vccd1 sky130_fd_sc_hd__tapvpwrvgnd_1
XTAP_319 vssd1 vccd1 sky130_fd_sc_hd__tapvpwrvgnd_1
XFILLER_0_21_102 vssd1 vssd1 vccd1 vccd1 sky130_fd_sc_hd__decap_8
XFILLER_0_21_113 vssd1 vssd1 vccd1 vccd1 sky130_ef_sc_hd__decap_12
X_1000_ spi_mem0.latency\[3\] vssd1 vssd1 vccd1 vccd1 _0929_ sky130_fd_sc_hd__inv_2
XFILLER_0_69_360 vssd1 vssd1 vccd1 vccd1 sky130_ef_sc_hd__decap_12
XFILLER_0_29_279 vssd1 vssd1 vccd1 vccd1 sky130_fd_sc_hd__fill_1
X_1902_ net166 net401 _0869_ _0873_ vssd1 vssd1 vccd1 vccd1 _0874_ sky130_fd_sc_hd__a22o_1
XFILLER_0_44_249 vssd1 vssd1 vccd1 vccd1 sky130_fd_sc_hd__decap_3
XFILLER_0_4_346 vssd1 vssd1 vccd1 vccd1 sky130_fd_sc_hd__fill_2
X_1764_ net203 _0783_ vssd1 vssd1 vccd1 vccd1 _0785_ sky130_fd_sc_hd__nand2_1
X_1833_ spi_mem2.data_buf\[30\] net626 net380 vssd1 vssd1 vccd1 vccd1 _0300_ sky130_fd_sc_hd__mux2_1
X_1695_ net668 net12 _0743_ vssd1 vssd1 vccd1 vccd1 _0234_ sky130_fd_sc_hd__mux2_1
X_2316_ clknet_leaf_38_clk_i _0324_ net447 vssd1 vssd1 vccd1 vccd1 spi_mem2.data_buf\[14\]
+ sky130_fd_sc_hd__dfrtp_1
XFILLER_0_79_113 vssd1 vssd1 vccd1 vccd1 sky130_ef_sc_hd__decap_12
X_2178_ clknet_leaf_17_clk_i _0197_ net483 vssd1 vssd1 vccd1 vccd1 net243 sky130_fd_sc_hd__dfrtp_1
XFILLER_0_73_72 vssd1 vssd1 vccd1 vccd1 sky130_fd_sc_hd__decap_3
X_1129_ _0929_ _0388_ _0387_ _0377_ vssd1 vssd1 vccd1 vccd1 _0023_ sky130_fd_sc_hd__o2bb2a_1
XFILLER_0_25_3 vssd1 vssd1 vccd1 vccd1 sky130_fd_sc_hd__fill_1
X_2247_ clknet_leaf_29_clk_i _0261_ net461 vssd1 vssd1 vccd1 vccd1 spi_mem2.address\[20\]
+ sky130_fd_sc_hd__dfrtp_1
XFILLER_0_75_330 vssd1 vssd1 vccd1 vccd1 sky130_fd_sc_hd__decap_6
XFILLER_0_7_140 vssd1 vssd1 vccd1 vccd1 sky130_fd_sc_hd__fill_1
XFILLER_0_7_173 vssd1 vssd1 vccd1 vccd1 sky130_fd_sc_hd__fill_1
Xinput113 sport1_i[34] vssd1 vssd1 vccd1 vccd1 net113 sky130_fd_sc_hd__dlymetal6s2s_1
Xinput146 sport1_i[64] vssd1 vssd1 vccd1 vccd1 net146 sky130_fd_sc_hd__buf_2
Xinput124 sport1_i[44] vssd1 vssd1 vccd1 vccd1 net124 sky130_fd_sc_hd__buf_2
Xinput102 sport1_i[24] vssd1 vssd1 vccd1 vccd1 net102 sky130_fd_sc_hd__dlymetal6s2s_1
Xinput135 sport1_i[54] vssd1 vssd1 vccd1 vccd1 net135 sky130_fd_sc_hd__buf_1
Xinput157 sport2_i[11] vssd1 vssd1 vccd1 vccd1 net157 sky130_fd_sc_hd__clkbuf_1
Xinput168 sport2_i[21] vssd1 vssd1 vccd1 vccd1 net168 sky130_fd_sc_hd__clkbuf_1
Xinput179 sport2_i[31] vssd1 vssd1 vccd1 vccd1 net179 sky130_fd_sc_hd__clkbuf_1
XPHY_152 vssd1 vssd1 vccd1 vccd1 sky130_fd_sc_hd__decap_3
XPHY_141 vssd1 vssd1 vccd1 vccd1 sky130_fd_sc_hd__decap_3
XPHY_130 vssd1 vssd1 vccd1 vccd1 sky130_fd_sc_hd__decap_3
XPHY_163 vssd1 vssd1 vccd1 vccd1 sky130_fd_sc_hd__decap_3
XFILLER_0_26_249 vssd1 vssd1 vccd1 vccd1 sky130_fd_sc_hd__decap_3
XFILLER_0_26_205 vssd1 vssd1 vccd1 vccd1 sky130_ef_sc_hd__decap_12
X_1480_ net143 net142 net140 net139 vssd1 vssd1 vccd1 vccd1 _0605_ sky130_fd_sc_hd__or4_1
X_2101_ clknet_leaf_34_clk_i _0121_ net463 vssd1 vssd1 vccd1 vccd1 spi_mem0.data_buf\[27\]
+ sky130_fd_sc_hd__dfrtp_1
XFILLER_0_27_76 vssd1 vssd1 vccd1 vccd1 sky130_fd_sc_hd__decap_4
X_2032_ clknet_leaf_1_clk_i net763 net451 vssd1 vssd1 vccd1 vccd1 net287 sky130_fd_sc_hd__dfrtp_1
XFILLER_0_76_138 vssd1 vssd1 vccd1 vccd1 sky130_fd_sc_hd__fill_2
XFILLER_0_72_377 vssd1 vssd1 vccd1 vccd1 sky130_fd_sc_hd__fill_1
X_1678_ net619 _0729_ _0732_ net371 vssd1 vssd1 vccd1 vccd1 _0228_ sky130_fd_sc_hd__a22o_1
Xhold312 spi_mem2.state\[2\] vssd1 vssd1 vccd1 vccd1 net816 sky130_fd_sc_hd__dlygate4sd3_1
XFILLER_0_32_219 vssd1 vssd1 vccd1 vccd1 sky130_ef_sc_hd__decap_12
X_1747_ _0765_ _0773_ vssd1 vssd1 vccd1 vccd1 _0774_ sky130_fd_sc_hd__or2_1
Xhold301 spi_mem2.data_buf\[24\] vssd1 vssd1 vccd1 vccd1 net805 sky130_fd_sc_hd__dlygate4sd3_1
X_1816_ net739 net757 net381 vssd1 vssd1 vccd1 vccd1 _0283_ sky130_fd_sc_hd__mux2_1
XTAP_694 vssd1 vccd1 sky130_fd_sc_hd__tapvpwrvgnd_1
XTAP_683 vssd1 vccd1 sky130_fd_sc_hd__tapvpwrvgnd_1
XTAP_672 vssd1 vccd1 sky130_fd_sc_hd__tapvpwrvgnd_1
XTAP_661 vssd1 vccd1 sky130_fd_sc_hd__tapvpwrvgnd_1
XTAP_650 vssd1 vccd1 sky130_fd_sc_hd__tapvpwrvgnd_1
XFILLER_0_68_83 vssd1 vssd1 vccd1 vccd1 sky130_fd_sc_hd__fill_1
XFILLER_0_82_108 vssd1 vssd1 vccd1 vccd1 sky130_fd_sc_hd__fill_1
XFILLER_0_48_363 vssd1 vssd1 vccd1 vccd1 sky130_fd_sc_hd__fill_1
XFILLER_0_80_29 vssd1 vssd1 vccd1 vccd1 sky130_fd_sc_hd__decap_6
XFILLER_0_58_149 vssd1 vssd1 vccd1 vccd1 sky130_fd_sc_hd__decap_6
XFILLER_0_39_352 vssd1 vssd1 vccd1 vccd1 sky130_ef_sc_hd__decap_12
X_1601_ _0684_ net430 _0682_ vssd1 vssd1 vccd1 vccd1 _0199_ sky130_fd_sc_hd__mux2_1
X_1532_ net536 net309 net385 vssd1 vssd1 vccd1 vccd1 _0185_ sky130_fd_sc_hd__mux2_1
XFILLER_0_22_285 vssd1 vssd1 vccd1 vccd1 sky130_fd_sc_hd__decap_4
X_1394_ spi_mem1.latency\[0\] _0538_ _0549_ vssd1 vssd1 vccd1 vccd1 _0550_ sky130_fd_sc_hd__o21ba_1
X_1463_ net513 _0591_ net413 vssd1 vssd1 vccd1 vccd1 _0154_ sky130_fd_sc_hd__mux2_1
XFILLER_0_38_97 vssd1 vssd1 vccd1 vccd1 sky130_ef_sc_hd__decap_12
XFILLER_0_54_85 vssd1 vssd1 vccd1 vccd1 sky130_ef_sc_hd__decap_12
X_2015_ clknet_leaf_30_clk_i _0041_ net459 vssd1 vssd1 vccd1 vccd1 spi_mem0.address\[15\]
+ sky130_fd_sc_hd__dfrtp_1
XFILLER_0_45_388 vssd1 vssd1 vccd1 vccd1 sky130_fd_sc_hd__decap_4
Xhold164 spi_mem2.has_2lc vssd1 vssd1 vccd1 vccd1 net668 sky130_fd_sc_hd__dlygate4sd3_1
Xhold186 spi_mem1.data_buf\[7\] vssd1 vssd1 vccd1 vccd1 net690 sky130_fd_sc_hd__dlygate4sd3_1
Xhold197 net266 vssd1 vssd1 vccd1 vccd1 net701 sky130_fd_sc_hd__dlygate4sd3_1
Xhold175 spi_mem0.data_buf\[28\] vssd1 vssd1 vccd1 vccd1 net679 sky130_fd_sc_hd__dlygate4sd3_1
Xhold142 spi_mem2.data_buf\[11\] vssd1 vssd1 vccd1 vccd1 net646 sky130_fd_sc_hd__dlygate4sd3_1
Xhold120 net335 vssd1 vssd1 vccd1 vccd1 net624 sky130_fd_sc_hd__dlygate4sd3_1
Xhold131 _0273_ vssd1 vssd1 vccd1 vccd1 net635 sky130_fd_sc_hd__dlygate4sd3_1
Xhold153 spi_mem2.data_buf\[21\] vssd1 vssd1 vccd1 vccd1 net657 sky130_fd_sc_hd__dlygate4sd3_1
XTAP_491 vssd1 vccd1 sky130_fd_sc_hd__tapvpwrvgnd_1
XTAP_480 vssd1 vccd1 sky130_fd_sc_hd__tapvpwrvgnd_1
XFILLER_0_36_333 vssd1 vssd1 vccd1 vccd1 sky130_ef_sc_hd__decap_12
XFILLER_0_36_377 vssd1 vssd1 vccd1 vccd1 sky130_fd_sc_hd__decap_3
XFILLER_0_59_403 vssd1 vssd1 vccd1 vccd1 sky130_fd_sc_hd__decap_4
XFILLER_0_46_108 vssd1 vssd1 vccd1 vccd1 sky130_ef_sc_hd__decap_12
XFILLER_0_40_76 vssd1 vssd1 vccd1 vccd1 sky130_fd_sc_hd__fill_1
XFILLER_0_40_54 vssd1 vssd1 vccd1 vccd1 sky130_fd_sc_hd__fill_1
XFILLER_0_27_388 vssd1 vssd1 vccd1 vccd1 sky130_fd_sc_hd__decap_4
Xoutput247 net247 vssd1 vssd1 vccd1 vccd1 spi1_sio_en_o[3] sky130_fd_sc_hd__clkbuf_4
Xoutput258 net258 vssd1 vssd1 vccd1 vccd1 spi2_sio_en_o[2] sky130_fd_sc_hd__clkbuf_4
Xoutput236 net236 vssd1 vssd1 vccd1 vccd1 spi1_clk_o sky130_fd_sc_hd__clkbuf_4
Xoutput225 net225 vssd1 vssd1 vccd1 vccd1 spi0_cs_o sky130_fd_sc_hd__clkbuf_4
X_1515_ net694 net324 net387 vssd1 vssd1 vccd1 vccd1 _0168_ sky130_fd_sc_hd__mux2_1
XFILLER_0_10_277 vssd1 vssd1 vccd1 vccd1 sky130_fd_sc_hd__fill_1
Xoutput269 net269 vssd1 vssd1 vccd1 vccd1 sport0_o[18] sky130_fd_sc_hd__clkbuf_4
X_1377_ spi_mem1.address_nibble\[0\] spi_mem1.address_nibble\[1\] vssd1 vssd1 vccd1
+ vccd1 _0534_ sky130_fd_sc_hd__and2b_2
X_1446_ _0579_ vssd1 vssd1 vccd1 vccd1 _0580_ sky130_fd_sc_hd__inv_2
XFILLER_0_4_76 vssd1 vssd1 vccd1 vccd1 sky130_fd_sc_hd__fill_2
XFILLER_0_65_406 vssd1 vssd1 vccd1 vccd1 sky130_fd_sc_hd__fill_1
XFILLER_0_60_155 vssd1 vssd1 vccd1 vccd1 sky130_fd_sc_hd__fill_1
Xfanout430 spi_mem1.data_nibble vssd1 vssd1 vccd1 vccd1 net430 sky130_fd_sc_hd__clkbuf_4
Xfanout474 net476 vssd1 vssd1 vccd1 vccd1 net474 sky130_fd_sc_hd__clkbuf_4
Xfanout441 spi_mem0.state\[2\] vssd1 vssd1 vccd1 vccd1 net441 sky130_fd_sc_hd__buf_2
XFILLER_0_41_391 vssd1 vssd1 vccd1 vccd1 sky130_fd_sc_hd__fill_1
Xfanout452 net456 vssd1 vssd1 vccd1 vccd1 net452 sky130_fd_sc_hd__buf_2
Xfanout463 net466 vssd1 vssd1 vccd1 vccd1 net463 sky130_fd_sc_hd__clkbuf_4
Xfanout485 net487 vssd1 vssd1 vccd1 vccd1 net485 sky130_fd_sc_hd__clkbuf_4
XFILLER_0_68_277 vssd1 vssd1 vccd1 vccd1 sky130_fd_sc_hd__decap_4
XFILLER_0_36_141 vssd1 vssd1 vccd1 vccd1 sky130_fd_sc_hd__decap_3
XFILLER_0_3_208 vssd1 vssd1 vccd1 vccd1 sky130_fd_sc_hd__fill_1
X_1162_ _0376_ _0390_ _0394_ net443 vssd1 vssd1 vccd1 vccd1 _0050_ sky130_fd_sc_hd__a2bb2o_1
XFILLER_0_35_21 vssd1 vssd1 vccd1 vccd1 sky130_fd_sc_hd__fill_1
X_1231_ spi_mem0.data_buf\[16\] _0349_ _0426_ spi_mem0.data_buf\[28\] vssd1 vssd1
+ vccd1 vccd1 _0427_ sky130_fd_sc_hd__a22o_1
X_1300_ net798 _0483_ _0487_ net372 vssd1 vssd1 vccd1 vccd1 _0095_ sky130_fd_sc_hd__a22o_1
X_2280_ clknet_leaf_37_clk_i net570 net448 vssd1 vssd1 vccd1 vccd1 net344 sky130_fd_sc_hd__dfrtp_1
XFILLER_0_59_266 vssd1 vssd1 vccd1 vccd1 sky130_ef_sc_hd__decap_12
XFILLER_0_47_406 vssd1 vssd1 vccd1 vccd1 sky130_fd_sc_hd__fill_1
X_1093_ _0960_ net392 vssd1 vssd1 vccd1 vccd1 _0358_ sky130_fd_sc_hd__nand2_1
XFILLER_0_35_98 vssd1 vssd1 vccd1 vccd1 sky130_ef_sc_hd__decap_12
X_1995_ clknet_leaf_9_clk_i _0021_ net474 vssd1 vssd1 vccd1 vccd1 spi_mem0.latency\[1\]
+ sky130_fd_sc_hd__dfrtp_1
XFILLER_0_42_111 vssd1 vssd1 vccd1 vccd1 sky130_fd_sc_hd__fill_1
XFILLER_0_76_61 vssd1 vssd1 vccd1 vccd1 sky130_fd_sc_hd__decap_4
X_1429_ net124 _0564_ vssd1 vssd1 vccd1 vccd1 _0567_ sky130_fd_sc_hd__xnor2_1
XFILLER_0_55_3 vssd1 vssd1 vccd1 vccd1 sky130_ef_sc_hd__decap_12
XFILLER_0_23_391 vssd1 vssd1 vccd1 vccd1 sky130_fd_sc_hd__fill_1
XFILLER_0_38_406 vssd1 vssd1 vccd1 vccd1 sky130_fd_sc_hd__fill_1
XFILLER_0_33_155 vssd1 vssd1 vccd1 vccd1 sky130_fd_sc_hd__decap_4
X_1780_ spi_mem2.spi_clk net215 vssd1 vssd1 vccd1 vccd1 _0797_ sky130_fd_sc_hd__nand2_2
X_2332_ clknet_leaf_30_clk_i _0340_ net457 vssd1 vssd1 vccd1 vccd1 spi_mem2.data_buf\[30\]
+ sky130_fd_sc_hd__dfrtp_1
X_2194_ clknet_leaf_12_clk_i _0208_ net474 vssd1 vssd1 vccd1 vccd1 spi_mem1.data_buf\[6\]
+ sky130_fd_sc_hd__dfrtp_1
XFILLER_0_46_97 vssd1 vssd1 vccd1 vccd1 sky130_fd_sc_hd__fill_2
X_1214_ net713 net273 net389 vssd1 vssd1 vccd1 vccd1 _0076_ sky130_fd_sc_hd__mux2_1
X_1145_ net55 net561 net408 vssd1 vssd1 vccd1 vccd1 _0038_ sky130_fd_sc_hd__mux2_1
X_2263_ clknet_leaf_38_clk_i net564 net444 vssd1 vssd1 vccd1 vccd1 net359 sky130_fd_sc_hd__dfrtp_1
XFILLER_0_62_228 vssd1 vssd1 vccd1 vccd1 sky130_fd_sc_hd__fill_2
XFILLER_0_62_41 vssd1 vssd1 vccd1 vccd1 sky130_fd_sc_hd__fill_1
X_1076_ net442 _0343_ vssd1 vssd1 vccd1 vccd1 _0345_ sky130_fd_sc_hd__or2_1
XFILLER_0_47_247 vssd1 vssd1 vccd1 vccd1 sky130_fd_sc_hd__decap_3
XFILLER_0_11_350 vssd1 vssd1 vccd1 vccd1 sky130_ef_sc_hd__decap_12
Xhold13 spi_mem1.address\[9\] vssd1 vssd1 vccd1 vccd1 net517 sky130_fd_sc_hd__dlygate4sd3_1
Xhold68 _0183_ vssd1 vssd1 vccd1 vccd1 net572 sky130_fd_sc_hd__dlygate4sd3_1
Xhold57 spi_mem0.address\[12\] vssd1 vssd1 vccd1 vccd1 net561 sky130_fd_sc_hd__dlygate4sd3_1
Xhold79 spi_mem0.address\[5\] vssd1 vssd1 vccd1 vccd1 net583 sky130_fd_sc_hd__dlygate4sd3_1
Xhold35 spi_mem0.address\[13\] vssd1 vssd1 vccd1 vccd1 net539 sky130_fd_sc_hd__dlygate4sd3_1
Xhold24 spi_mem2.address\[13\] vssd1 vssd1 vccd1 vccd1 net528 sky130_fd_sc_hd__dlygate4sd3_1
Xhold46 spi_mem2.data_buf\[18\] vssd1 vssd1 vccd1 vccd1 net550 sky130_fd_sc_hd__dlygate4sd3_1
XFILLER_0_61_294 vssd1 vssd1 vccd1 vccd1 sky130_fd_sc_hd__fill_1
XTAP_309 vssd1 vccd1 sky130_fd_sc_hd__tapvpwrvgnd_1
XFILLER_0_44_217 vssd1 vssd1 vccd1 vccd1 sky130_fd_sc_hd__fill_2
X_1901_ spi_mem2.delayed_miso\[1\] _0967_ vssd1 vssd1 vccd1 vccd1 _0873_ sky130_fd_sc_hd__and2_4
XFILLER_0_29_225 vssd1 vssd1 vccd1 vccd1 sky130_fd_sc_hd__fill_2
XFILLER_0_29_203 vssd1 vssd1 vccd1 vccd1 sky130_fd_sc_hd__fill_1
X_1832_ spi_mem2.data_buf\[29\] net677 net383 vssd1 vssd1 vccd1 vccd1 _0299_ sky130_fd_sc_hd__mux2_1
X_1694_ _0926_ _0740_ _0742_ vssd1 vssd1 vccd1 vccd1 _0743_ sky130_fd_sc_hd__and3_1
X_1763_ _0783_ _0784_ net796 net404 vssd1 vssd1 vccd1 vccd1 _0261_ sky130_fd_sc_hd__a2bb2o_1
XFILLER_0_12_136 vssd1 vssd1 vccd1 vccd1 sky130_fd_sc_hd__decap_4
X_2246_ clknet_leaf_29_clk_i _0260_ net461 vssd1 vssd1 vccd1 vccd1 spi_mem2.address\[19\]
+ sky130_fd_sc_hd__dfrtp_1
X_2315_ clknet_leaf_37_clk_i _0323_ net449 vssd1 vssd1 vccd1 vccd1 spi_mem2.data_buf\[13\]
+ sky130_fd_sc_hd__dfrtp_1
X_2177_ clknet_leaf_17_clk_i _0196_ net484 vssd1 vssd1 vccd1 vccd1 net242 sky130_fd_sc_hd__dfrtp_1
XFILLER_0_79_125 vssd1 vssd1 vccd1 vccd1 sky130_fd_sc_hd__decap_6
XFILLER_0_73_95 vssd1 vssd1 vccd1 vccd1 sky130_ef_sc_hd__decap_12
X_1128_ _0377_ _0386_ vssd1 vssd1 vccd1 vccd1 _0388_ sky130_fd_sc_hd__nand2b_1
X_1059_ _0970_ _0972_ _0974_ _0967_ net764 vssd1 vssd1 vccd1 vccd1 _0986_ sky130_fd_sc_hd__a32o_1
XFILLER_0_18_3 vssd1 vssd1 vccd1 vccd1 sky130_fd_sc_hd__fill_2
XFILLER_0_50_209 vssd1 vssd1 vccd1 vccd1 sky130_ef_sc_hd__decap_12
XFILLER_0_7_196 vssd1 vssd1 vccd1 vccd1 sky130_fd_sc_hd__fill_1
XFILLER_0_43_294 vssd1 vssd1 vccd1 vccd1 sky130_fd_sc_hd__decap_4
Xinput103 sport1_i[25] vssd1 vssd1 vccd1 vccd1 net103 sky130_fd_sc_hd__dlymetal6s2s_1
Xinput147 sport1_i[65] vssd1 vssd1 vccd1 vccd1 net147 sky130_fd_sc_hd__clkbuf_2
Xinput114 sport1_i[35] vssd1 vssd1 vccd1 vccd1 net114 sky130_fd_sc_hd__dlymetal6s2s_1
Xinput169 sport2_i[22] vssd1 vssd1 vccd1 vccd1 net169 sky130_fd_sc_hd__clkbuf_1
Xinput125 sport1_i[45] vssd1 vssd1 vccd1 vccd1 net125 sky130_fd_sc_hd__clkbuf_2
Xinput136 sport1_i[55] vssd1 vssd1 vccd1 vccd1 net136 sky130_fd_sc_hd__clkbuf_1
Xinput158 sport2_i[12] vssd1 vssd1 vccd1 vccd1 net158 sky130_fd_sc_hd__clkbuf_1
XPHY_164 vssd1 vssd1 vccd1 vccd1 sky130_fd_sc_hd__decap_3
XPHY_153 vssd1 vssd1 vccd1 vccd1 sky130_fd_sc_hd__decap_3
XPHY_142 vssd1 vssd1 vccd1 vccd1 sky130_fd_sc_hd__decap_3
XFILLER_0_66_342 vssd1 vssd1 vccd1 vccd1 sky130_fd_sc_hd__decap_8
XPHY_131 vssd1 vssd1 vccd1 vccd1 sky130_fd_sc_hd__decap_3
XPHY_120 vssd1 vssd1 vccd1 vccd1 sky130_fd_sc_hd__decap_3
XFILLER_0_26_217 vssd1 vssd1 vccd1 vccd1 sky130_ef_sc_hd__decap_12
XFILLER_0_81_389 vssd1 vssd1 vccd1 vccd1 sky130_fd_sc_hd__decap_3
XFILLER_0_81_334 vssd1 vssd1 vccd1 vccd1 sky130_fd_sc_hd__fill_2
XFILLER_0_78_29 vssd1 vssd1 vccd1 vccd1 sky130_ef_sc_hd__decap_12
X_2100_ clknet_leaf_34_clk_i _0120_ net455 vssd1 vssd1 vccd1 vccd1 spi_mem0.data_buf\[26\]
+ sky130_fd_sc_hd__dfrtp_1
XFILLER_0_27_33 vssd1 vssd1 vccd1 vccd1 sky130_fd_sc_hd__decap_3
XFILLER_0_43_65 vssd1 vssd1 vccd1 vccd1 sky130_ef_sc_hd__decap_12
XPHY_0 vssd1 vssd1 vccd1 vccd1 sky130_fd_sc_hd__decap_3
X_2031_ clknet_leaf_1_clk_i _0057_ net451 vssd1 vssd1 vccd1 vccd1 net282 sky130_fd_sc_hd__dfrtp_1
XFILLER_0_4_100 vssd1 vssd1 vccd1 vccd1 sky130_fd_sc_hd__fill_1
X_1815_ spi_mem2.data_buf\[12\] net650 net379 vssd1 vssd1 vccd1 vccd1 _0282_ sky130_fd_sc_hd__mux2_1
Xhold313 spi_mem1.address\[16\] vssd1 vssd1 vccd1 vccd1 net817 sky130_fd_sc_hd__dlygate4sd3_1
X_1677_ net104 net399 _0609_ _0696_ vssd1 vssd1 vccd1 vccd1 _0732_ sky130_fd_sc_hd__a22o_1
XFILLER_0_40_253 vssd1 vssd1 vccd1 vccd1 sky130_ef_sc_hd__decap_12
X_1746_ net196 net195 net194 vssd1 vssd1 vccd1 vccd1 _0773_ sky130_fd_sc_hd__or3_1
Xhold302 spi_mem2.data_buf\[27\] vssd1 vssd1 vccd1 vccd1 net806 sky130_fd_sc_hd__dlygate4sd3_1
XTAP_695 vssd1 vccd1 sky130_fd_sc_hd__tapvpwrvgnd_1
XTAP_684 vssd1 vccd1 sky130_fd_sc_hd__tapvpwrvgnd_1
XTAP_673 vssd1 vccd1 sky130_fd_sc_hd__tapvpwrvgnd_1
XTAP_662 vssd1 vccd1 sky130_fd_sc_hd__tapvpwrvgnd_1
XTAP_651 vssd1 vccd1 sky130_fd_sc_hd__tapvpwrvgnd_1
XTAP_640 vssd1 vccd1 sky130_fd_sc_hd__tapvpwrvgnd_1
X_2229_ clknet_leaf_28_clk_i _0243_ net460 vssd1 vssd1 vccd1 vccd1 spi_mem2.address\[2\]
+ sky130_fd_sc_hd__dfrtp_1
XFILLER_0_63_334 vssd1 vssd1 vccd1 vccd1 sky130_fd_sc_hd__fill_2
XFILLER_0_31_253 vssd1 vssd1 vccd1 vccd1 sky130_fd_sc_hd__fill_2
XFILLER_0_31_275 vssd1 vssd1 vccd1 vccd1 sky130_fd_sc_hd__decap_4
XFILLER_0_7_3 vssd1 vssd1 vccd1 vccd1 sky130_fd_sc_hd__fill_2
XFILLER_0_81_164 vssd1 vssd1 vccd1 vccd1 sky130_fd_sc_hd__fill_1
XFILLER_0_39_364 vssd1 vssd1 vccd1 vccd1 sky130_fd_sc_hd__fill_1
X_1600_ _0976_ net394 _0683_ vssd1 vssd1 vccd1 vccd1 _0684_ sky130_fd_sc_hd__a21o_1
X_1462_ net134 _0588_ vssd1 vssd1 vccd1 vccd1 _0591_ sky130_fd_sc_hd__xor2_1
X_1531_ net509 net308 net385 vssd1 vssd1 vccd1 vccd1 _0184_ sky130_fd_sc_hd__mux2_1
XFILLER_0_22_253 vssd1 vssd1 vccd1 vccd1 sky130_ef_sc_hd__decap_12
X_1393_ spi_mem1.has_2lc _0537_ vssd1 vssd1 vccd1 vccd1 _0549_ sky130_fd_sc_hd__nor2_1
XFILLER_0_70_41 vssd1 vssd1 vccd1 vccd1 sky130_fd_sc_hd__decap_3
XFILLER_0_54_97 vssd1 vssd1 vccd1 vccd1 sky130_fd_sc_hd__decap_6
X_2014_ clknet_leaf_33_clk_i _0040_ net462 vssd1 vssd1 vccd1 vccd1 spi_mem0.address\[14\]
+ sky130_fd_sc_hd__dfrtp_1
XFILLER_0_9_225 vssd1 vssd1 vccd1 vccd1 sky130_ef_sc_hd__decap_12
XFILLER_0_72_197 vssd1 vssd1 vccd1 vccd1 sky130_fd_sc_hd__fill_2
XFILLER_0_70_74 vssd1 vssd1 vccd1 vccd1 sky130_fd_sc_hd__decap_3
Xhold110 spi_mem0.address\[11\] vssd1 vssd1 vccd1 vccd1 net614 sky130_fd_sc_hd__dlygate4sd3_1
XFILLER_0_79_83 vssd1 vssd1 vccd1 vccd1 sky130_fd_sc_hd__decap_8
Xhold198 spi_mem1.data_buf\[8\] vssd1 vssd1 vccd1 vccd1 net702 sky130_fd_sc_hd__dlygate4sd3_1
Xhold187 _0169_ vssd1 vssd1 vccd1 vccd1 net691 sky130_fd_sc_hd__dlygate4sd3_1
Xhold143 spi_mem1.address\[7\] vssd1 vssd1 vccd1 vccd1 net647 sky130_fd_sc_hd__dlygate4sd3_1
Xhold176 _0083_ vssd1 vssd1 vccd1 vccd1 net680 sky130_fd_sc_hd__dlygate4sd3_1
Xhold165 spi_mem2.data_buf\[23\] vssd1 vssd1 vccd1 vccd1 net669 sky130_fd_sc_hd__dlygate4sd3_1
Xhold121 _0286_ vssd1 vssd1 vccd1 vccd1 net625 sky130_fd_sc_hd__dlygate4sd3_1
Xhold132 spi_mem2.address\[7\] vssd1 vssd1 vccd1 vccd1 net636 sky130_fd_sc_hd__dlygate4sd3_1
Xhold154 _0291_ vssd1 vssd1 vccd1 vccd1 net658 sky130_fd_sc_hd__dlygate4sd3_1
X_1729_ _0922_ net527 net405 vssd1 vssd1 vccd1 vccd1 _0250_ sky130_fd_sc_hd__mux2_1
XFILLER_0_68_404 vssd1 vssd1 vccd1 vccd1 sky130_fd_sc_hd__decap_3
XTAP_492 vssd1 vccd1 sky130_fd_sc_hd__tapvpwrvgnd_1
XTAP_481 vssd1 vccd1 sky130_fd_sc_hd__tapvpwrvgnd_1
XTAP_470 vssd1 vccd1 sky130_fd_sc_hd__tapvpwrvgnd_1
XFILLER_0_63_164 vssd1 vssd1 vccd1 vccd1 sky130_fd_sc_hd__decap_4
XFILLER_0_36_345 vssd1 vssd1 vccd1 vccd1 sky130_ef_sc_hd__decap_12
XFILLER_0_51_337 vssd1 vssd1 vccd1 vccd1 sky130_ef_sc_hd__decap_12
XFILLER_0_36_389 vssd1 vssd1 vccd1 vccd1 sky130_ef_sc_hd__decap_12
XFILLER_0_24_89 vssd1 vssd1 vccd1 vccd1 sky130_ef_sc_hd__decap_12
XFILLER_0_54_197 vssd1 vssd1 vccd1 vccd1 sky130_fd_sc_hd__decap_6
XFILLER_0_27_334 vssd1 vssd1 vccd1 vccd1 sky130_fd_sc_hd__fill_2
Xoutput248 net248 vssd1 vssd1 vccd1 vccd1 spi2_clk_o sky130_fd_sc_hd__clkbuf_4
Xoutput237 net237 vssd1 vssd1 vccd1 vccd1 spi1_cs_o sky130_fd_sc_hd__clkbuf_4
Xoutput226 net226 vssd1 vssd1 vccd1 vccd1 spi0_dqsm_en_o sky130_fd_sc_hd__clkbuf_4
Xoutput259 net259 vssd1 vssd1 vccd1 vccd1 spi2_sio_en_o[3] sky130_fd_sc_hd__clkbuf_4
X_1514_ net778 net323 net387 vssd1 vssd1 vccd1 vccd1 _0167_ sky130_fd_sc_hd__mux2_1
Xclkbuf_2_3__f_clk_i clknet_0_clk_i vssd1 vssd1 vccd1 vccd1 clknet_2_3__leaf_clk_i
+ sky130_fd_sc_hd__clkbuf_16
X_1445_ net125 net124 _0564_ _0574_ net128 vssd1 vssd1 vccd1 vccd1 _0579_ sky130_fd_sc_hd__o41a_4
X_1376_ _0936_ _0939_ vssd1 vssd1 vccd1 vccd1 _0533_ sky130_fd_sc_hd__nand2_1
XFILLER_0_65_63 vssd1 vssd1 vccd1 vccd1 sky130_fd_sc_hd__fill_1
XFILLER_0_65_41 vssd1 vssd1 vccd1 vccd1 sky130_ef_sc_hd__decap_12
XFILLER_0_81_62 vssd1 vssd1 vccd1 vccd1 sky130_ef_sc_hd__decap_12
XFILLER_0_18_334 vssd1 vssd1 vccd1 vccd1 sky130_ef_sc_hd__decap_12
XFILLER_0_60_134 vssd1 vssd1 vccd1 vccd1 sky130_fd_sc_hd__decap_6
XFILLER_0_33_337 vssd1 vssd1 vccd1 vccd1 sky130_fd_sc_hd__decap_4
Xfanout486 net487 vssd1 vssd1 vccd1 vccd1 net486 sky130_fd_sc_hd__clkbuf_4
Xfanout475 net476 vssd1 vssd1 vccd1 vccd1 net475 sky130_fd_sc_hd__clkbuf_4
Xfanout431 spi_mem1.data_nibble vssd1 vssd1 vccd1 vccd1 net431 sky130_fd_sc_hd__clkbuf_4
Xfanout442 spi_mem0.state\[0\] vssd1 vssd1 vccd1 vccd1 net442 sky130_fd_sc_hd__buf_2
Xfanout453 net456 vssd1 vssd1 vccd1 vccd1 net453 sky130_fd_sc_hd__clkbuf_4
Xfanout464 net466 vssd1 vssd1 vccd1 vccd1 net464 sky130_fd_sc_hd__clkbuf_4
Xfanout420 net421 vssd1 vssd1 vccd1 vccd1 net420 sky130_fd_sc_hd__buf_2
X_1979__3 clknet_leaf_17_clk_i vssd1 vssd1 vccd1 vccd1 net492 sky130_fd_sc_hd__inv_2
XFILLER_0_68_289 vssd1 vssd1 vccd1 vccd1 sky130_ef_sc_hd__decap_12
XFILLER_0_10_25 vssd1 vssd1 vccd1 vccd1 sky130_fd_sc_hd__decap_3
X_1092_ _0953_ _0965_ _0355_ vssd1 vssd1 vccd1 vccd1 _0357_ sky130_fd_sc_hd__a21o_1
X_1161_ spi_mem0.address_nibble\[0\] spi_mem0.address_nibble\[1\] _0390_ vssd1 vssd1
+ vccd1 vccd1 _0394_ sky130_fd_sc_hd__or3_1
XFILLER_0_35_55 vssd1 vssd1 vccd1 vccd1 sky130_fd_sc_hd__fill_1
X_1230_ net439 net437 vssd1 vssd1 vccd1 vccd1 _0426_ sky130_fd_sc_hd__and2_2
X_1994_ clknet_leaf_10_clk_i _0020_ net474 vssd1 vssd1 vccd1 vccd1 spi_mem0.latency\[0\]
+ sky130_fd_sc_hd__dfrtp_2
XFILLER_0_59_278 vssd1 vssd1 vccd1 vccd1 sky130_fd_sc_hd__fill_2
XFILLER_0_59_245 vssd1 vssd1 vccd1 vccd1 sky130_ef_sc_hd__decap_12
XFILLER_0_59_223 vssd1 vssd1 vccd1 vccd1 sky130_fd_sc_hd__fill_1
XFILLER_0_30_307 vssd1 vssd1 vccd1 vccd1 sky130_fd_sc_hd__fill_1
XFILLER_0_76_73 vssd1 vssd1 vccd1 vccd1 sky130_fd_sc_hd__fill_1
X_1428_ net538 _0566_ net413 vssd1 vssd1 vccd1 vccd1 _0144_ sky130_fd_sc_hd__mux2_1
XFILLER_0_48_3 vssd1 vssd1 vccd1 vccd1 sky130_ef_sc_hd__decap_12
XFILLER_0_65_215 vssd1 vssd1 vccd1 vccd1 sky130_fd_sc_hd__fill_1
X_1359_ net34 net417 _0479_ _0486_ vssd1 vssd1 vccd1 vccd1 _0523_ sky130_fd_sc_hd__a22o_1
XFILLER_0_18_186 vssd1 vssd1 vccd1 vccd1 sky130_fd_sc_hd__decap_3
XFILLER_0_33_167 vssd1 vssd1 vccd1 vccd1 sky130_fd_sc_hd__fill_1
XFILLER_0_24_101 vssd1 vssd1 vccd1 vccd1 sky130_ef_sc_hd__decap_12
XFILLER_0_12_329 vssd1 vssd1 vccd1 vccd1 sky130_fd_sc_hd__decap_6
X_1213_ net628 net272 net390 vssd1 vssd1 vccd1 vccd1 _0075_ sky130_fd_sc_hd__mux2_1
X_2331_ clknet_leaf_31_clk_i _0339_ net457 vssd1 vssd1 vccd1 vccd1 spi_mem2.data_buf\[29\]
+ sky130_fd_sc_hd__dfrtp_1
X_2262_ clknet_leaf_1_clk_i net519 net446 vssd1 vssd1 vccd1 vccd1 net358 sky130_fd_sc_hd__dfrtp_1
XFILLER_0_79_329 vssd1 vssd1 vccd1 vccd1 sky130_fd_sc_hd__fill_1
X_2193_ clknet_leaf_11_clk_i _0207_ net476 vssd1 vssd1 vccd1 vccd1 spi_mem1.data_buf\[5\]
+ sky130_fd_sc_hd__dfrtp_1
X_1075_ net442 _0343_ vssd1 vssd1 vccd1 vccd1 _0344_ sky130_fd_sc_hd__nor2_1
XFILLER_0_1_23 vssd1 vssd1 vccd1 vccd1 sky130_fd_sc_hd__fill_1
X_1144_ net54 net614 net408 vssd1 vssd1 vccd1 vccd1 _0037_ sky130_fd_sc_hd__mux2_1
X_1977_ net717 _0914_ _0918_ net364 vssd1 vssd1 vccd1 vccd1 _0341_ sky130_fd_sc_hd__a22o_1
XFILLER_0_15_145 vssd1 vssd1 vccd1 vccd1 sky130_fd_sc_hd__fill_1
XFILLER_0_30_126 vssd1 vssd1 vccd1 vccd1 sky130_fd_sc_hd__fill_1
XFILLER_0_11_362 vssd1 vssd1 vccd1 vccd1 sky130_fd_sc_hd__fill_2
XFILLER_0_11_373 vssd1 vssd1 vccd1 vccd1 sky130_fd_sc_hd__decap_3
XFILLER_0_15_167 vssd1 vssd1 vccd1 vccd1 sky130_fd_sc_hd__fill_1
Xhold25 spi_mem1.latency\[5\] vssd1 vssd1 vccd1 vccd1 net529 sky130_fd_sc_hd__dlygate4sd3_1
Xhold58 spi_mem1.address\[3\] vssd1 vssd1 vccd1 vccd1 net562 sky130_fd_sc_hd__dlygate4sd3_1
Xhold36 spi_mem2.address\[10\] vssd1 vssd1 vccd1 vccd1 net540 sky130_fd_sc_hd__dlygate4sd3_1
Xhold69 spi_mem0.address\[21\] vssd1 vssd1 vccd1 vccd1 net573 sky130_fd_sc_hd__dlygate4sd3_1
Xhold47 _0288_ vssd1 vssd1 vccd1 vccd1 net551 sky130_fd_sc_hd__dlygate4sd3_1
Xhold14 spi_mem2.data_buf\[6\] vssd1 vssd1 vccd1 vccd1 net518 sky130_fd_sc_hd__dlygate4sd3_1
XFILLER_0_78_362 vssd1 vssd1 vccd1 vccd1 sky130_fd_sc_hd__fill_2
XFILLER_0_16_57 vssd1 vssd1 vccd1 vccd1 sky130_fd_sc_hd__decap_4
XFILLER_0_37_281 vssd1 vssd1 vccd1 vccd1 sky130_fd_sc_hd__decap_4
XFILLER_0_32_89 vssd1 vssd1 vccd1 vccd1 sky130_fd_sc_hd__fill_1
XFILLER_0_32_23 vssd1 vssd1 vccd1 vccd1 sky130_fd_sc_hd__decap_4
X_1900_ net749 _0870_ _0872_ net362 vssd1 vssd1 vccd1 vccd1 _0310_ sky130_fd_sc_hd__a22o_1
X_1831_ spi_mem2.data_buf\[28\] net588 net380 vssd1 vssd1 vccd1 vccd1 _0298_ sky130_fd_sc_hd__mux2_1
XFILLER_0_52_262 vssd1 vssd1 vccd1 vccd1 sky130_ef_sc_hd__decap_12
X_1693_ spi_mem2.address_nibble\[0\] spi_mem2.address_nibble\[1\] vssd1 vssd1 vccd1
+ vccd1 _0742_ sky130_fd_sc_hd__and2b_2
X_1762_ net202 _0780_ net406 vssd1 vssd1 vccd1 vccd1 _0784_ sky130_fd_sc_hd__o21ai_1
XFILLER_0_12_126 vssd1 vssd1 vccd1 vccd1 sky130_fd_sc_hd__decap_3
X_2176_ clknet_leaf_17_clk_i _0195_ net483 vssd1 vssd1 vccd1 vccd1 net241 sky130_fd_sc_hd__dfrtp_1
X_2245_ clknet_leaf_27_clk_i _0259_ net464 vssd1 vssd1 vccd1 vccd1 spi_mem2.address\[18\]
+ sky130_fd_sc_hd__dfrtp_1
X_2314_ clknet_leaf_38_clk_i _0322_ net445 vssd1 vssd1 vccd1 vccd1 spi_mem2.data_buf\[12\]
+ sky130_fd_sc_hd__dfrtp_1
XFILLER_0_73_63 vssd1 vssd1 vccd1 vccd1 sky130_fd_sc_hd__fill_1
XFILLER_0_73_41 vssd1 vssd1 vccd1 vccd1 sky130_ef_sc_hd__decap_12
X_1127_ _0371_ _0386_ _0379_ vssd1 vssd1 vccd1 vccd1 _0387_ sky130_fd_sc_hd__o21ba_1
X_1058_ _0973_ vssd1 vssd1 vccd1 vccd1 _0974_ sky130_fd_sc_hd__inv_2
XFILLER_0_35_218 vssd1 vssd1 vccd1 vccd1 sky130_fd_sc_hd__decap_6
Xinput126 sport1_i[46] vssd1 vssd1 vccd1 vccd1 net126 sky130_fd_sc_hd__clkbuf_2
Xinput104 sport1_i[26] vssd1 vssd1 vccd1 vccd1 net104 sky130_fd_sc_hd__dlymetal6s2s_1
Xinput115 sport1_i[36] vssd1 vssd1 vccd1 vccd1 net115 sky130_fd_sc_hd__buf_1
Xinput148 sport1_i[66] vssd1 vssd1 vccd1 vccd1 net148 sky130_fd_sc_hd__clkbuf_4
Xinput137 sport1_i[56] vssd1 vssd1 vccd1 vccd1 net137 sky130_fd_sc_hd__clkbuf_1
Xinput159 sport2_i[13] vssd1 vssd1 vccd1 vccd1 net159 sky130_fd_sc_hd__clkbuf_1
XPHY_165 vssd1 vssd1 vccd1 vccd1 sky130_fd_sc_hd__decap_3
XFILLER_0_81_357 vssd1 vssd1 vccd1 vccd1 sky130_ef_sc_hd__decap_12
XPHY_154 vssd1 vssd1 vccd1 vccd1 sky130_fd_sc_hd__decap_3
XPHY_143 vssd1 vssd1 vccd1 vccd1 sky130_fd_sc_hd__decap_3
XFILLER_0_66_387 vssd1 vssd1 vccd1 vccd1 sky130_fd_sc_hd__fill_1
XPHY_132 vssd1 vssd1 vccd1 vccd1 sky130_fd_sc_hd__decap_3
XPHY_121 vssd1 vssd1 vccd1 vccd1 sky130_fd_sc_hd__decap_3
XPHY_110 vssd1 vssd1 vccd1 vccd1 sky130_fd_sc_hd__decap_3
XFILLER_0_26_229 vssd1 vssd1 vccd1 vccd1 sky130_ef_sc_hd__decap_12
X_2030_ clknet_leaf_1_clk_i net761 net451 vssd1 vssd1 vccd1 vccd1 net271 sky130_fd_sc_hd__dfrtp_1
XFILLER_0_43_77 vssd1 vssd1 vccd1 vccd1 sky130_ef_sc_hd__decap_12
XPHY_1 vssd1 vssd1 vccd1 vccd1 sky130_fd_sc_hd__decap_3
X_1814_ spi_mem2.data_buf\[11\] net639 net379 vssd1 vssd1 vccd1 vccd1 _0281_ sky130_fd_sc_hd__mux2_1
X_1745_ net664 net406 _0770_ _0772_ vssd1 vssd1 vccd1 vccd1 _0255_ sky130_fd_sc_hd__o22a_1
XFILLER_0_17_218 vssd1 vssd1 vccd1 vccd1 sky130_fd_sc_hd__decap_6
XTAP_652 vssd1 vccd1 sky130_fd_sc_hd__tapvpwrvgnd_1
Xhold314 spi_mem0.latency\[0\] vssd1 vssd1 vccd1 vccd1 net818 sky130_fd_sc_hd__dlygate4sd3_1
XTAP_641 vssd1 vccd1 sky130_fd_sc_hd__tapvpwrvgnd_1
XTAP_630 vssd1 vccd1 sky130_fd_sc_hd__tapvpwrvgnd_1
X_1676_ net703 _0729_ _0731_ net371 vssd1 vssd1 vccd1 vccd1 _0227_ sky130_fd_sc_hd__a22o_1
Xhold303 spi_mem1.data_buf\[1\] vssd1 vssd1 vccd1 vccd1 net807 sky130_fd_sc_hd__dlygate4sd3_1
XFILLER_0_40_298 vssd1 vssd1 vccd1 vccd1 sky130_fd_sc_hd__decap_8
XFILLER_0_40_265 vssd1 vssd1 vccd1 vccd1 sky130_fd_sc_hd__decap_8
XTAP_696 vssd1 vccd1 sky130_fd_sc_hd__tapvpwrvgnd_1
XTAP_685 vssd1 vccd1 sky130_fd_sc_hd__tapvpwrvgnd_1
XTAP_674 vssd1 vccd1 sky130_fd_sc_hd__tapvpwrvgnd_1
XTAP_663 vssd1 vccd1 sky130_fd_sc_hd__tapvpwrvgnd_1
X_2159_ clknet_leaf_6_clk_i net604 net470 vssd1 vssd1 vccd1 vccd1 net302 sky130_fd_sc_hd__dfrtp_2
XFILLER_0_30_3 vssd1 vssd1 vccd1 vccd1 sky130_ef_sc_hd__decap_12
X_2228_ clknet_leaf_27_clk_i _0242_ net464 vssd1 vssd1 vccd1 vccd1 spi_mem2.address\[1\]
+ sky130_fd_sc_hd__dfrtp_1
XFILLER_0_75_184 vssd1 vssd1 vccd1 vccd1 sky130_fd_sc_hd__fill_1
XFILLER_0_63_313 vssd1 vssd1 vccd1 vccd1 sky130_fd_sc_hd__fill_1
XFILLER_0_48_321 vssd1 vssd1 vccd1 vccd1 sky130_fd_sc_hd__decap_3
XFILLER_0_16_251 vssd1 vssd1 vccd1 vccd1 sky130_fd_sc_hd__fill_1
XFILLER_0_66_195 vssd1 vssd1 vccd1 vccd1 sky130_fd_sc_hd__fill_1
X_1392_ net395 _0537_ _0543_ _0544_ _0547_ vssd1 vssd1 vccd1 vccd1 _0548_ sky130_fd_sc_hd__o2111a_2
X_1530_ net571 net307 net387 vssd1 vssd1 vccd1 vccd1 _0183_ sky130_fd_sc_hd__mux2_1
X_1461_ net129 _0579_ _0585_ net133 net134 vssd1 vssd1 vccd1 vccd1 _0590_ sky130_fd_sc_hd__o2111a_1
XFILLER_0_22_276 vssd1 vssd1 vccd1 vccd1 sky130_fd_sc_hd__fill_1
XFILLER_0_22_265 vssd1 vssd1 vccd1 vccd1 sky130_fd_sc_hd__fill_2
XFILLER_0_77_405 vssd1 vssd1 vccd1 vccd1 sky130_fd_sc_hd__fill_2
XFILLER_0_38_77 vssd1 vssd1 vccd1 vccd1 sky130_fd_sc_hd__decap_6
X_2013_ clknet_leaf_30_clk_i _0039_ net461 vssd1 vssd1 vccd1 vccd1 spi_mem0.address\[13\]
+ sky130_fd_sc_hd__dfrtp_1
XFILLER_0_45_335 vssd1 vssd1 vccd1 vccd1 sky130_fd_sc_hd__fill_1
XFILLER_0_9_237 vssd1 vssd1 vccd1 vccd1 sky130_fd_sc_hd__decap_6
Xhold111 net230 vssd1 vssd1 vccd1 vccd1 net615 sky130_fd_sc_hd__dlygate4sd3_1
XFILLER_0_78_3 vssd1 vssd1 vccd1 vccd1 sky130_fd_sc_hd__decap_4
XFILLER_0_72_176 vssd1 vssd1 vccd1 vccd1 sky130_fd_sc_hd__fill_1
Xhold100 _0179_ vssd1 vssd1 vccd1 vccd1 net604 sky130_fd_sc_hd__dlygate4sd3_1
XFILLER_0_53_390 vssd1 vssd1 vccd1 vccd1 sky130_fd_sc_hd__fill_2
Xhold133 spi_mem0.data_buf\[25\] vssd1 vssd1 vccd1 vccd1 net637 sky130_fd_sc_hd__dlygate4sd3_1
Xhold144 spi_mem0.data_buf\[31\] vssd1 vssd1 vccd1 vccd1 net648 sky130_fd_sc_hd__dlygate4sd3_1
Xhold122 net351 vssd1 vssd1 vccd1 vccd1 net626 sky130_fd_sc_hd__dlygate4sd3_1
X_1728_ net189 net537 net405 vssd1 vssd1 vccd1 vccd1 _0249_ sky130_fd_sc_hd__mux2_1
Xhold155 spi_mem1.address\[10\] vssd1 vssd1 vccd1 vccd1 net659 sky130_fd_sc_hd__dlygate4sd3_1
Xhold199 spi_mem1.data_buf\[25\] vssd1 vssd1 vccd1 vccd1 net703 sky130_fd_sc_hd__dlygate4sd3_1
Xhold188 spi_mem1.data_buf\[16\] vssd1 vssd1 vccd1 vccd1 net692 sky130_fd_sc_hd__dlygate4sd3_1
X_1659_ net526 _0718_ _0721_ net370 vssd1 vssd1 vccd1 vccd1 _0220_ sky130_fd_sc_hd__a22o_1
XTAP_493 vssd1 vccd1 sky130_fd_sc_hd__tapvpwrvgnd_1
XTAP_482 vssd1 vccd1 sky130_fd_sc_hd__tapvpwrvgnd_1
XTAP_471 vssd1 vccd1 sky130_fd_sc_hd__tapvpwrvgnd_1
XTAP_460 vssd1 vccd1 sky130_fd_sc_hd__tapvpwrvgnd_1
Xhold177 spi_mem0.data_buf\[23\] vssd1 vssd1 vccd1 vccd1 net681 sky130_fd_sc_hd__dlygate4sd3_1
Xhold166 _0293_ vssd1 vssd1 vccd1 vccd1 net670 sky130_fd_sc_hd__dlygate4sd3_1
XFILLER_0_63_187 vssd1 vssd1 vccd1 vccd1 sky130_fd_sc_hd__fill_1
XFILLER_0_48_195 vssd1 vssd1 vccd1 vccd1 sky130_fd_sc_hd__fill_1
XFILLER_0_48_173 vssd1 vssd1 vccd1 vccd1 sky130_fd_sc_hd__fill_2
XFILLER_0_36_357 vssd1 vssd1 vccd1 vccd1 sky130_fd_sc_hd__decap_6
XFILLER_0_51_349 vssd1 vssd1 vccd1 vccd1 sky130_fd_sc_hd__fill_1
XFILLER_0_39_195 vssd1 vssd1 vccd1 vccd1 sky130_fd_sc_hd__fill_1
XFILLER_0_24_35 vssd1 vssd1 vccd1 vccd1 sky130_fd_sc_hd__fill_1
XFILLER_0_27_357 vssd1 vssd1 vccd1 vccd1 sky130_ef_sc_hd__decap_12
Xoutput249 net249 vssd1 vssd1 vccd1 vccd1 spi2_cs_o sky130_fd_sc_hd__clkbuf_4
Xoutput238 net238 vssd1 vssd1 vccd1 vccd1 spi1_dqsm_en_o sky130_fd_sc_hd__clkbuf_4
Xoutput227 net227 vssd1 vssd1 vccd1 vccd1 spi0_dqsm_o sky130_fd_sc_hd__clkbuf_4
X_1375_ _0936_ _0939_ vssd1 vssd1 vccd1 vccd1 _0532_ sky130_fd_sc_hd__and2_1
X_1513_ net748 net753 net387 vssd1 vssd1 vccd1 vccd1 _0166_ sky130_fd_sc_hd__mux2_1
X_1444_ net128 _0575_ vssd1 vssd1 vccd1 vccd1 _0578_ sky130_fd_sc_hd__or2_1
XFILLER_0_10_213 vssd1 vssd1 vccd1 vccd1 sky130_fd_sc_hd__decap_6
XFILLER_0_81_52 vssd1 vssd1 vccd1 vccd1 sky130_fd_sc_hd__decap_4
XFILLER_0_65_53 vssd1 vssd1 vccd1 vccd1 sky130_fd_sc_hd__decap_3
XFILLER_0_77_279 vssd1 vssd1 vccd1 vccd1 sky130_fd_sc_hd__fill_1
XFILLER_0_60_113 vssd1 vssd1 vccd1 vccd1 sky130_fd_sc_hd__fill_1
XFILLER_0_18_346 vssd1 vssd1 vccd1 vccd1 sky130_ef_sc_hd__decap_12
XFILLER_0_41_393 vssd1 vssd1 vccd1 vccd1 sky130_ef_sc_hd__decap_12
XFILLER_0_5_295 vssd1 vssd1 vccd1 vccd1 sky130_fd_sc_hd__fill_1
Xfanout432 spi_mem1.state\[1\] vssd1 vssd1 vccd1 vccd1 net432 sky130_fd_sc_hd__buf_2
Xfanout410 net411 vssd1 vssd1 vccd1 vccd1 net410 sky130_fd_sc_hd__clkbuf_4
Xfanout476 net489 vssd1 vssd1 vccd1 vccd1 net476 sky130_fd_sc_hd__clkbuf_2
Xfanout487 net488 vssd1 vssd1 vccd1 vccd1 net487 sky130_fd_sc_hd__clkbuf_4
Xfanout443 spi_mem0.address_nibble\[2\] vssd1 vssd1 vccd1 vccd1 net443 sky130_fd_sc_hd__buf_2
Xfanout465 net466 vssd1 vssd1 vccd1 vccd1 net465 sky130_fd_sc_hd__clkbuf_4
Xfanout454 net456 vssd1 vssd1 vccd1 vccd1 net454 sky130_fd_sc_hd__clkbuf_4
XTAP_290 vssd1 vccd1 sky130_fd_sc_hd__tapvpwrvgnd_1
Xfanout421 net422 vssd1 vssd1 vccd1 vccd1 net421 sky130_fd_sc_hd__clkbuf_2
XFILLER_0_51_157 vssd1 vssd1 vccd1 vccd1 sky130_fd_sc_hd__fill_1
X_1091_ _0355_ vssd1 vssd1 vccd1 vccd1 _0356_ sky130_fd_sc_hd__inv_2
XFILLER_0_35_89 vssd1 vssd1 vccd1 vccd1 sky130_fd_sc_hd__fill_2
X_1160_ _0928_ _0390_ _0393_ vssd1 vssd1 vccd1 vccd1 _0049_ sky130_fd_sc_hd__a21oi_1
XFILLER_0_82_260 vssd1 vssd1 vccd1 vccd1 sky130_fd_sc_hd__fill_2
XFILLER_0_74_249 vssd1 vssd1 vccd1 vccd1 sky130_fd_sc_hd__decap_3
X_1993_ clknet_leaf_10_clk_i _0019_ net475 vssd1 vssd1 vccd1 vccd1 spi_mem0.has_2lc
+ sky130_fd_sc_hd__dfrtp_1
XFILLER_0_51_33 vssd1 vssd1 vccd1 vccd1 sky130_fd_sc_hd__decap_3
XFILLER_0_82_293 vssd1 vssd1 vccd1 vccd1 sky130_fd_sc_hd__fill_1
X_1427_ _0564_ _0565_ vssd1 vssd1 vccd1 vccd1 _0566_ sky130_fd_sc_hd__and2b_1
X_1358_ net543 _0521_ _0522_ net376 vssd1 vssd1 vccd1 vccd1 _0118_ sky130_fd_sc_hd__a22o_1
X_1289_ _0478_ net436 _0475_ vssd1 vssd1 vccd1 vccd1 _0093_ sky130_fd_sc_hd__mux2_1
XFILLER_0_73_271 vssd1 vssd1 vccd1 vccd1 sky130_fd_sc_hd__fill_1
X_1981__5 clknet_leaf_23_clk_i vssd1 vssd1 vccd1 vccd1 net494 sky130_fd_sc_hd__inv_2
Xmax_cap418 net419 vssd1 vssd1 vccd1 vccd1 net418 sky130_fd_sc_hd__buf_1
XFILLER_0_24_113 vssd1 vssd1 vccd1 vccd1 sky130_fd_sc_hd__decap_4
XFILLER_0_21_69 vssd1 vssd1 vccd1 vccd1 sky130_fd_sc_hd__fill_1
X_2192_ clknet_leaf_11_clk_i _0206_ net474 vssd1 vssd1 vccd1 vccd1 spi_mem1.data_buf\[4\]
+ sky130_fd_sc_hd__dfrtp_1
X_1212_ net580 net270 net388 vssd1 vssd1 vccd1 vccd1 _0074_ sky130_fd_sc_hd__mux2_1
X_2330_ clknet_leaf_31_clk_i _0338_ net457 vssd1 vssd1 vccd1 vccd1 spi_mem2.data_buf\[28\]
+ sky130_fd_sc_hd__dfrtp_1
X_2261_ clknet_leaf_38_clk_i net735 net446 vssd1 vssd1 vccd1 vccd1 net357 sky130_fd_sc_hd__dfrtp_1
XFILLER_0_20_363 vssd1 vssd1 vccd1 vccd1 sky130_fd_sc_hd__fill_1
X_1074_ _0920_ spi_mem0.state\[3\] net441 vssd1 vssd1 vccd1 vccd1 _0343_ sky130_fd_sc_hd__or3b_1
X_1143_ net53 net579 net408 vssd1 vssd1 vccd1 vccd1 _0036_ sky130_fd_sc_hd__mux2_1
XFILLER_0_62_208 vssd1 vssd1 vccd1 vccd1 sky130_fd_sc_hd__fill_2
X_1976_ net179 net403 _0877_ _0913_ vssd1 vssd1 vccd1 vccd1 _0918_ sky130_fd_sc_hd__a22o_1
XFILLER_0_7_335 vssd1 vssd1 vccd1 vccd1 sky130_fd_sc_hd__fill_1
XFILLER_0_60_3 vssd1 vssd1 vccd1 vccd1 sky130_ef_sc_hd__decap_12
Xhold37 spi_mem1.has_2lc vssd1 vssd1 vccd1 vccd1 net541 sky130_fd_sc_hd__dlygate4sd3_1
Xhold26 spi_mem1.address\[13\] vssd1 vssd1 vccd1 vccd1 net530 sky130_fd_sc_hd__dlygate4sd3_1
Xhold48 spi_mem2.address\[0\] vssd1 vssd1 vccd1 vccd1 net552 sky130_fd_sc_hd__dlygate4sd3_1
Xhold59 net359 vssd1 vssd1 vccd1 vccd1 net563 sky130_fd_sc_hd__dlygate4sd3_1
Xhold15 _0276_ vssd1 vssd1 vccd1 vccd1 net519 sky130_fd_sc_hd__dlygate4sd3_1
XFILLER_0_34_400 vssd1 vssd1 vccd1 vccd1 sky130_fd_sc_hd__decap_6
XFILLER_0_32_57 vssd1 vssd1 vccd1 vccd1 sky130_fd_sc_hd__fill_1
XFILLER_0_29_249 vssd1 vssd1 vccd1 vccd1 sky130_ef_sc_hd__decap_12
X_1830_ spi_mem2.data_buf\[27\] net706 net383 vssd1 vssd1 vccd1 vccd1 _0297_ sky130_fd_sc_hd__mux2_1
X_1761_ net200 _0777_ net202 net201 vssd1 vssd1 vccd1 vccd1 _0783_ sky130_fd_sc_hd__o211a_1
XFILLER_0_52_274 vssd1 vssd1 vccd1 vccd1 sky130_ef_sc_hd__decap_12
X_1692_ _0956_ _0959_ vssd1 vssd1 vccd1 vccd1 _0741_ sky130_fd_sc_hd__or2_1
X_2313_ clknet_leaf_39_clk_i _0321_ net444 vssd1 vssd1 vccd1 vccd1 spi_mem2.data_buf\[11\]
+ sky130_fd_sc_hd__dfrtp_1
XFILLER_0_20_182 vssd1 vssd1 vccd1 vccd1 sky130_fd_sc_hd__decap_4
X_2175_ clknet_leaf_13_clk_i _0194_ net477 vssd1 vssd1 vccd1 vccd1 net240 sky130_fd_sc_hd__dfrtp_1
XFILLER_0_73_53 vssd1 vssd1 vccd1 vccd1 sky130_fd_sc_hd__decap_3
X_1126_ spi_mem0.latency\[3\] _0371_ _0370_ vssd1 vssd1 vccd1 vccd1 _0386_ sky130_fd_sc_hd__o21ai_1
XFILLER_0_57_98 vssd1 vssd1 vccd1 vccd1 sky130_ef_sc_hd__decap_12
XFILLER_0_57_65 vssd1 vssd1 vccd1 vccd1 sky130_fd_sc_hd__decap_4
X_2244_ clknet_leaf_29_clk_i _0258_ net461 vssd1 vssd1 vccd1 vccd1 spi_mem2.address\[17\]
+ sky130_fd_sc_hd__dfrtp_1
XFILLER_0_35_208 vssd1 vssd1 vccd1 vccd1 sky130_fd_sc_hd__decap_3
X_1057_ net218 net217 vssd1 vssd1 vccd1 vccd1 _0973_ sky130_fd_sc_hd__nand2_1
X_1959_ _0968_ _0353_ net365 vssd1 vssd1 vccd1 vccd1 _0908_ sky130_fd_sc_hd__o21ai_2
Xinput127 sport1_i[47] vssd1 vssd1 vccd1 vccd1 net127 sky130_fd_sc_hd__clkbuf_2
Xinput149 sport1_i[67] vssd1 vssd1 vccd1 vccd1 net149 sky130_fd_sc_hd__buf_2
Xinput105 sport1_i[27] vssd1 vssd1 vccd1 vccd1 net105 sky130_fd_sc_hd__dlymetal6s2s_1
Xinput138 sport1_i[57] vssd1 vssd1 vccd1 vccd1 net138 sky130_fd_sc_hd__clkbuf_1
Xinput116 sport1_i[37] vssd1 vssd1 vccd1 vccd1 net116 sky130_fd_sc_hd__clkbuf_2
XPHY_100 vssd1 vssd1 vccd1 vccd1 sky130_fd_sc_hd__decap_3
XFILLER_0_81_369 vssd1 vssd1 vccd1 vccd1 sky130_ef_sc_hd__decap_12
XPHY_155 vssd1 vssd1 vccd1 vccd1 sky130_fd_sc_hd__decap_3
XPHY_144 vssd1 vssd1 vccd1 vccd1 sky130_fd_sc_hd__decap_3
XPHY_133 vssd1 vssd1 vccd1 vccd1 sky130_fd_sc_hd__decap_3
XFILLER_0_66_377 vssd1 vssd1 vccd1 vccd1 sky130_fd_sc_hd__fill_1
XPHY_122 vssd1 vssd1 vccd1 vccd1 sky130_fd_sc_hd__decap_3
XPHY_111 vssd1 vssd1 vccd1 vccd1 sky130_fd_sc_hd__decap_3
XFILLER_0_34_296 vssd1 vssd1 vccd1 vccd1 sky130_fd_sc_hd__fill_1
XFILLER_0_27_57 vssd1 vssd1 vccd1 vccd1 sky130_fd_sc_hd__fill_2
XFILLER_0_69_182 vssd1 vssd1 vccd1 vccd1 sky130_fd_sc_hd__fill_2
XFILLER_0_57_388 vssd1 vssd1 vccd1 vccd1 sky130_fd_sc_hd__decap_4
XFILLER_0_57_333 vssd1 vssd1 vccd1 vccd1 sky130_fd_sc_hd__decap_3
XFILLER_0_57_322 vssd1 vssd1 vccd1 vccd1 sky130_fd_sc_hd__decap_3
XFILLER_0_43_89 vssd1 vssd1 vccd1 vccd1 sky130_fd_sc_hd__fill_2
XPHY_2 vssd1 vssd1 vccd1 vccd1 sky130_fd_sc_hd__decap_3
Xhold315 spi_mem1.latency\[0\] vssd1 vssd1 vccd1 vccd1 net819 sky130_fd_sc_hd__dlygate4sd3_1
Xhold304 spi_mem2.latency\[1\] vssd1 vssd1 vccd1 vccd1 net808 sky130_fd_sc_hd__dlygate4sd3_1
XFILLER_0_40_244 vssd1 vssd1 vccd1 vccd1 sky130_fd_sc_hd__fill_1
X_1813_ spi_mem2.data_buf\[10\] net671 net379 vssd1 vssd1 vccd1 vccd1 _0280_ sky130_fd_sc_hd__mux2_1
X_1744_ net406 _0771_ vssd1 vssd1 vccd1 vccd1 _0772_ sky130_fd_sc_hd__nand2_1
XTAP_686 vssd1 vccd1 sky130_fd_sc_hd__tapvpwrvgnd_1
XTAP_675 vssd1 vccd1 sky130_fd_sc_hd__tapvpwrvgnd_1
XTAP_664 vssd1 vccd1 sky130_fd_sc_hd__tapvpwrvgnd_1
XTAP_653 vssd1 vccd1 sky130_fd_sc_hd__tapvpwrvgnd_1
XTAP_642 vssd1 vccd1 sky130_fd_sc_hd__tapvpwrvgnd_1
XTAP_631 vssd1 vccd1 sky130_fd_sc_hd__tapvpwrvgnd_1
XTAP_620 vssd1 vccd1 sky130_fd_sc_hd__tapvpwrvgnd_1
X_1675_ net103 net399 _0609_ _0694_ vssd1 vssd1 vccd1 vccd1 _0731_ sky130_fd_sc_hd__a22o_1
XTAP_697 vssd1 vccd1 sky130_fd_sc_hd__tapvpwrvgnd_1
X_1109_ spi_mem0.latency\[3\] spi_mem0.latency\[4\] _0371_ vssd1 vssd1 vccd1 vccd1
+ _0372_ sky130_fd_sc_hd__or3_2
X_2158_ clknet_leaf_6_clk_i net693 net469 vssd1 vssd1 vccd1 vccd1 net301 sky130_fd_sc_hd__dfrtp_2
X_2089_ clknet_leaf_7_clk_i _0109_ net467 vssd1 vssd1 vccd1 vccd1 spi_mem0.data_buf\[15\]
+ sky130_fd_sc_hd__dfrtp_1
X_2227_ clknet_leaf_27_clk_i _0241_ net464 vssd1 vssd1 vccd1 vccd1 spi_mem2.address\[0\]
+ sky130_fd_sc_hd__dfrtp_1
XFILLER_0_23_3 vssd1 vssd1 vccd1 vccd1 sky130_fd_sc_hd__fill_2
XFILLER_0_75_130 vssd1 vssd1 vccd1 vccd1 sky130_fd_sc_hd__fill_2
XFILLER_0_48_333 vssd1 vssd1 vccd1 vccd1 sky130_ef_sc_hd__decap_12
XFILLER_0_66_141 vssd1 vssd1 vccd1 vccd1 sky130_fd_sc_hd__decap_6
XFILLER_0_66_130 vssd1 vssd1 vccd1 vccd1 sky130_fd_sc_hd__decap_8
XFILLER_0_81_111 vssd1 vssd1 vccd1 vccd1 sky130_fd_sc_hd__fill_1
XFILLER_0_54_369 vssd1 vssd1 vccd1 vccd1 sky130_fd_sc_hd__fill_1
X_1391_ net395 _0546_ vssd1 vssd1 vccd1 vccd1 _0547_ sky130_fd_sc_hd__nand2_1
X_1460_ net593 _0589_ net413 vssd1 vssd1 vccd1 vccd1 _0153_ sky130_fd_sc_hd__mux2_1
XFILLER_0_10_406 vssd1 vssd1 vccd1 vccd1 sky130_fd_sc_hd__fill_1
XFILLER_0_54_33 vssd1 vssd1 vccd1 vccd1 sky130_fd_sc_hd__fill_1
X_2012_ clknet_leaf_25_clk_i _0038_ net464 vssd1 vssd1 vccd1 vccd1 spi_mem0.address\[12\]
+ sky130_fd_sc_hd__dfrtp_1
XFILLER_0_72_122 vssd1 vssd1 vccd1 vccd1 sky130_fd_sc_hd__decap_3
XFILLER_0_57_163 vssd1 vssd1 vccd1 vccd1 sky130_fd_sc_hd__decap_4
Xhold101 net252 vssd1 vssd1 vccd1 vccd1 net605 sky130_fd_sc_hd__dlygate4sd3_1
XFILLER_0_79_52 vssd1 vssd1 vccd1 vccd1 sky130_fd_sc_hd__decap_4
Xhold156 net231 vssd1 vssd1 vccd1 vccd1 net660 sky130_fd_sc_hd__dlygate4sd3_1
Xhold112 spi_mem1.address\[6\] vssd1 vssd1 vccd1 vccd1 net616 sky130_fd_sc_hd__dlygate4sd3_1
X_1658_ net95 net396 _0979_ _0696_ vssd1 vssd1 vccd1 vccd1 _0721_ sky130_fd_sc_hd__a22o_1
Xhold134 _0080_ vssd1 vssd1 vccd1 vccd1 net638 sky130_fd_sc_hd__dlygate4sd3_1
Xhold145 _0086_ vssd1 vssd1 vccd1 vccd1 net649 sky130_fd_sc_hd__dlygate4sd3_1
Xhold123 _0300_ vssd1 vssd1 vccd1 vccd1 net627 sky130_fd_sc_hd__dlygate4sd3_1
X_1727_ net187 net636 net404 vssd1 vssd1 vccd1 vccd1 _0248_ sky130_fd_sc_hd__mux2_1
Xhold167 net329 vssd1 vssd1 vccd1 vccd1 net671 sky130_fd_sc_hd__dlygate4sd3_1
X_1589_ spi_mem1.address\[6\] _0534_ _0641_ spi_mem1.address\[2\] spi_mem1.address_nibble\[2\]
+ vssd1 vssd1 vccd1 vccd1 _0675_ sky130_fd_sc_hd__a221o_1
Xhold189 _0178_ vssd1 vssd1 vccd1 vccd1 net693 sky130_fd_sc_hd__dlygate4sd3_1
XTAP_494 vssd1 vccd1 sky130_fd_sc_hd__tapvpwrvgnd_1
XTAP_483 vssd1 vccd1 sky130_fd_sc_hd__tapvpwrvgnd_1
XTAP_472 vssd1 vccd1 sky130_fd_sc_hd__tapvpwrvgnd_1
XTAP_461 vssd1 vccd1 sky130_fd_sc_hd__tapvpwrvgnd_1
XTAP_450 vssd1 vccd1 sky130_fd_sc_hd__tapvpwrvgnd_1
Xhold178 _0078_ vssd1 vssd1 vccd1 vccd1 net682 sky130_fd_sc_hd__dlygate4sd3_1
XFILLER_0_63_111 vssd1 vssd1 vccd1 vccd1 sky130_fd_sc_hd__fill_1
XFILLER_0_27_314 vssd1 vssd1 vccd1 vccd1 sky130_fd_sc_hd__decap_4
Xoutput228 net228 vssd1 vssd1 vccd1 vccd1 spi0_mosi_o[0] sky130_fd_sc_hd__clkbuf_4
Xoutput239 net239 vssd1 vssd1 vccd1 vccd1 spi1_dqsm_o sky130_fd_sc_hd__clkbuf_4
X_1512_ net726 net321 net386 vssd1 vssd1 vccd1 vccd1 _0165_ sky130_fd_sc_hd__mux2_1
XFILLER_0_49_44 vssd1 vssd1 vccd1 vccd1 sky130_ef_sc_hd__decap_12
XFILLER_0_40_46 vssd1 vssd1 vccd1 vccd1 sky130_fd_sc_hd__decap_8
X_1443_ net817 net410 vssd1 vssd1 vccd1 vccd1 _0577_ sky130_fd_sc_hd__and2_1
X_1374_ net648 _0527_ _0531_ net375 vssd1 vssd1 vccd1 vccd1 _0125_ sky130_fd_sc_hd__a22o_1
XFILLER_0_77_225 vssd1 vssd1 vccd1 vccd1 sky130_ef_sc_hd__decap_12
XFILLER_0_60_147 vssd1 vssd1 vccd1 vccd1 sky130_fd_sc_hd__fill_1
XFILLER_0_45_177 vssd1 vssd1 vccd1 vccd1 sky130_fd_sc_hd__decap_4
XFILLER_0_45_166 vssd1 vssd1 vccd1 vccd1 sky130_fd_sc_hd__fill_2
XFILLER_0_45_111 vssd1 vssd1 vccd1 vccd1 sky130_fd_sc_hd__fill_1
XFILLER_0_18_358 vssd1 vssd1 vccd1 vccd1 sky130_fd_sc_hd__decap_6
Xfanout411 _0944_ vssd1 vssd1 vccd1 vccd1 net411 sky130_fd_sc_hd__clkbuf_2
XFILLER_0_41_383 vssd1 vssd1 vccd1 vccd1 sky130_fd_sc_hd__decap_8
XFILLER_0_41_361 vssd1 vssd1 vccd1 vccd1 sky130_ef_sc_hd__decap_12
Xfanout422 spi_mem2.data_byte\[0\] vssd1 vssd1 vccd1 vccd1 net422 sky130_fd_sc_hd__buf_2
Xfanout400 net402 vssd1 vssd1 vccd1 vccd1 net400 sky130_fd_sc_hd__buf_2
Xfanout433 net434 vssd1 vssd1 vccd1 vccd1 net433 sky130_fd_sc_hd__clkbuf_4
Xfanout477 net478 vssd1 vssd1 vccd1 vccd1 net477 sky130_fd_sc_hd__clkbuf_4
Xfanout488 net489 vssd1 vssd1 vccd1 vccd1 net488 sky130_fd_sc_hd__buf_2
Xfanout455 net456 vssd1 vssd1 vccd1 vccd1 net455 sky130_fd_sc_hd__buf_2
Xfanout466 net489 vssd1 vssd1 vccd1 vccd1 net466 sky130_fd_sc_hd__clkbuf_4
XTAP_280 vssd1 vccd1 sky130_fd_sc_hd__tapvpwrvgnd_1
Xfanout444 net450 vssd1 vssd1 vccd1 vccd1 net444 sky130_fd_sc_hd__clkbuf_4
XTAP_291 vssd1 vccd1 sky130_fd_sc_hd__tapvpwrvgnd_1
XFILLER_0_68_225 vssd1 vssd1 vccd1 vccd1 sky130_fd_sc_hd__decap_6
XFILLER_0_36_100 vssd1 vssd1 vccd1 vccd1 sky130_ef_sc_hd__decap_12
XFILLER_0_51_169 vssd1 vssd1 vccd1 vccd1 sky130_ef_sc_hd__decap_12
XFILLER_0_24_306 vssd1 vssd1 vccd1 vccd1 sky130_fd_sc_hd__fill_2
XFILLER_0_10_49 vssd1 vssd1 vccd1 vccd1 sky130_fd_sc_hd__decap_4
XFILLER_0_17_391 vssd1 vssd1 vccd1 vccd1 sky130_fd_sc_hd__fill_1
X_1090_ spi_mem2.state\[1\] net426 _0958_ vssd1 vssd1 vccd1 vccd1 _0355_ sky130_fd_sc_hd__nor3_4
XFILLER_0_35_57 vssd1 vssd1 vccd1 vccd1 sky130_fd_sc_hd__fill_2
XFILLER_0_74_217 vssd1 vssd1 vccd1 vccd1 sky130_fd_sc_hd__fill_2
XFILLER_0_51_89 vssd1 vssd1 vccd1 vccd1 sky130_fd_sc_hd__decap_6
X_1992_ clknet_leaf_26_clk_i _0018_ net465 vssd1 vssd1 vccd1 vccd1 spi_mem2.data_ready
+ sky130_fd_sc_hd__dfrtp_1
XFILLER_0_27_122 vssd1 vssd1 vccd1 vccd1 sky130_fd_sc_hd__decap_6
XFILLER_0_27_100 vssd1 vssd1 vccd1 vccd1 sky130_ef_sc_hd__decap_12
XFILLER_0_50_191 vssd1 vssd1 vccd1 vccd1 sky130_fd_sc_hd__decap_4
X_1426_ net120 net123 net122 net121 vssd1 vssd1 vccd1 vccd1 _0565_ sky130_fd_sc_hd__or4_1
X_1288_ _0406_ _0407_ _0477_ vssd1 vssd1 vccd1 vccd1 _0478_ sky130_fd_sc_hd__and3_1
X_1357_ net33 net415 _0479_ _0484_ vssd1 vssd1 vccd1 vccd1 _0522_ sky130_fd_sc_hd__a22o_1
XFILLER_0_65_239 vssd1 vssd1 vccd1 vccd1 sky130_fd_sc_hd__decap_3
XFILLER_0_33_169 vssd1 vssd1 vccd1 vccd1 sky130_ef_sc_hd__decap_12
Xmax_cap419 _0937_ vssd1 vssd1 vccd1 vccd1 net419 sky130_fd_sc_hd__buf_1
XFILLER_0_32_191 vssd1 vssd1 vccd1 vccd1 sky130_fd_sc_hd__decap_4
XFILLER_0_20_331 vssd1 vssd1 vccd1 vccd1 sky130_fd_sc_hd__decap_4
X_2191_ clknet_leaf_6_clk_i _0205_ net472 vssd1 vssd1 vccd1 vccd1 spi_mem1.data_buf\[3\]
+ sky130_fd_sc_hd__dfrtp_1
X_1142_ net52 net618 net407 vssd1 vssd1 vccd1 vccd1 _0035_ sky130_fd_sc_hd__mux2_1
X_2260_ clknet_leaf_0_clk_i net710 net446 vssd1 vssd1 vccd1 vccd1 net356 sky130_fd_sc_hd__dfrtp_1
X_1211_ net686 net269 net388 vssd1 vssd1 vccd1 vccd1 _0073_ sky130_fd_sc_hd__mux2_1
XFILLER_0_62_11 vssd1 vssd1 vccd1 vccd1 sky130_fd_sc_hd__fill_2
X_1073_ spi_mem0.state\[1\] net441 _0921_ vssd1 vssd1 vccd1 vccd1 _0342_ sky130_fd_sc_hd__and3_1
XFILLER_0_47_239 vssd1 vssd1 vccd1 vccd1 sky130_fd_sc_hd__decap_8
XFILLER_0_30_106 vssd1 vssd1 vccd1 vccd1 sky130_fd_sc_hd__decap_8
XFILLER_0_7_358 vssd1 vssd1 vccd1 vccd1 sky130_fd_sc_hd__decap_3
X_1975_ net791 _0914_ _0917_ net364 vssd1 vssd1 vccd1 vccd1 _0340_ sky130_fd_sc_hd__a22o_1
XFILLER_0_15_169 vssd1 vssd1 vccd1 vccd1 sky130_ef_sc_hd__decap_12
X_1409_ _0538_ _0541_ _0548_ vssd1 vssd1 vccd1 vccd1 _0560_ sky130_fd_sc_hd__o21ai_1
Xhold27 spi_mem1.address\[19\] vssd1 vssd1 vccd1 vccd1 net531 sky130_fd_sc_hd__dlygate4sd3_1
XFILLER_0_53_3 vssd1 vssd1 vccd1 vccd1 sky130_ef_sc_hd__decap_12
Xhold38 spi_mem0.data_ready vssd1 vssd1 vccd1 vccd1 net542 sky130_fd_sc_hd__dlygate4sd3_1
Xhold16 spi_mem0.data_buf\[8\] vssd1 vssd1 vccd1 vccd1 net520 sky130_fd_sc_hd__dlygate4sd3_1
XFILLER_0_11_331 vssd1 vssd1 vccd1 vccd1 sky130_fd_sc_hd__decap_4
XFILLER_0_78_342 vssd1 vssd1 vccd1 vccd1 sky130_ef_sc_hd__decap_12
Xhold49 spi_mem2.data_buf\[25\] vssd1 vssd1 vccd1 vccd1 net553 sky130_fd_sc_hd__dlygate4sd3_1
XFILLER_0_46_283 vssd1 vssd1 vccd1 vccd1 sky130_fd_sc_hd__decap_4
XFILLER_0_52_286 vssd1 vssd1 vccd1 vccd1 sky130_ef_sc_hd__decap_12
XFILLER_0_52_253 vssd1 vssd1 vccd1 vccd1 sky130_fd_sc_hd__decap_3
X_1691_ _0956_ _0959_ vssd1 vssd1 vccd1 vccd1 _0740_ sky130_fd_sc_hd__nor2_4
X_1760_ net774 net404 _0781_ _0782_ vssd1 vssd1 vccd1 vccd1 _0260_ sky130_fd_sc_hd__a22o_1
XFILLER_0_57_11 vssd1 vssd1 vccd1 vccd1 sky130_fd_sc_hd__decap_3
X_2312_ clknet_leaf_0_clk_i _0320_ net446 vssd1 vssd1 vccd1 vccd1 spi_mem2.data_buf\[10\]
+ sky130_fd_sc_hd__dfrtp_1
XFILLER_0_20_172 vssd1 vssd1 vccd1 vccd1 sky130_fd_sc_hd__decap_6
XFILLER_0_20_194 vssd1 vssd1 vccd1 vccd1 sky130_fd_sc_hd__fill_2
XFILLER_0_79_139 vssd1 vssd1 vccd1 vccd1 sky130_fd_sc_hd__decap_6
XFILLER_0_73_32 vssd1 vssd1 vccd1 vccd1 sky130_fd_sc_hd__fill_1
X_2174_ clknet_leaf_12_clk_i _0985_ net478 vssd1 vssd1 vccd1 vccd1 net320 sky130_fd_sc_hd__dfrtp_2
X_1125_ _0385_ net655 _0377_ vssd1 vssd1 vccd1 vccd1 _0022_ sky130_fd_sc_hd__mux2_1
X_2243_ clknet_leaf_26_clk_i _0257_ net464 vssd1 vssd1 vccd1 vccd1 spi_mem2.address\[16\]
+ sky130_fd_sc_hd__dfrtp_1
XFILLER_0_75_345 vssd1 vssd1 vccd1 vccd1 sky130_fd_sc_hd__decap_3
XFILLER_0_7_111 vssd1 vssd1 vccd1 vccd1 sky130_fd_sc_hd__fill_1
X_1056_ spi_mem2.data_byte\[1\] _0971_ vssd1 vssd1 vccd1 vccd1 _0972_ sky130_fd_sc_hd__and2_2
XFILLER_0_43_275 vssd1 vssd1 vccd1 vccd1 sky130_fd_sc_hd__decap_4
XFILLER_0_43_264 vssd1 vssd1 vccd1 vccd1 sky130_fd_sc_hd__decap_3
X_1889_ net425 _0745_ _0864_ _0356_ vssd1 vssd1 vccd1 vccd1 _0307_ sky130_fd_sc_hd__a22o_1
X_1958_ net669 _0903_ _0907_ net364 vssd1 vssd1 vccd1 vccd1 _0333_ sky130_fd_sc_hd__a22o_1
Xinput106 sport1_i[28] vssd1 vssd1 vccd1 vccd1 net106 sky130_fd_sc_hd__dlymetal6s2s_1
Xinput128 sport1_i[48] vssd1 vssd1 vccd1 vccd1 net128 sky130_fd_sc_hd__clkbuf_2
Xinput117 sport1_i[38] vssd1 vssd1 vccd1 vccd1 net117 sky130_fd_sc_hd__dlymetal6s2s_1
Xinput139 sport1_i[58] vssd1 vssd1 vccd1 vccd1 net139 sky130_fd_sc_hd__clkbuf_1
XPHY_134 vssd1 vssd1 vccd1 vccd1 sky130_fd_sc_hd__decap_3
XPHY_123 vssd1 vssd1 vccd1 vccd1 sky130_fd_sc_hd__decap_3
XPHY_112 vssd1 vssd1 vccd1 vccd1 sky130_fd_sc_hd__decap_3
XPHY_101 vssd1 vssd1 vccd1 vccd1 sky130_fd_sc_hd__decap_3
XPHY_156 vssd1 vssd1 vccd1 vccd1 sky130_fd_sc_hd__decap_3
XPHY_145 vssd1 vssd1 vccd1 vccd1 sky130_fd_sc_hd__decap_3
Xclkbuf_leaf_19_clk_i clknet_2_3__leaf_clk_i vssd1 vssd1 vccd1 vccd1 clknet_leaf_19_clk_i
+ sky130_fd_sc_hd__clkbuf_16
XFILLER_0_72_304 vssd1 vssd1 vccd1 vccd1 sky130_fd_sc_hd__decap_4
XFILLER_0_57_367 vssd1 vssd1 vccd1 vccd1 sky130_fd_sc_hd__fill_1
XPHY_3 vssd1 vssd1 vccd1 vccd1 sky130_fd_sc_hd__decap_3
X_1674_ net743 _0729_ _0730_ net371 vssd1 vssd1 vccd1 vccd1 _0226_ sky130_fd_sc_hd__a22o_1
Xhold305 spi_mem0.latency\[1\] vssd1 vssd1 vccd1 vccd1 net809 sky130_fd_sc_hd__dlygate4sd3_1
XFILLER_0_7_57 vssd1 vssd1 vccd1 vccd1 sky130_fd_sc_hd__decap_4
X_1743_ net195 net194 _0765_ vssd1 vssd1 vccd1 vccd1 _0771_ sky130_fd_sc_hd__or3_1
X_1812_ spi_mem2.data_buf\[9\] net673 net380 vssd1 vssd1 vccd1 vccd1 _0279_ sky130_fd_sc_hd__mux2_1
XTAP_698 vssd1 vccd1 sky130_fd_sc_hd__tapvpwrvgnd_1
XTAP_687 vssd1 vccd1 sky130_fd_sc_hd__tapvpwrvgnd_1
XTAP_676 vssd1 vccd1 sky130_fd_sc_hd__tapvpwrvgnd_1
XTAP_665 vssd1 vccd1 sky130_fd_sc_hd__tapvpwrvgnd_1
XTAP_654 vssd1 vccd1 sky130_fd_sc_hd__tapvpwrvgnd_1
XTAP_643 vssd1 vccd1 sky130_fd_sc_hd__tapvpwrvgnd_1
XTAP_632 vssd1 vccd1 sky130_fd_sc_hd__tapvpwrvgnd_1
XTAP_621 vssd1 vccd1 sky130_fd_sc_hd__tapvpwrvgnd_1
XTAP_610 vssd1 vccd1 sky130_fd_sc_hd__tapvpwrvgnd_1
X_2226_ clknet_leaf_21_clk_i _0240_ net481 vssd1 vssd1 vccd1 vccd1 spi_mem2.latency\[5\]
+ sky130_fd_sc_hd__dfrtp_1
X_1039_ net353 vssd1 vssd1 vccd1 vccd1 net249 sky130_fd_sc_hd__inv_2
X_1108_ spi_mem0.latency\[1\] spi_mem0.latency\[0\] spi_mem0.latency\[2\] vssd1 vssd1
+ vccd1 vccd1 _0371_ sky130_fd_sc_hd__or3_2
XFILLER_0_48_345 vssd1 vssd1 vccd1 vccd1 sky130_fd_sc_hd__decap_6
X_2157_ clknet_leaf_7_clk_i net773 net467 vssd1 vssd1 vccd1 vccd1 net300 sky130_fd_sc_hd__dfrtp_1
X_2088_ clknet_leaf_2_clk_i _0108_ net467 vssd1 vssd1 vccd1 vccd1 spi_mem0.data_buf\[14\]
+ sky130_fd_sc_hd__dfrtp_1
XFILLER_0_16_3 vssd1 vssd1 vccd1 vccd1 sky130_fd_sc_hd__fill_1
XFILLER_0_63_359 vssd1 vssd1 vccd1 vccd1 sky130_ef_sc_hd__decap_12
XFILLER_0_63_337 vssd1 vssd1 vccd1 vccd1 sky130_fd_sc_hd__decap_4
XFILLER_0_16_253 vssd1 vssd1 vccd1 vccd1 sky130_fd_sc_hd__decap_6
XFILLER_0_31_289 vssd1 vssd1 vccd1 vccd1 sky130_ef_sc_hd__decap_12
XFILLER_0_31_245 vssd1 vssd1 vccd1 vccd1 sky130_fd_sc_hd__decap_8
XFILLER_0_31_223 vssd1 vssd1 vccd1 vccd1 sky130_fd_sc_hd__fill_1
X_1989__13 clknet_leaf_18_clk_i vssd1 vssd1 vccd1 vccd1 net502 sky130_fd_sc_hd__inv_2
XFILLER_0_66_197 vssd1 vssd1 vccd1 vccd1 sky130_ef_sc_hd__decap_12
X_1390_ _0930_ _0545_ vssd1 vssd1 vccd1 vccd1 _0546_ sky130_fd_sc_hd__nand2_1
XFILLER_0_22_289 vssd1 vssd1 vccd1 vccd1 sky130_fd_sc_hd__fill_1
XFILLER_0_54_23 vssd1 vssd1 vccd1 vccd1 sky130_fd_sc_hd__decap_4
X_2011_ clknet_leaf_30_clk_i _0037_ net458 vssd1 vssd1 vccd1 vccd1 spi_mem0.address\[11\]
+ sky130_fd_sc_hd__dfrtp_1
XFILLER_0_45_337 vssd1 vssd1 vccd1 vccd1 sky130_ef_sc_hd__decap_12
XFILLER_0_45_315 vssd1 vssd1 vccd1 vccd1 sky130_ef_sc_hd__decap_12
XFILLER_0_45_304 vssd1 vssd1 vccd1 vccd1 sky130_fd_sc_hd__fill_2
XFILLER_0_79_64 vssd1 vssd1 vccd1 vccd1 sky130_fd_sc_hd__decap_3
Xhold102 spi_mem1.latency\[2\] vssd1 vssd1 vccd1 vccd1 net606 sky130_fd_sc_hd__dlygate4sd3_1
X_1588_ net434 net398 _0673_ vssd1 vssd1 vccd1 vccd1 _0674_ sky130_fd_sc_hd__and3_1
Xhold113 spi_mem1.address\[14\] vssd1 vssd1 vccd1 vccd1 net617 sky130_fd_sc_hd__dlygate4sd3_1
X_1657_ net603 _0718_ _0720_ net370 vssd1 vssd1 vccd1 vccd1 _0219_ sky130_fd_sc_hd__a22o_1
Xhold157 spi_mem1.data_buf\[13\] vssd1 vssd1 vccd1 vccd1 net661 sky130_fd_sc_hd__dlygate4sd3_1
Xhold124 spi_mem0.data_buf\[20\] vssd1 vssd1 vccd1 vccd1 net628 sky130_fd_sc_hd__dlygate4sd3_1
Xhold179 spi_mem0.data_buf\[16\] vssd1 vssd1 vccd1 vccd1 net683 sky130_fd_sc_hd__dlygate4sd3_1
X_1726_ net186 net547 net405 vssd1 vssd1 vccd1 vccd1 _0247_ sky130_fd_sc_hd__mux2_1
Xhold135 net330 vssd1 vssd1 vccd1 vccd1 net639 sky130_fd_sc_hd__dlygate4sd3_1
Xhold146 net331 vssd1 vssd1 vccd1 vccd1 net650 sky130_fd_sc_hd__dlygate4sd3_1
Xhold168 _0280_ vssd1 vssd1 vccd1 vccd1 net672 sky130_fd_sc_hd__dlygate4sd3_1
XFILLER_0_13_223 vssd1 vssd1 vccd1 vccd1 sky130_fd_sc_hd__fill_1
XFILLER_0_13_278 vssd1 vssd1 vccd1 vccd1 sky130_fd_sc_hd__fill_2
X_2209_ clknet_leaf_15_clk_i _0223_ net480 vssd1 vssd1 vccd1 vccd1 spi_mem1.data_buf\[21\]
+ sky130_fd_sc_hd__dfrtp_1
XTAP_495 vssd1 vccd1 sky130_fd_sc_hd__tapvpwrvgnd_1
XTAP_484 vssd1 vccd1 sky130_fd_sc_hd__tapvpwrvgnd_1
XTAP_473 vssd1 vccd1 sky130_fd_sc_hd__tapvpwrvgnd_1
XTAP_462 vssd1 vccd1 sky130_fd_sc_hd__tapvpwrvgnd_1
XTAP_451 vssd1 vccd1 sky130_fd_sc_hd__tapvpwrvgnd_1
XTAP_440 vssd1 vccd1 sky130_fd_sc_hd__tapvpwrvgnd_1
XFILLER_0_8_250 vssd1 vssd1 vccd1 vccd1 sky130_fd_sc_hd__fill_2
XFILLER_0_6_209 vssd1 vssd1 vccd1 vccd1 sky130_fd_sc_hd__fill_2
Xoutput229 net229 vssd1 vssd1 vccd1 vccd1 spi0_mosi_o[1] sky130_fd_sc_hd__clkbuf_4
X_1442_ net685 net412 _0573_ _0576_ vssd1 vssd1 vccd1 vccd1 _0148_ sky130_fd_sc_hd__o22a_1
X_1511_ net751 net316 net387 vssd1 vssd1 vccd1 vccd1 _0164_ sky130_fd_sc_hd__mux2_1
XFILLER_0_50_384 vssd1 vssd1 vccd1 vccd1 sky130_fd_sc_hd__decap_4
XFILLER_0_65_22 vssd1 vssd1 vccd1 vccd1 sky130_fd_sc_hd__decap_4
X_1373_ net41 net417 _0490_ _0526_ vssd1 vssd1 vccd1 vccd1 _0531_ sky130_fd_sc_hd__a22o_1
XFILLER_0_81_21 vssd1 vssd1 vccd1 vccd1 sky130_fd_sc_hd__decap_3
XFILLER_0_77_237 vssd1 vssd1 vccd1 vccd1 sky130_ef_sc_hd__decap_12
XFILLER_0_18_304 vssd1 vssd1 vccd1 vccd1 sky130_fd_sc_hd__decap_4
XFILLER_0_41_351 vssd1 vssd1 vccd1 vccd1 sky130_fd_sc_hd__decap_3
XFILLER_0_5_275 vssd1 vssd1 vccd1 vccd1 sky130_fd_sc_hd__fill_1
Xfanout434 spi_mem1.state\[0\] vssd1 vssd1 vccd1 vccd1 net434 sky130_fd_sc_hd__clkbuf_2
X_1709_ spi_mem2.latency\[1\] spi_mem2.latency\[0\] spi_mem2.latency\[2\] vssd1 vssd1
+ vccd1 vccd1 _0755_ sky130_fd_sc_hd__o21ai_1
Xfanout412 _0943_ vssd1 vssd1 vccd1 vccd1 net412 sky130_fd_sc_hd__clkbuf_4
XFILLER_0_41_373 vssd1 vssd1 vccd1 vccd1 sky130_fd_sc_hd__decap_6
Xfanout445 net450 vssd1 vssd1 vccd1 vccd1 net445 sky130_fd_sc_hd__buf_2
Xfanout401 net402 vssd1 vssd1 vccd1 vccd1 net401 sky130_fd_sc_hd__clkbuf_2
Xfanout423 net424 vssd1 vssd1 vccd1 vccd1 net423 sky130_fd_sc_hd__buf_2
Xfanout456 net489 vssd1 vssd1 vccd1 vccd1 net456 sky130_fd_sc_hd__clkbuf_2
Xfanout478 net489 vssd1 vssd1 vccd1 vccd1 net478 sky130_fd_sc_hd__buf_2
Xfanout467 net470 vssd1 vssd1 vccd1 vccd1 net467 sky130_fd_sc_hd__clkbuf_4
Xfanout489 net1 vssd1 vssd1 vccd1 vccd1 net489 sky130_fd_sc_hd__clkbuf_4
XTAP_270 vssd1 vccd1 sky130_fd_sc_hd__tapvpwrvgnd_1
XTAP_281 vssd1 vccd1 sky130_fd_sc_hd__tapvpwrvgnd_1
XTAP_292 vssd1 vccd1 sky130_fd_sc_hd__tapvpwrvgnd_1
XFILLER_0_76_281 vssd1 vssd1 vccd1 vccd1 sky130_fd_sc_hd__decap_4
XFILLER_0_36_112 vssd1 vssd1 vccd1 vccd1 sky130_fd_sc_hd__decap_4
XFILLER_0_82_273 vssd1 vssd1 vccd1 vccd1 sky130_fd_sc_hd__decap_6
XFILLER_0_67_281 vssd1 vssd1 vccd1 vccd1 sky130_ef_sc_hd__decap_12
XFILLER_0_27_167 vssd1 vssd1 vccd1 vccd1 sky130_fd_sc_hd__fill_1
X_1425_ net120 net122 net121 net123 vssd1 vssd1 vccd1 vccd1 _0564_ sky130_fd_sc_hd__o31a_2
X_1287_ net436 net438 vssd1 vssd1 vccd1 vccd1 _0477_ sky130_fd_sc_hd__or2_1
X_1356_ net393 _0479_ net376 vssd1 vssd1 vccd1 vccd1 _0521_ sky130_fd_sc_hd__o21ai_2
XFILLER_0_61_402 vssd1 vssd1 vccd1 vccd1 sky130_fd_sc_hd__decap_4
XFILLER_0_18_123 vssd1 vssd1 vccd1 vccd1 sky130_fd_sc_hd__decap_6
XFILLER_0_73_284 vssd1 vssd1 vccd1 vccd1 sky130_ef_sc_hd__decap_12
XFILLER_0_33_104 vssd1 vssd1 vccd1 vccd1 sky130_fd_sc_hd__decap_8
XFILLER_0_14_351 vssd1 vssd1 vccd1 vccd1 sky130_ef_sc_hd__decap_12
XFILLER_0_56_207 vssd1 vssd1 vccd1 vccd1 sky130_ef_sc_hd__decap_12
XFILLER_0_64_273 vssd1 vssd1 vccd1 vccd1 sky130_fd_sc_hd__decap_8
XFILLER_0_24_159 vssd1 vssd1 vccd1 vccd1 sky130_fd_sc_hd__decap_3
XFILLER_0_20_365 vssd1 vssd1 vccd1 vccd1 sky130_ef_sc_hd__decap_12
X_1072_ net815 _0982_ _0980_ vssd1 vssd1 vccd1 vccd1 _0985_ sky130_fd_sc_hd__a21o_1
X_2190_ clknet_leaf_14_clk_i _0204_ net472 vssd1 vssd1 vccd1 vccd1 spi_mem1.data_buf\[2\]
+ sky130_fd_sc_hd__dfrtp_1
X_1210_ net766 net268 net388 vssd1 vssd1 vccd1 vccd1 _0072_ sky130_fd_sc_hd__mux2_1
X_1141_ net51 net586 net407 vssd1 vssd1 vccd1 vccd1 _0034_ sky130_fd_sc_hd__mux2_1
XFILLER_0_62_23 vssd1 vssd1 vccd1 vccd1 sky130_fd_sc_hd__decap_4
X_1974_ net178 net403 _0875_ _0913_ vssd1 vssd1 vccd1 vccd1 _0917_ sky130_fd_sc_hd__a22o_1
X_1408_ _0537_ _0541_ _0548_ _0559_ net507 vssd1 vssd1 vccd1 vccd1 _0131_ sky130_fd_sc_hd__a32o_1
XFILLER_0_46_3 vssd1 vssd1 vccd1 vccd1 sky130_ef_sc_hd__decap_12
Xhold39 spi_mem0.data_buf\[24\] vssd1 vssd1 vccd1 vccd1 net543 sky130_fd_sc_hd__dlygate4sd3_1
Xhold28 spi_mem2.address\[16\] vssd1 vssd1 vccd1 vccd1 net532 sky130_fd_sc_hd__dlygate4sd3_1
Xhold17 _0063_ vssd1 vssd1 vccd1 vccd1 net521 sky130_fd_sc_hd__dlygate4sd3_1
XFILLER_0_78_365 vssd1 vssd1 vccd1 vccd1 sky130_ef_sc_hd__decap_12
XFILLER_0_78_354 vssd1 vssd1 vccd1 vccd1 sky130_fd_sc_hd__decap_8
X_1339_ net683 _0510_ _0511_ net374 vssd1 vssd1 vccd1 vccd1 _0110_ sky130_fd_sc_hd__a22o_1
XFILLER_0_61_221 vssd1 vssd1 vccd1 vccd1 sky130_fd_sc_hd__decap_3
XFILLER_0_46_240 vssd1 vssd1 vccd1 vccd1 sky130_ef_sc_hd__decap_12
XFILLER_0_69_387 vssd1 vssd1 vccd1 vccd1 sky130_fd_sc_hd__decap_4
XFILLER_0_52_298 vssd1 vssd1 vccd1 vccd1 sky130_fd_sc_hd__decap_8
X_1690_ net534 _0735_ _0739_ net369 vssd1 vssd1 vccd1 vccd1 _0233_ sky130_fd_sc_hd__a22o_1
XFILLER_0_25_402 vssd1 vssd1 vccd1 vccd1 sky130_fd_sc_hd__decap_4
X_2242_ clknet_leaf_27_clk_i _0256_ net464 vssd1 vssd1 vccd1 vccd1 spi_mem2.address\[15\]
+ sky130_fd_sc_hd__dfrtp_1
X_2311_ clknet_leaf_35_clk_i _0319_ net449 vssd1 vssd1 vccd1 vccd1 spi_mem2.data_buf\[9\]
+ sky130_fd_sc_hd__dfrtp_1
XFILLER_0_73_11 vssd1 vssd1 vccd1 vccd1 sky130_fd_sc_hd__fill_1
X_1124_ _0371_ _0384_ _0369_ vssd1 vssd1 vccd1 vccd1 _0385_ sky130_fd_sc_hd__a21oi_1
X_2173_ clknet_leaf_5_clk_i net535 net471 vssd1 vssd1 vccd1 vccd1 net318 sky130_fd_sc_hd__dfrtp_2
X_1055_ net423 net420 vssd1 vssd1 vccd1 vccd1 _0971_ sky130_fd_sc_hd__nor2_1
XFILLER_0_75_357 vssd1 vssd1 vccd1 vccd1 sky130_ef_sc_hd__decap_12
X_1957_ net170 net402 _0877_ _0902_ vssd1 vssd1 vccd1 vccd1 _0907_ sky130_fd_sc_hd__a22o_1
X_1888_ net425 _0744_ _0745_ vssd1 vssd1 vccd1 vccd1 _0864_ sky130_fd_sc_hd__a21oi_1
XFILLER_0_31_405 vssd1 vssd1 vccd1 vccd1 sky130_fd_sc_hd__fill_2
Xinput129 sport1_i[49] vssd1 vssd1 vccd1 vccd1 net129 sky130_fd_sc_hd__buf_2
Xinput107 sport1_i[29] vssd1 vssd1 vccd1 vccd1 net107 sky130_fd_sc_hd__dlymetal6s2s_1
Xinput118 sport1_i[39] vssd1 vssd1 vccd1 vccd1 net118 sky130_fd_sc_hd__buf_1
XPHY_157 vssd1 vssd1 vccd1 vccd1 sky130_fd_sc_hd__decap_3
XFILLER_0_78_195 vssd1 vssd1 vccd1 vccd1 sky130_fd_sc_hd__fill_1
XPHY_146 vssd1 vssd1 vccd1 vccd1 sky130_fd_sc_hd__decap_3
XPHY_135 vssd1 vssd1 vccd1 vccd1 sky130_fd_sc_hd__decap_3
XFILLER_0_66_313 vssd1 vssd1 vccd1 vccd1 sky130_fd_sc_hd__fill_1
XPHY_124 vssd1 vssd1 vccd1 vccd1 sky130_fd_sc_hd__decap_3
XPHY_113 vssd1 vssd1 vccd1 vccd1 sky130_fd_sc_hd__decap_3
XPHY_102 vssd1 vssd1 vccd1 vccd1 sky130_fd_sc_hd__decap_3
X_1811_ net601 net360 net379 vssd1 vssd1 vccd1 vccd1 _0278_ sky130_fd_sc_hd__mux2_1
XPHY_4 vssd1 vssd1 vccd1 vccd1 sky130_fd_sc_hd__decap_3
Xhold306 spi_mem1.latency\[1\] vssd1 vssd1 vccd1 vccd1 net810 sky130_fd_sc_hd__dlygate4sd3_1
X_1673_ net102 net399 _0609_ _0692_ vssd1 vssd1 vccd1 vccd1 _0730_ sky130_fd_sc_hd__a22o_1
XTAP_600 vssd1 vccd1 sky130_fd_sc_hd__tapvpwrvgnd_1
X_1742_ net194 _0765_ net195 vssd1 vssd1 vccd1 vccd1 _0770_ sky130_fd_sc_hd__o21a_1
XFILLER_0_13_405 vssd1 vssd1 vccd1 vccd1 sky130_fd_sc_hd__fill_2
XTAP_699 vssd1 vccd1 sky130_fd_sc_hd__tapvpwrvgnd_1
XTAP_688 vssd1 vccd1 sky130_fd_sc_hd__tapvpwrvgnd_1
XTAP_677 vssd1 vccd1 sky130_fd_sc_hd__tapvpwrvgnd_1
XTAP_666 vssd1 vccd1 sky130_fd_sc_hd__tapvpwrvgnd_1
XTAP_655 vssd1 vccd1 sky130_fd_sc_hd__tapvpwrvgnd_1
XTAP_644 vssd1 vccd1 sky130_fd_sc_hd__tapvpwrvgnd_1
XTAP_633 vssd1 vccd1 sky130_fd_sc_hd__tapvpwrvgnd_1
X_2225_ clknet_leaf_20_clk_i _0239_ net487 vssd1 vssd1 vccd1 vccd1 spi_mem2.latency\[4\]
+ sky130_fd_sc_hd__dfrtp_1
XTAP_622 vssd1 vccd1 sky130_fd_sc_hd__tapvpwrvgnd_1
XTAP_611 vssd1 vccd1 sky130_fd_sc_hd__tapvpwrvgnd_1
X_1038_ _0954_ _0956_ _0958_ _0959_ vssd1 vssd1 vccd1 vccd1 net353 sky130_fd_sc_hd__o22a_4
X_1107_ spi_mem0.state\[2\] _0921_ _0945_ _0368_ vssd1 vssd1 vccd1 vccd1 _0370_ sky130_fd_sc_hd__a31o_2
XFILLER_0_48_357 vssd1 vssd1 vccd1 vccd1 sky130_fd_sc_hd__decap_6
X_2156_ clknet_leaf_6_clk_i _0176_ net468 vssd1 vssd1 vccd1 vccd1 net299 sky130_fd_sc_hd__dfrtp_1
X_2087_ clknet_leaf_4_clk_i _0107_ net456 vssd1 vssd1 vccd1 vccd1 spi_mem0.data_buf\[13\]
+ sky130_fd_sc_hd__dfrtp_1
XFILLER_0_33_80 vssd1 vssd1 vccd1 vccd1 sky130_fd_sc_hd__decap_4
XFILLER_0_16_221 vssd1 vssd1 vccd1 vccd1 sky130_fd_sc_hd__decap_4
XFILLER_0_16_287 vssd1 vssd1 vccd1 vccd1 sky130_fd_sc_hd__decap_3
XFILLER_0_31_279 vssd1 vssd1 vccd1 vccd1 sky130_fd_sc_hd__fill_1
XFILLER_0_81_113 vssd1 vssd1 vccd1 vccd1 sky130_fd_sc_hd__decap_4
XFILLER_0_54_349 vssd1 vssd1 vccd1 vccd1 sky130_ef_sc_hd__decap_12
XFILLER_0_54_305 vssd1 vssd1 vccd1 vccd1 sky130_fd_sc_hd__decap_3
XFILLER_0_39_335 vssd1 vssd1 vccd1 vccd1 sky130_fd_sc_hd__fill_1
X_2010_ clknet_leaf_33_clk_i _0036_ net462 vssd1 vssd1 vccd1 vccd1 spi_mem0.address\[10\]
+ sky130_fd_sc_hd__dfrtp_1
XFILLER_0_57_121 vssd1 vssd1 vccd1 vccd1 sky130_fd_sc_hd__decap_6
XFILLER_0_57_110 vssd1 vssd1 vccd1 vccd1 sky130_fd_sc_hd__fill_2
XFILLER_0_53_393 vssd1 vssd1 vccd1 vccd1 sky130_fd_sc_hd__decap_6
XFILLER_0_45_349 vssd1 vssd1 vccd1 vccd1 sky130_fd_sc_hd__decap_6
XFILLER_0_45_327 vssd1 vssd1 vccd1 vccd1 sky130_fd_sc_hd__decap_8
X_1725_ net185 net613 net404 vssd1 vssd1 vccd1 vccd1 _0246_ sky130_fd_sc_hd__mux2_1
XFILLER_0_79_76 vssd1 vssd1 vccd1 vccd1 sky130_fd_sc_hd__decap_4
X_1587_ _0671_ _0672_ _0931_ vssd1 vssd1 vccd1 vccd1 _0673_ sky130_fd_sc_hd__mux2_1
X_1656_ net94 net397 _0979_ _0694_ vssd1 vssd1 vccd1 vccd1 _0720_ sky130_fd_sc_hd__a22o_1
XTAP_441 vssd1 vccd1 sky130_fd_sc_hd__tapvpwrvgnd_1
XTAP_430 vssd1 vccd1 sky130_fd_sc_hd__tapvpwrvgnd_1
Xhold125 _0075_ vssd1 vssd1 vccd1 vccd1 net629 sky130_fd_sc_hd__dlygate4sd3_1
Xhold114 spi_mem0.address\[9\] vssd1 vssd1 vccd1 vccd1 net618 sky130_fd_sc_hd__dlygate4sd3_1
Xhold147 _0282_ vssd1 vssd1 vccd1 vccd1 net651 sky130_fd_sc_hd__dlygate4sd3_1
Xhold136 _0281_ vssd1 vssd1 vccd1 vccd1 net640 sky130_fd_sc_hd__dlygate4sd3_1
Xhold103 net350 vssd1 vssd1 vccd1 vccd1 net607 sky130_fd_sc_hd__dlygate4sd3_1
Xhold158 net336 vssd1 vssd1 vccd1 vccd1 net662 sky130_fd_sc_hd__dlygate4sd3_1
Xhold169 net361 vssd1 vssd1 vccd1 vccd1 net673 sky130_fd_sc_hd__dlygate4sd3_1
X_2139_ clknet_leaf_17_clk_i _0159_ net483 vssd1 vssd1 vccd1 vccd1 spi_mem1.state\[1\]
+ sky130_fd_sc_hd__dfrtp_1
X_2208_ clknet_leaf_15_clk_i _0222_ net473 vssd1 vssd1 vccd1 vccd1 spi_mem1.data_buf\[20\]
+ sky130_fd_sc_hd__dfrtp_1
XTAP_496 vssd1 vccd1 sky130_fd_sc_hd__tapvpwrvgnd_1
XTAP_485 vssd1 vccd1 sky130_fd_sc_hd__tapvpwrvgnd_1
XTAP_474 vssd1 vccd1 sky130_fd_sc_hd__tapvpwrvgnd_1
XTAP_463 vssd1 vccd1 sky130_fd_sc_hd__tapvpwrvgnd_1
XTAP_452 vssd1 vccd1 sky130_fd_sc_hd__tapvpwrvgnd_1
XFILLER_0_28_80 vssd1 vssd1 vccd1 vccd1 sky130_fd_sc_hd__decap_4
XFILLER_0_63_113 vssd1 vssd1 vccd1 vccd1 sky130_ef_sc_hd__decap_12
XFILLER_0_36_305 vssd1 vssd1 vccd1 vccd1 sky130_fd_sc_hd__decap_3
XFILLER_0_29_390 vssd1 vssd1 vccd1 vccd1 sky130_fd_sc_hd__fill_2
XFILLER_0_8_240 vssd1 vssd1 vccd1 vccd1 sky130_fd_sc_hd__fill_1
XFILLER_0_8_262 vssd1 vssd1 vccd1 vccd1 sky130_fd_sc_hd__decap_4
XFILLER_0_63_179 vssd1 vssd1 vccd1 vccd1 sky130_fd_sc_hd__decap_8
XFILLER_0_63_157 vssd1 vssd1 vccd1 vccd1 sky130_fd_sc_hd__fill_2
XFILLER_0_8_295 vssd1 vssd1 vccd1 vccd1 sky130_fd_sc_hd__fill_1
Xclkbuf_leaf_18_clk_i clknet_2_3__leaf_clk_i vssd1 vssd1 vccd1 vccd1 clknet_leaf_18_clk_i
+ sky130_fd_sc_hd__clkbuf_16
XFILLER_0_24_16 vssd1 vssd1 vccd1 vccd1 sky130_fd_sc_hd__decap_4
XFILLER_0_54_168 vssd1 vssd1 vccd1 vccd1 sky130_ef_sc_hd__decap_12
XFILLER_0_54_124 vssd1 vssd1 vccd1 vccd1 sky130_fd_sc_hd__decap_8
XFILLER_0_39_165 vssd1 vssd1 vccd1 vccd1 sky130_fd_sc_hd__decap_3
XFILLER_0_40_37 vssd1 vssd1 vccd1 vccd1 sky130_fd_sc_hd__fill_2
XFILLER_0_35_393 vssd1 vssd1 vccd1 vccd1 sky130_ef_sc_hd__decap_12
XFILLER_0_35_371 vssd1 vssd1 vccd1 vccd1 sky130_fd_sc_hd__fill_1
X_1441_ net412 _0575_ vssd1 vssd1 vccd1 vccd1 _0576_ sky130_fd_sc_hd__nand2_1
X_1510_ spi_mem1.data_buf\[1\] net802 net386 vssd1 vssd1 vccd1 vccd1 _0163_ sky130_fd_sc_hd__mux2_1
XFILLER_0_49_57 vssd1 vssd1 vccd1 vccd1 sky130_ef_sc_hd__decap_12
XFILLER_0_49_35 vssd1 vssd1 vccd1 vccd1 sky130_fd_sc_hd__fill_1
X_1372_ net715 _0527_ _0530_ net375 vssd1 vssd1 vccd1 vccd1 _0124_ sky130_fd_sc_hd__a22o_1
XFILLER_0_4_37 vssd1 vssd1 vccd1 vccd1 sky130_fd_sc_hd__decap_4
XFILLER_0_4_26 vssd1 vssd1 vccd1 vccd1 sky130_fd_sc_hd__fill_2
XFILLER_0_77_249 vssd1 vssd1 vccd1 vccd1 sky130_fd_sc_hd__fill_2
XFILLER_0_45_113 vssd1 vssd1 vccd1 vccd1 sky130_ef_sc_hd__decap_12
XFILLER_0_76_3 vssd1 vssd1 vccd1 vccd1 sky130_ef_sc_hd__decap_12
X_1708_ net808 _0749_ _0754_ vssd1 vssd1 vccd1 vccd1 _0236_ sky130_fd_sc_hd__o21a_1
Xfanout413 _0943_ vssd1 vssd1 vccd1 vccd1 net413 sky130_fd_sc_hd__clkbuf_2
X_1639_ net87 net398 _0696_ _0706_ vssd1 vssd1 vccd1 vccd1 _0710_ sky130_fd_sc_hd__a22o_1
Xfanout479 net482 vssd1 vssd1 vccd1 vccd1 net479 sky130_fd_sc_hd__clkbuf_4
Xfanout435 spi_mem0.data_byte\[1\] vssd1 vssd1 vccd1 vccd1 net435 sky130_fd_sc_hd__buf_2
Xfanout468 net470 vssd1 vssd1 vccd1 vccd1 net468 sky130_fd_sc_hd__buf_2
Xfanout457 net459 vssd1 vssd1 vccd1 vccd1 net457 sky130_fd_sc_hd__clkbuf_4
Xfanout446 net450 vssd1 vssd1 vccd1 vccd1 net446 sky130_fd_sc_hd__clkbuf_4
XTAP_260 vssd1 vccd1 sky130_fd_sc_hd__tapvpwrvgnd_1
XTAP_271 vssd1 vccd1 sky130_fd_sc_hd__tapvpwrvgnd_1
Xfanout402 net403 vssd1 vssd1 vccd1 vccd1 net402 sky130_fd_sc_hd__clkbuf_4
XTAP_282 vssd1 vccd1 sky130_fd_sc_hd__tapvpwrvgnd_1
XTAP_293 vssd1 vccd1 sky130_fd_sc_hd__tapvpwrvgnd_1
Xfanout424 net425 vssd1 vssd1 vccd1 vccd1 net424 sky130_fd_sc_hd__buf_2
XFILLER_0_36_179 vssd1 vssd1 vccd1 vccd1 sky130_ef_sc_hd__decap_12
XFILLER_0_24_319 vssd1 vssd1 vccd1 vccd1 sky130_fd_sc_hd__fill_1
XFILLER_0_51_149 vssd1 vssd1 vccd1 vccd1 sky130_fd_sc_hd__fill_1
XFILLER_0_32_363 vssd1 vssd1 vccd1 vccd1 sky130_fd_sc_hd__fill_1
XFILLER_0_17_393 vssd1 vssd1 vccd1 vccd1 sky130_fd_sc_hd__decap_6
XFILLER_0_35_15 vssd1 vssd1 vccd1 vccd1 sky130_fd_sc_hd__decap_6
XFILLER_0_67_293 vssd1 vssd1 vccd1 vccd1 sky130_ef_sc_hd__decap_12
XFILLER_0_51_25 vssd1 vssd1 vccd1 vccd1 sky130_fd_sc_hd__decap_8
XFILLER_0_27_113 vssd1 vssd1 vccd1 vccd1 sky130_fd_sc_hd__fill_1
XFILLER_0_23_363 vssd1 vssd1 vccd1 vccd1 sky130_fd_sc_hd__decap_6
X_1424_ _0562_ _0563_ net659 net413 vssd1 vssd1 vccd1 vccd1 _0143_ sky130_fd_sc_hd__o2bb2a_1
X_1355_ net681 _0516_ _0520_ net375 vssd1 vssd1 vccd1 vccd1 _0117_ sky130_fd_sc_hd__a22o_1
X_1286_ _0476_ net437 _0475_ vssd1 vssd1 vccd1 vccd1 _0092_ sky130_fd_sc_hd__mux2_1
XFILLER_0_25_81 vssd1 vssd1 vccd1 vccd1 sky130_ef_sc_hd__decap_12
XFILLER_0_73_296 vssd1 vssd1 vccd1 vccd1 sky130_ef_sc_hd__decap_12
XFILLER_0_73_263 vssd1 vssd1 vccd1 vccd1 sky130_fd_sc_hd__decap_8
XFILLER_0_33_138 vssd1 vssd1 vccd1 vccd1 sky130_fd_sc_hd__fill_2
XFILLER_0_14_341 vssd1 vssd1 vccd1 vccd1 sky130_fd_sc_hd__fill_1
XFILLER_0_14_363 vssd1 vssd1 vccd1 vccd1 sky130_fd_sc_hd__fill_1
XFILLER_0_14_385 vssd1 vssd1 vccd1 vccd1 sky130_fd_sc_hd__fill_1
XFILLER_0_56_219 vssd1 vssd1 vccd1 vccd1 sky130_ef_sc_hd__decap_12
XFILLER_0_32_160 vssd1 vssd1 vccd1 vccd1 sky130_fd_sc_hd__decap_4
XFILLER_0_20_322 vssd1 vssd1 vccd1 vccd1 sky130_fd_sc_hd__fill_1
XFILLER_0_20_377 vssd1 vssd1 vccd1 vccd1 sky130_ef_sc_hd__decap_12
X_1071_ net433 _0981_ vssd1 vssd1 vccd1 vccd1 _0983_ sky130_fd_sc_hd__or2_1
X_1140_ net49 net587 net407 vssd1 vssd1 vccd1 vccd1 _0033_ sky130_fd_sc_hd__mux2_1
XFILLER_0_62_68 vssd1 vssd1 vccd1 vccd1 sky130_fd_sc_hd__decap_4
X_1973_ net794 _0914_ _0916_ net364 vssd1 vssd1 vccd1 vccd1 _0339_ sky130_fd_sc_hd__a22o_1
X_1407_ _0925_ _0559_ _0558_ vssd1 vssd1 vccd1 vccd1 _0130_ sky130_fd_sc_hd__a21oi_1
Xhold18 spi_mem1.address\[18\] vssd1 vssd1 vccd1 vccd1 net522 sky130_fd_sc_hd__dlygate4sd3_1
XFILLER_0_39_3 vssd1 vssd1 vccd1 vccd1 sky130_ef_sc_hd__decap_12
X_1338_ net24 net415 _0350_ _0484_ vssd1 vssd1 vccd1 vccd1 _0511_ sky130_fd_sc_hd__a22o_1
Xhold29 spi_mem0.address\[3\] vssd1 vssd1 vccd1 vccd1 net533 sky130_fd_sc_hd__dlygate4sd3_1
XFILLER_0_78_377 vssd1 vssd1 vccd1 vccd1 sky130_ef_sc_hd__decap_12
XFILLER_0_36_80 vssd1 vssd1 vccd1 vccd1 sky130_fd_sc_hd__decap_4
X_1269_ spi_mem0.data_buf\[11\] _0423_ _0425_ spi_mem0.data_buf\[7\] _0461_ vssd1
+ vssd1 vccd1 vccd1 _0462_ sky130_fd_sc_hd__a221o_1
XFILLER_0_61_200 vssd1 vssd1 vccd1 vccd1 sky130_ef_sc_hd__decap_12
XFILLER_0_46_296 vssd1 vssd1 vccd1 vccd1 sky130_fd_sc_hd__decap_3
XFILLER_0_14_182 vssd1 vssd1 vccd1 vccd1 sky130_fd_sc_hd__fill_2
XFILLER_0_37_274 vssd1 vssd1 vccd1 vccd1 sky130_fd_sc_hd__decap_6
XFILLER_0_32_38 vssd1 vssd1 vccd1 vccd1 sky130_fd_sc_hd__decap_8
XFILLER_0_32_27 vssd1 vssd1 vccd1 vccd1 sky130_fd_sc_hd__fill_1
XFILLER_0_40_406 vssd1 vssd1 vccd1 vccd1 sky130_fd_sc_hd__fill_1
X_2172_ clknet_leaf_5_clk_i net566 net471 vssd1 vssd1 vccd1 vccd1 net317 sky130_fd_sc_hd__dfrtp_2
X_2310_ clknet_leaf_0_clk_i _0318_ net444 vssd1 vssd1 vccd1 vccd1 spi_mem2.data_buf\[8\]
+ sky130_fd_sc_hd__dfrtp_1
X_2241_ clknet_leaf_28_clk_i _0255_ net466 vssd1 vssd1 vccd1 vccd1 spi_mem2.address\[14\]
+ sky130_fd_sc_hd__dfrtp_1
X_1123_ spi_mem0.latency\[1\] spi_mem0.latency\[0\] spi_mem0.latency\[2\] vssd1 vssd1
+ vccd1 vccd1 _0384_ sky130_fd_sc_hd__o21ai_1
X_1054_ net426 _0969_ vssd1 vssd1 vccd1 vccd1 _0970_ sky130_fd_sc_hd__and2_2
XFILLER_0_75_369 vssd1 vssd1 vccd1 vccd1 sky130_fd_sc_hd__decap_4
X_1887_ net815 _0543_ _0610_ _0982_ vssd1 vssd1 vccd1 vccd1 _0306_ sky130_fd_sc_hd__a22o_1
X_1956_ net596 _0903_ _0906_ net365 vssd1 vssd1 vccd1 vccd1 _0332_ sky130_fd_sc_hd__a22o_1
XFILLER_0_22_82 vssd1 vssd1 vccd1 vccd1 sky130_fd_sc_hd__fill_2
Xinput108 sport1_i[2] vssd1 vssd1 vccd1 vccd1 net108 sky130_fd_sc_hd__dlymetal6s2s_1
Xinput119 sport1_i[3] vssd1 vssd1 vccd1 vccd1 net119 sky130_fd_sc_hd__dlymetal6s2s_1
XPHY_158 vssd1 vssd1 vccd1 vccd1 sky130_fd_sc_hd__decap_3
XFILLER_0_78_141 vssd1 vssd1 vccd1 vccd1 sky130_ef_sc_hd__decap_12
XPHY_147 vssd1 vssd1 vccd1 vccd1 sky130_fd_sc_hd__decap_3
XPHY_136 vssd1 vssd1 vccd1 vccd1 sky130_fd_sc_hd__decap_3
XPHY_125 vssd1 vssd1 vccd1 vccd1 sky130_fd_sc_hd__decap_3
XPHY_114 vssd1 vssd1 vccd1 vccd1 sky130_fd_sc_hd__decap_3
XPHY_103 vssd1 vssd1 vccd1 vccd1 sky130_fd_sc_hd__decap_3
XPHY_5 vssd1 vssd1 vccd1 vccd1 sky130_fd_sc_hd__decap_3
XFILLER_0_80_361 vssd1 vssd1 vccd1 vccd1 sky130_fd_sc_hd__decap_3
XFILLER_0_25_211 vssd1 vssd1 vccd1 vccd1 sky130_fd_sc_hd__fill_1
XFILLER_0_4_149 vssd1 vssd1 vccd1 vccd1 sky130_fd_sc_hd__fill_1
X_1810_ spi_mem2.data_buf\[7\] net563 net379 vssd1 vssd1 vccd1 vccd1 _0277_ sky130_fd_sc_hd__mux2_1
X_1741_ net528 net406 _0768_ _0769_ vssd1 vssd1 vccd1 vccd1 _0254_ sky130_fd_sc_hd__o22a_1
XFILLER_0_68_67 vssd1 vssd1 vccd1 vccd1 sky130_ef_sc_hd__decap_12
XTAP_634 vssd1 vccd1 sky130_fd_sc_hd__tapvpwrvgnd_1
XTAP_623 vssd1 vccd1 sky130_fd_sc_hd__tapvpwrvgnd_1
XTAP_612 vssd1 vccd1 sky130_fd_sc_hd__tapvpwrvgnd_1
X_1672_ net394 _0609_ net371 vssd1 vssd1 vccd1 vccd1 _0729_ sky130_fd_sc_hd__o21ai_2
XTAP_601 vssd1 vccd1 sky130_fd_sc_hd__tapvpwrvgnd_1
Xhold307 spi_mem1.data_buf\[12\] vssd1 vssd1 vccd1 vccd1 net811 sky130_fd_sc_hd__dlygate4sd3_1
XTAP_689 vssd1 vccd1 sky130_fd_sc_hd__tapvpwrvgnd_1
XTAP_678 vssd1 vccd1 sky130_fd_sc_hd__tapvpwrvgnd_1
XTAP_667 vssd1 vccd1 sky130_fd_sc_hd__tapvpwrvgnd_1
XTAP_656 vssd1 vccd1 sky130_fd_sc_hd__tapvpwrvgnd_1
XTAP_645 vssd1 vccd1 sky130_fd_sc_hd__tapvpwrvgnd_1
X_2224_ clknet_leaf_20_clk_i _0238_ net487 vssd1 vssd1 vccd1 vccd1 spi_mem2.latency\[3\]
+ sky130_fd_sc_hd__dfrtp_2
X_1106_ spi_mem0.state\[2\] _0921_ _0945_ _0368_ vssd1 vssd1 vccd1 vccd1 _0369_ sky130_fd_sc_hd__a31oi_4
X_2155_ clknet_leaf_7_clk_i _0175_ net468 vssd1 vssd1 vccd1 vccd1 net298 sky130_fd_sc_hd__dfrtp_1
XFILLER_0_75_166 vssd1 vssd1 vccd1 vccd1 sky130_fd_sc_hd__fill_2
X_1037_ spi_mem2.state\[1\] net426 vssd1 vssd1 vccd1 vccd1 _0959_ sky130_fd_sc_hd__nand2_4
XFILLER_0_48_303 vssd1 vssd1 vccd1 vccd1 sky130_fd_sc_hd__decap_4
X_2086_ clknet_leaf_3_clk_i _0106_ net468 vssd1 vssd1 vccd1 vccd1 spi_mem0.data_buf\[12\]
+ sky130_fd_sc_hd__dfrtp_1
XFILLER_0_71_361 vssd1 vssd1 vccd1 vccd1 sky130_ef_sc_hd__decap_12
X_1939_ net576 _0892_ _0896_ net363 vssd1 vssd1 vccd1 vccd1 _0325_ sky130_fd_sc_hd__a22o_1
Xinput90 sport1_i[13] vssd1 vssd1 vccd1 vccd1 net90 sky130_fd_sc_hd__dlymetal6s2s_1
XFILLER_0_39_303 vssd1 vssd1 vccd1 vccd1 sky130_ef_sc_hd__decap_12
XFILLER_0_81_169 vssd1 vssd1 vccd1 vccd1 sky130_fd_sc_hd__decap_3
XFILLER_0_66_177 vssd1 vssd1 vccd1 vccd1 sky130_ef_sc_hd__decap_12
XFILLER_0_38_59 vssd1 vssd1 vccd1 vccd1 sky130_fd_sc_hd__fill_1
XFILLER_0_9_219 vssd1 vssd1 vccd1 vccd1 sky130_fd_sc_hd__decap_4
Xhold126 spi_mem1.address\[4\] vssd1 vssd1 vccd1 vccd1 net630 sky130_fd_sc_hd__dlygate4sd3_1
Xhold115 spi_mem1.data_buf\[26\] vssd1 vssd1 vccd1 vccd1 net619 sky130_fd_sc_hd__buf_1
XFILLER_0_53_361 vssd1 vssd1 vccd1 vccd1 sky130_fd_sc_hd__decap_4
Xhold104 _0272_ vssd1 vssd1 vccd1 vccd1 net608 sky130_fd_sc_hd__dlygate4sd3_1
XFILLER_0_13_225 vssd1 vssd1 vccd1 vccd1 sky130_fd_sc_hd__decap_3
X_1724_ net184 net555 net404 vssd1 vssd1 vccd1 vccd1 _0245_ sky130_fd_sc_hd__mux2_1
Xhold148 spi_mem0.has_2lc vssd1 vssd1 vccd1 vccd1 net652 sky130_fd_sc_hd__dlygate4sd3_1
X_1586_ spi_mem1.data_buf\[3\] spi_mem1.data_buf\[7\] spi_mem1.data_buf\[11\] spi_mem1.data_buf\[15\]
+ net431 net428 vssd1 vssd1 vccd1 vccd1 _0672_ sky130_fd_sc_hd__mux4_1
X_1655_ net692 _0718_ _0719_ net370 vssd1 vssd1 vccd1 vccd1 _0218_ sky130_fd_sc_hd__a22o_1
XTAP_475 vssd1 vccd1 sky130_fd_sc_hd__tapvpwrvgnd_1
XTAP_464 vssd1 vccd1 sky130_fd_sc_hd__tapvpwrvgnd_1
XTAP_453 vssd1 vccd1 sky130_fd_sc_hd__tapvpwrvgnd_1
XTAP_442 vssd1 vccd1 sky130_fd_sc_hd__tapvpwrvgnd_1
XTAP_431 vssd1 vccd1 sky130_fd_sc_hd__tapvpwrvgnd_1
XTAP_420 vssd1 vccd1 sky130_fd_sc_hd__tapvpwrvgnd_1
Xhold137 net328 vssd1 vssd1 vccd1 vccd1 net641 sky130_fd_sc_hd__dlygate4sd3_1
XFILLER_0_0_141 vssd1 vssd1 vccd1 vccd1 sky130_fd_sc_hd__fill_1
Xhold159 _0287_ vssd1 vssd1 vccd1 vccd1 net663 sky130_fd_sc_hd__dlygate4sd3_1
X_2069_ net493 net6 net486 vssd1 vssd1 vccd1 vccd1 spi_mem0.delayed_miso\[3\] sky130_fd_sc_hd__dfrtp_1
X_2138_ clknet_leaf_13_clk_i _0158_ net477 vssd1 vssd1 vccd1 vccd1 spi_mem1.state\[0\]
+ sky130_fd_sc_hd__dfrtp_1
XTAP_497 vssd1 vccd1 sky130_fd_sc_hd__tapvpwrvgnd_1
XTAP_486 vssd1 vccd1 sky130_fd_sc_hd__tapvpwrvgnd_1
X_2207_ clknet_leaf_5_clk_i _0221_ net471 vssd1 vssd1 vccd1 vccd1 spi_mem1.data_buf\[19\]
+ sky130_fd_sc_hd__dfrtp_1
XFILLER_0_21_3 vssd1 vssd1 vccd1 vccd1 sky130_fd_sc_hd__fill_2
X_1984__8 clknet_leaf_18_clk_i vssd1 vssd1 vccd1 vccd1 net497 sky130_fd_sc_hd__inv_2
XFILLER_0_63_136 vssd1 vssd1 vccd1 vccd1 sky130_fd_sc_hd__decap_6
XFILLER_0_63_125 vssd1 vssd1 vccd1 vccd1 sky130_fd_sc_hd__fill_2
XFILLER_0_48_122 vssd1 vssd1 vccd1 vccd1 sky130_fd_sc_hd__decap_6
XFILLER_0_44_383 vssd1 vssd1 vccd1 vccd1 sky130_ef_sc_hd__decap_12
XFILLER_0_44_361 vssd1 vssd1 vccd1 vccd1 sky130_fd_sc_hd__decap_3
XFILLER_0_54_103 vssd1 vssd1 vccd1 vccd1 sky130_fd_sc_hd__fill_1
X_1440_ net125 net124 _0564_ _0574_ vssd1 vssd1 vccd1 vccd1 _0575_ sky130_fd_sc_hd__or4_1
XFILLER_0_49_69 vssd1 vssd1 vccd1 vccd1 sky130_ef_sc_hd__decap_12
X_1371_ net40 net417 _0488_ _0526_ vssd1 vssd1 vccd1 vccd1 _0530_ sky130_fd_sc_hd__a22o_1
XFILLER_0_65_57 vssd1 vssd1 vccd1 vccd1 sky130_fd_sc_hd__decap_6
XFILLER_0_45_125 vssd1 vssd1 vccd1 vccd1 sky130_ef_sc_hd__decap_12
XFILLER_0_33_309 vssd1 vssd1 vccd1 vccd1 sky130_fd_sc_hd__decap_3
XFILLER_0_14_83 vssd1 vssd1 vccd1 vccd1 sky130_fd_sc_hd__fill_1
X_1707_ net392 _0753_ _0750_ _0748_ vssd1 vssd1 vccd1 vccd1 _0754_ sky130_fd_sc_hd__a211o_1
XFILLER_0_69_3 vssd1 vssd1 vccd1 vccd1 sky130_ef_sc_hd__decap_12
X_1638_ net711 _0707_ _0709_ net367 vssd1 vssd1 vccd1 vccd1 _0211_ sky130_fd_sc_hd__a22o_1
XFILLER_0_5_244 vssd1 vssd1 vccd1 vccd1 sky130_fd_sc_hd__fill_1
X_1569_ spi_mem1.address\[4\] spi_mem1.address\[8\] spi_mem1.address_nibble\[0\] vssd1
+ vssd1 vccd1 vccd1 _0657_ sky130_fd_sc_hd__mux2_1
Xfanout469 net470 vssd1 vssd1 vccd1 vccd1 net469 sky130_fd_sc_hd__clkbuf_4
Xfanout425 spi_mem2.data_nibble vssd1 vssd1 vccd1 vccd1 net425 sky130_fd_sc_hd__clkbuf_4
Xfanout436 spi_mem0.data_byte\[1\] vssd1 vssd1 vccd1 vccd1 net436 sky130_fd_sc_hd__buf_2
Xfanout414 net415 vssd1 vssd1 vccd1 vccd1 net414 sky130_fd_sc_hd__buf_2
XTAP_250 vssd1 vccd1 sky130_fd_sc_hd__tapvpwrvgnd_1
XTAP_261 vssd1 vccd1 sky130_fd_sc_hd__tapvpwrvgnd_1
XTAP_272 vssd1 vccd1 sky130_fd_sc_hd__tapvpwrvgnd_1
Xfanout447 net450 vssd1 vssd1 vccd1 vccd1 net447 sky130_fd_sc_hd__clkbuf_2
Xfanout458 net459 vssd1 vssd1 vccd1 vccd1 net458 sky130_fd_sc_hd__clkbuf_4
XTAP_283 vssd1 vccd1 sky130_fd_sc_hd__tapvpwrvgnd_1
XTAP_294 vssd1 vccd1 sky130_fd_sc_hd__tapvpwrvgnd_1
Xfanout403 _0969_ vssd1 vssd1 vccd1 vccd1 net403 sky130_fd_sc_hd__buf_2
XFILLER_0_68_239 vssd1 vssd1 vccd1 vccd1 sky130_fd_sc_hd__decap_4
XFILLER_0_68_206 vssd1 vssd1 vccd1 vccd1 sky130_fd_sc_hd__decap_4
XFILLER_0_76_294 vssd1 vssd1 vccd1 vccd1 sky130_fd_sc_hd__fill_1
XFILLER_0_36_125 vssd1 vssd1 vccd1 vccd1 sky130_ef_sc_hd__decap_12
XFILLER_0_32_331 vssd1 vssd1 vccd1 vccd1 sky130_ef_sc_hd__decap_12
XFILLER_0_24_309 vssd1 vssd1 vccd1 vccd1 sky130_fd_sc_hd__decap_4
XFILLER_0_82_253 vssd1 vssd1 vccd1 vccd1 sky130_fd_sc_hd__fill_1
XFILLER_0_82_220 vssd1 vssd1 vccd1 vccd1 sky130_fd_sc_hd__decap_4
XFILLER_0_51_15 vssd1 vssd1 vccd1 vccd1 sky130_fd_sc_hd__decap_4
XFILLER_0_27_169 vssd1 vssd1 vccd1 vccd1 sky130_ef_sc_hd__decap_12
XFILLER_0_27_147 vssd1 vssd1 vccd1 vccd1 sky130_fd_sc_hd__decap_4
XFILLER_0_82_297 vssd1 vssd1 vccd1 vccd1 sky130_fd_sc_hd__decap_4
X_1423_ net120 net122 net121 net412 vssd1 vssd1 vccd1 vccd1 _0563_ sky130_fd_sc_hd__o31a_1
X_1285_ net437 _0945_ vssd1 vssd1 vccd1 vccd1 _0476_ sky130_fd_sc_hd__nor2_1
X_1354_ net32 net415 _0490_ _0515_ vssd1 vssd1 vccd1 vccd1 _0520_ sky130_fd_sc_hd__a22o_1
XFILLER_0_65_209 vssd1 vssd1 vccd1 vccd1 sky130_fd_sc_hd__decap_6
XFILLER_0_25_93 vssd1 vssd1 vccd1 vccd1 sky130_ef_sc_hd__decap_12
Xclkbuf_leaf_17_clk_i clknet_2_3__leaf_clk_i vssd1 vssd1 vccd1 vccd1 clknet_leaf_17_clk_i
+ sky130_fd_sc_hd__clkbuf_16
XFILLER_0_41_161 vssd1 vssd1 vccd1 vccd1 sky130_fd_sc_hd__decap_6
XFILLER_0_49_261 vssd1 vssd1 vccd1 vccd1 sky130_fd_sc_hd__fill_1
XFILLER_0_46_37 vssd1 vssd1 vccd1 vccd1 sky130_fd_sc_hd__decap_6
XFILLER_0_46_15 vssd1 vssd1 vccd1 vccd1 sky130_ef_sc_hd__decap_12
XFILLER_0_20_345 vssd1 vssd1 vccd1 vccd1 sky130_fd_sc_hd__decap_4
XFILLER_0_20_389 vssd1 vssd1 vccd1 vccd1 sky130_ef_sc_hd__decap_12
X_1070_ net433 _0981_ vssd1 vssd1 vccd1 vccd1 _0982_ sky130_fd_sc_hd__nor2_4
XFILLER_0_70_212 vssd1 vssd1 vccd1 vccd1 sky130_ef_sc_hd__decap_12
X_1972_ net176 net402 _0873_ _0913_ vssd1 vssd1 vccd1 vccd1 _0916_ sky130_fd_sc_hd__a22o_1
Xhold19 net254 vssd1 vssd1 vccd1 vccd1 net523 sky130_fd_sc_hd__dlygate4sd3_1
X_1406_ _0548_ _0556_ vssd1 vssd1 vccd1 vccd1 _0559_ sky130_fd_sc_hd__nand2_1
X_1268_ net439 net437 spi_mem0.data_buf\[15\] vssd1 vssd1 vccd1 vccd1 _0461_ sky130_fd_sc_hd__and3_1
X_1337_ net393 _0350_ net374 vssd1 vssd1 vccd1 vccd1 _0510_ sky130_fd_sc_hd__o21ai_2
XFILLER_0_78_389 vssd1 vssd1 vccd1 vccd1 sky130_ef_sc_hd__decap_12
X_1199_ net741 net290 net390 vssd1 vssd1 vccd1 vccd1 _0061_ sky130_fd_sc_hd__mux2_1
XFILLER_0_19_401 vssd1 vssd1 vccd1 vccd1 sky130_fd_sc_hd__decap_6
XFILLER_0_61_212 vssd1 vssd1 vccd1 vccd1 sky130_fd_sc_hd__fill_2
XFILLER_0_46_253 vssd1 vssd1 vccd1 vccd1 sky130_fd_sc_hd__fill_2
XFILLER_0_69_312 vssd1 vssd1 vccd1 vccd1 sky130_ef_sc_hd__decap_12
X_1122_ net809 _0378_ _0383_ vssd1 vssd1 vccd1 vccd1 _0021_ sky130_fd_sc_hd__o21a_1
XFILLER_0_57_36 vssd1 vssd1 vccd1 vccd1 sky130_ef_sc_hd__decap_12
X_2171_ clknet_leaf_14_clk_i net759 net472 vssd1 vssd1 vccd1 vccd1 net315 sky130_fd_sc_hd__dfrtp_1
X_2240_ clknet_leaf_29_clk_i _0254_ net466 vssd1 vssd1 vccd1 vccd1 spi_mem2.address\[13\]
+ sky130_fd_sc_hd__dfrtp_1
XFILLER_0_20_197 vssd1 vssd1 vccd1 vccd1 sky130_fd_sc_hd__decap_4
XFILLER_0_75_337 vssd1 vssd1 vccd1 vccd1 sky130_fd_sc_hd__decap_8
XFILLER_0_73_57 vssd1 vssd1 vccd1 vccd1 sky130_fd_sc_hd__decap_6
X_1053_ spi_mem2.state\[1\] _0958_ vssd1 vssd1 vccd1 vccd1 _0969_ sky130_fd_sc_hd__nor2_2
X_1886_ net799 _0818_ _0862_ _0863_ vssd1 vssd1 vccd1 vccd1 _0305_ sky130_fd_sc_hd__a22o_1
XFILLER_0_43_234 vssd1 vssd1 vccd1 vccd1 sky130_fd_sc_hd__fill_2
XFILLER_0_28_253 vssd1 vssd1 vccd1 vccd1 sky130_ef_sc_hd__decap_12
XFILLER_0_7_147 vssd1 vssd1 vccd1 vccd1 sky130_fd_sc_hd__fill_2
XFILLER_0_7_169 vssd1 vssd1 vccd1 vccd1 sky130_fd_sc_hd__decap_4
X_1955_ net169 net402 _0875_ _0902_ vssd1 vssd1 vccd1 vccd1 _0906_ sky130_fd_sc_hd__a22o_1
XFILLER_0_51_3 vssd1 vssd1 vccd1 vccd1 sky130_ef_sc_hd__decap_12
Xinput109 sport1_i[30] vssd1 vssd1 vccd1 vccd1 net109 sky130_fd_sc_hd__buf_1
XFILLER_0_11_186 vssd1 vssd1 vccd1 vccd1 sky130_fd_sc_hd__decap_8
XFILLER_0_78_153 vssd1 vssd1 vccd1 vccd1 sky130_ef_sc_hd__decap_12
XPHY_159 vssd1 vssd1 vccd1 vccd1 sky130_fd_sc_hd__decap_3
XFILLER_0_78_197 vssd1 vssd1 vccd1 vccd1 sky130_ef_sc_hd__decap_12
XPHY_148 vssd1 vssd1 vccd1 vccd1 sky130_fd_sc_hd__decap_3
XPHY_137 vssd1 vssd1 vccd1 vccd1 sky130_fd_sc_hd__decap_3
XPHY_126 vssd1 vssd1 vccd1 vccd1 sky130_fd_sc_hd__decap_3
XPHY_115 vssd1 vssd1 vccd1 vccd1 sky130_fd_sc_hd__decap_3
XPHY_104 vssd1 vssd1 vccd1 vccd1 sky130_fd_sc_hd__decap_3
XFILLER_0_34_278 vssd1 vssd1 vccd1 vccd1 sky130_ef_sc_hd__decap_12
XFILLER_0_34_256 vssd1 vssd1 vccd1 vccd1 sky130_fd_sc_hd__decap_8
XFILLER_0_69_175 vssd1 vssd1 vccd1 vccd1 sky130_fd_sc_hd__fill_1
XFILLER_0_57_337 vssd1 vssd1 vccd1 vccd1 sky130_fd_sc_hd__fill_2
XPHY_6 vssd1 vssd1 vccd1 vccd1 sky130_fd_sc_hd__decap_3
Xhold308 spi_mem2.latency\[3\] vssd1 vssd1 vccd1 vccd1 net812 sky130_fd_sc_hd__dlygate4sd3_1
XFILLER_0_65_381 vssd1 vssd1 vccd1 vccd1 sky130_fd_sc_hd__fill_1
X_1671_ net536 _0724_ _0728_ net369 vssd1 vssd1 vccd1 vccd1 _0225_ sky130_fd_sc_hd__a22o_1
XFILLER_0_25_223 vssd1 vssd1 vccd1 vccd1 sky130_fd_sc_hd__fill_1
X_1740_ net194 _0765_ net406 vssd1 vssd1 vccd1 vccd1 _0769_ sky130_fd_sc_hd__o21ai_1
XTAP_668 vssd1 vccd1 sky130_fd_sc_hd__tapvpwrvgnd_1
XTAP_657 vssd1 vccd1 sky130_fd_sc_hd__tapvpwrvgnd_1
XFILLER_0_68_79 vssd1 vssd1 vccd1 vccd1 sky130_fd_sc_hd__decap_4
XFILLER_0_68_57 vssd1 vssd1 vccd1 vccd1 sky130_fd_sc_hd__fill_2
XTAP_646 vssd1 vccd1 sky130_fd_sc_hd__tapvpwrvgnd_1
XTAP_635 vssd1 vccd1 sky130_fd_sc_hd__tapvpwrvgnd_1
XTAP_624 vssd1 vccd1 sky130_fd_sc_hd__tapvpwrvgnd_1
XTAP_613 vssd1 vccd1 sky130_fd_sc_hd__tapvpwrvgnd_1
XTAP_602 vssd1 vccd1 sky130_fd_sc_hd__tapvpwrvgnd_1
XTAP_679 vssd1 vccd1 sky130_fd_sc_hd__tapvpwrvgnd_1
X_2223_ clknet_leaf_20_clk_i _0237_ net487 vssd1 vssd1 vccd1 vccd1 spi_mem2.latency\[2\]
+ sky130_fd_sc_hd__dfrtp_1
X_2154_ clknet_leaf_7_clk_i net793 net467 vssd1 vssd1 vccd1 vccd1 net297 sky130_fd_sc_hd__dfrtp_1
X_1105_ net442 net416 vssd1 vssd1 vccd1 vccd1 _0368_ sky130_fd_sc_hd__and2b_2
X_2085_ clknet_leaf_1_clk_i _0105_ net452 vssd1 vssd1 vccd1 vccd1 spi_mem0.data_buf\[11\]
+ sky130_fd_sc_hd__dfrtp_1
XFILLER_0_75_178 vssd1 vssd1 vccd1 vccd1 sky130_fd_sc_hd__decap_6
XFILLER_0_63_307 vssd1 vssd1 vccd1 vccd1 sky130_fd_sc_hd__decap_6
X_1036_ spi_mem2.state\[2\] spi_mem2.state\[3\] vssd1 vssd1 vccd1 vccd1 _0958_ sky130_fd_sc_hd__nand2b_2
XFILLER_0_71_373 vssd1 vssd1 vccd1 vccd1 sky130_fd_sc_hd__decap_3
XFILLER_0_31_215 vssd1 vssd1 vccd1 vccd1 sky130_fd_sc_hd__decap_8
X_1938_ net161 net400 _0877_ _0891_ vssd1 vssd1 vccd1 vccd1 _0896_ sky130_fd_sc_hd__a22o_1
Xinput91 sport1_i[14] vssd1 vssd1 vccd1 vccd1 net91 sky130_fd_sc_hd__dlymetal6s2s_1
Xinput80 sport0_i[67] vssd1 vssd1 vccd1 vccd1 net80 sky130_fd_sc_hd__clkbuf_2
X_1869_ spi_mem2.data_byte\[1\] _0844_ _0847_ _0970_ vssd1 vssd1 vccd1 vccd1 _0848_
+ sky130_fd_sc_hd__o211a_1
XFILLER_0_39_315 vssd1 vssd1 vccd1 vccd1 sky130_ef_sc_hd__decap_12
XFILLER_0_66_189 vssd1 vssd1 vccd1 vccd1 sky130_fd_sc_hd__decap_6
XFILLER_0_66_156 vssd1 vssd1 vccd1 vccd1 sky130_fd_sc_hd__decap_6
XFILLER_0_62_362 vssd1 vssd1 vccd1 vccd1 sky130_fd_sc_hd__fill_2
XFILLER_0_22_237 vssd1 vssd1 vccd1 vccd1 sky130_ef_sc_hd__decap_12
XFILLER_0_54_15 vssd1 vssd1 vccd1 vccd1 sky130_fd_sc_hd__decap_4
XFILLER_0_57_167 vssd1 vssd1 vccd1 vccd1 sky130_fd_sc_hd__fill_1
XFILLER_0_57_134 vssd1 vssd1 vccd1 vccd1 sky130_ef_sc_hd__decap_12
Xhold116 net242 vssd1 vssd1 vccd1 vccd1 net620 sky130_fd_sc_hd__dlygate4sd3_1
Xhold127 spi_mem1.address\[2\] vssd1 vssd1 vccd1 vccd1 net631 sky130_fd_sc_hd__dlygate4sd3_1
X_1654_ net93 net396 _0979_ _0692_ vssd1 vssd1 vccd1 vccd1 _0719_ sky130_fd_sc_hd__a22o_1
Xhold138 _0270_ vssd1 vssd1 vccd1 vccd1 net642 sky130_fd_sc_hd__dlygate4sd3_1
X_1723_ net183 net545 net404 vssd1 vssd1 vccd1 vccd1 _0244_ sky130_fd_sc_hd__mux2_1
Xhold149 net339 vssd1 vssd1 vccd1 vccd1 net653 sky130_fd_sc_hd__dlygate4sd3_1
XFILLER_0_13_215 vssd1 vssd1 vccd1 vccd1 sky130_fd_sc_hd__decap_8
XFILLER_0_13_248 vssd1 vssd1 vccd1 vccd1 sky130_ef_sc_hd__decap_12
Xhold105 spi_mem0.address\[18\] vssd1 vssd1 vccd1 vccd1 net609 sky130_fd_sc_hd__dlygate4sd3_1
X_1585_ spi_mem1.data_buf\[19\] spi_mem1.data_buf\[23\] spi_mem1.data_buf\[27\] spi_mem1.data_buf\[31\]
+ net431 net428 vssd1 vssd1 vccd1 vccd1 _0671_ sky130_fd_sc_hd__mux4_1
XTAP_498 vssd1 vccd1 sky130_fd_sc_hd__tapvpwrvgnd_1
X_2206_ clknet_leaf_15_clk_i _0220_ net471 vssd1 vssd1 vccd1 vccd1 spi_mem1.data_buf\[18\]
+ sky130_fd_sc_hd__dfrtp_1
XTAP_487 vssd1 vccd1 sky130_fd_sc_hd__tapvpwrvgnd_1
XTAP_476 vssd1 vccd1 sky130_fd_sc_hd__tapvpwrvgnd_1
XTAP_465 vssd1 vccd1 sky130_fd_sc_hd__tapvpwrvgnd_1
XTAP_454 vssd1 vccd1 sky130_fd_sc_hd__tapvpwrvgnd_1
XTAP_443 vssd1 vccd1 sky130_fd_sc_hd__tapvpwrvgnd_1
XTAP_432 vssd1 vccd1 sky130_fd_sc_hd__tapvpwrvgnd_1
XTAP_421 vssd1 vccd1 sky130_fd_sc_hd__tapvpwrvgnd_1
XTAP_410 vssd1 vccd1 sky130_fd_sc_hd__tapvpwrvgnd_1
XFILLER_0_28_93 vssd1 vssd1 vccd1 vccd1 sky130_fd_sc_hd__decap_4
X_2068_ net492 net5 net483 vssd1 vssd1 vccd1 vccd1 spi_mem0.delayed_miso\[2\] sky130_fd_sc_hd__dfrtp_1
X_1019_ spi_mem1.spi_clk net319 net411 vssd1 vssd1 vccd1 vccd1 net236 sky130_fd_sc_hd__and3_1
X_2137_ clknet_leaf_17_clk_i _0157_ net488 vssd1 vssd1 vccd1 vccd1 spi_mem1.address_nibble\[2\]
+ sky130_fd_sc_hd__dfstp_2
XFILLER_0_14_3 vssd1 vssd1 vccd1 vccd1 sky130_fd_sc_hd__fill_2
XFILLER_0_48_189 vssd1 vssd1 vccd1 vccd1 sky130_fd_sc_hd__decap_6
XFILLER_0_44_351 vssd1 vssd1 vccd1 vccd1 sky130_fd_sc_hd__decap_3
XFILLER_0_71_192 vssd1 vssd1 vccd1 vccd1 sky130_ef_sc_hd__decap_12
XFILLER_0_71_181 vssd1 vssd1 vccd1 vccd1 sky130_fd_sc_hd__decap_8
XFILLER_0_44_395 vssd1 vssd1 vccd1 vccd1 sky130_ef_sc_hd__decap_12
XFILLER_0_27_318 vssd1 vssd1 vccd1 vccd1 sky130_fd_sc_hd__fill_1
XFILLER_0_24_29 vssd1 vssd1 vccd1 vccd1 sky130_fd_sc_hd__decap_6
XFILLER_0_50_365 vssd1 vssd1 vccd1 vccd1 sky130_fd_sc_hd__fill_2
XFILLER_0_50_321 vssd1 vssd1 vccd1 vccd1 sky130_fd_sc_hd__fill_2
XFILLER_0_49_15 vssd1 vssd1 vccd1 vccd1 sky130_ef_sc_hd__decap_12
X_1370_ net746 _0527_ _0529_ net375 vssd1 vssd1 vccd1 vccd1 _0123_ sky130_fd_sc_hd__a22o_1
XFILLER_0_81_57 vssd1 vssd1 vccd1 vccd1 sky130_fd_sc_hd__fill_2
XFILLER_0_45_137 vssd1 vssd1 vccd1 vccd1 sky130_fd_sc_hd__fill_1
XFILLER_0_26_362 vssd1 vssd1 vccd1 vccd1 sky130_fd_sc_hd__fill_2
XFILLER_0_5_223 vssd1 vssd1 vccd1 vccd1 sky130_fd_sc_hd__fill_1
X_1706_ spi_mem2.latency\[1\] spi_mem2.latency\[0\] vssd1 vssd1 vccd1 vccd1 _0753_
+ sky130_fd_sc_hd__xnor2_1
X_1637_ net154 net398 _0694_ _0706_ vssd1 vssd1 vccd1 vccd1 _0709_ sky130_fd_sc_hd__a22o_1
XFILLER_0_53_192 vssd1 vssd1 vccd1 vccd1 sky130_fd_sc_hd__decap_4
XFILLER_0_30_83 vssd1 vssd1 vccd1 vccd1 sky130_fd_sc_hd__fill_1
Xfanout404 net405 vssd1 vssd1 vccd1 vccd1 net404 sky130_fd_sc_hd__clkbuf_4
X_1499_ net433 _0981_ _0623_ vssd1 vssd1 vccd1 vccd1 _0624_ sky130_fd_sc_hd__a21oi_1
X_1568_ spi_mem1.address\[18\] _0534_ _0655_ _0930_ vssd1 vssd1 vccd1 vccd1 _0656_
+ sky130_fd_sc_hd__a211o_1
Xfanout426 spi_mem2.state\[0\] vssd1 vssd1 vccd1 vccd1 net426 sky130_fd_sc_hd__buf_4
Xfanout437 spi_mem0.data_byte\[0\] vssd1 vssd1 vccd1 vccd1 net437 sky130_fd_sc_hd__clkbuf_4
XFILLER_0_39_92 vssd1 vssd1 vccd1 vccd1 sky130_fd_sc_hd__fill_1
Xfanout415 net417 vssd1 vssd1 vccd1 vccd1 net415 sky130_fd_sc_hd__buf_2
Xfanout459 net466 vssd1 vssd1 vccd1 vccd1 net459 sky130_fd_sc_hd__buf_2
Xfanout448 net449 vssd1 vssd1 vccd1 vccd1 net448 sky130_fd_sc_hd__clkbuf_4
XTAP_240 vssd1 vccd1 sky130_fd_sc_hd__tapvpwrvgnd_1
XTAP_251 vssd1 vccd1 sky130_fd_sc_hd__tapvpwrvgnd_1
XTAP_262 vssd1 vccd1 sky130_fd_sc_hd__tapvpwrvgnd_1
XTAP_273 vssd1 vccd1 sky130_fd_sc_hd__tapvpwrvgnd_1
XTAP_284 vssd1 vccd1 sky130_fd_sc_hd__tapvpwrvgnd_1
XTAP_295 vssd1 vccd1 sky130_fd_sc_hd__tapvpwrvgnd_1
XFILLER_0_76_251 vssd1 vssd1 vccd1 vccd1 sky130_fd_sc_hd__fill_1
XFILLER_0_36_137 vssd1 vssd1 vccd1 vccd1 sky130_fd_sc_hd__decap_3
XFILLER_0_32_365 vssd1 vssd1 vccd1 vccd1 sky130_ef_sc_hd__decap_12
XFILLER_0_32_343 vssd1 vssd1 vccd1 vccd1 sky130_ef_sc_hd__decap_12
XFILLER_0_32_321 vssd1 vssd1 vccd1 vccd1 sky130_fd_sc_hd__decap_4
XFILLER_0_3_3 vssd1 vssd1 vccd1 vccd1 sky130_fd_sc_hd__fill_2
XFILLER_0_35_39 vssd1 vssd1 vccd1 vccd1 sky130_ef_sc_hd__decap_12
XFILLER_0_67_273 vssd1 vssd1 vccd1 vccd1 sky130_fd_sc_hd__decap_6
XFILLER_0_67_240 vssd1 vssd1 vccd1 vccd1 sky130_ef_sc_hd__decap_12
XFILLER_0_55_402 vssd1 vssd1 vccd1 vccd1 sky130_fd_sc_hd__decap_4
X_1422_ net120 net121 net122 vssd1 vssd1 vccd1 vccd1 _0562_ sky130_fd_sc_hd__o21ai_1
XFILLER_0_50_195 vssd1 vssd1 vccd1 vccd1 sky130_fd_sc_hd__fill_1
XFILLER_0_76_35 vssd1 vssd1 vccd1 vccd1 sky130_fd_sc_hd__fill_1
X_1284_ _0368_ _0475_ _0474_ net439 vssd1 vssd1 vccd1 vccd1 _0091_ sky130_fd_sc_hd__a2bb2o_1
Xclkbuf_0_clk_i clk_i vssd1 vssd1 vccd1 vccd1 clknet_0_clk_i sky130_fd_sc_hd__clkbuf_16
X_1353_ net724 _0516_ _0519_ net375 vssd1 vssd1 vccd1 vccd1 _0116_ sky130_fd_sc_hd__a22o_1
XFILLER_0_81_3 vssd1 vssd1 vccd1 vccd1 sky130_ef_sc_hd__decap_12
X_0999_ net804 vssd1 vssd1 vccd1 vccd1 _0928_ sky130_fd_sc_hd__inv_2
XFILLER_0_14_321 vssd1 vssd1 vccd1 vccd1 sky130_ef_sc_hd__decap_12
XFILLER_0_14_365 vssd1 vssd1 vccd1 vccd1 sky130_ef_sc_hd__decap_12
XFILLER_0_64_232 vssd1 vssd1 vccd1 vccd1 sky130_ef_sc_hd__decap_12
XFILLER_0_49_295 vssd1 vssd1 vccd1 vccd1 sky130_fd_sc_hd__decap_3
XFILLER_0_9_381 vssd1 vssd1 vccd1 vccd1 sky130_fd_sc_hd__decap_8
XFILLER_0_32_195 vssd1 vssd1 vccd1 vccd1 sky130_fd_sc_hd__fill_1
XFILLER_0_20_302 vssd1 vssd1 vccd1 vccd1 sky130_fd_sc_hd__fill_2
XFILLER_0_20_335 vssd1 vssd1 vccd1 vccd1 sky130_fd_sc_hd__fill_1
XFILLER_0_20_357 vssd1 vssd1 vccd1 vccd1 sky130_fd_sc_hd__decap_6
XFILLER_0_46_27 vssd1 vssd1 vccd1 vccd1 sky130_fd_sc_hd__fill_1
XFILLER_0_62_59 vssd1 vssd1 vccd1 vccd1 sky130_fd_sc_hd__fill_1
XFILLER_0_28_402 vssd1 vssd1 vccd1 vccd1 sky130_fd_sc_hd__decap_4
XFILLER_0_70_246 vssd1 vssd1 vccd1 vccd1 sky130_fd_sc_hd__decap_6
XFILLER_0_70_224 vssd1 vssd1 vccd1 vccd1 sky130_fd_sc_hd__decap_4
X_1971_ net801 _0914_ _0915_ net364 vssd1 vssd1 vccd1 vccd1 _0338_ sky130_fd_sc_hd__a22o_1
XFILLER_0_15_129 vssd1 vssd1 vccd1 vccd1 sky130_ef_sc_hd__decap_12
X_1405_ _0549_ _0557_ _0548_ vssd1 vssd1 vccd1 vccd1 _0558_ sky130_fd_sc_hd__o21a_1
XFILLER_0_11_96 vssd1 vssd1 vccd1 vccd1 sky130_fd_sc_hd__decap_4
XFILLER_0_11_335 vssd1 vssd1 vccd1 vccd1 sky130_fd_sc_hd__fill_1
X_1267_ _0460_ net615 _0422_ vssd1 vssd1 vccd1 vccd1 _0089_ sky130_fd_sc_hd__mux2_1
XFILLER_0_78_313 vssd1 vssd1 vccd1 vccd1 sky130_fd_sc_hd__fill_1
X_1336_ net675 _0505_ _0509_ net373 vssd1 vssd1 vccd1 vccd1 _0109_ sky130_fd_sc_hd__a22o_1
X_1198_ net730 net289 net390 vssd1 vssd1 vccd1 vccd1 _0060_ sky130_fd_sc_hd__mux2_1
Xinput1 nrst_i vssd1 vssd1 vccd1 vccd1 net1 sky130_fd_sc_hd__clkbuf_1
XFILLER_0_52_81 vssd1 vssd1 vccd1 vccd1 sky130_fd_sc_hd__decap_3
XFILLER_0_46_287 vssd1 vssd1 vccd1 vccd1 sky130_fd_sc_hd__fill_1
XFILLER_0_6_362 vssd1 vssd1 vccd1 vccd1 sky130_fd_sc_hd__fill_2
Xoutput360 net360 vssd1 vssd1 vccd1 vccd1 sport2_o[8] sky130_fd_sc_hd__clkbuf_4
XFILLER_0_69_324 vssd1 vssd1 vccd1 vccd1 sky130_ef_sc_hd__decap_12
XFILLER_0_57_48 vssd1 vssd1 vccd1 vccd1 sky130_fd_sc_hd__decap_8
X_1121_ _0370_ _0382_ _0379_ _0377_ vssd1 vssd1 vccd1 vccd1 _0383_ sky130_fd_sc_hd__a211o_1
Xclkbuf_leaf_16_clk_i clknet_2_3__leaf_clk_i vssd1 vssd1 vccd1 vccd1 clknet_leaf_16_clk_i
+ sky130_fd_sc_hd__clkbuf_16
X_2170_ clknet_leaf_5_clk_i net697 net472 vssd1 vssd1 vccd1 vccd1 net314 sky130_fd_sc_hd__dfrtp_1
X_1052_ net426 _0966_ vssd1 vssd1 vccd1 vccd1 _0968_ sky130_fd_sc_hd__or2_4
XFILLER_0_28_265 vssd1 vssd1 vccd1 vccd1 sky130_ef_sc_hd__decap_12
X_1954_ net657 _0903_ _0905_ net364 vssd1 vssd1 vccd1 vccd1 _0331_ sky130_fd_sc_hd__a22o_1
X_1885_ net219 _0817_ _0818_ vssd1 vssd1 vccd1 vccd1 _0863_ sky130_fd_sc_hd__a21oi_1
XFILLER_0_43_279 vssd1 vssd1 vccd1 vccd1 sky130_fd_sc_hd__fill_1
XFILLER_0_44_3 vssd1 vssd1 vccd1 vccd1 sky130_ef_sc_hd__decap_12
XFILLER_0_78_165 vssd1 vssd1 vccd1 vccd1 sky130_ef_sc_hd__decap_12
XPHY_116 vssd1 vssd1 vccd1 vccd1 sky130_fd_sc_hd__decap_3
XPHY_105 vssd1 vssd1 vccd1 vccd1 sky130_fd_sc_hd__decap_3
X_2299_ clknet_leaf_26_clk_i _0307_ net465 vssd1 vssd1 vccd1 vccd1 spi_mem2.data_nibble
+ sky130_fd_sc_hd__dfrtp_1
X_1319_ net84 net414 _0484_ _0498_ vssd1 vssd1 vccd1 vccd1 _0500_ sky130_fd_sc_hd__a22o_1
XFILLER_0_2_83 vssd1 vssd1 vccd1 vccd1 sky130_fd_sc_hd__fill_1
XPHY_149 vssd1 vssd1 vccd1 vccd1 sky130_fd_sc_hd__decap_3
XPHY_138 vssd1 vssd1 vccd1 vccd1 sky130_fd_sc_hd__decap_3
XPHY_127 vssd1 vssd1 vccd1 vccd1 sky130_fd_sc_hd__decap_3
XFILLER_0_19_287 vssd1 vssd1 vccd1 vccd1 sky130_fd_sc_hd__decap_8
XFILLER_0_43_28 vssd1 vssd1 vccd1 vccd1 sky130_fd_sc_hd__decap_8
XPHY_7 vssd1 vssd1 vccd1 vccd1 sky130_fd_sc_hd__decap_3
Xhold309 net243 vssd1 vssd1 vccd1 vccd1 net813 sky130_fd_sc_hd__dlygate4sd3_1
X_1670_ net101 net397 _0698_ _0723_ vssd1 vssd1 vccd1 vccd1 _0728_ sky130_fd_sc_hd__a22o_1
XFILLER_0_25_246 vssd1 vssd1 vccd1 vccd1 sky130_fd_sc_hd__decap_4
X_2222_ clknet_leaf_19_clk_i _0236_ net485 vssd1 vssd1 vccd1 vccd1 spi_mem2.latency\[1\]
+ sky130_fd_sc_hd__dfrtp_1
XTAP_669 vssd1 vccd1 sky130_fd_sc_hd__tapvpwrvgnd_1
XTAP_658 vssd1 vccd1 sky130_fd_sc_hd__tapvpwrvgnd_1
XTAP_647 vssd1 vccd1 sky130_fd_sc_hd__tapvpwrvgnd_1
XTAP_636 vssd1 vccd1 sky130_fd_sc_hd__tapvpwrvgnd_1
XTAP_625 vssd1 vccd1 sky130_fd_sc_hd__tapvpwrvgnd_1
XTAP_614 vssd1 vccd1 sky130_fd_sc_hd__tapvpwrvgnd_1
XTAP_603 vssd1 vccd1 sky130_fd_sc_hd__tapvpwrvgnd_1
XFILLER_0_0_335 vssd1 vssd1 vccd1 vccd1 sky130_fd_sc_hd__fill_1
X_1104_ net2 net652 _0367_ vssd1 vssd1 vccd1 vccd1 _0019_ sky130_fd_sc_hd__mux2_1
X_2153_ clknet_leaf_6_clk_i net516 net469 vssd1 vssd1 vccd1 vccd1 net296 sky130_fd_sc_hd__dfrtp_2
X_1035_ _0923_ spi_mem2.state\[2\] vssd1 vssd1 vccd1 vccd1 _0957_ sky130_fd_sc_hd__nor2_1
X_2084_ clknet_leaf_1_clk_i _0104_ net451 vssd1 vssd1 vccd1 vccd1 spi_mem0.data_buf\[10\]
+ sky130_fd_sc_hd__dfrtp_1
XFILLER_0_56_382 vssd1 vssd1 vccd1 vccd1 sky130_fd_sc_hd__fill_2
X_1937_ net698 _0892_ _0895_ net363 vssd1 vssd1 vccd1 vccd1 _0324_ sky130_fd_sc_hd__a22o_1
X_1799_ spi_mem2.state\[1\] net427 _0965_ _0809_ vssd1 vssd1 vccd1 vccd1 _0813_ sky130_fd_sc_hd__a31o_1
XFILLER_0_3_173 vssd1 vssd1 vccd1 vccd1 sky130_fd_sc_hd__fill_1
Xinput81 sport0_i[68] vssd1 vssd1 vccd1 vccd1 net81 sky130_fd_sc_hd__clkbuf_2
Xinput92 sport1_i[15] vssd1 vssd1 vccd1 vccd1 net92 sky130_fd_sc_hd__dlymetal6s2s_1
Xinput70 sport0_i[58] vssd1 vssd1 vccd1 vccd1 net70 sky130_fd_sc_hd__clkbuf_1
X_1868_ spi_mem2.data_buf\[26\] _0819_ _0846_ _0927_ vssd1 vssd1 vccd1 vccd1 _0847_
+ sky130_fd_sc_hd__a211o_1
XFILLER_0_81_105 vssd1 vssd1 vccd1 vccd1 sky130_fd_sc_hd__decap_6
XFILLER_0_39_327 vssd1 vssd1 vccd1 vccd1 sky130_fd_sc_hd__decap_8
XFILLER_0_81_138 vssd1 vssd1 vccd1 vccd1 sky130_fd_sc_hd__decap_3
XFILLER_0_62_330 vssd1 vssd1 vccd1 vccd1 sky130_ef_sc_hd__decap_12
XFILLER_0_22_249 vssd1 vssd1 vccd1 vccd1 sky130_fd_sc_hd__decap_3
XFILLER_0_38_39 vssd1 vssd1 vccd1 vccd1 sky130_ef_sc_hd__decap_12
XFILLER_0_54_27 vssd1 vssd1 vccd1 vccd1 sky130_fd_sc_hd__fill_1
XFILLER_0_70_15 vssd1 vssd1 vccd1 vccd1 sky130_ef_sc_hd__decap_12
XFILLER_0_57_146 vssd1 vssd1 vccd1 vccd1 sky130_fd_sc_hd__fill_1
XFILLER_0_57_113 vssd1 vssd1 vccd1 vccd1 sky130_fd_sc_hd__fill_1
XFILLER_0_79_57 vssd1 vssd1 vccd1 vccd1 sky130_fd_sc_hd__decap_3
X_1584_ _0670_ net620 _0632_ vssd1 vssd1 vccd1 vccd1 _0196_ sky130_fd_sc_hd__mux2_1
Xhold117 spi_mem1.address\[1\] vssd1 vssd1 vccd1 vccd1 net621 sky130_fd_sc_hd__dlygate4sd3_1
X_1653_ _0979_ net394 net370 vssd1 vssd1 vccd1 vccd1 _0718_ sky130_fd_sc_hd__o21ai_2
XTAP_400 vssd1 vccd1 sky130_fd_sc_hd__tapvpwrvgnd_1
Xhold128 net340 vssd1 vssd1 vccd1 vccd1 net632 sky130_fd_sc_hd__dlygate4sd3_1
Xhold139 spi_mem2.address\[21\] vssd1 vssd1 vccd1 vccd1 net643 sky130_fd_sc_hd__dlygate4sd3_1
Xhold106 net333 vssd1 vssd1 vccd1 vccd1 net610 sky130_fd_sc_hd__dlygate4sd3_1
X_1722_ net182 net728 net404 vssd1 vssd1 vccd1 vccd1 _0243_ sky130_fd_sc_hd__mux2_1
X_2205_ clknet_leaf_14_clk_i _0219_ net472 vssd1 vssd1 vccd1 vccd1 spi_mem1.data_buf\[17\]
+ sky130_fd_sc_hd__dfrtp_1
XTAP_499 vssd1 vccd1 sky130_fd_sc_hd__tapvpwrvgnd_1
XTAP_488 vssd1 vccd1 sky130_fd_sc_hd__tapvpwrvgnd_1
XTAP_477 vssd1 vccd1 sky130_fd_sc_hd__tapvpwrvgnd_1
XTAP_466 vssd1 vccd1 sky130_fd_sc_hd__tapvpwrvgnd_1
XTAP_455 vssd1 vccd1 sky130_fd_sc_hd__tapvpwrvgnd_1
XTAP_444 vssd1 vccd1 sky130_fd_sc_hd__tapvpwrvgnd_1
XTAP_433 vssd1 vccd1 sky130_fd_sc_hd__tapvpwrvgnd_1
XTAP_422 vssd1 vccd1 sky130_fd_sc_hd__tapvpwrvgnd_1
XTAP_411 vssd1 vccd1 sky130_fd_sc_hd__tapvpwrvgnd_1
X_2067_ net491 net4 net477 vssd1 vssd1 vccd1 vccd1 spi_mem0.delayed_miso\[1\] sky130_fd_sc_hd__dfrtp_1
X_2136_ clknet_leaf_18_clk_i _0156_ net486 vssd1 vssd1 vccd1 vccd1 spi_mem1.address_nibble\[1\]
+ sky130_fd_sc_hd__dfstp_2
X_1018_ _0935_ _0942_ vssd1 vssd1 vccd1 vccd1 _0944_ sky130_fd_sc_hd__or2_1
XFILLER_0_48_157 vssd1 vssd1 vccd1 vccd1 sky130_fd_sc_hd__fill_1
XFILLER_0_44_82 vssd1 vssd1 vccd1 vccd1 sky130_fd_sc_hd__fill_2
XFILLER_0_63_149 vssd1 vssd1 vccd1 vccd1 sky130_fd_sc_hd__decap_8
XFILLER_0_44_374 vssd1 vssd1 vccd1 vccd1 sky130_fd_sc_hd__decap_4
XFILLER_0_8_93 vssd1 vssd1 vccd1 vccd1 sky130_fd_sc_hd__fill_2
XFILLER_0_79_260 vssd1 vssd1 vccd1 vccd1 sky130_fd_sc_hd__decap_4
XFILLER_0_54_138 vssd1 vssd1 vccd1 vccd1 sky130_fd_sc_hd__fill_2
XFILLER_0_39_179 vssd1 vssd1 vccd1 vccd1 sky130_ef_sc_hd__decap_12
XFILLER_0_39_113 vssd1 vssd1 vccd1 vccd1 sky130_fd_sc_hd__fill_1
XFILLER_0_62_160 vssd1 vssd1 vccd1 vccd1 sky130_fd_sc_hd__decap_8
XFILLER_0_50_388 vssd1 vssd1 vccd1 vccd1 sky130_fd_sc_hd__fill_1
XFILLER_0_50_377 vssd1 vssd1 vccd1 vccd1 sky130_fd_sc_hd__decap_4
XFILLER_0_49_27 vssd1 vssd1 vccd1 vccd1 sky130_fd_sc_hd__decap_8
X_1705_ _0752_ spi_mem2.latency\[0\] _0748_ vssd1 vssd1 vccd1 vccd1 _0235_ sky130_fd_sc_hd__mux2_1
XFILLER_0_41_333 vssd1 vssd1 vccd1 vccd1 sky130_fd_sc_hd__decap_3
XFILLER_0_26_385 vssd1 vssd1 vccd1 vccd1 sky130_fd_sc_hd__fill_2
XFILLER_0_26_341 vssd1 vssd1 vccd1 vccd1 sky130_fd_sc_hd__decap_4
X_1567_ spi_mem1.address\[10\] _0545_ _0641_ spi_mem1.address\[14\] vssd1 vssd1 vccd1
+ vccd1 _0655_ sky130_fd_sc_hd__a22o_1
X_1636_ net702 _0707_ _0708_ net367 vssd1 vssd1 vccd1 vccd1 _0210_ sky130_fd_sc_hd__a22o_1
Xfanout427 spi_mem2.state\[0\] vssd1 vssd1 vccd1 vccd1 net427 sky130_fd_sc_hd__clkbuf_2
Xfanout405 _0963_ vssd1 vssd1 vccd1 vccd1 net405 sky130_fd_sc_hd__clkbuf_4
Xfanout416 net417 vssd1 vssd1 vccd1 vccd1 net416 sky130_fd_sc_hd__buf_2
Xfanout438 spi_mem0.data_byte\[0\] vssd1 vssd1 vccd1 vccd1 net438 sky130_fd_sc_hd__clkbuf_2
XTAP_230 vssd1 vccd1 sky130_fd_sc_hd__tapvpwrvgnd_1
XTAP_241 vssd1 vccd1 sky130_fd_sc_hd__tapvpwrvgnd_1
X_1498_ _0938_ net238 vssd1 vssd1 vccd1 vccd1 _0623_ sky130_fd_sc_hd__nor2_1
X_2119_ clknet_leaf_16_clk_i _0139_ net484 vssd1 vssd1 vccd1 vccd1 spi_mem1.address\[6\]
+ sky130_fd_sc_hd__dfrtp_1
Xfanout449 net450 vssd1 vssd1 vccd1 vccd1 net449 sky130_fd_sc_hd__buf_4
XTAP_252 vssd1 vccd1 sky130_fd_sc_hd__tapvpwrvgnd_1
XTAP_263 vssd1 vccd1 sky130_fd_sc_hd__tapvpwrvgnd_1
XTAP_274 vssd1 vccd1 sky130_fd_sc_hd__tapvpwrvgnd_1
XTAP_285 vssd1 vccd1 sky130_fd_sc_hd__tapvpwrvgnd_1
XTAP_296 vssd1 vccd1 sky130_fd_sc_hd__tapvpwrvgnd_1
XFILLER_0_76_230 vssd1 vssd1 vccd1 vccd1 sky130_fd_sc_hd__fill_1
XFILLER_0_71_91 vssd1 vssd1 vccd1 vccd1 sky130_fd_sc_hd__decap_8
XFILLER_0_36_116 vssd1 vssd1 vccd1 vccd1 sky130_fd_sc_hd__fill_1
XFILLER_0_32_377 vssd1 vssd1 vccd1 vccd1 sky130_fd_sc_hd__decap_3
XFILLER_0_32_355 vssd1 vssd1 vccd1 vccd1 sky130_fd_sc_hd__decap_8
XFILLER_0_67_252 vssd1 vssd1 vccd1 vccd1 sky130_ef_sc_hd__decap_12
XFILLER_0_82_244 vssd1 vssd1 vccd1 vccd1 sky130_fd_sc_hd__fill_2
XFILLER_0_27_138 vssd1 vssd1 vccd1 vccd1 sky130_fd_sc_hd__decap_3
X_1421_ net517 _0561_ net412 vssd1 vssd1 vccd1 vccd1 _0142_ sky130_fd_sc_hd__mux2_1
XFILLER_0_50_141 vssd1 vssd1 vccd1 vccd1 sky130_ef_sc_hd__decap_12
X_1283_ net439 _0406_ _0474_ vssd1 vssd1 vccd1 vccd1 _0475_ sky130_fd_sc_hd__a21o_1
X_1352_ net31 net415 _0488_ _0515_ vssd1 vssd1 vccd1 vccd1 _0519_ sky130_fd_sc_hd__a22o_1
XFILLER_0_58_296 vssd1 vssd1 vccd1 vccd1 sky130_fd_sc_hd__decap_3
XFILLER_0_25_40 vssd1 vssd1 vccd1 vccd1 sky130_fd_sc_hd__fill_1
XFILLER_0_74_3 vssd1 vssd1 vccd1 vccd1 sky130_ef_sc_hd__decap_12
XFILLER_0_61_406 vssd1 vssd1 vccd1 vccd1 sky130_fd_sc_hd__fill_1
XFILLER_0_14_333 vssd1 vssd1 vccd1 vccd1 sky130_fd_sc_hd__decap_8
XFILLER_0_14_377 vssd1 vssd1 vccd1 vccd1 sky130_fd_sc_hd__decap_8
X_0998_ spi_mem2.data_byte\[1\] vssd1 vssd1 vccd1 vccd1 _0927_ sky130_fd_sc_hd__inv_2
X_1619_ net751 _0691_ _0697_ net367 vssd1 vssd1 vccd1 vccd1 _0204_ sky130_fd_sc_hd__a22o_1
XFILLER_0_5_72 vssd1 vssd1 vccd1 vccd1 sky130_fd_sc_hd__fill_1
XFILLER_0_64_244 vssd1 vssd1 vccd1 vccd1 sky130_fd_sc_hd__decap_8
XFILLER_0_64_211 vssd1 vssd1 vccd1 vccd1 sky130_fd_sc_hd__fill_1
XFILLER_0_9_360 vssd1 vssd1 vccd1 vccd1 sky130_fd_sc_hd__fill_1
XFILLER_0_9_393 vssd1 vssd1 vccd1 vccd1 sky130_fd_sc_hd__decap_8
XFILLER_0_62_27 vssd1 vssd1 vccd1 vccd1 sky130_fd_sc_hd__fill_1
XFILLER_0_55_222 vssd1 vssd1 vccd1 vccd1 sky130_fd_sc_hd__fill_2
X_1970_ net175 net402 _0871_ _0913_ vssd1 vssd1 vccd1 vccd1 _0915_ sky130_fd_sc_hd__a22o_1
XFILLER_0_70_203 vssd1 vssd1 vccd1 vccd1 sky130_fd_sc_hd__fill_1
XFILLER_0_43_406 vssd1 vssd1 vccd1 vccd1 sky130_fd_sc_hd__fill_1
XFILLER_0_11_75 vssd1 vssd1 vccd1 vccd1 sky130_fd_sc_hd__fill_1
X_1404_ _0539_ _0556_ vssd1 vssd1 vccd1 vccd1 _0557_ sky130_fd_sc_hd__nor2_1
X_1335_ net23 net416 _0490_ _0504_ vssd1 vssd1 vccd1 vccd1 _0509_ sky130_fd_sc_hd__a22o_1
Xinput2 spi0_dqsm_i vssd1 vssd1 vccd1 vccd1 net2 sky130_fd_sc_hd__clkbuf_1
XFILLER_0_36_72 vssd1 vssd1 vccd1 vccd1 sky130_fd_sc_hd__fill_1
X_1266_ net82 _0368_ _0455_ _0459_ vssd1 vssd1 vccd1 vccd1 _0460_ sky130_fd_sc_hd__a211o_1
X_1197_ net732 net288 net390 vssd1 vssd1 vccd1 vccd1 _0059_ sky130_fd_sc_hd__mux2_1
XFILLER_0_61_225 vssd1 vssd1 vccd1 vccd1 sky130_ef_sc_hd__decap_12
XFILLER_0_52_71 vssd1 vssd1 vccd1 vccd1 sky130_fd_sc_hd__decap_3
XFILLER_0_34_406 vssd1 vssd1 vccd1 vccd1 sky130_fd_sc_hd__fill_1
XFILLER_0_6_374 vssd1 vssd1 vccd1 vccd1 sky130_fd_sc_hd__decap_6
Xoutput361 net361 vssd1 vssd1 vccd1 vccd1 sport2_o[9] sky130_fd_sc_hd__clkbuf_4
XFILLER_0_14_141 vssd1 vssd1 vccd1 vccd1 sky130_fd_sc_hd__fill_2
Xoutput350 net350 vssd1 vssd1 vccd1 vccd1 sport2_o[2] sky130_fd_sc_hd__clkbuf_4
XFILLER_0_77_391 vssd1 vssd1 vccd1 vccd1 sky130_fd_sc_hd__fill_1
XFILLER_0_52_247 vssd1 vssd1 vccd1 vccd1 sky130_fd_sc_hd__fill_1
XFILLER_0_25_406 vssd1 vssd1 vccd1 vccd1 sky130_fd_sc_hd__fill_1
X_1120_ spi_mem0.latency\[1\] spi_mem0.latency\[0\] vssd1 vssd1 vccd1 vccd1 _0382_
+ sky130_fd_sc_hd__xnor2_1
X_1051_ net426 _0966_ vssd1 vssd1 vccd1 vccd1 _0967_ sky130_fd_sc_hd__nor2_2
X_1884_ _0740_ _0859_ _0860_ _0861_ _0857_ vssd1 vssd1 vccd1 vccd1 _0862_ sky130_fd_sc_hd__a311o_1
XFILLER_0_28_277 vssd1 vssd1 vccd1 vccd1 sky130_ef_sc_hd__decap_12
XFILLER_0_28_244 vssd1 vssd1 vccd1 vccd1 sky130_fd_sc_hd__decap_8
X_1953_ net168 net402 _0873_ _0902_ vssd1 vssd1 vccd1 vccd1 _0905_ sky130_fd_sc_hd__a22o_1
XFILLER_0_22_85 vssd1 vssd1 vccd1 vccd1 sky130_ef_sc_hd__decap_12
XFILLER_0_11_100 vssd1 vssd1 vccd1 vccd1 sky130_fd_sc_hd__fill_1
XFILLER_0_11_166 vssd1 vssd1 vccd1 vccd1 sky130_fd_sc_hd__fill_2
X_2298_ net504 _0001_ net482 vssd1 vssd1 vccd1 vccd1 spi_mem2.spi_clk sky130_fd_sc_hd__dfrtp_2
XFILLER_0_37_3 vssd1 vssd1 vccd1 vccd1 sky130_ef_sc_hd__decap_12
X_1318_ net393 _0498_ net374 vssd1 vssd1 vccd1 vccd1 _0499_ sky130_fd_sc_hd__o21ai_2
XFILLER_0_78_177 vssd1 vssd1 vccd1 vccd1 sky130_ef_sc_hd__decap_12
XPHY_139 vssd1 vssd1 vccd1 vccd1 sky130_fd_sc_hd__decap_3
XPHY_128 vssd1 vssd1 vccd1 vccd1 sky130_fd_sc_hd__decap_3
XFILLER_0_59_391 vssd1 vssd1 vccd1 vccd1 sky130_fd_sc_hd__fill_1
XPHY_117 vssd1 vssd1 vccd1 vccd1 sky130_fd_sc_hd__decap_3
XPHY_106 vssd1 vssd1 vccd1 vccd1 sky130_fd_sc_hd__decap_3
X_1249_ _0347_ _0440_ _0443_ vssd1 vssd1 vccd1 vccd1 _0444_ sky130_fd_sc_hd__and3_1
XFILLER_0_2_73 vssd1 vssd1 vccd1 vccd1 sky130_fd_sc_hd__fill_1
XFILLER_0_19_233 vssd1 vssd1 vccd1 vccd1 sky130_fd_sc_hd__decap_4
XFILLER_0_34_236 vssd1 vssd1 vccd1 vccd1 sky130_fd_sc_hd__decap_4
XFILLER_0_19_277 vssd1 vssd1 vccd1 vccd1 sky130_fd_sc_hd__decap_3
XFILLER_0_69_100 vssd1 vssd1 vccd1 vccd1 sky130_fd_sc_hd__fill_2
XFILLER_0_72_309 vssd1 vssd1 vccd1 vccd1 sky130_ef_sc_hd__decap_12
XFILLER_0_25_225 vssd1 vssd1 vccd1 vccd1 sky130_ef_sc_hd__decap_12
XPHY_8 vssd1 vssd1 vccd1 vccd1 sky130_fd_sc_hd__decap_3
X_2221_ clknet_leaf_19_clk_i _0235_ net486 vssd1 vssd1 vccd1 vccd1 spi_mem2.latency\[0\]
+ sky130_fd_sc_hd__dfrtp_1
XTAP_659 vssd1 vccd1 sky130_fd_sc_hd__tapvpwrvgnd_1
XTAP_648 vssd1 vccd1 sky130_fd_sc_hd__tapvpwrvgnd_1
XTAP_637 vssd1 vccd1 sky130_fd_sc_hd__tapvpwrvgnd_1
X_2152_ clknet_leaf_9_clk_i _0172_ net474 vssd1 vssd1 vccd1 vccd1 net295 sky130_fd_sc_hd__dfrtp_2
XTAP_626 vssd1 vccd1 sky130_fd_sc_hd__tapvpwrvgnd_1
XTAP_615 vssd1 vccd1 sky130_fd_sc_hd__tapvpwrvgnd_1
XTAP_604 vssd1 vccd1 sky130_fd_sc_hd__tapvpwrvgnd_1
XFILLER_0_17_41 vssd1 vssd1 vccd1 vccd1 sky130_fd_sc_hd__fill_1
X_1034_ spi_mem2.state\[3\] spi_mem2.state\[2\] vssd1 vssd1 vccd1 vccd1 _0956_ sky130_fd_sc_hd__or2_2
X_1103_ net443 _0365_ _0366_ vssd1 vssd1 vccd1 vccd1 _0367_ sky130_fd_sc_hd__or3b_4
X_2083_ clknet_leaf_3_clk_i _0103_ net452 vssd1 vssd1 vccd1 vccd1 spi_mem0.data_buf\[9\]
+ sky130_fd_sc_hd__dfrtp_1
XFILLER_0_75_158 vssd1 vssd1 vccd1 vccd1 sky130_fd_sc_hd__decap_8
XFILLER_0_71_386 vssd1 vssd1 vccd1 vccd1 sky130_fd_sc_hd__fill_2
XFILLER_0_71_331 vssd1 vssd1 vccd1 vccd1 sky130_fd_sc_hd__decap_4
X_1936_ net160 net401 _0875_ _0891_ vssd1 vssd1 vccd1 vccd1 _0895_ sky130_fd_sc_hd__a22o_1
X_1867_ spi_mem2.data_buf\[18\] _0971_ _0820_ spi_mem2.data_buf\[22\] _0845_ vssd1
+ vssd1 vccd1 vccd1 _0846_ sky130_fd_sc_hd__a221o_1
XFILLER_0_16_225 vssd1 vssd1 vccd1 vccd1 sky130_fd_sc_hd__fill_1
XFILLER_0_16_247 vssd1 vssd1 vccd1 vccd1 sky130_fd_sc_hd__decap_4
X_1798_ net816 _0812_ _0808_ vssd1 vssd1 vccd1 vccd1 _0268_ sky130_fd_sc_hd__mux2_1
Xinput93 sport1_i[16] vssd1 vssd1 vccd1 vccd1 net93 sky130_fd_sc_hd__dlymetal6s2s_1
Xinput82 sport0_i[6] vssd1 vssd1 vccd1 vccd1 net82 sky130_fd_sc_hd__dlymetal6s2s_1
Xinput71 sport0_i[59] vssd1 vssd1 vccd1 vccd1 net71 sky130_fd_sc_hd__clkbuf_1
Xinput60 sport0_i[49] vssd1 vssd1 vccd1 vccd1 net60 sky130_fd_sc_hd__clkbuf_1
XFILLER_0_81_117 vssd1 vssd1 vccd1 vccd1 sky130_fd_sc_hd__fill_1
XFILLER_0_66_147 vssd1 vssd1 vccd1 vccd1 sky130_fd_sc_hd__fill_1
XFILLER_0_54_309 vssd1 vssd1 vccd1 vccd1 sky130_ef_sc_hd__decap_12
XFILLER_0_62_342 vssd1 vssd1 vccd1 vccd1 sky130_ef_sc_hd__decap_12
Xclkbuf_leaf_15_clk_i clknet_2_3__leaf_clk_i vssd1 vssd1 vccd1 vccd1 clknet_leaf_15_clk_i
+ sky130_fd_sc_hd__clkbuf_16
XFILLER_0_38_29 vssd1 vssd1 vccd1 vccd1 sky130_fd_sc_hd__decap_6
XFILLER_0_70_27 vssd1 vssd1 vccd1 vccd1 sky130_fd_sc_hd__fill_1
XFILLER_0_57_169 vssd1 vssd1 vccd1 vccd1 sky130_fd_sc_hd__decap_4
XFILLER_0_38_372 vssd1 vssd1 vccd1 vccd1 sky130_ef_sc_hd__decap_12
XFILLER_0_38_361 vssd1 vssd1 vccd1 vccd1 sky130_fd_sc_hd__decap_3
X_1721_ net181 net598 net404 vssd1 vssd1 vccd1 vccd1 _0242_ sky130_fd_sc_hd__mux2_1
X_1583_ _0532_ _0667_ _0668_ _0669_ vssd1 vssd1 vccd1 vccd1 _0670_ sky130_fd_sc_hd__a31o_1
X_1652_ net772 _0713_ _0717_ net368 vssd1 vssd1 vccd1 vccd1 _0217_ sky130_fd_sc_hd__a22o_1
XTAP_423 vssd1 vccd1 sky130_fd_sc_hd__tapvpwrvgnd_1
XTAP_412 vssd1 vccd1 sky130_fd_sc_hd__tapvpwrvgnd_1
XTAP_401 vssd1 vccd1 sky130_fd_sc_hd__tapvpwrvgnd_1
Xhold118 net338 vssd1 vssd1 vccd1 vccd1 net622 sky130_fd_sc_hd__dlygate4sd3_1
Xhold129 _0290_ vssd1 vssd1 vccd1 vccd1 net633 sky130_fd_sc_hd__dlygate4sd3_1
Xhold107 _0284_ vssd1 vssd1 vccd1 vccd1 net611 sky130_fd_sc_hd__dlygate4sd3_1
X_2135_ clknet_leaf_17_clk_i _0155_ net488 vssd1 vssd1 vccd1 vccd1 spi_mem1.address_nibble\[0\]
+ sky130_fd_sc_hd__dfstp_2
X_2204_ clknet_leaf_14_clk_i _0218_ net472 vssd1 vssd1 vccd1 vccd1 spi_mem1.data_buf\[16\]
+ sky130_fd_sc_hd__dfrtp_1
XTAP_489 vssd1 vccd1 sky130_fd_sc_hd__tapvpwrvgnd_1
XTAP_478 vssd1 vccd1 sky130_fd_sc_hd__tapvpwrvgnd_1
XTAP_467 vssd1 vccd1 sky130_fd_sc_hd__tapvpwrvgnd_1
XTAP_456 vssd1 vccd1 sky130_fd_sc_hd__tapvpwrvgnd_1
XTAP_445 vssd1 vccd1 sky130_fd_sc_hd__tapvpwrvgnd_1
XTAP_434 vssd1 vccd1 sky130_fd_sc_hd__tapvpwrvgnd_1
X_2066_ net490 net3 net477 vssd1 vssd1 vccd1 vccd1 spi_mem0.delayed_miso\[0\] sky130_fd_sc_hd__dfrtp_1
XFILLER_0_76_401 vssd1 vssd1 vccd1 vccd1 sky130_fd_sc_hd__decap_6
X_1017_ _0935_ _0942_ vssd1 vssd1 vccd1 vccd1 _0943_ sky130_fd_sc_hd__nor2_1
XFILLER_0_36_309 vssd1 vssd1 vccd1 vccd1 sky130_ef_sc_hd__decap_12
XFILLER_0_8_266 vssd1 vssd1 vccd1 vccd1 sky130_fd_sc_hd__fill_1
X_1919_ net755 _0880_ _0884_ net362 vssd1 vssd1 vccd1 vccd1 _0317_ sky130_fd_sc_hd__a22o_1
XFILLER_0_12_261 vssd1 vssd1 vccd1 vccd1 sky130_fd_sc_hd__decap_3
XFILLER_0_82_404 vssd1 vssd1 vccd1 vccd1 sky130_fd_sc_hd__decap_3
XFILLER_0_39_169 vssd1 vssd1 vccd1 vccd1 sky130_fd_sc_hd__fill_2
XFILLER_0_62_183 vssd1 vssd1 vccd1 vccd1 sky130_ef_sc_hd__decap_12
XFILLER_0_81_15 vssd1 vssd1 vccd1 vccd1 sky130_fd_sc_hd__decap_3
XFILLER_0_18_309 vssd1 vssd1 vccd1 vccd1 sky130_ef_sc_hd__decap_12
X_1704_ _0751_ vssd1 vssd1 vccd1 vccd1 _0752_ sky130_fd_sc_hd__inv_2
XFILLER_0_41_345 vssd1 vssd1 vccd1 vccd1 sky130_fd_sc_hd__fill_2
XFILLER_0_30_85 vssd1 vssd1 vccd1 vccd1 sky130_ef_sc_hd__decap_12
X_1497_ net419 _0607_ _0621_ vssd1 vssd1 vccd1 vccd1 _0622_ sky130_fd_sc_hd__a21oi_2
X_1566_ _0977_ _0650_ _0653_ vssd1 vssd1 vccd1 vccd1 _0654_ sky130_fd_sc_hd__and3_1
Xfanout428 net429 vssd1 vssd1 vccd1 vccd1 net428 sky130_fd_sc_hd__clkbuf_4
X_1635_ net153 net398 _0692_ _0706_ vssd1 vssd1 vccd1 vccd1 _0708_ sky130_fd_sc_hd__a22o_1
Xfanout417 _0346_ vssd1 vssd1 vccd1 vccd1 net417 sky130_fd_sc_hd__buf_2
Xfanout439 spi_mem0.data_nibble vssd1 vssd1 vccd1 vccd1 net439 sky130_fd_sc_hd__clkbuf_4
XTAP_220 vssd1 vccd1 sky130_fd_sc_hd__tapvpwrvgnd_1
XTAP_231 vssd1 vccd1 sky130_fd_sc_hd__tapvpwrvgnd_1
XTAP_242 vssd1 vccd1 sky130_fd_sc_hd__tapvpwrvgnd_1
XTAP_253 vssd1 vccd1 sky130_fd_sc_hd__tapvpwrvgnd_1
XTAP_264 vssd1 vccd1 sky130_fd_sc_hd__tapvpwrvgnd_1
XTAP_275 vssd1 vccd1 sky130_fd_sc_hd__tapvpwrvgnd_1
Xfanout406 _0962_ vssd1 vssd1 vccd1 vccd1 net406 sky130_fd_sc_hd__clkbuf_4
X_2118_ clknet_leaf_18_clk_i _0138_ net484 vssd1 vssd1 vccd1 vccd1 spi_mem1.address\[5\]
+ sky130_fd_sc_hd__dfrtp_1
XFILLER_0_55_93 vssd1 vssd1 vccd1 vccd1 sky130_fd_sc_hd__decap_4
X_2049_ clknet_leaf_4_clk_i net629 net454 vssd1 vssd1 vccd1 vccd1 net272 sky130_fd_sc_hd__dfrtp_1
XTAP_286 vssd1 vccd1 sky130_fd_sc_hd__tapvpwrvgnd_1
XTAP_297 vssd1 vccd1 sky130_fd_sc_hd__tapvpwrvgnd_1
XFILLER_0_29_191 vssd1 vssd1 vccd1 vccd1 sky130_ef_sc_hd__decap_12
XFILLER_0_29_180 vssd1 vssd1 vccd1 vccd1 sky130_fd_sc_hd__decap_3
XFILLER_0_17_331 vssd1 vssd1 vccd1 vccd1 sky130_fd_sc_hd__decap_4
XFILLER_0_17_364 vssd1 vssd1 vccd1 vccd1 sky130_fd_sc_hd__fill_1
XFILLER_0_32_301 vssd1 vssd1 vccd1 vccd1 sky130_fd_sc_hd__decap_6
XFILLER_0_82_212 vssd1 vssd1 vccd1 vccd1 sky130_fd_sc_hd__fill_2
XFILLER_0_67_264 vssd1 vssd1 vccd1 vccd1 sky130_fd_sc_hd__fill_1
XFILLER_0_27_128 vssd1 vssd1 vccd1 vccd1 sky130_fd_sc_hd__fill_1
XFILLER_0_23_334 vssd1 vssd1 vccd1 vccd1 sky130_fd_sc_hd__fill_2
XFILLER_0_76_15 vssd1 vssd1 vccd1 vccd1 sky130_ef_sc_hd__decap_12
X_1420_ net120 net121 vssd1 vssd1 vccd1 vccd1 _0561_ sky130_fd_sc_hd__xnor2_1
XFILLER_0_50_197 vssd1 vssd1 vccd1 vccd1 sky130_ef_sc_hd__decap_12
XFILLER_0_50_153 vssd1 vssd1 vccd1 vccd1 sky130_fd_sc_hd__decap_6
X_1351_ net713 _0516_ _0518_ net375 vssd1 vssd1 vccd1 vccd1 _0115_ sky130_fd_sc_hd__a22o_1
X_1282_ net393 _0348_ _0369_ _0404_ vssd1 vssd1 vccd1 vccd1 _0474_ sky130_fd_sc_hd__a31o_1
XFILLER_0_73_278 vssd1 vssd1 vccd1 vccd1 sky130_fd_sc_hd__fill_2
XFILLER_0_73_223 vssd1 vssd1 vccd1 vccd1 sky130_fd_sc_hd__fill_1
XFILLER_0_58_253 vssd1 vssd1 vccd1 vccd1 sky130_ef_sc_hd__decap_12
XFILLER_0_67_3 vssd1 vssd1 vccd1 vccd1 sky130_fd_sc_hd__decap_4
X_1618_ net108 net396 _0690_ _0696_ vssd1 vssd1 vccd1 vccd1 _0697_ sky130_fd_sc_hd__a22o_1
X_0997_ spi_mem2.address_nibble\[2\] vssd1 vssd1 vccd1 vccd1 _0926_ sky130_fd_sc_hd__inv_2
X_1549_ net430 net429 spi_mem1.data_buf\[12\] vssd1 vssd1 vccd1 vccd1 _0638_ sky130_fd_sc_hd__and3_1
XFILLER_0_32_197 vssd1 vssd1 vccd1 vccd1 sky130_fd_sc_hd__fill_2
XFILLER_0_32_164 vssd1 vssd1 vccd1 vccd1 sky130_fd_sc_hd__fill_1
Xhold290 spi_mem2.data_buf\[29\] vssd1 vssd1 vccd1 vccd1 net794 sky130_fd_sc_hd__dlygate4sd3_1
XFILLER_0_55_289 vssd1 vssd1 vccd1 vccd1 sky130_fd_sc_hd__decap_3
XFILLER_0_23_153 vssd1 vssd1 vccd1 vccd1 sky130_fd_sc_hd__decap_6
XFILLER_0_11_337 vssd1 vssd1 vccd1 vccd1 sky130_fd_sc_hd__decap_4
X_1403_ spi_mem1.latency\[3\] _0539_ _0537_ vssd1 vssd1 vccd1 vccd1 _0556_ sky130_fd_sc_hd__o21ai_1
X_1334_ net765 _0505_ _0508_ net373 vssd1 vssd1 vccd1 vccd1 _0108_ sky130_fd_sc_hd__a22o_1
X_1265_ _0456_ _0457_ _0458_ _0364_ vssd1 vssd1 vccd1 vccd1 _0459_ sky130_fd_sc_hd__o211a_1
Xinput3 spi0_miso_i[0] vssd1 vssd1 vccd1 vccd1 net3 sky130_fd_sc_hd__clkbuf_1
X_1196_ spi_mem0.data_buf\[3\] net762 net389 vssd1 vssd1 vccd1 vccd1 _0058_ sky130_fd_sc_hd__mux2_1
XFILLER_0_61_237 vssd1 vssd1 vccd1 vccd1 sky130_fd_sc_hd__decap_3
Xoutput351 net351 vssd1 vssd1 vccd1 vccd1 sport2_o[30] sky130_fd_sc_hd__clkbuf_4
Xoutput340 net340 vssd1 vssd1 vccd1 vccd1 sport2_o[20] sky130_fd_sc_hd__clkbuf_4
XFILLER_0_10_370 vssd1 vssd1 vccd1 vccd1 sky130_ef_sc_hd__decap_12
XFILLER_0_69_348 vssd1 vssd1 vccd1 vccd1 sky130_ef_sc_hd__decap_12
XFILLER_0_69_337 vssd1 vssd1 vccd1 vccd1 sky130_fd_sc_hd__fill_2
XFILLER_0_37_223 vssd1 vssd1 vccd1 vccd1 sky130_fd_sc_hd__fill_1
XFILLER_0_60_281 vssd1 vssd1 vccd1 vccd1 sky130_ef_sc_hd__decap_12
X_1050_ spi_mem2.state\[1\] _0965_ vssd1 vssd1 vccd1 vccd1 _0966_ sky130_fd_sc_hd__nand2_2
XFILLER_0_68_392 vssd1 vssd1 vccd1 vccd1 sky130_ef_sc_hd__decap_12
XFILLER_0_43_215 vssd1 vssd1 vccd1 vccd1 sky130_fd_sc_hd__decap_3
X_1883_ net221 _0355_ _0817_ vssd1 vssd1 vccd1 vccd1 _0861_ sky130_fd_sc_hd__a21o_1
XFILLER_0_28_289 vssd1 vssd1 vccd1 vccd1 sky130_ef_sc_hd__decap_12
X_1952_ net783 _0903_ _0904_ net364 vssd1 vssd1 vccd1 vccd1 _0330_ sky130_fd_sc_hd__a22o_1
XFILLER_0_22_97 vssd1 vssd1 vccd1 vccd1 sky130_fd_sc_hd__decap_4
XFILLER_0_3_345 vssd1 vssd1 vccd1 vccd1 sky130_fd_sc_hd__fill_1
XFILLER_0_3_334 vssd1 vssd1 vccd1 vccd1 sky130_fd_sc_hd__fill_2
X_2297_ net503 net16 net487 vssd1 vssd1 vccd1 vccd1 spi_mem2.delayed_miso\[3\] sky130_fd_sc_hd__dfrtp_2
X_1248_ spi_mem0.data_buf\[13\] _0426_ _0441_ _0442_ vssd1 vssd1 vccd1 vccd1 _0443_
+ sky130_fd_sc_hd__a211o_1
X_1317_ net440 net436 net438 vssd1 vssd1 vccd1 vccd1 _0498_ sky130_fd_sc_hd__nor3b_2
XFILLER_0_78_189 vssd1 vssd1 vccd1 vccd1 sky130_fd_sc_hd__decap_6
XFILLER_0_74_351 vssd1 vssd1 vccd1 vccd1 sky130_ef_sc_hd__decap_12
XPHY_129 vssd1 vssd1 vccd1 vccd1 sky130_fd_sc_hd__decap_3
XPHY_118 vssd1 vssd1 vccd1 vccd1 sky130_fd_sc_hd__decap_3
XPHY_107 vssd1 vssd1 vccd1 vccd1 sky130_fd_sc_hd__decap_3
X_1179_ net441 spi_mem0.state\[3\] _0946_ _0406_ _0409_ vssd1 vssd1 vccd1 vccd1 _0411_
+ sky130_fd_sc_hd__a32o_1
XFILLER_0_2_85 vssd1 vssd1 vccd1 vccd1 sky130_fd_sc_hd__decap_4
XFILLER_0_34_204 vssd1 vssd1 vccd1 vccd1 sky130_fd_sc_hd__decap_4
XFILLER_0_69_167 vssd1 vssd1 vccd1 vccd1 sky130_fd_sc_hd__fill_1
XFILLER_0_69_156 vssd1 vssd1 vccd1 vccd1 sky130_fd_sc_hd__decap_4
XPHY_9 vssd1 vssd1 vccd1 vccd1 sky130_fd_sc_hd__decap_3
XFILLER_0_80_343 vssd1 vssd1 vccd1 vccd1 sky130_ef_sc_hd__decap_12
XFILLER_0_80_332 vssd1 vssd1 vccd1 vccd1 sky130_fd_sc_hd__decap_3
XFILLER_0_25_237 vssd1 vssd1 vccd1 vccd1 sky130_fd_sc_hd__fill_2
XFILLER_0_80_365 vssd1 vssd1 vccd1 vccd1 sky130_ef_sc_hd__decap_12
XTAP_616 vssd1 vccd1 sky130_fd_sc_hd__tapvpwrvgnd_1
XTAP_605 vssd1 vccd1 sky130_fd_sc_hd__tapvpwrvgnd_1
XFILLER_0_33_281 vssd1 vssd1 vccd1 vccd1 sky130_ef_sc_hd__decap_12
X_2220_ clknet_leaf_19_clk_i _0234_ net486 vssd1 vssd1 vccd1 vccd1 spi_mem2.has_2lc
+ sky130_fd_sc_hd__dfrtp_1
XTAP_649 vssd1 vccd1 sky130_fd_sc_hd__tapvpwrvgnd_1
XTAP_638 vssd1 vccd1 sky130_fd_sc_hd__tapvpwrvgnd_1
XTAP_627 vssd1 vccd1 sky130_fd_sc_hd__tapvpwrvgnd_1
X_2151_ clknet_leaf_9_clk_i _0171_ net469 vssd1 vssd1 vccd1 vccd1 net327 sky130_fd_sc_hd__dfrtp_2
X_1102_ spi_mem0.address_nibble\[0\] _0928_ vssd1 vssd1 vccd1 vccd1 _0366_ sky130_fd_sc_hd__nor2_2
X_2082_ clknet_leaf_3_clk_i _0102_ net452 vssd1 vssd1 vccd1 vccd1 spi_mem0.data_buf\[8\]
+ sky130_fd_sc_hd__dfrtp_1
X_1033_ spi_mem2.state\[3\] spi_mem2.state\[2\] vssd1 vssd1 vccd1 vccd1 _0955_ sky130_fd_sc_hd__nor2_1
XFILLER_0_48_307 vssd1 vssd1 vccd1 vccd1 sky130_fd_sc_hd__fill_1
XFILLER_0_56_351 vssd1 vssd1 vccd1 vccd1 sky130_ef_sc_hd__decap_12
X_1797_ _0959_ _0965_ _0740_ _0932_ _0809_ vssd1 vssd1 vccd1 vccd1 _0812_ sky130_fd_sc_hd__a221o_1
Xinput50 sport0_i[3] vssd1 vssd1 vccd1 vccd1 net50 sky130_fd_sc_hd__buf_1
Xinput61 sport0_i[4] vssd1 vssd1 vccd1 vccd1 net61 sky130_fd_sc_hd__clkbuf_2
Xinput72 sport0_i[5] vssd1 vssd1 vccd1 vccd1 net72 sky130_fd_sc_hd__clkbuf_2
X_1935_ net739 _0892_ _0894_ net363 vssd1 vssd1 vccd1 vccd1 _0323_ sky130_fd_sc_hd__a22o_1
X_1866_ net423 net420 spi_mem2.data_buf\[30\] vssd1 vssd1 vccd1 vccd1 _0845_ sky130_fd_sc_hd__and3_1
XFILLER_0_58_93 vssd1 vssd1 vccd1 vccd1 sky130_fd_sc_hd__decap_6
Xinput83 sport0_i[7] vssd1 vssd1 vccd1 vccd1 net83 sky130_fd_sc_hd__clkbuf_2
Xinput94 sport1_i[17] vssd1 vssd1 vccd1 vccd1 net94 sky130_fd_sc_hd__dlymetal6s2s_1
XFILLER_0_74_81 vssd1 vssd1 vccd1 vccd1 sky130_fd_sc_hd__decap_3
XFILLER_0_62_365 vssd1 vssd1 vccd1 vccd1 sky130_ef_sc_hd__decap_12
XFILLER_0_62_354 vssd1 vssd1 vccd1 vccd1 sky130_fd_sc_hd__decap_8
XFILLER_0_15_281 vssd1 vssd1 vccd1 vccd1 sky130_fd_sc_hd__decap_8
XFILLER_0_54_29 vssd1 vssd1 vccd1 vccd1 sky130_fd_sc_hd__decap_4
Xhold108 net241 vssd1 vssd1 vccd1 vccd1 net612 sky130_fd_sc_hd__dlygate4sd3_1
XFILLER_0_79_15 vssd1 vssd1 vccd1 vccd1 sky130_ef_sc_hd__decap_12
X_1651_ net92 net396 _0698_ _0712_ vssd1 vssd1 vccd1 vccd1 _0717_ sky130_fd_sc_hd__a22o_1
XFILLER_0_38_384 vssd1 vssd1 vccd1 vccd1 sky130_fd_sc_hd__fill_2
XFILLER_0_38_351 vssd1 vssd1 vccd1 vccd1 sky130_fd_sc_hd__decap_4
X_1720_ net180 net552 net405 vssd1 vssd1 vccd1 vccd1 _0241_ sky130_fd_sc_hd__mux2_1
X_1582_ _0977_ _0662_ _0665_ _0536_ net151 vssd1 vssd1 vccd1 vccd1 _0669_ sky130_fd_sc_hd__a32o_1
XTAP_457 vssd1 vccd1 sky130_fd_sc_hd__tapvpwrvgnd_1
XTAP_446 vssd1 vccd1 sky130_fd_sc_hd__tapvpwrvgnd_1
XTAP_435 vssd1 vccd1 sky130_fd_sc_hd__tapvpwrvgnd_1
XTAP_424 vssd1 vccd1 sky130_fd_sc_hd__tapvpwrvgnd_1
XTAP_413 vssd1 vccd1 sky130_fd_sc_hd__tapvpwrvgnd_1
XTAP_402 vssd1 vccd1 sky130_fd_sc_hd__tapvpwrvgnd_1
Xhold119 _0289_ vssd1 vssd1 vccd1 vccd1 net623 sky130_fd_sc_hd__dlygate4sd3_1
XFILLER_0_21_273 vssd1 vssd1 vccd1 vccd1 sky130_fd_sc_hd__decap_6
X_2065_ clknet_leaf_18_clk_i _0090_ net486 vssd1 vssd1 vccd1 vccd1 net231 sky130_fd_sc_hd__dfrtp_1
X_2134_ clknet_leaf_20_clk_i _0154_ net485 vssd1 vssd1 vccd1 vccd1 spi_mem1.address\[21\]
+ sky130_fd_sc_hd__dfrtp_1
X_2203_ clknet_leaf_7_clk_i _0217_ net467 vssd1 vssd1 vccd1 vccd1 spi_mem1.data_buf\[15\]
+ sky130_fd_sc_hd__dfrtp_1
XFILLER_0_44_62 vssd1 vssd1 vccd1 vccd1 sky130_ef_sc_hd__decap_12
XTAP_479 vssd1 vccd1 sky130_fd_sc_hd__tapvpwrvgnd_1
XTAP_468 vssd1 vccd1 sky130_fd_sc_hd__tapvpwrvgnd_1
XFILLER_0_28_85 vssd1 vssd1 vccd1 vccd1 sky130_fd_sc_hd__fill_1
X_1016_ spi_mem1.state\[2\] spi_mem1.state\[3\] vssd1 vssd1 vccd1 vccd1 _0942_ sky130_fd_sc_hd__nand2_1
XFILLER_0_60_83 vssd1 vssd1 vccd1 vccd1 sky130_fd_sc_hd__fill_1
XFILLER_0_8_212 vssd1 vssd1 vccd1 vccd1 sky130_fd_sc_hd__fill_2
X_1849_ _0970_ _0823_ _0829_ vssd1 vssd1 vccd1 vccd1 _0830_ sky130_fd_sc_hd__a21o_1
X_1918_ net221 net403 _0877_ _0879_ vssd1 vssd1 vccd1 vccd1 _0884_ sky130_fd_sc_hd__a22o_1
XFILLER_0_79_284 vssd1 vssd1 vccd1 vccd1 sky130_fd_sc_hd__fill_1
XFILLER_0_62_195 vssd1 vssd1 vccd1 vccd1 sky130_fd_sc_hd__fill_1
XFILLER_0_73_405 vssd1 vssd1 vccd1 vccd1 sky130_fd_sc_hd__fill_2
XFILLER_0_45_107 vssd1 vssd1 vccd1 vccd1 sky130_fd_sc_hd__decap_4
X_1703_ spi_mem2.has_2lc spi_mem2.latency\[0\] net392 vssd1 vssd1 vccd1 vccd1 _0751_
+ sky130_fd_sc_hd__mux2_1
X_1634_ net394 _0706_ net371 vssd1 vssd1 vccd1 vccd1 _0707_ sky130_fd_sc_hd__o21ai_2
XFILLER_0_26_365 vssd1 vssd1 vccd1 vccd1 sky130_ef_sc_hd__decap_12
Xfanout429 spi_mem1.data_byte\[0\] vssd1 vssd1 vccd1 vccd1 net429 sky130_fd_sc_hd__clkbuf_4
X_1496_ _0919_ net434 _0613_ _0620_ vssd1 vssd1 vccd1 vccd1 _0621_ sky130_fd_sc_hd__a31o_1
X_1565_ spi_mem1.data_buf\[1\] _0978_ _0652_ spi_mem1.data_byte\[1\] vssd1 vssd1 vccd1
+ vccd1 _0653_ sky130_fd_sc_hd__a211o_1
XFILLER_0_39_84 vssd1 vssd1 vccd1 vccd1 sky130_fd_sc_hd__decap_8
XFILLER_0_39_40 vssd1 vssd1 vccd1 vccd1 sky130_ef_sc_hd__decap_12
XTAP_210 vssd1 vccd1 sky130_fd_sc_hd__tapvpwrvgnd_1
XTAP_221 vssd1 vccd1 sky130_fd_sc_hd__tapvpwrvgnd_1
XTAP_232 vssd1 vccd1 sky130_fd_sc_hd__tapvpwrvgnd_1
XTAP_243 vssd1 vccd1 sky130_fd_sc_hd__tapvpwrvgnd_1
XTAP_254 vssd1 vccd1 sky130_fd_sc_hd__tapvpwrvgnd_1
XTAP_265 vssd1 vccd1 sky130_fd_sc_hd__tapvpwrvgnd_1
Xfanout407 net409 vssd1 vssd1 vccd1 vccd1 net407 sky130_fd_sc_hd__clkbuf_4
XTAP_276 vssd1 vccd1 sky130_fd_sc_hd__tapvpwrvgnd_1
XTAP_287 vssd1 vccd1 sky130_fd_sc_hd__tapvpwrvgnd_1
XTAP_298 vssd1 vccd1 sky130_fd_sc_hd__tapvpwrvgnd_1
X_2117_ clknet_leaf_16_clk_i _0137_ net479 vssd1 vssd1 vccd1 vccd1 spi_mem1.address\[4\]
+ sky130_fd_sc_hd__dfrtp_1
Xclkbuf_leaf_14_clk_i clknet_2_2__leaf_clk_i vssd1 vssd1 vccd1 vccd1 clknet_leaf_14_clk_i
+ sky130_fd_sc_hd__clkbuf_16
XFILLER_0_55_50 vssd1 vssd1 vccd1 vccd1 sky130_fd_sc_hd__decap_6
X_2048_ clknet_leaf_4_clk_i net581 net452 vssd1 vssd1 vccd1 vccd1 net270 sky130_fd_sc_hd__dfrtp_2
XFILLER_0_44_151 vssd1 vssd1 vccd1 vccd1 sky130_fd_sc_hd__decap_3
Xclkbuf_leaf_29_clk_i clknet_2_1__leaf_clk_i vssd1 vssd1 vccd1 vccd1 clknet_leaf_29_clk_i
+ sky130_fd_sc_hd__clkbuf_16
XFILLER_0_17_387 vssd1 vssd1 vccd1 vccd1 sky130_fd_sc_hd__decap_4
XFILLER_0_67_210 vssd1 vssd1 vccd1 vccd1 sky130_ef_sc_hd__decap_12
XFILLER_0_82_279 vssd1 vssd1 vccd1 vccd1 sky130_fd_sc_hd__fill_1
XFILLER_0_82_268 vssd1 vssd1 vccd1 vccd1 sky130_fd_sc_hd__fill_2
XFILLER_0_23_324 vssd1 vssd1 vccd1 vccd1 sky130_fd_sc_hd__fill_1
X_1281_ _0473_ net660 _0422_ vssd1 vssd1 vccd1 vccd1 _0090_ sky130_fd_sc_hd__mux2_1
XFILLER_0_76_27 vssd1 vssd1 vccd1 vccd1 sky130_fd_sc_hd__fill_1
X_1350_ net30 net415 _0486_ _0515_ vssd1 vssd1 vccd1 vccd1 _0518_ sky130_fd_sc_hd__a22o_1
XFILLER_0_58_232 vssd1 vssd1 vccd1 vccd1 sky130_ef_sc_hd__decap_12
X_0996_ net782 vssd1 vssd1 vccd1 vccd1 _0925_ sky130_fd_sc_hd__inv_2
XFILLER_0_58_265 vssd1 vssd1 vccd1 vccd1 sky130_fd_sc_hd__decap_6
XFILLER_0_41_63 vssd1 vssd1 vccd1 vccd1 sky130_fd_sc_hd__decap_4
XFILLER_0_41_41 vssd1 vssd1 vccd1 vccd1 sky130_fd_sc_hd__decap_4
XFILLER_0_26_151 vssd1 vssd1 vccd1 vccd1 sky130_ef_sc_hd__decap_12
X_1617_ spi_mem1.delayed_miso\[2\] _0982_ vssd1 vssd1 vccd1 vccd1 _0696_ sky130_fd_sc_hd__and2_2
XFILLER_0_41_176 vssd1 vssd1 vccd1 vccd1 sky130_ef_sc_hd__decap_12
XFILLER_0_26_195 vssd1 vssd1 vccd1 vccd1 sky130_fd_sc_hd__fill_1
X_1479_ spi_mem1.spi_clk net146 vssd1 vssd1 vccd1 vccd1 _0604_ sky130_fd_sc_hd__nand2_2
XFILLER_0_66_82 vssd1 vssd1 vccd1 vccd1 sky130_fd_sc_hd__fill_2
X_1548_ spi_mem1.data_buf\[24\] _0633_ _0636_ _0931_ vssd1 vssd1 vccd1 vccd1 _0637_
+ sky130_fd_sc_hd__a211o_1
XFILLER_0_82_92 vssd1 vssd1 vccd1 vccd1 sky130_fd_sc_hd__fill_2
XFILLER_0_37_405 vssd1 vssd1 vccd1 vccd1 sky130_fd_sc_hd__fill_2
Xhold291 spi_mem0.state\[1\] vssd1 vssd1 vccd1 vccd1 net795 sky130_fd_sc_hd__dlygate4sd3_1
Xhold280 spi_mem2.data_buf\[17\] vssd1 vssd1 vccd1 vccd1 net784 sky130_fd_sc_hd__dlygate4sd3_1
XFILLER_0_13_390 vssd1 vssd1 vccd1 vccd1 sky130_fd_sc_hd__fill_2
XFILLER_0_62_29 vssd1 vssd1 vccd1 vccd1 sky130_ef_sc_hd__decap_12
XFILLER_0_55_257 vssd1 vssd1 vccd1 vccd1 sky130_fd_sc_hd__decap_3
X_1402_ net606 _0555_ _0548_ vssd1 vssd1 vccd1 vccd1 _0129_ sky130_fd_sc_hd__mux2_1
Xinput4 spi0_miso_i[1] vssd1 vssd1 vccd1 vccd1 net4 sky130_fd_sc_hd__clkbuf_1
X_1333_ net22 net416 _0488_ _0504_ vssd1 vssd1 vccd1 vccd1 _0508_ sky130_fd_sc_hd__a22o_1
XFILLER_0_36_63 vssd1 vssd1 vccd1 vccd1 sky130_fd_sc_hd__fill_1
XFILLER_0_36_41 vssd1 vssd1 vccd1 vccd1 sky130_fd_sc_hd__fill_2
X_1264_ spi_mem0.address\[5\] _0366_ _0392_ spi_mem0.address\[1\] net443 vssd1 vssd1
+ vccd1 vccd1 _0458_ sky130_fd_sc_hd__a221o_1
XFILLER_0_36_85 vssd1 vssd1 vccd1 vccd1 sky130_fd_sc_hd__decap_6
X_1195_ net750 net754 net389 vssd1 vssd1 vccd1 vccd1 _0057_ sky130_fd_sc_hd__mux2_1
XFILLER_0_6_332 vssd1 vssd1 vccd1 vccd1 sky130_fd_sc_hd__fill_1
Xoutput352 net352 vssd1 vssd1 vccd1 vccd1 sport2_o[31] sky130_fd_sc_hd__clkbuf_4
Xoutput330 net330 vssd1 vssd1 vccd1 vccd1 sport2_o[11] sky130_fd_sc_hd__clkbuf_4
XFILLER_0_10_382 vssd1 vssd1 vccd1 vccd1 sky130_ef_sc_hd__decap_12
Xoutput341 net341 vssd1 vssd1 vccd1 vccd1 sport2_o[21] sky130_fd_sc_hd__clkbuf_4
XFILLER_0_77_393 vssd1 vssd1 vccd1 vccd1 sky130_ef_sc_hd__decap_12
XFILLER_0_60_293 vssd1 vssd1 vccd1 vccd1 sky130_fd_sc_hd__decap_8
X_1882_ spi_mem2.address\[20\] _0742_ _0858_ _0926_ vssd1 vssd1 vccd1 vccd1 _0860_
+ sky130_fd_sc_hd__a211o_1
X_1951_ net167 net402 _0871_ _0902_ vssd1 vssd1 vccd1 vccd1 _0904_ sky130_fd_sc_hd__a22o_1
XFILLER_0_7_107 vssd1 vssd1 vccd1 vccd1 sky130_fd_sc_hd__decap_4
XFILLER_0_11_113 vssd1 vssd1 vccd1 vccd1 sky130_fd_sc_hd__decap_4
XFILLER_0_11_146 vssd1 vssd1 vccd1 vccd1 sky130_fd_sc_hd__fill_1
X_2296_ net502 net15 net486 vssd1 vssd1 vccd1 vccd1 spi_mem2.delayed_miso\[2\] sky130_fd_sc_hd__dfrtp_1
XFILLER_0_78_113 vssd1 vssd1 vccd1 vccd1 sky130_ef_sc_hd__decap_12
X_1178_ net77 _0949_ _0950_ _0376_ vssd1 vssd1 vccd1 vccd1 _0410_ sky130_fd_sc_hd__a31o_1
X_1316_ net665 _0493_ _0497_ net373 vssd1 vssd1 vccd1 vccd1 _0101_ sky130_fd_sc_hd__a22o_1
X_1247_ spi_mem0.data_buf\[1\] _0349_ _0425_ spi_mem0.data_buf\[5\] vssd1 vssd1 vccd1
+ vccd1 _0442_ sky130_fd_sc_hd__a22o_1
XFILLER_0_74_363 vssd1 vssd1 vccd1 vccd1 sky130_fd_sc_hd__fill_1
XPHY_119 vssd1 vssd1 vccd1 vccd1 sky130_fd_sc_hd__decap_3
XFILLER_0_59_393 vssd1 vssd1 vccd1 vccd1 sky130_fd_sc_hd__fill_2
XPHY_108 vssd1 vssd1 vccd1 vccd1 sky130_fd_sc_hd__decap_3
XFILLER_0_19_257 vssd1 vssd1 vccd1 vccd1 sky130_ef_sc_hd__decap_12
XFILLER_0_42_282 vssd1 vssd1 vccd1 vccd1 sky130_fd_sc_hd__fill_2
XFILLER_0_6_195 vssd1 vssd1 vccd1 vccd1 sky130_fd_sc_hd__fill_1
XFILLER_0_69_113 vssd1 vssd1 vccd1 vccd1 sky130_ef_sc_hd__decap_12
XFILLER_0_80_377 vssd1 vssd1 vccd1 vccd1 sky130_fd_sc_hd__fill_2
XFILLER_0_80_355 vssd1 vssd1 vccd1 vccd1 sky130_fd_sc_hd__decap_3
XFILLER_0_65_363 vssd1 vssd1 vccd1 vccd1 sky130_ef_sc_hd__decap_12
XFILLER_0_65_341 vssd1 vssd1 vccd1 vccd1 sky130_fd_sc_hd__fill_1
XTAP_639 vssd1 vccd1 sky130_fd_sc_hd__tapvpwrvgnd_1
XTAP_628 vssd1 vccd1 sky130_fd_sc_hd__tapvpwrvgnd_1
XTAP_617 vssd1 vccd1 sky130_fd_sc_hd__tapvpwrvgnd_1
XTAP_606 vssd1 vccd1 sky130_fd_sc_hd__tapvpwrvgnd_1
XFILLER_0_33_293 vssd1 vssd1 vccd1 vccd1 sky130_fd_sc_hd__fill_2
XFILLER_0_33_260 vssd1 vssd1 vccd1 vccd1 sky130_ef_sc_hd__decap_12
X_2150_ clknet_leaf_9_clk_i _0170_ net474 vssd1 vssd1 vccd1 vccd1 net326 sky130_fd_sc_hd__dfrtp_2
X_1032_ spi_mem2.state\[1\] net426 vssd1 vssd1 vccd1 vccd1 _0954_ sky130_fd_sc_hd__or2_2
X_1101_ _0947_ _0950_ vssd1 vssd1 vccd1 vccd1 _0365_ sky130_fd_sc_hd__nand2_2
X_2081_ clknet_leaf_2_clk_i _0101_ net453 vssd1 vssd1 vccd1 vccd1 spi_mem0.data_buf\[7\]
+ sky130_fd_sc_hd__dfrtp_1
XFILLER_0_56_374 vssd1 vssd1 vccd1 vccd1 sky130_fd_sc_hd__decap_8
XFILLER_0_56_363 vssd1 vssd1 vccd1 vccd1 sky130_fd_sc_hd__fill_1
XFILLER_0_56_330 vssd1 vssd1 vccd1 vccd1 sky130_ef_sc_hd__decap_12
X_1934_ net159 net401 _0873_ _0891_ vssd1 vssd1 vccd1 vccd1 _0894_ sky130_fd_sc_hd__a22o_1
XFILLER_0_8_405 vssd1 vssd1 vccd1 vccd1 sky130_fd_sc_hd__fill_2
XFILLER_0_71_322 vssd1 vssd1 vccd1 vccd1 sky130_fd_sc_hd__decap_3
X_1796_ spi_mem2.state\[1\] _0811_ _0808_ vssd1 vssd1 vccd1 vccd1 _0267_ sky130_fd_sc_hd__mux2_1
XFILLER_0_24_260 vssd1 vssd1 vccd1 vccd1 sky130_ef_sc_hd__decap_12
Xinput62 sport0_i[50] vssd1 vssd1 vccd1 vccd1 net62 sky130_fd_sc_hd__buf_1
XFILLER_0_3_121 vssd1 vssd1 vccd1 vccd1 sky130_fd_sc_hd__fill_2
Xinput84 sport0_i[8] vssd1 vssd1 vccd1 vccd1 net84 sky130_fd_sc_hd__buf_1
Xinput95 sport1_i[18] vssd1 vssd1 vccd1 vccd1 net95 sky130_fd_sc_hd__buf_1
Xinput40 sport0_i[30] vssd1 vssd1 vccd1 vccd1 net40 sky130_fd_sc_hd__buf_1
Xinput51 sport0_i[40] vssd1 vssd1 vccd1 vccd1 net51 sky130_fd_sc_hd__buf_1
Xinput73 sport0_i[60] vssd1 vssd1 vccd1 vccd1 net73 sky130_fd_sc_hd__clkbuf_1
X_1865_ spi_mem2.data_buf\[2\] spi_mem2.data_buf\[6\] spi_mem2.data_buf\[10\] spi_mem2.data_buf\[14\]
+ net424 net421 vssd1 vssd1 vccd1 vccd1 _0844_ sky130_fd_sc_hd__mux4_2
XFILLER_0_42_3 vssd1 vssd1 vccd1 vccd1 sky130_ef_sc_hd__decap_12
X_2279_ clknet_leaf_31_clk_i net670 net457 vssd1 vssd1 vccd1 vccd1 net343 sky130_fd_sc_hd__dfrtp_1
XFILLER_0_74_182 vssd1 vssd1 vccd1 vccd1 sky130_fd_sc_hd__fill_2
XFILLER_0_66_138 vssd1 vssd1 vccd1 vccd1 sky130_fd_sc_hd__fill_2
XFILLER_0_47_341 vssd1 vssd1 vccd1 vccd1 sky130_fd_sc_hd__fill_1
XFILLER_0_62_377 vssd1 vssd1 vccd1 vccd1 sky130_ef_sc_hd__decap_12
XFILLER_0_54_19 vssd1 vssd1 vccd1 vccd1 sky130_fd_sc_hd__fill_1
XFILLER_0_70_29 vssd1 vssd1 vccd1 vccd1 sky130_ef_sc_hd__decap_12
XFILLER_0_79_27 vssd1 vssd1 vccd1 vccd1 sky130_fd_sc_hd__fill_2
X_1581_ spi_mem1.address\[5\] _0534_ _0641_ spi_mem1.address\[1\] spi_mem1.address_nibble\[2\]
+ vssd1 vssd1 vccd1 vccd1 _0668_ sky130_fd_sc_hd__a221o_1
XFILLER_0_53_333 vssd1 vssd1 vccd1 vccd1 sky130_fd_sc_hd__decap_3
X_1650_ net777 _0713_ _0716_ net368 vssd1 vssd1 vccd1 vccd1 _0216_ sky130_fd_sc_hd__a22o_1
Xhold109 spi_mem2.address\[5\] vssd1 vssd1 vccd1 vccd1 net613 sky130_fd_sc_hd__dlygate4sd3_1
X_2202_ clknet_leaf_6_clk_i _0216_ net468 vssd1 vssd1 vccd1 vccd1 spi_mem1.data_buf\[14\]
+ sky130_fd_sc_hd__dfrtp_1
XTAP_469 vssd1 vccd1 sky130_fd_sc_hd__tapvpwrvgnd_1
XTAP_458 vssd1 vccd1 sky130_fd_sc_hd__tapvpwrvgnd_1
XTAP_447 vssd1 vccd1 sky130_fd_sc_hd__tapvpwrvgnd_1
XTAP_436 vssd1 vccd1 sky130_fd_sc_hd__tapvpwrvgnd_1
XTAP_425 vssd1 vccd1 sky130_fd_sc_hd__tapvpwrvgnd_1
XTAP_414 vssd1 vccd1 sky130_fd_sc_hd__tapvpwrvgnd_1
XTAP_403 vssd1 vccd1 sky130_fd_sc_hd__tapvpwrvgnd_1
XFILLER_0_0_113 vssd1 vssd1 vccd1 vccd1 sky130_fd_sc_hd__fill_1
X_2064_ clknet_leaf_17_clk_i _0089_ net483 vssd1 vssd1 vccd1 vccd1 net230 sky130_fd_sc_hd__dfrtp_1
X_1015_ spi_mem1.spi_clk net319 vssd1 vssd1 vccd1 vccd1 _0941_ sky130_fd_sc_hd__and2_1
X_2133_ clknet_leaf_20_clk_i _0153_ net485 vssd1 vssd1 vccd1 vccd1 spi_mem1.address\[20\]
+ sky130_fd_sc_hd__dfrtp_1
XFILLER_0_44_85 vssd1 vssd1 vccd1 vccd1 sky130_ef_sc_hd__decap_12
XFILLER_0_44_74 vssd1 vssd1 vccd1 vccd1 sky130_fd_sc_hd__decap_8
XFILLER_0_28_97 vssd1 vssd1 vccd1 vccd1 sky130_fd_sc_hd__fill_1
XFILLER_0_48_149 vssd1 vssd1 vccd1 vccd1 sky130_fd_sc_hd__decap_8
XFILLER_0_48_138 vssd1 vssd1 vccd1 vccd1 sky130_fd_sc_hd__fill_2
XFILLER_0_29_330 vssd1 vssd1 vccd1 vccd1 sky130_fd_sc_hd__decap_6
X_1917_ net518 _0880_ _0883_ net362 vssd1 vssd1 vccd1 vccd1 _0316_ sky130_fd_sc_hd__a22o_1
X_1848_ net199 _0355_ _0740_ _0828_ vssd1 vssd1 vccd1 vccd1 _0829_ sky130_fd_sc_hd__a22o_1
X_1779_ net213 net212 net211 net209 vssd1 vssd1 vccd1 vccd1 _0796_ sky130_fd_sc_hd__or4_1
XFILLER_0_79_274 vssd1 vssd1 vccd1 vccd1 sky130_fd_sc_hd__decap_6
XFILLER_0_39_149 vssd1 vssd1 vccd1 vccd1 sky130_fd_sc_hd__fill_1
XFILLER_0_39_127 vssd1 vssd1 vccd1 vccd1 sky130_fd_sc_hd__fill_2
XFILLER_0_47_193 vssd1 vssd1 vccd1 vccd1 sky130_fd_sc_hd__fill_1
XFILLER_0_35_355 vssd1 vssd1 vccd1 vccd1 sky130_ef_sc_hd__decap_12
XFILLER_0_65_29 vssd1 vssd1 vccd1 vccd1 sky130_ef_sc_hd__decap_12
X_1702_ spi_mem2.has_2lc net392 vssd1 vssd1 vccd1 vccd1 _0750_ sky130_fd_sc_hd__nor2_1
X_1564_ spi_mem1.data_buf\[9\] _0633_ _0634_ spi_mem1.data_buf\[5\] _0651_ vssd1 vssd1
+ vccd1 vccd1 _0652_ sky130_fd_sc_hd__a221o_1
X_1633_ net431 _0931_ net428 vssd1 vssd1 vccd1 vccd1 _0706_ sky130_fd_sc_hd__and3b_2
X_1991__15 clknet_leaf_21_clk_i vssd1 vssd1 vccd1 vccd1 net504 sky130_fd_sc_hd__inv_2
XFILLER_0_53_196 vssd1 vssd1 vccd1 vccd1 sky130_fd_sc_hd__fill_1
XFILLER_0_41_325 vssd1 vssd1 vccd1 vccd1 sky130_fd_sc_hd__decap_8
XFILLER_0_41_314 vssd1 vssd1 vccd1 vccd1 sky130_fd_sc_hd__decap_4
XFILLER_0_26_377 vssd1 vssd1 vccd1 vccd1 sky130_fd_sc_hd__decap_8
X_1495_ _0615_ _0617_ _0619_ _0542_ _0980_ vssd1 vssd1 vccd1 vccd1 _0620_ sky130_fd_sc_hd__a2111o_1
XFILLER_0_39_52 vssd1 vssd1 vccd1 vccd1 sky130_fd_sc_hd__decap_4
Xfanout408 net409 vssd1 vssd1 vccd1 vccd1 net408 sky130_fd_sc_hd__clkbuf_4
XTAP_200 vssd1 vccd1 sky130_fd_sc_hd__tapvpwrvgnd_1
XTAP_211 vssd1 vccd1 sky130_fd_sc_hd__tapvpwrvgnd_1
XTAP_222 vssd1 vccd1 sky130_fd_sc_hd__tapvpwrvgnd_1
XTAP_233 vssd1 vccd1 sky130_fd_sc_hd__tapvpwrvgnd_1
XTAP_244 vssd1 vccd1 sky130_fd_sc_hd__tapvpwrvgnd_1
XTAP_255 vssd1 vccd1 sky130_fd_sc_hd__tapvpwrvgnd_1
XTAP_266 vssd1 vccd1 sky130_fd_sc_hd__tapvpwrvgnd_1
XTAP_277 vssd1 vccd1 sky130_fd_sc_hd__tapvpwrvgnd_1
XTAP_288 vssd1 vccd1 sky130_fd_sc_hd__tapvpwrvgnd_1
XTAP_299 vssd1 vccd1 sky130_fd_sc_hd__tapvpwrvgnd_1
X_2116_ clknet_leaf_16_clk_i _0136_ net479 vssd1 vssd1 vccd1 vccd1 spi_mem1.address\[3\]
+ sky130_fd_sc_hd__dfrtp_1
X_2047_ clknet_leaf_38_clk_i net687 net446 vssd1 vssd1 vccd1 vccd1 net269 sky130_fd_sc_hd__dfrtp_1
XFILLER_0_44_163 vssd1 vssd1 vccd1 vccd1 sky130_fd_sc_hd__decap_4
XFILLER_0_44_141 vssd1 vssd1 vccd1 vccd1 sky130_fd_sc_hd__fill_1
XFILLER_0_82_236 vssd1 vssd1 vccd1 vccd1 sky130_fd_sc_hd__fill_2
XFILLER_0_67_222 vssd1 vssd1 vccd1 vccd1 sky130_fd_sc_hd__fill_2
XFILLER_0_55_406 vssd1 vssd1 vccd1 vccd1 sky130_fd_sc_hd__fill_1
XFILLER_0_50_122 vssd1 vssd1 vccd1 vccd1 sky130_ef_sc_hd__decap_12
XFILLER_0_35_152 vssd1 vssd1 vccd1 vccd1 sky130_fd_sc_hd__decap_4
XFILLER_0_23_369 vssd1 vssd1 vccd1 vccd1 sky130_fd_sc_hd__fill_1
X_1280_ net81 _0421_ _0467_ _0472_ vssd1 vssd1 vccd1 vccd1 _0473_ sky130_fd_sc_hd__o2bb2a_1
XFILLER_0_31_391 vssd1 vssd1 vccd1 vccd1 sky130_fd_sc_hd__fill_1
XFILLER_0_58_244 vssd1 vssd1 vccd1 vccd1 sky130_fd_sc_hd__decap_8
X_0995_ net120 vssd1 vssd1 vccd1 vccd1 _0924_ sky130_fd_sc_hd__inv_2
XFILLER_0_41_100 vssd1 vssd1 vccd1 vccd1 sky130_ef_sc_hd__decap_12
XFILLER_0_41_53 vssd1 vssd1 vccd1 vccd1 sky130_fd_sc_hd__decap_3
XFILLER_0_26_163 vssd1 vssd1 vccd1 vccd1 sky130_ef_sc_hd__decap_12
XFILLER_0_26_141 vssd1 vssd1 vccd1 vccd1 sky130_fd_sc_hd__fill_2
X_1616_ net807 _0691_ _0695_ net368 vssd1 vssd1 vccd1 vccd1 _0203_ sky130_fd_sc_hd__a22o_1
X_1547_ spi_mem1.data_buf\[16\] _0978_ _0634_ spi_mem1.data_buf\[20\] _0635_ vssd1
+ vssd1 vccd1 vccd1 _0636_ sky130_fd_sc_hd__a221o_1
XFILLER_0_41_188 vssd1 vssd1 vccd1 vccd1 sky130_ef_sc_hd__decap_12
X_1478_ net138 net136 net144 net145 vssd1 vssd1 vccd1 vccd1 _0603_ sky130_fd_sc_hd__or4_1
XFILLER_0_49_211 vssd1 vssd1 vccd1 vccd1 sky130_ef_sc_hd__decap_12
XFILLER_0_72_280 vssd1 vssd1 vccd1 vccd1 sky130_ef_sc_hd__decap_12
Xhold281 net304 vssd1 vssd1 vccd1 vccd1 net785 sky130_fd_sc_hd__dlygate4sd3_1
Xhold292 spi_mem2.address\[20\] vssd1 vssd1 vccd1 vccd1 net796 sky130_fd_sc_hd__dlygate4sd3_1
Xhold270 spi_mem2.address\[19\] vssd1 vssd1 vccd1 vccd1 net774 sky130_fd_sc_hd__dlygate4sd3_1
XFILLER_0_62_19 vssd1 vssd1 vccd1 vccd1 sky130_fd_sc_hd__fill_1
XFILLER_0_28_406 vssd1 vssd1 vccd1 vccd1 sky130_fd_sc_hd__fill_1
XFILLER_0_70_228 vssd1 vssd1 vccd1 vccd1 sky130_fd_sc_hd__fill_1
XFILLER_0_55_225 vssd1 vssd1 vccd1 vccd1 sky130_fd_sc_hd__decap_4
Xclkbuf_leaf_13_clk_i clknet_2_2__leaf_clk_i vssd1 vssd1 vccd1 vccd1 clknet_leaf_13_clk_i
+ sky130_fd_sc_hd__clkbuf_16
X_1401_ _0539_ _0554_ _0538_ vssd1 vssd1 vccd1 vccd1 _0555_ sky130_fd_sc_hd__a21oi_1
XFILLER_0_23_177 vssd1 vssd1 vccd1 vccd1 sky130_fd_sc_hd__fill_1
XFILLER_0_23_166 vssd1 vssd1 vccd1 vccd1 sky130_fd_sc_hd__fill_2
Xinput5 spi0_miso_i[2] vssd1 vssd1 vccd1 vccd1 net5 sky130_fd_sc_hd__clkbuf_1
X_1332_ net700 _0505_ _0507_ net373 vssd1 vssd1 vccd1 vccd1 _0107_ sky130_fd_sc_hd__a22o_1
Xclkbuf_leaf_28_clk_i clknet_2_1__leaf_clk_i vssd1 vssd1 vccd1 vccd1 clknet_leaf_28_clk_i
+ sky130_fd_sc_hd__clkbuf_16
X_1263_ spi_mem0.address\[19\] _0366_ net443 vssd1 vssd1 vccd1 vccd1 _0457_ sky130_fd_sc_hd__a21bo_1
X_1194_ spi_mem0.data_buf\[1\] net760 net389 vssd1 vssd1 vccd1 vccd1 _0056_ sky130_fd_sc_hd__mux2_1
XFILLER_0_52_63 vssd1 vssd1 vccd1 vccd1 sky130_fd_sc_hd__decap_8
XFILLER_0_52_41 vssd1 vssd1 vccd1 vccd1 sky130_ef_sc_hd__decap_12
XFILLER_0_72_3 vssd1 vssd1 vccd1 vccd1 sky130_ef_sc_hd__decap_12
Xoutput353 net353 vssd1 vssd1 vccd1 vccd1 sport2_o[32] sky130_fd_sc_hd__clkbuf_4
Xoutput320 net320 vssd1 vssd1 vccd1 vccd1 sport1_o[33] sky130_fd_sc_hd__clkbuf_4
Xoutput342 net342 vssd1 vssd1 vccd1 vccd1 sport2_o[22] sky130_fd_sc_hd__clkbuf_4
Xoutput331 net331 vssd1 vssd1 vccd1 vccd1 sport2_o[12] sky130_fd_sc_hd__clkbuf_4
XFILLER_0_10_394 vssd1 vssd1 vccd1 vccd1 sky130_ef_sc_hd__decap_12
XFILLER_0_52_239 vssd1 vssd1 vccd1 vccd1 sky130_fd_sc_hd__decap_8
XFILLER_0_37_225 vssd1 vssd1 vccd1 vccd1 sky130_ef_sc_hd__decap_12
XFILLER_0_28_225 vssd1 vssd1 vccd1 vccd1 sky130_fd_sc_hd__decap_4
XFILLER_0_28_203 vssd1 vssd1 vccd1 vccd1 sky130_fd_sc_hd__fill_1
X_1950_ _0968_ _0902_ net364 vssd1 vssd1 vccd1 vccd1 _0903_ sky130_fd_sc_hd__o21ai_2
XFILLER_0_43_206 vssd1 vssd1 vccd1 vccd1 sky130_fd_sc_hd__decap_3
XFILLER_0_36_291 vssd1 vssd1 vccd1 vccd1 sky130_fd_sc_hd__decap_4
X_1881_ spi_mem2.address\[6\] _0742_ _0824_ spi_mem2.address\[2\] spi_mem2.address_nibble\[2\]
+ vssd1 vssd1 vccd1 vccd1 _0859_ sky130_fd_sc_hd__a221o_1
X_1315_ net83 net416 _0490_ _0492_ vssd1 vssd1 vccd1 vccd1 _0497_ sky130_fd_sc_hd__a22o_1
XFILLER_0_11_169 vssd1 vssd1 vccd1 vccd1 sky130_fd_sc_hd__fill_1
X_2295_ net501 net14 net483 vssd1 vssd1 vccd1 vccd1 spi_mem2.delayed_miso\[1\] sky130_fd_sc_hd__dfrtp_1
XFILLER_0_78_125 vssd1 vssd1 vccd1 vccd1 sky130_ef_sc_hd__decap_12
XFILLER_0_66_309 vssd1 vssd1 vccd1 vccd1 sky130_fd_sc_hd__decap_4
XFILLER_0_59_350 vssd1 vssd1 vccd1 vccd1 sky130_fd_sc_hd__decap_6
X_1177_ net79 _0407_ _0408_ net80 net439 vssd1 vssd1 vccd1 vccd1 _0409_ sky130_fd_sc_hd__a221o_1
X_1246_ spi_mem0.data_buf\[9\] _0423_ net435 vssd1 vssd1 vccd1 vccd1 _0441_ sky130_fd_sc_hd__a21o_1
XPHY_109 vssd1 vssd1 vccd1 vccd1 sky130_fd_sc_hd__decap_3
XFILLER_0_19_269 vssd1 vssd1 vccd1 vccd1 sky130_fd_sc_hd__decap_8
XFILLER_0_69_169 vssd1 vssd1 vccd1 vccd1 sky130_fd_sc_hd__decap_6
XFILLER_0_69_125 vssd1 vssd1 vccd1 vccd1 sky130_fd_sc_hd__decap_3
XFILLER_0_80_312 vssd1 vssd1 vccd1 vccd1 sky130_ef_sc_hd__decap_12
XFILLER_0_65_375 vssd1 vssd1 vccd1 vccd1 sky130_fd_sc_hd__decap_6
XFILLER_0_40_209 vssd1 vssd1 vccd1 vccd1 sky130_fd_sc_hd__fill_2
XFILLER_0_33_272 vssd1 vssd1 vccd1 vccd1 sky130_fd_sc_hd__decap_8
XTAP_629 vssd1 vccd1 sky130_fd_sc_hd__tapvpwrvgnd_1
XTAP_618 vssd1 vccd1 sky130_fd_sc_hd__tapvpwrvgnd_1
XTAP_607 vssd1 vccd1 sky130_fd_sc_hd__tapvpwrvgnd_1
X_1031_ spi_mem2.state\[1\] net426 vssd1 vssd1 vccd1 vccd1 _0953_ sky130_fd_sc_hd__nor2_2
XFILLER_0_48_309 vssd1 vssd1 vccd1 vccd1 sky130_ef_sc_hd__decap_12
X_2080_ clknet_leaf_7_clk_i _0100_ net467 vssd1 vssd1 vccd1 vccd1 spi_mem0.data_buf\[6\]
+ sky130_fd_sc_hd__dfrtp_1
X_1100_ _0947_ _0950_ vssd1 vssd1 vccd1 vccd1 _0364_ sky130_fd_sc_hd__and2_2
XFILLER_0_17_66 vssd1 vssd1 vccd1 vccd1 sky130_fd_sc_hd__decap_4
XFILLER_0_17_99 vssd1 vssd1 vccd1 vccd1 sky130_ef_sc_hd__decap_12
XFILLER_0_75_139 vssd1 vssd1 vccd1 vccd1 sky130_fd_sc_hd__decap_4
XFILLER_0_56_320 vssd1 vssd1 vccd1 vccd1 sky130_fd_sc_hd__decap_6
X_1933_ net708 _0892_ _0893_ net362 vssd1 vssd1 vccd1 vccd1 _0322_ sky130_fd_sc_hd__a22o_1
X_1864_ _0843_ net781 _0818_ vssd1 vssd1 vccd1 vccd1 _0303_ sky130_fd_sc_hd__mux2_1
X_1795_ spi_mem2.state\[2\] _0959_ _0961_ _0954_ vssd1 vssd1 vccd1 vccd1 _0811_ sky130_fd_sc_hd__o211a_1
XFILLER_0_24_272 vssd1 vssd1 vccd1 vccd1 sky130_fd_sc_hd__decap_8
Xinput63 sport0_i[51] vssd1 vssd1 vccd1 vccd1 net63 sky130_fd_sc_hd__buf_1
Xinput74 sport0_i[61] vssd1 vssd1 vccd1 vccd1 net74 sky130_fd_sc_hd__clkbuf_1
Xinput30 sport0_i[21] vssd1 vssd1 vccd1 vccd1 net30 sky130_fd_sc_hd__buf_1
Xinput96 sport1_i[19] vssd1 vssd1 vccd1 vccd1 net96 sky130_fd_sc_hd__buf_1
Xinput41 sport0_i[31] vssd1 vssd1 vccd1 vccd1 net41 sky130_fd_sc_hd__buf_1
Xinput52 sport0_i[41] vssd1 vssd1 vccd1 vccd1 net52 sky130_fd_sc_hd__clkbuf_1
Xinput85 sport0_i[9] vssd1 vssd1 vccd1 vccd1 net85 sky130_fd_sc_hd__buf_1
XFILLER_0_74_61 vssd1 vssd1 vccd1 vccd1 sky130_ef_sc_hd__decap_12
XFILLER_0_35_3 vssd1 vssd1 vccd1 vccd1 sky130_ef_sc_hd__decap_12
X_2278_ clknet_leaf_37_clk_i net597 net449 vssd1 vssd1 vccd1 vccd1 net342 sky130_fd_sc_hd__dfrtp_1
X_1229_ net437 net439 vssd1 vssd1 vccd1 vccd1 _0425_ sky130_fd_sc_hd__and2b_2
XFILLER_0_74_194 vssd1 vssd1 vccd1 vccd1 sky130_fd_sc_hd__fill_2
XFILLER_0_62_389 vssd1 vssd1 vccd1 vccd1 sky130_ef_sc_hd__decap_12
Xclkbuf_2_2__f_clk_i clknet_0_clk_i vssd1 vssd1 vccd1 vccd1 clknet_2_2__leaf_clk_i
+ sky130_fd_sc_hd__clkbuf_16
XFILLER_0_47_364 vssd1 vssd1 vccd1 vccd1 sky130_ef_sc_hd__decap_12
XFILLER_0_22_209 vssd1 vssd1 vccd1 vccd1 sky130_fd_sc_hd__fill_2
XFILLER_0_15_272 vssd1 vssd1 vccd1 vccd1 sky130_fd_sc_hd__decap_8
XFILLER_0_30_253 vssd1 vssd1 vccd1 vccd1 sky130_fd_sc_hd__decap_6
XFILLER_0_38_342 vssd1 vssd1 vccd1 vccd1 sky130_fd_sc_hd__decap_4
X_1580_ spi_mem1.address\[19\] _0534_ _0666_ _0930_ vssd1 vssd1 vccd1 vccd1 _0667_
+ sky130_fd_sc_hd__a211o_1
XFILLER_0_53_378 vssd1 vssd1 vccd1 vccd1 sky130_ef_sc_hd__decap_12
X_2132_ clknet_leaf_18_clk_i _0152_ net486 vssd1 vssd1 vccd1 vccd1 spi_mem1.address\[19\]
+ sky130_fd_sc_hd__dfrtp_1
X_2201_ clknet_leaf_6_clk_i _0215_ net470 vssd1 vssd1 vccd1 vccd1 spi_mem1.data_buf\[13\]
+ sky130_fd_sc_hd__dfrtp_1
XTAP_459 vssd1 vccd1 sky130_fd_sc_hd__tapvpwrvgnd_1
XTAP_448 vssd1 vccd1 sky130_fd_sc_hd__tapvpwrvgnd_1
XTAP_437 vssd1 vccd1 sky130_fd_sc_hd__tapvpwrvgnd_1
XTAP_426 vssd1 vccd1 sky130_fd_sc_hd__tapvpwrvgnd_1
XTAP_415 vssd1 vccd1 sky130_fd_sc_hd__tapvpwrvgnd_1
XTAP_404 vssd1 vccd1 sky130_fd_sc_hd__tapvpwrvgnd_1
XFILLER_0_0_169 vssd1 vssd1 vccd1 vccd1 sky130_fd_sc_hd__fill_1
XFILLER_0_21_297 vssd1 vssd1 vccd1 vccd1 sky130_fd_sc_hd__decap_6
X_1014_ net319 vssd1 vssd1 vccd1 vccd1 net237 sky130_fd_sc_hd__inv_2
X_2063_ clknet_leaf_17_clk_i _0088_ net483 vssd1 vssd1 vccd1 vccd1 net229 sky130_fd_sc_hd__dfrtp_1
XFILLER_0_48_128 vssd1 vssd1 vccd1 vccd1 sky130_fd_sc_hd__fill_1
XFILLER_0_44_97 vssd1 vssd1 vccd1 vccd1 sky130_fd_sc_hd__fill_2
XFILLER_0_60_96 vssd1 vssd1 vccd1 vccd1 sky130_fd_sc_hd__fill_2
XFILLER_0_60_85 vssd1 vssd1 vccd1 vccd1 sky130_fd_sc_hd__decap_3
XFILLER_0_56_194 vssd1 vssd1 vccd1 vccd1 sky130_fd_sc_hd__fill_2
XFILLER_0_29_364 vssd1 vssd1 vccd1 vccd1 sky130_fd_sc_hd__decap_6
X_1847_ _0926_ spi_mem2.address_nibble\[1\] _0825_ _0827_ vssd1 vssd1 vccd1 vccd1
+ _0828_ sky130_fd_sc_hd__a31o_1
X_1916_ net220 net403 _0875_ _0879_ vssd1 vssd1 vccd1 vccd1 _0883_ sky130_fd_sc_hd__a22o_1
X_1778_ net208 net207 net206 net214 vssd1 vssd1 vccd1 vccd1 _0795_ sky130_fd_sc_hd__or4_1
XFILLER_0_12_220 vssd1 vssd1 vccd1 vccd1 sky130_ef_sc_hd__decap_12
XFILLER_0_12_253 vssd1 vssd1 vccd1 vccd1 sky130_fd_sc_hd__decap_8
XFILLER_0_79_264 vssd1 vssd1 vccd1 vccd1 sky130_fd_sc_hd__fill_1
XFILLER_0_50_337 vssd1 vssd1 vccd1 vccd1 sky130_ef_sc_hd__decap_12
XFILLER_0_35_367 vssd1 vssd1 vccd1 vccd1 sky130_fd_sc_hd__decap_4
XFILLER_0_35_345 vssd1 vssd1 vccd1 vccd1 sky130_fd_sc_hd__fill_2
Xinput220 sport2_i[6] vssd1 vssd1 vccd1 vccd1 net220 sky130_fd_sc_hd__clkbuf_2
X_1701_ _0748_ vssd1 vssd1 vccd1 vccd1 _0749_ sky130_fd_sc_hd__inv_2
XFILLER_0_41_304 vssd1 vssd1 vccd1 vccd1 sky130_fd_sc_hd__fill_1
XFILLER_0_38_150 vssd1 vssd1 vccd1 vccd1 sky130_fd_sc_hd__decap_8
XFILLER_0_26_345 vssd1 vssd1 vccd1 vccd1 sky130_fd_sc_hd__fill_1
XFILLER_0_26_301 vssd1 vssd1 vccd1 vccd1 sky130_fd_sc_hd__decap_6
XFILLER_0_14_56 vssd1 vssd1 vccd1 vccd1 sky130_fd_sc_hd__fill_2
X_1632_ net690 _0701_ _0705_ net367 vssd1 vssd1 vccd1 vccd1 _0209_ sky130_fd_sc_hd__a22o_1
X_1494_ net146 _0938_ _0939_ _0618_ vssd1 vssd1 vccd1 vccd1 _0619_ sky130_fd_sc_hd__a31o_1
X_1563_ net431 net428 spi_mem1.data_buf\[13\] vssd1 vssd1 vccd1 vccd1 _0651_ sky130_fd_sc_hd__and3_1
Xfanout409 _0952_ vssd1 vssd1 vccd1 vccd1 net409 sky130_fd_sc_hd__buf_2
XFILLER_0_41_337 vssd1 vssd1 vccd1 vccd1 sky130_fd_sc_hd__decap_3
XTAP_201 vssd1 vccd1 sky130_fd_sc_hd__tapvpwrvgnd_1
XTAP_212 vssd1 vccd1 sky130_fd_sc_hd__tapvpwrvgnd_1
XTAP_223 vssd1 vccd1 sky130_fd_sc_hd__tapvpwrvgnd_1
X_2115_ clknet_leaf_16_clk_i _0135_ net484 vssd1 vssd1 vccd1 vccd1 spi_mem1.address\[2\]
+ sky130_fd_sc_hd__dfrtp_1
XFILLER_0_55_63 vssd1 vssd1 vccd1 vccd1 sky130_fd_sc_hd__fill_1
XFILLER_0_55_30 vssd1 vssd1 vccd1 vccd1 sky130_ef_sc_hd__decap_12
XTAP_234 vssd1 vccd1 sky130_fd_sc_hd__tapvpwrvgnd_1
XTAP_245 vssd1 vccd1 sky130_fd_sc_hd__tapvpwrvgnd_1
XTAP_256 vssd1 vccd1 sky130_fd_sc_hd__tapvpwrvgnd_1
XTAP_267 vssd1 vccd1 sky130_fd_sc_hd__tapvpwrvgnd_1
XTAP_278 vssd1 vccd1 sky130_fd_sc_hd__tapvpwrvgnd_1
XTAP_289 vssd1 vccd1 sky130_fd_sc_hd__tapvpwrvgnd_1
X_2046_ clknet_leaf_4_clk_i net767 net452 vssd1 vssd1 vccd1 vccd1 net268 sky130_fd_sc_hd__dfrtp_1
XFILLER_0_4_261 vssd1 vssd1 vccd1 vccd1 sky130_fd_sc_hd__fill_1
XFILLER_0_82_204 vssd1 vssd1 vccd1 vccd1 sky130_fd_sc_hd__fill_2
XFILLER_0_35_164 vssd1 vssd1 vccd1 vccd1 sky130_fd_sc_hd__decap_4
XFILLER_0_76_29 vssd1 vssd1 vccd1 vccd1 sky130_fd_sc_hd__decap_6
XFILLER_0_50_167 vssd1 vssd1 vccd1 vccd1 sky130_ef_sc_hd__decap_12
XFILLER_0_50_134 vssd1 vssd1 vccd1 vccd1 sky130_fd_sc_hd__decap_6
XFILLER_0_50_101 vssd1 vssd1 vccd1 vccd1 sky130_fd_sc_hd__fill_1
XFILLER_0_23_337 vssd1 vssd1 vccd1 vccd1 sky130_ef_sc_hd__decap_12
XFILLER_0_41_32 vssd1 vssd1 vccd1 vccd1 sky130_fd_sc_hd__fill_1
XFILLER_0_25_55 vssd1 vssd1 vccd1 vccd1 sky130_fd_sc_hd__fill_1
X_0994_ spi_mem2.state\[3\] vssd1 vssd1 vccd1 vccd1 _0923_ sky130_fd_sc_hd__inv_2
XFILLER_0_41_167 vssd1 vssd1 vccd1 vccd1 sky130_fd_sc_hd__fill_1
XFILLER_0_26_175 vssd1 vssd1 vccd1 vccd1 sky130_ef_sc_hd__decap_12
X_1615_ net97 net396 _0690_ _0694_ vssd1 vssd1 vccd1 vccd1 _0695_ sky130_fd_sc_hd__a22o_1
X_1546_ net431 net428 spi_mem1.data_buf\[28\] vssd1 vssd1 vccd1 vccd1 _0635_ sky130_fd_sc_hd__and3_1
X_1477_ _0581_ _0601_ _0598_ _0591_ _0589_ vssd1 vssd1 vccd1 vccd1 _0602_ sky130_fd_sc_hd__o2111a_1
XFILLER_0_82_61 vssd1 vssd1 vccd1 vccd1 sky130_fd_sc_hd__fill_1
XFILLER_0_66_95 vssd1 vssd1 vccd1 vccd1 sky130_fd_sc_hd__decap_3
XFILLER_0_49_223 vssd1 vssd1 vccd1 vccd1 sky130_fd_sc_hd__fill_1
XFILLER_0_49_278 vssd1 vssd1 vccd1 vccd1 sky130_fd_sc_hd__fill_2
X_2029_ clknet_leaf_1_clk_i net776 net451 vssd1 vssd1 vccd1 vccd1 net260 sky130_fd_sc_hd__dfrtp_1
XFILLER_0_72_292 vssd1 vssd1 vccd1 vccd1 sky130_ef_sc_hd__decap_12
Xhold260 spi_mem2.data_ready vssd1 vssd1 vccd1 vccd1 net764 sky130_fd_sc_hd__dlygate4sd3_1
Xhold271 net260 vssd1 vssd1 vccd1 vccd1 net775 sky130_fd_sc_hd__dlygate4sd3_1
XFILLER_0_20_307 vssd1 vssd1 vccd1 vccd1 sky130_fd_sc_hd__fill_1
XFILLER_0_20_318 vssd1 vssd1 vccd1 vccd1 sky130_fd_sc_hd__decap_4
Xclkbuf_leaf_9_clk_i clknet_2_2__leaf_clk_i vssd1 vssd1 vccd1 vccd1 clknet_leaf_9_clk_i
+ sky130_fd_sc_hd__clkbuf_16
Xhold282 spi_mem0.data_buf\[3\] vssd1 vssd1 vccd1 vccd1 net786 sky130_fd_sc_hd__dlygate4sd3_1
Xhold293 spi_mem2.data_buf\[1\] vssd1 vssd1 vccd1 vccd1 net797 sky130_fd_sc_hd__dlygate4sd3_1
XFILLER_0_63_281 vssd1 vssd1 vccd1 vccd1 sky130_fd_sc_hd__decap_3
XFILLER_0_11_57 vssd1 vssd1 vccd1 vccd1 sky130_fd_sc_hd__decap_3
X_1400_ spi_mem1.latency\[0\] spi_mem1.latency\[1\] spi_mem1.latency\[2\] vssd1 vssd1
+ vccd1 vccd1 _0554_ sky130_fd_sc_hd__o21ai_1
X_1331_ net21 net416 _0486_ _0504_ vssd1 vssd1 vccd1 vccd1 _0507_ sky130_fd_sc_hd__a22o_1
Xinput6 spi0_miso_i[3] vssd1 vssd1 vccd1 vccd1 net6 sky130_fd_sc_hd__clkbuf_1
X_1193_ spi_mem0.data_buf\[0\] net775 net389 vssd1 vssd1 vccd1 vccd1 _0055_ sky130_fd_sc_hd__mux2_1
X_1262_ spi_mem0.address\[11\] _0375_ _0392_ spi_mem0.address\[15\] vssd1 vssd1 vccd1
+ vccd1 _0456_ sky130_fd_sc_hd__a22o_1
XFILLER_0_52_53 vssd1 vssd1 vccd1 vccd1 sky130_fd_sc_hd__fill_2
XFILLER_0_46_204 vssd1 vssd1 vccd1 vccd1 sky130_ef_sc_hd__decap_12
XFILLER_0_65_3 vssd1 vssd1 vccd1 vccd1 sky130_ef_sc_hd__decap_12
Xoutput310 net310 vssd1 vssd1 vccd1 vccd1 sport1_o[24] sky130_fd_sc_hd__clkbuf_4
Xoutput343 net343 vssd1 vssd1 vccd1 vccd1 sport2_o[23] sky130_fd_sc_hd__clkbuf_4
Xoutput321 net321 vssd1 vssd1 vccd1 vccd1 sport1_o[3] sky130_fd_sc_hd__clkbuf_4
Xoutput332 net332 vssd1 vssd1 vccd1 vccd1 sport2_o[13] sky130_fd_sc_hd__clkbuf_4
XFILLER_0_77_72 vssd1 vssd1 vccd1 vccd1 sky130_fd_sc_hd__fill_1
X_1529_ net524 net306 net385 vssd1 vssd1 vccd1 vccd1 _0182_ sky130_fd_sc_hd__mux2_1
Xoutput354 net354 vssd1 vssd1 vccd1 vccd1 sport2_o[33] sky130_fd_sc_hd__clkbuf_4
XFILLER_0_10_362 vssd1 vssd1 vccd1 vccd1 sky130_fd_sc_hd__fill_2
XFILLER_0_45_281 vssd1 vssd1 vccd1 vccd1 sky130_fd_sc_hd__decap_8
XFILLER_0_37_237 vssd1 vssd1 vccd1 vccd1 sky130_fd_sc_hd__decap_4
XFILLER_0_68_384 vssd1 vssd1 vccd1 vccd1 sky130_fd_sc_hd__fill_2
XPHY_90 vssd1 vssd1 vccd1 vccd1 sky130_fd_sc_hd__decap_3
X_1880_ spi_mem2.address\[12\] _0746_ _0824_ spi_mem2.address\[16\] vssd1 vssd1 vccd1
+ vccd1 _0858_ sky130_fd_sc_hd__a22o_1
XFILLER_0_22_56 vssd1 vssd1 vccd1 vccd1 sky130_fd_sc_hd__fill_1
X_2294_ net500 net13 net478 vssd1 vssd1 vccd1 vccd1 spi_mem2.delayed_miso\[0\] sky130_fd_sc_hd__dfrtp_1
X_1314_ net741 _0493_ _0496_ net372 vssd1 vssd1 vccd1 vccd1 _0100_ sky130_fd_sc_hd__a22o_1
XFILLER_0_78_137 vssd1 vssd1 vccd1 vccd1 sky130_fd_sc_hd__decap_3
XFILLER_0_63_74 vssd1 vssd1 vccd1 vccd1 sky130_fd_sc_hd__decap_4
X_1176_ net79 net78 vssd1 vssd1 vccd1 vccd1 _0408_ sky130_fd_sc_hd__nand2_1
X_1245_ spi_mem0.data_buf\[21\] _0425_ _0438_ _0439_ vssd1 vssd1 vccd1 vccd1 _0440_
+ sky130_fd_sc_hd__a211o_1
XFILLER_0_74_365 vssd1 vssd1 vccd1 vccd1 sky130_fd_sc_hd__decap_6
XFILLER_0_27_281 vssd1 vssd1 vccd1 vccd1 sky130_ef_sc_hd__decap_12
XFILLER_0_10_181 vssd1 vssd1 vccd1 vccd1 sky130_fd_sc_hd__fill_1
XFILLER_0_77_181 vssd1 vssd1 vccd1 vccd1 sky130_ef_sc_hd__decap_12
Xclkbuf_leaf_12_clk_i clknet_2_2__leaf_clk_i vssd1 vssd1 vccd1 vccd1 clknet_leaf_12_clk_i
+ sky130_fd_sc_hd__clkbuf_16
XFILLER_0_80_324 vssd1 vssd1 vccd1 vccd1 sky130_fd_sc_hd__decap_8
Xclkbuf_leaf_27_clk_i clknet_2_1__leaf_clk_i vssd1 vssd1 vccd1 vccd1 clknet_leaf_27_clk_i
+ sky130_fd_sc_hd__clkbuf_16
XFILLER_0_0_307 vssd1 vssd1 vccd1 vccd1 sky130_fd_sc_hd__fill_1
XFILLER_0_18_292 vssd1 vssd1 vccd1 vccd1 sky130_ef_sc_hd__decap_12
XTAP_619 vssd1 vccd1 sky130_fd_sc_hd__tapvpwrvgnd_1
XTAP_608 vssd1 vccd1 sky130_fd_sc_hd__tapvpwrvgnd_1
XFILLER_0_17_23 vssd1 vssd1 vccd1 vccd1 sky130_fd_sc_hd__fill_2
X_1030_ spi_mem0.spi_clk net285 net409 vssd1 vssd1 vccd1 vccd1 net224 sky130_fd_sc_hd__and3_2
XFILLER_0_71_335 vssd1 vssd1 vccd1 vccd1 sky130_fd_sc_hd__fill_1
XFILLER_0_71_302 vssd1 vssd1 vccd1 vccd1 sky130_fd_sc_hd__fill_1
X_1863_ _0817_ _0837_ _0842_ vssd1 vssd1 vccd1 vccd1 _0843_ sky130_fd_sc_hd__or3_2
X_1932_ net158 net400 _0871_ _0891_ vssd1 vssd1 vccd1 vccd1 _0893_ sky130_fd_sc_hd__a22o_1
Xinput31 sport0_i[22] vssd1 vssd1 vccd1 vccd1 net31 sky130_fd_sc_hd__buf_1
Xinput20 sport0_i[12] vssd1 vssd1 vccd1 vccd1 net20 sky130_fd_sc_hd__buf_1
X_1794_ net427 _0810_ _0808_ vssd1 vssd1 vccd1 vccd1 _0266_ sky130_fd_sc_hd__mux2_1
Xinput75 sport0_i[62] vssd1 vssd1 vccd1 vccd1 net75 sky130_fd_sc_hd__clkbuf_1
Xinput86 sport1_i[0] vssd1 vssd1 vccd1 vccd1 net86 sky130_fd_sc_hd__dlymetal6s2s_1
Xinput53 sport0_i[42] vssd1 vssd1 vccd1 vccd1 net53 sky130_fd_sc_hd__buf_1
Xinput97 sport1_i[1] vssd1 vssd1 vccd1 vccd1 net97 sky130_fd_sc_hd__dlymetal6s2s_1
Xinput64 sport0_i[52] vssd1 vssd1 vccd1 vccd1 net64 sky130_fd_sc_hd__buf_1
Xinput42 sport0_i[32] vssd1 vssd1 vccd1 vccd1 net42 sky130_fd_sc_hd__clkbuf_1
X_1228_ spi_mem0.data_buf\[24\] _0423_ net435 vssd1 vssd1 vccd1 vccd1 _0424_ sky130_fd_sc_hd__a21bo_1
X_2277_ clknet_leaf_37_clk_i net658 net448 vssd1 vssd1 vccd1 vccd1 net341 sky130_fd_sc_hd__dfrtp_1
XFILLER_0_66_118 vssd1 vssd1 vccd1 vccd1 sky130_ef_sc_hd__decap_12
X_1159_ _0366_ _0392_ _0364_ vssd1 vssd1 vccd1 vccd1 _0393_ sky130_fd_sc_hd__o21a_1
XFILLER_0_47_376 vssd1 vssd1 vccd1 vccd1 sky130_fd_sc_hd__decap_3
XFILLER_0_30_221 vssd1 vssd1 vccd1 vccd1 sky130_fd_sc_hd__decap_8
XFILLER_0_15_262 vssd1 vssd1 vccd1 vccd1 sky130_fd_sc_hd__fill_1
XTAP_405 vssd1 vccd1 sky130_fd_sc_hd__tapvpwrvgnd_1
XFILLER_0_21_221 vssd1 vssd1 vccd1 vccd1 sky130_fd_sc_hd__decap_3
X_2062_ clknet_leaf_12_clk_i _0087_ net477 vssd1 vssd1 vccd1 vccd1 net228 sky130_fd_sc_hd__dfrtp_1
X_2131_ clknet_leaf_20_clk_i _0151_ net485 vssd1 vssd1 vccd1 vccd1 spi_mem1.address\[18\]
+ sky130_fd_sc_hd__dfrtp_1
X_2200_ clknet_leaf_7_clk_i _0214_ net467 vssd1 vssd1 vccd1 vccd1 spi_mem1.data_buf\[12\]
+ sky130_fd_sc_hd__dfrtp_1
XTAP_449 vssd1 vccd1 sky130_fd_sc_hd__tapvpwrvgnd_1
XTAP_438 vssd1 vccd1 sky130_fd_sc_hd__tapvpwrvgnd_1
XTAP_427 vssd1 vccd1 sky130_fd_sc_hd__tapvpwrvgnd_1
XTAP_416 vssd1 vccd1 sky130_fd_sc_hd__tapvpwrvgnd_1
X_1013_ _0938_ _0939_ net418 vssd1 vssd1 vccd1 vccd1 net319 sky130_fd_sc_hd__a21oi_4
X_1846_ spi_mem2.address_nibble\[2\] _0826_ vssd1 vssd1 vccd1 vccd1 _0827_ sky130_fd_sc_hd__and2_1
X_1777_ net203 net204 _0783_ _0793_ net205 vssd1 vssd1 vccd1 vccd1 _0794_ sky130_fd_sc_hd__a32o_1
X_1915_ net800 _0880_ _0882_ net363 vssd1 vssd1 vccd1 vccd1 _0315_ sky130_fd_sc_hd__a22o_1
XFILLER_0_12_232 vssd1 vssd1 vccd1 vccd1 sky130_ef_sc_hd__decap_12
XFILLER_0_79_210 vssd1 vssd1 vccd1 vccd1 sky130_fd_sc_hd__decap_8
XFILLER_0_67_405 vssd1 vssd1 vccd1 vccd1 sky130_fd_sc_hd__fill_2
X_2329_ clknet_leaf_30_clk_i _0337_ net459 vssd1 vssd1 vccd1 vccd1 spi_mem2.data_buf\[27\]
+ sky130_fd_sc_hd__dfrtp_1
XFILLER_0_35_335 vssd1 vssd1 vccd1 vccd1 sky130_fd_sc_hd__fill_1
XFILLER_0_50_349 vssd1 vssd1 vccd1 vccd1 sky130_fd_sc_hd__fill_2
Xinput221 sport2_i[7] vssd1 vssd1 vccd1 vccd1 net221 sky130_fd_sc_hd__clkbuf_2
Xinput210 sport2_i[5] vssd1 vssd1 vccd1 vccd1 net210 sky130_fd_sc_hd__clkbuf_2
XFILLER_0_58_405 vssd1 vssd1 vccd1 vccd1 sky130_fd_sc_hd__fill_2
XFILLER_0_14_46 vssd1 vssd1 vccd1 vccd1 sky130_fd_sc_hd__decap_4
X_1631_ net152 net398 _0698_ _0700_ vssd1 vssd1 vccd1 vccd1 _0705_ sky130_fd_sc_hd__a22o_1
XFILLER_0_53_165 vssd1 vssd1 vccd1 vccd1 sky130_fd_sc_hd__decap_3
X_1700_ net392 _0740_ _0745_ _0747_ _0358_ vssd1 vssd1 vccd1 vccd1 _0748_ sky130_fd_sc_hd__o2111ai_4
X_1493_ spi_mem1.state\[2\] spi_mem1.state\[3\] _0935_ net395 _0546_ vssd1 vssd1 vccd1
+ vccd1 _0618_ sky130_fd_sc_hd__a32o_1
X_1562_ spi_mem1.data_buf\[25\] _0633_ _0649_ _0931_ vssd1 vssd1 vccd1 vccd1 _0650_
+ sky130_fd_sc_hd__a211o_1
XTAP_202 vssd1 vccd1 sky130_fd_sc_hd__tapvpwrvgnd_1
XTAP_213 vssd1 vccd1 sky130_fd_sc_hd__tapvpwrvgnd_1
XTAP_224 vssd1 vccd1 sky130_fd_sc_hd__tapvpwrvgnd_1
XTAP_235 vssd1 vccd1 sky130_fd_sc_hd__tapvpwrvgnd_1
XTAP_246 vssd1 vccd1 sky130_fd_sc_hd__tapvpwrvgnd_1
XTAP_257 vssd1 vccd1 sky130_fd_sc_hd__tapvpwrvgnd_1
X_2114_ clknet_leaf_16_clk_i _0134_ net484 vssd1 vssd1 vccd1 vccd1 spi_mem1.address\[1\]
+ sky130_fd_sc_hd__dfrtp_1
XFILLER_0_55_97 vssd1 vssd1 vccd1 vccd1 sky130_fd_sc_hd__fill_1
XFILLER_0_55_42 vssd1 vssd1 vccd1 vccd1 sky130_fd_sc_hd__fill_2
XFILLER_0_49_405 vssd1 vssd1 vccd1 vccd1 sky130_fd_sc_hd__fill_2
X_2045_ clknet_leaf_3_clk_i net684 net453 vssd1 vssd1 vccd1 vccd1 net267 sky130_fd_sc_hd__dfrtp_1
XTAP_268 vssd1 vccd1 sky130_fd_sc_hd__tapvpwrvgnd_1
XTAP_279 vssd1 vccd1 sky130_fd_sc_hd__tapvpwrvgnd_1
XFILLER_0_76_235 vssd1 vssd1 vccd1 vccd1 sky130_ef_sc_hd__decap_12
XFILLER_0_17_335 vssd1 vssd1 vccd1 vccd1 sky130_fd_sc_hd__fill_1
X_1829_ net511 net346 net383 vssd1 vssd1 vccd1 vccd1 _0296_ sky130_fd_sc_hd__mux2_1
XFILLER_0_82_249 vssd1 vssd1 vccd1 vccd1 sky130_fd_sc_hd__decap_3
XFILLER_0_67_279 vssd1 vssd1 vccd1 vccd1 sky130_fd_sc_hd__fill_1
XFILLER_0_35_176 vssd1 vssd1 vccd1 vccd1 sky130_ef_sc_hd__decap_12
XFILLER_0_35_110 vssd1 vssd1 vccd1 vccd1 sky130_fd_sc_hd__fill_2
XFILLER_0_50_179 vssd1 vssd1 vccd1 vccd1 sky130_ef_sc_hd__decap_12
XFILLER_0_31_393 vssd1 vssd1 vccd1 vccd1 sky130_ef_sc_hd__decap_12
XFILLER_0_31_371 vssd1 vssd1 vccd1 vccd1 sky130_ef_sc_hd__decap_12
X_0993_ net505 vssd1 vssd1 vccd1 vccd1 _0001_ sky130_fd_sc_hd__inv_2
X_1614_ spi_mem1.delayed_miso\[1\] _0982_ vssd1 vssd1 vccd1 vccd1 _0694_ sky130_fd_sc_hd__and2_2
XFILLER_0_41_113 vssd1 vssd1 vccd1 vccd1 sky130_ef_sc_hd__decap_12
XFILLER_0_26_187 vssd1 vssd1 vccd1 vccd1 sky130_fd_sc_hd__fill_1
XFILLER_0_14_305 vssd1 vssd1 vccd1 vccd1 sky130_fd_sc_hd__decap_3
XFILLER_0_66_85 vssd1 vssd1 vccd1 vccd1 sky130_fd_sc_hd__fill_2
XFILLER_0_66_74 vssd1 vssd1 vccd1 vccd1 sky130_fd_sc_hd__decap_8
XFILLER_0_67_7 vssd1 vssd1 vccd1 vccd1 sky130_fd_sc_hd__fill_1
X_1545_ net429 net430 vssd1 vssd1 vccd1 vccd1 _0634_ sky130_fd_sc_hd__and2b_1
X_1476_ _0570_ _0600_ _0580_ _0578_ vssd1 vssd1 vccd1 vccd1 _0601_ sky130_fd_sc_hd__o211a_1
XFILLER_0_22_393 vssd1 vssd1 vccd1 vccd1 sky130_fd_sc_hd__fill_1
XFILLER_0_82_73 vssd1 vssd1 vccd1 vccd1 sky130_fd_sc_hd__decap_4
X_2028_ clknet_leaf_23_clk_i _0054_ net481 vssd1 vssd1 vccd1 vccd1 spi_mem0.state\[3\]
+ sky130_fd_sc_hd__dfrtp_4
XFILLER_0_10_3 vssd1 vssd1 vccd1 vccd1 sky130_fd_sc_hd__decap_4
XFILLER_0_64_205 vssd1 vssd1 vccd1 vccd1 sky130_fd_sc_hd__decap_6
XFILLER_0_9_321 vssd1 vssd1 vccd1 vccd1 sky130_ef_sc_hd__decap_12
XFILLER_0_9_354 vssd1 vssd1 vccd1 vccd1 sky130_fd_sc_hd__decap_6
Xhold261 spi_mem0.data_buf\[14\] vssd1 vssd1 vccd1 vccd1 net765 sky130_fd_sc_hd__dlygate4sd3_1
Xhold272 _0055_ vssd1 vssd1 vccd1 vccd1 net776 sky130_fd_sc_hd__dlygate4sd3_1
Xhold294 spi_mem0.data_buf\[1\] vssd1 vssd1 vccd1 vccd1 net798 sky130_fd_sc_hd__dlygate4sd3_1
XFILLER_0_13_393 vssd1 vssd1 vccd1 vccd1 sky130_ef_sc_hd__decap_12
Xhold283 spi_mem2.data_buf\[9\] vssd1 vssd1 vccd1 vccd1 net787 sky130_fd_sc_hd__dlygate4sd3_1
Xhold250 net282 vssd1 vssd1 vccd1 vccd1 net754 sky130_fd_sc_hd__dlygate4sd3_1
XFILLER_0_55_249 vssd1 vssd1 vccd1 vccd1 sky130_fd_sc_hd__decap_8
XFILLER_0_11_319 vssd1 vssd1 vccd1 vccd1 sky130_fd_sc_hd__decap_4
X_1330_ net514 _0505_ _0506_ net373 vssd1 vssd1 vccd1 vccd1 _0106_ sky130_fd_sc_hd__a22o_1
X_1261_ net435 _0451_ _0454_ _0347_ vssd1 vssd1 vccd1 vccd1 _0455_ sky130_fd_sc_hd__o211a_1
Xinput7 spi1_dqsm_i vssd1 vssd1 vccd1 vccd1 net7 sky130_fd_sc_hd__clkbuf_1
X_1192_ net442 spi_mem0.data_ready _0342_ vssd1 vssd1 vccd1 vccd1 _0420_ sky130_fd_sc_hd__o21ai_1
XFILLER_0_36_33 vssd1 vssd1 vccd1 vccd1 sky130_fd_sc_hd__fill_1
XFILLER_0_46_216 vssd1 vssd1 vccd1 vccd1 sky130_ef_sc_hd__decap_12
XFILLER_0_77_40 vssd1 vssd1 vccd1 vccd1 sky130_ef_sc_hd__decap_12
XFILLER_0_58_3 vssd1 vssd1 vccd1 vccd1 sky130_fd_sc_hd__decap_6
Xoutput355 net355 vssd1 vssd1 vccd1 vccd1 sport2_o[3] sky130_fd_sc_hd__clkbuf_4
Xoutput344 net344 vssd1 vssd1 vccd1 vccd1 sport2_o[24] sky130_fd_sc_hd__clkbuf_4
Xoutput311 net311 vssd1 vssd1 vccd1 vccd1 sport1_o[25] sky130_fd_sc_hd__clkbuf_4
Xoutput333 net333 vssd1 vssd1 vccd1 vccd1 sport2_o[14] sky130_fd_sc_hd__clkbuf_4
XFILLER_0_10_330 vssd1 vssd1 vccd1 vccd1 sky130_ef_sc_hd__decap_12
Xoutput322 net322 vssd1 vssd1 vccd1 vccd1 sport1_o[4] sky130_fd_sc_hd__clkbuf_4
Xoutput300 net300 vssd1 vssd1 vccd1 vccd1 sport1_o[15] sky130_fd_sc_hd__clkbuf_4
X_1459_ net133 _0586_ vssd1 vssd1 vccd1 vccd1 _0589_ sky130_fd_sc_hd__xnor2_1
X_1528_ net780 net785 net385 vssd1 vssd1 vccd1 vccd1 _0181_ sky130_fd_sc_hd__mux2_1
XFILLER_0_77_385 vssd1 vssd1 vccd1 vccd1 sky130_fd_sc_hd__decap_6
XFILLER_0_77_363 vssd1 vssd1 vccd1 vccd1 sky130_fd_sc_hd__fill_2
XFILLER_0_37_205 vssd1 vssd1 vccd1 vccd1 sky130_ef_sc_hd__decap_12
XFILLER_0_9_184 vssd1 vssd1 vccd1 vccd1 sky130_fd_sc_hd__fill_1
XFILLER_0_20_138 vssd1 vssd1 vccd1 vccd1 sky130_fd_sc_hd__fill_2
XFILLER_0_20_149 vssd1 vssd1 vccd1 vccd1 sky130_fd_sc_hd__decap_3
XPHY_91 vssd1 vssd1 vccd1 vccd1 sky130_fd_sc_hd__decap_3
XPHY_80 vssd1 vssd1 vccd1 vccd1 sky130_fd_sc_hd__decap_3
XFILLER_0_51_274 vssd1 vssd1 vccd1 vccd1 sky130_fd_sc_hd__fill_1
X_2293_ clknet_leaf_12_clk_i _0306_ net477 vssd1 vssd1 vccd1 vccd1 spi_mem1.data_ready
+ sky130_fd_sc_hd__dfrtp_1
XFILLER_0_47_65 vssd1 vssd1 vccd1 vccd1 sky130_fd_sc_hd__decap_4
XFILLER_0_47_54 vssd1 vssd1 vccd1 vccd1 sky130_fd_sc_hd__fill_2
X_1313_ net82 net416 _0488_ _0492_ vssd1 vssd1 vccd1 vccd1 _0496_ sky130_fd_sc_hd__a22o_1
X_1244_ spi_mem0.data_buf\[17\] _0349_ _0426_ spi_mem0.data_buf\[29\] vssd1 vssd1
+ vccd1 vccd1 _0439_ sky130_fd_sc_hd__a22o_1
XFILLER_0_78_105 vssd1 vssd1 vccd1 vccd1 sky130_fd_sc_hd__fill_2
XFILLER_0_63_31 vssd1 vssd1 vccd1 vccd1 sky130_ef_sc_hd__decap_12
XFILLER_0_59_385 vssd1 vssd1 vccd1 vccd1 sky130_fd_sc_hd__decap_6
X_1175_ net435 net437 vssd1 vssd1 vccd1 vccd1 _0407_ sky130_fd_sc_hd__nand2_1
XFILLER_0_2_89 vssd1 vssd1 vccd1 vccd1 sky130_fd_sc_hd__fill_1
XFILLER_0_74_399 vssd1 vssd1 vccd1 vccd1 sky130_fd_sc_hd__decap_8
Xclkbuf_leaf_8_clk_i clknet_2_2__leaf_clk_i vssd1 vssd1 vccd1 vccd1 clknet_leaf_8_clk_i
+ sky130_fd_sc_hd__clkbuf_16
XFILLER_0_42_241 vssd1 vssd1 vccd1 vccd1 sky130_fd_sc_hd__decap_4
XFILLER_0_34_208 vssd1 vssd1 vccd1 vccd1 sky130_fd_sc_hd__fill_1
XFILLER_0_27_293 vssd1 vssd1 vccd1 vccd1 sky130_ef_sc_hd__decap_12
XFILLER_0_77_193 vssd1 vssd1 vccd1 vccd1 sky130_fd_sc_hd__decap_8
XFILLER_0_25_219 vssd1 vssd1 vccd1 vccd1 sky130_fd_sc_hd__decap_4
XFILLER_0_33_241 vssd1 vssd1 vccd1 vccd1 sky130_fd_sc_hd__fill_2
XTAP_609 vssd1 vccd1 sky130_fd_sc_hd__tapvpwrvgnd_1
Xfanout390 net391 vssd1 vssd1 vccd1 vccd1 net390 sky130_fd_sc_hd__buf_4
XFILLER_0_75_108 vssd1 vssd1 vccd1 vccd1 sky130_fd_sc_hd__decap_4
XFILLER_0_33_34 vssd1 vssd1 vccd1 vccd1 sky130_fd_sc_hd__fill_1
XFILLER_0_17_57 vssd1 vssd1 vccd1 vccd1 sky130_fd_sc_hd__decap_3
Xinput10 spi1_miso_i[2] vssd1 vssd1 vccd1 vccd1 net10 sky130_fd_sc_hd__clkbuf_1
XFILLER_0_71_314 vssd1 vssd1 vccd1 vccd1 sky130_fd_sc_hd__decap_8
X_1793_ net427 _0966_ _0809_ vssd1 vssd1 vccd1 vccd1 _0810_ sky130_fd_sc_hd__a21oi_1
X_1862_ _0740_ _0839_ _0841_ _0355_ net210 vssd1 vssd1 vccd1 vccd1 _0842_ sky130_fd_sc_hd__a32o_1
Xinput21 sport0_i[13] vssd1 vssd1 vccd1 vccd1 net21 sky130_fd_sc_hd__buf_1
Xinput43 sport0_i[33] vssd1 vssd1 vccd1 vccd1 net43 sky130_fd_sc_hd__clkbuf_1
Xinput54 sport0_i[43] vssd1 vssd1 vccd1 vccd1 net54 sky130_fd_sc_hd__buf_1
X_1931_ _0968_ _0891_ net366 vssd1 vssd1 vccd1 vccd1 _0892_ sky130_fd_sc_hd__o21ai_2
Xinput32 sport0_i[23] vssd1 vssd1 vccd1 vccd1 net32 sky130_fd_sc_hd__buf_1
Xinput65 sport0_i[53] vssd1 vssd1 vccd1 vccd1 net65 sky130_fd_sc_hd__buf_1
Xinput76 sport0_i[63] vssd1 vssd1 vccd1 vccd1 net76 sky130_fd_sc_hd__clkbuf_1
Xinput87 sport1_i[10] vssd1 vssd1 vccd1 vccd1 net87 sky130_fd_sc_hd__dlymetal6s2s_1
Xinput98 sport1_i[20] vssd1 vssd1 vccd1 vccd1 net98 sky130_fd_sc_hd__dlymetal6s2s_1
XFILLER_0_74_85 vssd1 vssd1 vccd1 vccd1 sky130_ef_sc_hd__decap_12
X_1227_ net439 net437 vssd1 vssd1 vccd1 vccd1 _0423_ sky130_fd_sc_hd__and2b_2
X_1158_ spi_mem0.address_nibble\[0\] _0928_ vssd1 vssd1 vccd1 vccd1 _0392_ sky130_fd_sc_hd__and2_2
X_2276_ clknet_leaf_37_clk_i net633 net448 vssd1 vssd1 vccd1 vccd1 net340 sky130_fd_sc_hd__dfrtp_1
XFILLER_0_74_163 vssd1 vssd1 vccd1 vccd1 sky130_fd_sc_hd__fill_1
X_1089_ net425 net216 _0973_ _0352_ vssd1 vssd1 vccd1 vccd1 _0354_ sky130_fd_sc_hd__or4_2
XFILLER_0_30_299 vssd1 vssd1 vccd1 vccd1 sky130_fd_sc_hd__decap_8
X_1988__12 clknet_leaf_17_clk_i vssd1 vssd1 vccd1 vccd1 net501 sky130_fd_sc_hd__inv_2
XFILLER_0_65_152 vssd1 vssd1 vccd1 vccd1 sky130_ef_sc_hd__decap_12
XTAP_439 vssd1 vccd1 sky130_fd_sc_hd__tapvpwrvgnd_1
XTAP_428 vssd1 vccd1 sky130_fd_sc_hd__tapvpwrvgnd_1
XTAP_417 vssd1 vccd1 sky130_fd_sc_hd__tapvpwrvgnd_1
XTAP_406 vssd1 vccd1 sky130_fd_sc_hd__tapvpwrvgnd_1
XFILLER_0_28_23 vssd1 vssd1 vccd1 vccd1 sky130_fd_sc_hd__decap_4
X_1012_ net432 net433 vssd1 vssd1 vccd1 vccd1 _0940_ sky130_fd_sc_hd__nand2_1
X_2130_ clknet_leaf_21_clk_i _0150_ net481 vssd1 vssd1 vccd1 vccd1 spi_mem1.address\[17\]
+ sky130_fd_sc_hd__dfrtp_1
X_2061_ clknet_leaf_5_clk_i _0984_ net471 vssd1 vssd1 vccd1 vccd1 net286 sky130_fd_sc_hd__dfrtp_1
X_1914_ net210 net403 _0873_ _0879_ vssd1 vssd1 vccd1 vccd1 _0882_ sky130_fd_sc_hd__a22o_1
XFILLER_0_71_111 vssd1 vssd1 vccd1 vccd1 sky130_fd_sc_hd__fill_1
XFILLER_0_56_185 vssd1 vssd1 vccd1 vccd1 sky130_fd_sc_hd__decap_3
X_1776_ net203 net202 _0792_ vssd1 vssd1 vccd1 vccd1 _0793_ sky130_fd_sc_hd__nand3_1
XFILLER_0_8_44 vssd1 vssd1 vccd1 vccd1 sky130_fd_sc_hd__decap_4
XFILLER_0_12_244 vssd1 vssd1 vccd1 vccd1 sky130_fd_sc_hd__decap_8
X_1845_ spi_mem2.address\[9\] spi_mem2.address\[13\] spi_mem2.address\[17\] spi_mem2.address\[21\]
+ spi_mem2.address_nibble\[0\] spi_mem2.address_nibble\[1\] vssd1 vssd1 vccd1 vccd1
+ _0826_ sky130_fd_sc_hd__mux4_1
Xclkbuf_leaf_11_clk_i clknet_2_2__leaf_clk_i vssd1 vssd1 vccd1 vccd1 clknet_leaf_11_clk_i
+ sky130_fd_sc_hd__clkbuf_16
XFILLER_0_40_3 vssd1 vssd1 vccd1 vccd1 sky130_fd_sc_hd__decap_4
Xclkbuf_leaf_26_clk_i clknet_2_1__leaf_clk_i vssd1 vssd1 vccd1 vccd1 clknet_leaf_26_clk_i
+ sky130_fd_sc_hd__clkbuf_16
X_2328_ clknet_leaf_32_clk_i _0336_ net458 vssd1 vssd1 vccd1 vccd1 spi_mem2.data_buf\[26\]
+ sky130_fd_sc_hd__dfrtp_1
XFILLER_0_39_108 vssd1 vssd1 vccd1 vccd1 sky130_fd_sc_hd__decap_4
X_2259_ clknet_leaf_39_clk_i net635 net444 vssd1 vssd1 vccd1 vccd1 net355 sky130_fd_sc_hd__dfrtp_1
XFILLER_0_35_325 vssd1 vssd1 vccd1 vccd1 sky130_fd_sc_hd__fill_2
Xinput200 sport2_i[50] vssd1 vssd1 vccd1 vccd1 net200 sky130_fd_sc_hd__clkbuf_2
Xinput222 sport2_i[8] vssd1 vssd1 vccd1 vccd1 net222 sky130_fd_sc_hd__clkbuf_1
Xinput211 sport2_i[60] vssd1 vssd1 vccd1 vccd1 net211 sky130_fd_sc_hd__clkbuf_1
XFILLER_0_14_25 vssd1 vssd1 vccd1 vccd1 sky130_fd_sc_hd__decap_3
X_1630_ net694 _0701_ _0704_ net367 vssd1 vssd1 vccd1 vccd1 _0208_ sky130_fd_sc_hd__a22o_1
XFILLER_0_30_79 vssd1 vssd1 vccd1 vccd1 sky130_fd_sc_hd__decap_4
X_1492_ _0977_ _0616_ _0982_ vssd1 vssd1 vccd1 vccd1 _0617_ sky130_fd_sc_hd__a21o_1
X_1561_ spi_mem1.data_buf\[17\] _0978_ _0634_ spi_mem1.data_buf\[21\] _0648_ vssd1
+ vssd1 vccd1 vccd1 _0649_ sky130_fd_sc_hd__a221o_1
XFILLER_0_39_77 vssd1 vssd1 vccd1 vccd1 sky130_fd_sc_hd__decap_3
XTAP_203 vssd1 vccd1 sky130_fd_sc_hd__tapvpwrvgnd_1
XTAP_214 vssd1 vccd1 sky130_fd_sc_hd__tapvpwrvgnd_1
XTAP_225 vssd1 vccd1 sky130_fd_sc_hd__tapvpwrvgnd_1
XTAP_236 vssd1 vccd1 sky130_fd_sc_hd__tapvpwrvgnd_1
XTAP_247 vssd1 vccd1 sky130_fd_sc_hd__tapvpwrvgnd_1
XTAP_258 vssd1 vccd1 sky130_fd_sc_hd__tapvpwrvgnd_1
XTAP_269 vssd1 vccd1 sky130_fd_sc_hd__tapvpwrvgnd_1
XFILLER_0_76_214 vssd1 vssd1 vccd1 vccd1 sky130_ef_sc_hd__decap_12
XFILLER_0_76_203 vssd1 vssd1 vccd1 vccd1 sky130_fd_sc_hd__fill_2
X_2113_ clknet_leaf_16_clk_i _0133_ net479 vssd1 vssd1 vccd1 vccd1 spi_mem1.address\[0\]
+ sky130_fd_sc_hd__dfrtp_1
X_2044_ clknet_leaf_7_clk_i _0070_ net467 vssd1 vssd1 vccd1 vccd1 net266 sky130_fd_sc_hd__dfrtp_1
XFILLER_0_76_247 vssd1 vssd1 vccd1 vccd1 sky130_fd_sc_hd__decap_4
XFILLER_0_17_314 vssd1 vssd1 vccd1 vccd1 sky130_fd_sc_hd__decap_3
XFILLER_0_17_347 vssd1 vssd1 vccd1 vccd1 sky130_ef_sc_hd__decap_12
XFILLER_0_44_188 vssd1 vssd1 vccd1 vccd1 sky130_fd_sc_hd__decap_8
XFILLER_0_25_391 vssd1 vssd1 vccd1 vccd1 sky130_fd_sc_hd__fill_1
X_1759_ net200 net201 _0777_ net406 vssd1 vssd1 vccd1 vccd1 _0782_ sky130_fd_sc_hd__o31a_1
X_1828_ net553 net345 net381 vssd1 vssd1 vccd1 vccd1 _0295_ sky130_fd_sc_hd__mux2_1
XFILLER_0_67_225 vssd1 vssd1 vccd1 vccd1 sky130_fd_sc_hd__fill_2
XFILLER_0_82_228 vssd1 vssd1 vccd1 vccd1 sky130_fd_sc_hd__fill_2
XFILLER_0_35_188 vssd1 vssd1 vccd1 vccd1 sky130_ef_sc_hd__decap_12
XFILLER_0_23_306 vssd1 vssd1 vccd1 vccd1 sky130_ef_sc_hd__decap_12
XFILLER_0_31_361 vssd1 vssd1 vccd1 vccd1 sky130_fd_sc_hd__decap_3
XFILLER_0_25_57 vssd1 vssd1 vccd1 vccd1 sky130_ef_sc_hd__decap_12
XFILLER_0_73_239 vssd1 vssd1 vccd1 vccd1 sky130_fd_sc_hd__decap_4
XFILLER_0_41_45 vssd1 vssd1 vccd1 vccd1 sky130_fd_sc_hd__fill_1
X_0992_ net190 vssd1 vssd1 vccd1 vccd1 _0922_ sky130_fd_sc_hd__inv_2
X_1544_ net430 net429 vssd1 vssd1 vccd1 vccd1 _0633_ sky130_fd_sc_hd__and2b_1
X_1613_ net737 _0691_ _0693_ net367 vssd1 vssd1 vccd1 vccd1 _0202_ sky130_fd_sc_hd__a22o_1
XFILLER_0_41_125 vssd1 vssd1 vccd1 vccd1 sky130_ef_sc_hd__decap_12
XFILLER_0_1_222 vssd1 vssd1 vccd1 vccd1 sky130_fd_sc_hd__fill_2
XFILLER_0_66_53 vssd1 vssd1 vccd1 vccd1 sky130_fd_sc_hd__fill_1
X_1475_ _0566_ _0599_ _0574_ _0567_ vssd1 vssd1 vccd1 vccd1 _0600_ sky130_fd_sc_hd__a211o_1
XFILLER_0_5_23 vssd1 vssd1 vccd1 vccd1 sky130_fd_sc_hd__decap_4
XFILLER_0_82_85 vssd1 vssd1 vccd1 vccd1 sky130_fd_sc_hd__fill_1
XFILLER_0_49_269 vssd1 vssd1 vccd1 vccd1 sky130_fd_sc_hd__decap_4
XFILLER_0_49_225 vssd1 vssd1 vccd1 vccd1 sky130_fd_sc_hd__decap_4
X_2027_ clknet_leaf_23_clk_i _0053_ net481 vssd1 vssd1 vccd1 vccd1 spi_mem0.state\[2\]
+ sky130_fd_sc_hd__dfrtp_2
XFILLER_0_9_333 vssd1 vssd1 vccd1 vccd1 sky130_fd_sc_hd__decap_3
XFILLER_0_72_261 vssd1 vssd1 vccd1 vccd1 sky130_fd_sc_hd__decap_3
XFILLER_0_17_111 vssd1 vssd1 vccd1 vccd1 sky130_fd_sc_hd__fill_1
Xhold240 _0186_ vssd1 vssd1 vccd1 vccd1 net744 sky130_fd_sc_hd__dlygate4sd3_1
Xhold295 net255 vssd1 vssd1 vccd1 vccd1 net799 sky130_fd_sc_hd__dlygate4sd3_1
Xhold273 spi_mem1.data_buf\[14\] vssd1 vssd1 vccd1 vccd1 net777 sky130_fd_sc_hd__dlygate4sd3_1
Xhold262 spi_mem0.data_buf\[17\] vssd1 vssd1 vccd1 vccd1 net766 sky130_fd_sc_hd__dlygate4sd3_1
Xhold284 spi_mem2.data_buf\[16\] vssd1 vssd1 vccd1 vccd1 net788 sky130_fd_sc_hd__dlygate4sd3_1
Xhold251 spi_mem2.data_buf\[7\] vssd1 vssd1 vccd1 vccd1 net755 sky130_fd_sc_hd__dlygate4sd3_1
Xinput8 spi1_miso_i[0] vssd1 vssd1 vccd1 vccd1 net8 sky130_fd_sc_hd__clkbuf_1
X_1191_ spi_mem0.state\[3\] _0419_ net378 vssd1 vssd1 vccd1 vccd1 _0054_ sky130_fd_sc_hd__mux2_1
XFILLER_0_36_23 vssd1 vssd1 vccd1 vccd1 sky130_fd_sc_hd__decap_4
X_1260_ spi_mem0.data_buf\[30\] _0426_ _0452_ _0453_ vssd1 vssd1 vccd1 vccd1 _0454_
+ sky130_fd_sc_hd__a211o_1
XFILLER_0_78_309 vssd1 vssd1 vccd1 vccd1 sky130_fd_sc_hd__decap_4
XFILLER_0_54_250 vssd1 vssd1 vccd1 vccd1 sky130_fd_sc_hd__fill_2
XFILLER_0_46_228 vssd1 vssd1 vccd1 vccd1 sky130_ef_sc_hd__decap_12
XFILLER_0_42_401 vssd1 vssd1 vccd1 vccd1 sky130_fd_sc_hd__decap_6
XFILLER_0_77_52 vssd1 vssd1 vccd1 vccd1 sky130_fd_sc_hd__decap_4
X_1527_ net526 net303 net385 vssd1 vssd1 vccd1 vccd1 _0180_ sky130_fd_sc_hd__mux2_1
Xoutput323 net323 vssd1 vssd1 vccd1 vccd1 sport1_o[5] sky130_fd_sc_hd__clkbuf_4
Xoutput345 net345 vssd1 vssd1 vccd1 vccd1 sport2_o[25] sky130_fd_sc_hd__clkbuf_4
Xoutput312 net312 vssd1 vssd1 vccd1 vccd1 sport1_o[26] sky130_fd_sc_hd__clkbuf_4
Xoutput334 net334 vssd1 vssd1 vccd1 vccd1 sport2_o[15] sky130_fd_sc_hd__clkbuf_4
Xoutput356 net356 vssd1 vssd1 vccd1 vccd1 sport2_o[4] sky130_fd_sc_hd__clkbuf_4
XFILLER_0_10_342 vssd1 vssd1 vccd1 vccd1 sky130_ef_sc_hd__decap_12
Xoutput301 net301 vssd1 vssd1 vccd1 vccd1 sport1_o[16] sky130_fd_sc_hd__clkbuf_4
X_1389_ spi_mem1.address_nibble\[1\] spi_mem1.address_nibble\[0\] vssd1 vssd1 vccd1
+ vccd1 _0545_ sky130_fd_sc_hd__nor2_2
X_1458_ net129 _0579_ _0585_ net133 vssd1 vssd1 vccd1 vccd1 _0588_ sky130_fd_sc_hd__o211a_1
XFILLER_0_37_217 vssd1 vssd1 vccd1 vccd1 sky130_fd_sc_hd__decap_6
XFILLER_0_9_163 vssd1 vssd1 vccd1 vccd1 sky130_fd_sc_hd__fill_1
XFILLER_0_60_231 vssd1 vssd1 vccd1 vccd1 sky130_ef_sc_hd__decap_12
XFILLER_0_45_261 vssd1 vssd1 vccd1 vccd1 sky130_fd_sc_hd__decap_3
XPHY_92 vssd1 vssd1 vccd1 vccd1 sky130_fd_sc_hd__decap_3
XPHY_81 vssd1 vssd1 vccd1 vccd1 sky130_fd_sc_hd__decap_3
XFILLER_0_36_250 vssd1 vssd1 vccd1 vccd1 sky130_fd_sc_hd__fill_2
XPHY_70 vssd1 vssd1 vccd1 vccd1 sky130_fd_sc_hd__decap_3
X_2292_ clknet_leaf_21_clk_i _0305_ net482 vssd1 vssd1 vccd1 vccd1 net255 sky130_fd_sc_hd__dfrtp_1
XFILLER_0_47_99 vssd1 vssd1 vccd1 vccd1 sky130_ef_sc_hd__decap_12
X_1174_ net393 _0348_ vssd1 vssd1 vccd1 vccd1 _0406_ sky130_fd_sc_hd__nand2_1
X_1312_ net730 _0493_ _0495_ net372 vssd1 vssd1 vccd1 vccd1 _0099_ sky130_fd_sc_hd__a22o_1
X_1243_ spi_mem0.data_buf\[25\] _0423_ net435 vssd1 vssd1 vccd1 vccd1 _0438_ sky130_fd_sc_hd__a21bo_1
XFILLER_0_63_43 vssd1 vssd1 vccd1 vccd1 sky130_fd_sc_hd__decap_8
XFILLER_0_59_320 vssd1 vssd1 vccd1 vccd1 sky130_fd_sc_hd__decap_4
XFILLER_0_70_3 vssd1 vssd1 vccd1 vccd1 sky130_ef_sc_hd__decap_12
XFILLER_0_10_194 vssd1 vssd1 vccd1 vccd1 sky130_fd_sc_hd__fill_2
XFILLER_0_0_309 vssd1 vssd1 vccd1 vccd1 sky130_fd_sc_hd__fill_2
Xfanout391 _0420_ vssd1 vssd1 vccd1 vccd1 net391 sky130_fd_sc_hd__clkbuf_2
Xfanout380 net382 vssd1 vssd1 vccd1 vccd1 net380 sky130_fd_sc_hd__clkbuf_4
XFILLER_0_68_150 vssd1 vssd1 vccd1 vccd1 sky130_fd_sc_hd__decap_8
X_1930_ net423 _0927_ net420 vssd1 vssd1 vccd1 vccd1 _0891_ sky130_fd_sc_hd__and3_2
Xinput11 spi1_miso_i[3] vssd1 vssd1 vccd1 vccd1 net11 sky130_fd_sc_hd__clkbuf_1
XFILLER_0_71_337 vssd1 vssd1 vccd1 vccd1 sky130_fd_sc_hd__decap_4
X_1792_ _0957_ net250 vssd1 vssd1 vccd1 vccd1 _0809_ sky130_fd_sc_hd__nor2_1
X_1861_ spi_mem2.address\[0\] _0824_ _0840_ spi_mem2.address_nibble\[1\] spi_mem2.address_nibble\[2\]
+ vssd1 vssd1 vccd1 vccd1 _0841_ sky130_fd_sc_hd__a221o_1
Xinput66 sport0_i[54] vssd1 vssd1 vccd1 vccd1 net66 sky130_fd_sc_hd__clkbuf_1
XFILLER_0_3_125 vssd1 vssd1 vccd1 vccd1 sky130_fd_sc_hd__fill_2
Xinput88 sport1_i[11] vssd1 vssd1 vccd1 vccd1 net88 sky130_fd_sc_hd__dlymetal6s2s_1
Xinput77 sport0_i[64] vssd1 vssd1 vccd1 vccd1 net77 sky130_fd_sc_hd__dlymetal6s2s_1
Xinput33 sport0_i[24] vssd1 vssd1 vccd1 vccd1 net33 sky130_fd_sc_hd__buf_1
Xinput44 sport0_i[34] vssd1 vssd1 vccd1 vccd1 net44 sky130_fd_sc_hd__buf_1
Xinput55 sport0_i[44] vssd1 vssd1 vccd1 vccd1 net55 sky130_fd_sc_hd__buf_1
Xinput22 sport0_i[14] vssd1 vssd1 vccd1 vccd1 net22 sky130_fd_sc_hd__buf_1
XFILLER_0_12_404 vssd1 vssd1 vccd1 vccd1 sky130_fd_sc_hd__decap_3
XFILLER_0_16_209 vssd1 vssd1 vccd1 vccd1 sky130_ef_sc_hd__decap_12
Xinput99 sport1_i[21] vssd1 vssd1 vccd1 vccd1 net99 sky130_fd_sc_hd__dlymetal6s2s_1
XFILLER_0_74_97 vssd1 vssd1 vccd1 vccd1 sky130_ef_sc_hd__decap_12
X_1226_ net409 _0421_ _0405_ vssd1 vssd1 vccd1 vccd1 _0422_ sky130_fd_sc_hd__a21o_2
X_1157_ _0391_ vssd1 vssd1 vccd1 vccd1 _0048_ sky130_fd_sc_hd__inv_2
X_2275_ clknet_leaf_38_clk_i net623 net448 vssd1 vssd1 vccd1 vccd1 net338 sky130_fd_sc_hd__dfrtp_1
XFILLER_0_74_197 vssd1 vssd1 vccd1 vccd1 sky130_fd_sc_hd__decap_6
XFILLER_0_62_304 vssd1 vssd1 vccd1 vccd1 sky130_fd_sc_hd__decap_4
X_1088_ net425 _0352_ vssd1 vssd1 vccd1 vccd1 _0353_ sky130_fd_sc_hd__nor2_2
XFILLER_0_15_231 vssd1 vssd1 vccd1 vccd1 sky130_fd_sc_hd__decap_3
XFILLER_0_15_242 vssd1 vssd1 vccd1 vccd1 sky130_fd_sc_hd__decap_6
XFILLER_0_65_131 vssd1 vssd1 vccd1 vccd1 sky130_fd_sc_hd__fill_1
XFILLER_0_80_189 vssd1 vssd1 vccd1 vccd1 sky130_fd_sc_hd__decap_4
XFILLER_0_65_197 vssd1 vssd1 vccd1 vccd1 sky130_ef_sc_hd__decap_12
XFILLER_0_65_164 vssd1 vssd1 vccd1 vccd1 sky130_fd_sc_hd__decap_4
XFILLER_0_61_370 vssd1 vssd1 vccd1 vccd1 sky130_ef_sc_hd__decap_12
XFILLER_0_53_337 vssd1 vssd1 vccd1 vccd1 sky130_ef_sc_hd__decap_12
XFILLER_0_21_201 vssd1 vssd1 vccd1 vccd1 sky130_ef_sc_hd__decap_12
XTAP_429 vssd1 vccd1 sky130_fd_sc_hd__tapvpwrvgnd_1
XTAP_418 vssd1 vccd1 sky130_fd_sc_hd__tapvpwrvgnd_1
XTAP_407 vssd1 vccd1 sky130_fd_sc_hd__tapvpwrvgnd_1
XFILLER_0_28_57 vssd1 vssd1 vccd1 vccd1 sky130_fd_sc_hd__decap_8
X_1011_ net432 net434 vssd1 vssd1 vccd1 vccd1 _0939_ sky130_fd_sc_hd__and2_2
Xclkbuf_leaf_7_clk_i clknet_2_2__leaf_clk_i vssd1 vssd1 vccd1 vccd1 clknet_leaf_7_clk_i
+ sky130_fd_sc_hd__clkbuf_16
X_2060_ clknet_leaf_35_clk_i net649 net454 vssd1 vssd1 vccd1 vccd1 net284 sky130_fd_sc_hd__dfrtp_1
XFILLER_0_56_197 vssd1 vssd1 vccd1 vccd1 sky130_fd_sc_hd__decap_4
XFILLER_0_44_304 vssd1 vssd1 vccd1 vccd1 sky130_fd_sc_hd__decap_4
XFILLER_0_8_228 vssd1 vssd1 vccd1 vccd1 sky130_ef_sc_hd__decap_12
X_1913_ net789 _0880_ _0881_ net362 vssd1 vssd1 vccd1 vccd1 _0314_ sky130_fd_sc_hd__a22o_1
XFILLER_0_71_167 vssd1 vssd1 vccd1 vccd1 sky130_fd_sc_hd__fill_1
Xmax_cap377 net378 vssd1 vssd1 vccd1 vccd1 net377 sky130_fd_sc_hd__buf_1
X_1775_ net200 net198 net197 _0791_ net201 vssd1 vssd1 vccd1 vccd1 _0792_ sky130_fd_sc_hd__a41o_1
XFILLER_0_12_212 vssd1 vssd1 vccd1 vccd1 sky130_fd_sc_hd__fill_1
X_1844_ spi_mem2.address\[3\] spi_mem2.address\[7\] spi_mem2.address_nibble\[0\] vssd1
+ vssd1 vccd1 vccd1 _0825_ sky130_fd_sc_hd__mux2_1
XFILLER_0_33_3 vssd1 vssd1 vccd1 vccd1 sky130_fd_sc_hd__decap_4
X_2258_ clknet_leaf_0_clk_i net608 net444 vssd1 vssd1 vccd1 vccd1 net350 sky130_fd_sc_hd__dfrtp_1
X_2327_ clknet_leaf_32_clk_i _0335_ net458 vssd1 vssd1 vccd1 vccd1 spi_mem2.data_buf\[25\]
+ sky130_fd_sc_hd__dfrtp_1
X_2189_ clknet_leaf_6_clk_i _0203_ net472 vssd1 vssd1 vccd1 vccd1 spi_mem1.data_buf\[1\]
+ sky130_fd_sc_hd__dfrtp_1
X_1209_ net683 net267 net388 vssd1 vssd1 vccd1 vccd1 _0071_ sky130_fd_sc_hd__mux2_1
Xinput201 sport2_i[51] vssd1 vssd1 vccd1 vccd1 net201 sky130_fd_sc_hd__clkbuf_2
Xinput212 sport2_i[61] vssd1 vssd1 vccd1 vccd1 net212 sky130_fd_sc_hd__clkbuf_1
Xinput223 sport2_i[9] vssd1 vssd1 vccd1 vccd1 net223 sky130_fd_sc_hd__clkbuf_1
X_1560_ net431 net428 spi_mem1.data_buf\[29\] vssd1 vssd1 vccd1 vccd1 _0648_ sky130_fd_sc_hd__and3_1
XFILLER_0_41_318 vssd1 vssd1 vccd1 vccd1 sky130_fd_sc_hd__fill_1
X_2112_ clknet_leaf_11_clk_i _0132_ net475 vssd1 vssd1 vccd1 vccd1 spi_mem1.latency\[5\]
+ sky130_fd_sc_hd__dfrtp_1
X_1491_ net148 net149 spi_mem1.data_nibble vssd1 vssd1 vccd1 vccd1 _0616_ sky130_fd_sc_hd__a21oi_1
XTAP_204 vssd1 vccd1 sky130_fd_sc_hd__tapvpwrvgnd_1
XTAP_215 vssd1 vccd1 sky130_fd_sc_hd__tapvpwrvgnd_1
XTAP_226 vssd1 vccd1 sky130_fd_sc_hd__tapvpwrvgnd_1
XTAP_237 vssd1 vccd1 sky130_fd_sc_hd__tapvpwrvgnd_1
XTAP_248 vssd1 vccd1 sky130_fd_sc_hd__tapvpwrvgnd_1
XTAP_259 vssd1 vccd1 sky130_fd_sc_hd__tapvpwrvgnd_1
XFILLER_0_76_226 vssd1 vssd1 vccd1 vccd1 sky130_fd_sc_hd__decap_4
X_2043_ clknet_leaf_2_clk_i _0069_ net453 vssd1 vssd1 vccd1 vccd1 net265 sky130_fd_sc_hd__dfrtp_1
XFILLER_0_44_167 vssd1 vssd1 vccd1 vccd1 sky130_fd_sc_hd__fill_1
XFILLER_0_32_307 vssd1 vssd1 vccd1 vccd1 sky130_fd_sc_hd__fill_1
XFILLER_0_29_164 vssd1 vssd1 vccd1 vccd1 sky130_fd_sc_hd__decap_4
X_1827_ spi_mem2.data_buf\[24\] net569 net380 vssd1 vssd1 vccd1 vccd1 _0294_ sky130_fd_sc_hd__mux2_1
XFILLER_0_17_337 vssd1 vssd1 vccd1 vccd1 sky130_fd_sc_hd__fill_2
XFILLER_0_17_359 vssd1 vssd1 vccd1 vccd1 sky130_fd_sc_hd__fill_1
X_1689_ net110 net399 _0698_ _0734_ vssd1 vssd1 vccd1 vccd1 _0739_ sky130_fd_sc_hd__a22o_1
XFILLER_0_40_373 vssd1 vssd1 vccd1 vccd1 sky130_fd_sc_hd__fill_2
XFILLER_0_40_362 vssd1 vssd1 vccd1 vccd1 sky130_fd_sc_hd__fill_2
X_1758_ net200 _0777_ net201 vssd1 vssd1 vccd1 vccd1 _0781_ sky130_fd_sc_hd__o21ai_1
XTAP_760 vssd1 vccd1 sky130_fd_sc_hd__tapvpwrvgnd_1
XFILLER_0_75_281 vssd1 vssd1 vccd1 vccd1 sky130_fd_sc_hd__decap_6
XFILLER_0_75_270 vssd1 vssd1 vccd1 vccd1 sky130_fd_sc_hd__fill_1
XFILLER_0_50_159 vssd1 vssd1 vccd1 vccd1 sky130_fd_sc_hd__fill_1
XFILLER_0_35_156 vssd1 vssd1 vccd1 vccd1 sky130_fd_sc_hd__fill_1
XFILLER_0_23_318 vssd1 vssd1 vccd1 vccd1 sky130_fd_sc_hd__decap_6
Xclkbuf_leaf_10_clk_i clknet_2_2__leaf_clk_i vssd1 vssd1 vccd1 vccd1 clknet_leaf_10_clk_i
+ sky130_fd_sc_hd__clkbuf_16
XFILLER_0_25_69 vssd1 vssd1 vccd1 vccd1 sky130_ef_sc_hd__decap_12
XFILLER_0_81_262 vssd1 vssd1 vccd1 vccd1 sky130_ef_sc_hd__decap_12
XFILLER_0_81_251 vssd1 vssd1 vccd1 vccd1 sky130_fd_sc_hd__decap_8
XFILLER_0_73_207 vssd1 vssd1 vccd1 vccd1 sky130_fd_sc_hd__fill_2
X_0991_ net729 vssd1 vssd1 vccd1 vccd1 _0000_ sky130_fd_sc_hd__inv_2
XFILLER_0_41_24 vssd1 vssd1 vccd1 vccd1 sky130_fd_sc_hd__decap_8
Xclkbuf_leaf_25_clk_i clknet_2_1__leaf_clk_i vssd1 vssd1 vccd1 vccd1 clknet_leaf_25_clk_i
+ sky130_fd_sc_hd__clkbuf_16
X_1543_ net411 _0631_ _0630_ _0542_ vssd1 vssd1 vccd1 vccd1 _0632_ sky130_fd_sc_hd__a211o_2
X_1474_ _0924_ net122 net121 vssd1 vssd1 vccd1 vccd1 _0599_ sky130_fd_sc_hd__or3_1
X_1612_ net86 net396 _0690_ _0692_ vssd1 vssd1 vccd1 vccd1 _0693_ sky130_fd_sc_hd__a22o_1
XFILLER_0_41_137 vssd1 vssd1 vccd1 vccd1 sky130_ef_sc_hd__decap_12
XFILLER_0_22_351 vssd1 vssd1 vccd1 vccd1 sky130_fd_sc_hd__fill_1
XFILLER_0_82_20 vssd1 vssd1 vccd1 vccd1 sky130_fd_sc_hd__fill_2
XFILLER_0_5_46 vssd1 vssd1 vccd1 vccd1 sky130_fd_sc_hd__decap_3
XFILLER_0_57_281 vssd1 vssd1 vccd1 vccd1 sky130_fd_sc_hd__decap_4
X_2026_ clknet_leaf_23_clk_i _0052_ net479 vssd1 vssd1 vccd1 vccd1 spi_mem0.state\[1\]
+ sky130_fd_sc_hd__dfrtp_4
XFILLER_0_32_148 vssd1 vssd1 vccd1 vccd1 sky130_ef_sc_hd__decap_12
XFILLER_0_9_389 vssd1 vssd1 vccd1 vccd1 sky130_fd_sc_hd__decap_3
XFILLER_0_17_145 vssd1 vssd1 vccd1 vccd1 sky130_fd_sc_hd__decap_4
Xhold241 net229 vssd1 vssd1 vccd1 vccd1 net745 sky130_fd_sc_hd__dlygate4sd3_1
Xhold274 spi_mem1.data_buf\[5\] vssd1 vssd1 vccd1 vccd1 net778 sky130_fd_sc_hd__dlygate4sd3_1
Xhold252 spi_mem2.data_buf\[10\] vssd1 vssd1 vccd1 vccd1 net756 sky130_fd_sc_hd__dlygate4sd3_1
Xhold230 net357 vssd1 vssd1 vccd1 vccd1 net734 sky130_fd_sc_hd__dlygate4sd3_1
Xhold296 spi_mem2.data_buf\[5\] vssd1 vssd1 vccd1 vccd1 net800 sky130_fd_sc_hd__dlygate4sd3_1
Xhold285 spi_mem2.data_buf\[4\] vssd1 vssd1 vccd1 vccd1 net789 sky130_fd_sc_hd__dlygate4sd3_1
Xhold263 _0072_ vssd1 vssd1 vccd1 vccd1 net767 sky130_fd_sc_hd__dlygate4sd3_1
XTAP_590 vssd1 vccd1 sky130_fd_sc_hd__tapvpwrvgnd_1
XFILLER_0_51_402 vssd1 vssd1 vccd1 vccd1 sky130_fd_sc_hd__decap_4
XFILLER_0_48_281 vssd1 vssd1 vccd1 vccd1 sky130_fd_sc_hd__decap_3
XFILLER_0_63_295 vssd1 vssd1 vccd1 vccd1 sky130_ef_sc_hd__decap_12
Xinput9 spi1_miso_i[1] vssd1 vssd1 vccd1 vccd1 net9 sky130_fd_sc_hd__clkbuf_1
X_1190_ net81 _0364_ _0414_ _0418_ vssd1 vssd1 vccd1 vccd1 _0419_ sky130_fd_sc_hd__a211o_1
XFILLER_0_39_281 vssd1 vssd1 vccd1 vccd1 sky130_ef_sc_hd__decap_12
XFILLER_0_6_326 vssd1 vssd1 vccd1 vccd1 sky130_fd_sc_hd__decap_6
X_1457_ net531 net411 _0587_ vssd1 vssd1 vccd1 vccd1 _0152_ sky130_fd_sc_hd__a21o_1
X_1526_ net603 net302 net385 vssd1 vssd1 vccd1 vccd1 _0179_ sky130_fd_sc_hd__mux2_1
Xoutput324 net324 vssd1 vssd1 vccd1 vccd1 sport1_o[6] sky130_fd_sc_hd__clkbuf_4
XFILLER_0_22_192 vssd1 vssd1 vccd1 vccd1 sky130_fd_sc_hd__decap_4
Xoutput302 net302 vssd1 vssd1 vccd1 vccd1 sport1_o[17] sky130_fd_sc_hd__clkbuf_4
Xoutput335 net335 vssd1 vssd1 vccd1 vccd1 sport2_o[16] sky130_fd_sc_hd__clkbuf_4
XFILLER_0_10_354 vssd1 vssd1 vccd1 vccd1 sky130_fd_sc_hd__decap_8
Xoutput313 net313 vssd1 vssd1 vccd1 vccd1 sport1_o[27] sky130_fd_sc_hd__clkbuf_4
Xoutput346 net346 vssd1 vssd1 vccd1 vccd1 sport2_o[26] sky130_fd_sc_hd__clkbuf_4
Xoutput357 net357 vssd1 vssd1 vccd1 vccd1 sport2_o[5] sky130_fd_sc_hd__clkbuf_4
X_1388_ net236 _0537_ vssd1 vssd1 vccd1 vccd1 _0544_ sky130_fd_sc_hd__nand2_1
XFILLER_0_33_402 vssd1 vssd1 vccd1 vccd1 sky130_fd_sc_hd__decap_4
X_2009_ clknet_leaf_30_clk_i _0035_ net461 vssd1 vssd1 vccd1 vccd1 spi_mem0.address\[9\]
+ sky130_fd_sc_hd__dfrtp_1
X_1982__6 clknet_leaf_13_clk_i vssd1 vssd1 vccd1 vccd1 net495 sky130_fd_sc_hd__inv_2
XFILLER_0_60_221 vssd1 vssd1 vccd1 vccd1 sky130_fd_sc_hd__decap_3
XFILLER_0_68_365 vssd1 vssd1 vccd1 vccd1 sky130_ef_sc_hd__decap_12
XPHY_82 vssd1 vssd1 vccd1 vccd1 sky130_fd_sc_hd__decap_3
XPHY_71 vssd1 vssd1 vccd1 vccd1 sky130_fd_sc_hd__decap_3
XPHY_60 vssd1 vssd1 vccd1 vccd1 sky130_fd_sc_hd__decap_3
XFILLER_0_28_229 vssd1 vssd1 vccd1 vccd1 sky130_fd_sc_hd__fill_1
XFILLER_0_51_232 vssd1 vssd1 vccd1 vccd1 sky130_ef_sc_hd__decap_12
XPHY_93 vssd1 vssd1 vccd1 vccd1 sky130_fd_sc_hd__decap_3
XFILLER_0_36_273 vssd1 vssd1 vccd1 vccd1 sky130_fd_sc_hd__fill_1
XFILLER_0_22_26 vssd1 vssd1 vccd1 vccd1 sky130_fd_sc_hd__fill_2
X_2291_ clknet_leaf_19_clk_i _0304_ net486 vssd1 vssd1 vccd1 vccd1 net254 sky130_fd_sc_hd__dfrtp_1
XFILLER_0_51_287 vssd1 vssd1 vccd1 vccd1 sky130_fd_sc_hd__fill_2
X_1311_ net72 net416 _0486_ _0492_ vssd1 vssd1 vccd1 vccd1 _0495_ sky130_fd_sc_hd__a22o_1
X_1242_ _0437_ net567 _0422_ vssd1 vssd1 vccd1 vccd1 _0087_ sky130_fd_sc_hd__mux2_1
XFILLER_0_63_55 vssd1 vssd1 vccd1 vccd1 sky130_fd_sc_hd__fill_1
XFILLER_0_59_332 vssd1 vssd1 vccd1 vccd1 sky130_fd_sc_hd__decap_4
X_1173_ _0920_ net442 spi_mem0.spi_clk _0947_ _0404_ vssd1 vssd1 vccd1 vccd1 _0405_
+ sky130_fd_sc_hd__a41o_1
XFILLER_0_74_324 vssd1 vssd1 vccd1 vccd1 sky130_fd_sc_hd__fill_1
XFILLER_0_15_402 vssd1 vssd1 vccd1 vccd1 sky130_fd_sc_hd__decap_4
XFILLER_0_19_218 vssd1 vssd1 vccd1 vccd1 sky130_fd_sc_hd__decap_6
XFILLER_0_2_362 vssd1 vssd1 vccd1 vccd1 sky130_fd_sc_hd__fill_2
X_1509_ net737 net294 net387 vssd1 vssd1 vccd1 vccd1 _0162_ sky130_fd_sc_hd__mux2_1
XFILLER_0_65_324 vssd1 vssd1 vccd1 vccd1 sky130_ef_sc_hd__decap_12
XFILLER_0_65_313 vssd1 vssd1 vccd1 vccd1 sky130_fd_sc_hd__fill_2
Xfanout370 net371 vssd1 vssd1 vccd1 vccd1 net370 sky130_fd_sc_hd__clkbuf_4
Xfanout392 _0357_ vssd1 vssd1 vccd1 vccd1 net392 sky130_fd_sc_hd__buf_4
XFILLER_0_17_37 vssd1 vssd1 vccd1 vccd1 sky130_fd_sc_hd__decap_4
XFILLER_0_17_48 vssd1 vssd1 vccd1 vccd1 sky130_fd_sc_hd__fill_2
Xfanout381 net382 vssd1 vssd1 vccd1 vccd1 net381 sky130_fd_sc_hd__clkbuf_2
XFILLER_0_68_173 vssd1 vssd1 vccd1 vccd1 sky130_fd_sc_hd__decap_3
X_1860_ spi_mem2.address\[4\] spi_mem2.address\[8\] spi_mem2.address_nibble\[0\] vssd1
+ vssd1 vccd1 vccd1 _0840_ sky130_fd_sc_hd__mux2_1
Xinput12 spi2_dqsm_i vssd1 vssd1 vccd1 vccd1 net12 sky130_fd_sc_hd__buf_1
XFILLER_0_71_349 vssd1 vssd1 vccd1 vccd1 sky130_ef_sc_hd__decap_12
X_1791_ _0806_ _0807_ _0799_ vssd1 vssd1 vccd1 vccd1 _0808_ sky130_fd_sc_hd__and3b_2
Xinput56 sport0_i[45] vssd1 vssd1 vccd1 vccd1 net56 sky130_fd_sc_hd__buf_1
Xinput67 sport0_i[55] vssd1 vssd1 vccd1 vccd1 net67 sky130_fd_sc_hd__clkbuf_1
Xinput89 sport1_i[12] vssd1 vssd1 vccd1 vccd1 net89 sky130_fd_sc_hd__dlymetal6s2s_1
Xinput78 sport0_i[65] vssd1 vssd1 vccd1 vccd1 net78 sky130_fd_sc_hd__dlymetal6s2s_1
Xinput34 sport0_i[25] vssd1 vssd1 vccd1 vccd1 net34 sky130_fd_sc_hd__buf_1
Xinput45 sport0_i[35] vssd1 vssd1 vccd1 vccd1 net45 sky130_fd_sc_hd__clkbuf_1
Xinput23 sport0_i[15] vssd1 vssd1 vccd1 vccd1 net23 sky130_fd_sc_hd__buf_1
XFILLER_0_58_99 vssd1 vssd1 vccd1 vccd1 sky130_fd_sc_hd__fill_1
XFILLER_0_58_33 vssd1 vssd1 vccd1 vccd1 sky130_fd_sc_hd__decap_3
X_2274_ clknet_leaf_37_clk_i net551 net447 vssd1 vssd1 vccd1 vccd1 net337 sky130_fd_sc_hd__dfrtp_1
XFILLER_0_79_405 vssd1 vssd1 vccd1 vccd1 sky130_fd_sc_hd__fill_2
X_1225_ net442 _0947_ net417 vssd1 vssd1 vccd1 vccd1 _0421_ sky130_fd_sc_hd__a21oi_2
X_1156_ _0390_ _0364_ spi_mem0.address_nibble\[0\] vssd1 vssd1 vccd1 vccd1 _0391_
+ sky130_fd_sc_hd__mux2_1
X_1087_ spi_mem2.data_byte\[1\] net422 vssd1 vssd1 vccd1 vccd1 _0352_ sky130_fd_sc_hd__nand2_1
XFILLER_0_59_195 vssd1 vssd1 vccd1 vccd1 sky130_fd_sc_hd__fill_1
XFILLER_0_47_335 vssd1 vssd1 vccd1 vccd1 sky130_fd_sc_hd__fill_1
XFILLER_0_30_213 vssd1 vssd1 vccd1 vccd1 sky130_fd_sc_hd__fill_1
XFILLER_0_65_121 vssd1 vssd1 vccd1 vccd1 sky130_fd_sc_hd__fill_2
XFILLER_0_53_305 vssd1 vssd1 vccd1 vccd1 sky130_ef_sc_hd__decap_12
XFILLER_0_61_382 vssd1 vssd1 vccd1 vccd1 sky130_fd_sc_hd__decap_3
XFILLER_0_53_349 vssd1 vssd1 vccd1 vccd1 sky130_ef_sc_hd__decap_12
XFILLER_0_21_213 vssd1 vssd1 vccd1 vccd1 sky130_fd_sc_hd__decap_8
XTAP_419 vssd1 vccd1 sky130_fd_sc_hd__tapvpwrvgnd_1
XTAP_408 vssd1 vccd1 sky130_fd_sc_hd__tapvpwrvgnd_1
XFILLER_0_21_279 vssd1 vssd1 vccd1 vccd1 sky130_fd_sc_hd__fill_1
X_1010_ spi_mem1.state\[2\] spi_mem1.state\[3\] vssd1 vssd1 vccd1 vccd1 _0938_ sky130_fd_sc_hd__and2b_2
XFILLER_0_29_302 vssd1 vssd1 vccd1 vccd1 sky130_fd_sc_hd__decap_3
XFILLER_0_71_113 vssd1 vssd1 vccd1 vccd1 sky130_fd_sc_hd__decap_6
XFILLER_0_60_56 vssd1 vssd1 vccd1 vccd1 sky130_fd_sc_hd__decap_3
XFILLER_0_29_346 vssd1 vssd1 vccd1 vccd1 sky130_fd_sc_hd__fill_2
X_1843_ spi_mem2.address_nibble\[1\] spi_mem2.address_nibble\[0\] vssd1 vssd1 vccd1
+ vccd1 _0824_ sky130_fd_sc_hd__and2b_2
X_1912_ net199 net403 _0871_ _0879_ vssd1 vssd1 vccd1 vccd1 _0881_ sky130_fd_sc_hd__a22o_1
X_1774_ net193 net192 _0790_ _0773_ vssd1 vssd1 vccd1 vccd1 _0791_ sky130_fd_sc_hd__a31o_1
X_1208_ net675 net701 net390 vssd1 vssd1 vccd1 vccd1 _0070_ sky130_fd_sc_hd__mux2_1
XFILLER_0_26_3 vssd1 vssd1 vccd1 vccd1 sky130_ef_sc_hd__decap_12
X_2257_ clknet_leaf_0_clk_i net654 net446 vssd1 vssd1 vccd1 vccd1 net339 sky130_fd_sc_hd__dfrtp_1
X_2326_ clknet_leaf_32_clk_i _0334_ net458 vssd1 vssd1 vccd1 vccd1 spi_mem2.data_buf\[24\]
+ sky130_fd_sc_hd__dfrtp_1
X_2188_ clknet_leaf_14_clk_i _0202_ net472 vssd1 vssd1 vccd1 vccd1 spi_mem1.data_buf\[0\]
+ sky130_fd_sc_hd__dfrtp_1
XFILLER_0_35_305 vssd1 vssd1 vccd1 vccd1 sky130_ef_sc_hd__decap_12
X_1139_ net48 net578 net409 vssd1 vssd1 vccd1 vccd1 _0032_ sky130_fd_sc_hd__mux2_1
XFILLER_0_62_168 vssd1 vssd1 vccd1 vccd1 sky130_fd_sc_hd__fill_1
XFILLER_0_62_102 vssd1 vssd1 vccd1 vccd1 sky130_ef_sc_hd__decap_12
XFILLER_0_28_390 vssd1 vssd1 vccd1 vccd1 sky130_ef_sc_hd__decap_12
Xinput202 sport2_i[52] vssd1 vssd1 vccd1 vccd1 net202 sky130_fd_sc_hd__buf_1
Xinput213 sport2_i[62] vssd1 vssd1 vccd1 vccd1 net213 sky130_fd_sc_hd__clkbuf_1
XFILLER_0_53_157 vssd1 vssd1 vccd1 vccd1 sky130_fd_sc_hd__decap_8
XFILLER_0_53_113 vssd1 vssd1 vccd1 vccd1 sky130_ef_sc_hd__decap_12
XFILLER_0_30_15 vssd1 vssd1 vccd1 vccd1 sky130_ef_sc_hd__decap_12
X_1490_ net148 _0608_ _0614_ net149 net430 vssd1 vssd1 vccd1 vccd1 _0615_ sky130_fd_sc_hd__a221o_1
XFILLER_0_39_57 vssd1 vssd1 vccd1 vccd1 sky130_ef_sc_hd__decap_12
XTAP_205 vssd1 vccd1 sky130_fd_sc_hd__tapvpwrvgnd_1
X_2111_ clknet_leaf_10_clk_i _0131_ net475 vssd1 vssd1 vccd1 vccd1 spi_mem1.latency\[4\]
+ sky130_fd_sc_hd__dfrtp_1
Xhold1 spi_mem2.spi_clk vssd1 vssd1 vccd1 vccd1 net505 sky130_fd_sc_hd__dlygate4sd3_1
X_2042_ clknet_leaf_3_clk_i _0068_ net453 vssd1 vssd1 vccd1 vccd1 net264 sky130_fd_sc_hd__dfrtp_1
XTAP_216 vssd1 vccd1 sky130_fd_sc_hd__tapvpwrvgnd_1
XTAP_227 vssd1 vccd1 sky130_fd_sc_hd__tapvpwrvgnd_1
XTAP_238 vssd1 vccd1 sky130_fd_sc_hd__tapvpwrvgnd_1
XTAP_249 vssd1 vccd1 sky130_fd_sc_hd__tapvpwrvgnd_1
XFILLER_0_71_99 vssd1 vssd1 vccd1 vccd1 sky130_fd_sc_hd__fill_2
X_1826_ net669 net343 net383 vssd1 vssd1 vccd1 vccd1 _0293_ sky130_fd_sc_hd__mux2_1
XTAP_750 vssd1 vccd1 sky130_fd_sc_hd__tapvpwrvgnd_1
X_1688_ net565 _0735_ _0738_ net369 vssd1 vssd1 vccd1 vccd1 _0232_ sky130_fd_sc_hd__a22o_1
XFILLER_0_40_385 vssd1 vssd1 vccd1 vccd1 sky130_fd_sc_hd__fill_1
X_1757_ net200 _0777_ net201 vssd1 vssd1 vccd1 vccd1 _0780_ sky130_fd_sc_hd__o21a_1
XFILLER_0_20_81 vssd1 vssd1 vccd1 vccd1 sky130_fd_sc_hd__decap_3
X_2309_ clknet_leaf_1_clk_i _0317_ net447 vssd1 vssd1 vccd1 vccd1 spi_mem2.data_buf\[7\]
+ sky130_fd_sc_hd__dfrtp_1
XFILLER_0_35_135 vssd1 vssd1 vccd1 vccd1 sky130_fd_sc_hd__decap_4
XFILLER_0_35_113 vssd1 vssd1 vccd1 vccd1 sky130_ef_sc_hd__decap_12
Xclkbuf_leaf_6_clk_i clknet_2_2__leaf_clk_i vssd1 vssd1 vccd1 vccd1 clknet_leaf_6_clk_i
+ sky130_fd_sc_hd__clkbuf_16
XFILLER_0_81_274 vssd1 vssd1 vccd1 vccd1 sky130_fd_sc_hd__decap_3
X_1611_ spi_mem1.delayed_miso\[0\] _0982_ vssd1 vssd1 vccd1 vccd1 _0692_ sky130_fd_sc_hd__and2_2
XFILLER_0_66_293 vssd1 vssd1 vccd1 vccd1 sky130_fd_sc_hd__decap_8
X_0990_ spi_mem0.state\[3\] vssd1 vssd1 vccd1 vccd1 _0921_ sky130_fd_sc_hd__inv_2
XFILLER_0_41_149 vssd1 vssd1 vccd1 vccd1 sky130_ef_sc_hd__decap_12
XFILLER_0_26_124 vssd1 vssd1 vccd1 vccd1 sky130_ef_sc_hd__decap_12
X_1542_ net434 _0936_ net398 vssd1 vssd1 vccd1 vccd1 _0631_ sky130_fd_sc_hd__a21oi_2
XFILLER_0_66_33 vssd1 vssd1 vccd1 vccd1 sky130_ef_sc_hd__decap_12
X_1473_ _0583_ net132 _0582_ _0586_ vssd1 vssd1 vccd1 vccd1 _0598_ sky130_fd_sc_hd__and4b_1
XFILLER_0_22_363 vssd1 vssd1 vccd1 vccd1 sky130_fd_sc_hd__fill_1
XFILLER_0_5_36 vssd1 vssd1 vccd1 vccd1 sky130_fd_sc_hd__fill_2
X_2025_ clknet_leaf_23_clk_i _0051_ net481 vssd1 vssd1 vccd1 vccd1 spi_mem0.state\[0\]
+ sky130_fd_sc_hd__dfrtp_1
XFILLER_0_72_241 vssd1 vssd1 vccd1 vccd1 sky130_fd_sc_hd__decap_8
XFILLER_0_49_249 vssd1 vssd1 vccd1 vccd1 sky130_ef_sc_hd__decap_12
XFILLER_0_17_113 vssd1 vssd1 vccd1 vccd1 sky130_fd_sc_hd__decap_3
XFILLER_0_32_138 vssd1 vssd1 vccd1 vccd1 sky130_fd_sc_hd__fill_2
Xhold242 spi_mem0.data_buf\[29\] vssd1 vssd1 vccd1 vccd1 net746 sky130_fd_sc_hd__dlygate4sd3_1
X_1809_ net518 net358 net382 vssd1 vssd1 vccd1 vccd1 _0276_ sky130_fd_sc_hd__mux2_1
Xhold253 net332 vssd1 vssd1 vccd1 vccd1 net757 sky130_fd_sc_hd__dlygate4sd3_1
Xhold231 _0275_ vssd1 vssd1 vccd1 vccd1 net735 sky130_fd_sc_hd__dlygate4sd3_1
XFILLER_0_17_157 vssd1 vssd1 vccd1 vccd1 sky130_fd_sc_hd__decap_4
Xhold220 spi_mem0.data_buf\[22\] vssd1 vssd1 vccd1 vccd1 net724 sky130_fd_sc_hd__dlygate4sd3_1
Xhold275 _0167_ vssd1 vssd1 vccd1 vccd1 net779 sky130_fd_sc_hd__dlygate4sd3_1
XTAP_591 vssd1 vccd1 sky130_fd_sc_hd__tapvpwrvgnd_1
XTAP_580 vssd1 vccd1 sky130_fd_sc_hd__tapvpwrvgnd_1
XFILLER_0_40_182 vssd1 vssd1 vccd1 vccd1 sky130_ef_sc_hd__decap_12
Xhold264 net265 vssd1 vssd1 vccd1 vccd1 net768 sky130_fd_sc_hd__dlygate4sd3_1
Xhold286 spi_mem0.data_buf\[0\] vssd1 vssd1 vccd1 vccd1 net790 sky130_fd_sc_hd__dlygate4sd3_1
Xhold297 spi_mem2.data_buf\[28\] vssd1 vssd1 vccd1 vccd1 net801 sky130_fd_sc_hd__dlygate4sd3_1
XFILLER_0_39_293 vssd1 vssd1 vccd1 vccd1 sky130_fd_sc_hd__decap_6
XFILLER_0_39_271 vssd1 vssd1 vccd1 vccd1 sky130_fd_sc_hd__decap_8
Xoutput303 net303 vssd1 vssd1 vccd1 vccd1 sport1_o[18] sky130_fd_sc_hd__clkbuf_4
XFILLER_0_14_105 vssd1 vssd1 vccd1 vccd1 sky130_fd_sc_hd__decap_4
XFILLER_0_14_138 vssd1 vssd1 vccd1 vccd1 sky130_fd_sc_hd__fill_2
Xoutput314 net314 vssd1 vssd1 vccd1 vccd1 sport1_o[28] sky130_fd_sc_hd__clkbuf_4
Xoutput325 net325 vssd1 vssd1 vccd1 vccd1 sport1_o[7] sky130_fd_sc_hd__clkbuf_4
X_1387_ net394 _0538_ _0542_ vssd1 vssd1 vccd1 vccd1 _0543_ sky130_fd_sc_hd__a21o_1
X_1456_ net132 _0583_ _0586_ net412 vssd1 vssd1 vccd1 vccd1 _0587_ sky130_fd_sc_hd__o211a_1
X_1525_ net692 net301 net386 vssd1 vssd1 vccd1 vccd1 _0178_ sky130_fd_sc_hd__mux2_1
Xoutput347 net347 vssd1 vssd1 vccd1 vccd1 sport2_o[27] sky130_fd_sc_hd__clkbuf_4
Xoutput336 net336 vssd1 vssd1 vccd1 vccd1 sport2_o[17] sky130_fd_sc_hd__clkbuf_4
Xoutput358 net358 vssd1 vssd1 vccd1 vccd1 sport2_o[6] sky130_fd_sc_hd__clkbuf_4
XFILLER_0_77_355 vssd1 vssd1 vccd1 vccd1 sky130_fd_sc_hd__decap_8
X_2008_ clknet_leaf_30_clk_i _0034_ net458 vssd1 vssd1 vccd1 vccd1 spi_mem0.address\[8\]
+ sky130_fd_sc_hd__dfrtp_1
XFILLER_0_9_121 vssd1 vssd1 vccd1 vccd1 sky130_fd_sc_hd__fill_1
XFILLER_0_9_154 vssd1 vssd1 vccd1 vccd1 sky130_fd_sc_hd__fill_2
Xclkbuf_leaf_24_clk_i clknet_2_3__leaf_clk_i vssd1 vssd1 vccd1 vccd1 clknet_leaf_24_clk_i
+ sky130_fd_sc_hd__clkbuf_16
XFILLER_0_68_377 vssd1 vssd1 vccd1 vccd1 sky130_fd_sc_hd__fill_1
XPHY_94 vssd1 vssd1 vccd1 vccd1 sky130_fd_sc_hd__decap_3
XPHY_83 vssd1 vssd1 vccd1 vccd1 sky130_fd_sc_hd__decap_3
XPHY_72 vssd1 vssd1 vccd1 vccd1 sky130_fd_sc_hd__decap_3
XPHY_61 vssd1 vssd1 vccd1 vccd1 sky130_fd_sc_hd__decap_3
XPHY_50 vssd1 vssd1 vccd1 vccd1 sky130_fd_sc_hd__decap_3
Xclkbuf_leaf_39_clk_i clknet_2_0__leaf_clk_i vssd1 vssd1 vccd1 vccd1 clknet_leaf_39_clk_i
+ sky130_fd_sc_hd__clkbuf_16
XFILLER_0_22_38 vssd1 vssd1 vccd1 vccd1 sky130_fd_sc_hd__fill_1
XFILLER_0_51_244 vssd1 vssd1 vccd1 vccd1 sky130_fd_sc_hd__decap_6
X_2290_ clknet_leaf_19_clk_i _0303_ net487 vssd1 vssd1 vccd1 vccd1 net253 sky130_fd_sc_hd__dfrtp_1
XFILLER_0_47_35 vssd1 vssd1 vccd1 vccd1 sky130_fd_sc_hd__fill_2
X_1310_ net732 _0493_ _0494_ net372 vssd1 vssd1 vccd1 vccd1 _0098_ sky130_fd_sc_hd__a22o_1
X_1241_ _0347_ _0428_ _0431_ _0436_ vssd1 vssd1 vccd1 vccd1 _0437_ sky130_fd_sc_hd__a31o_1
X_1172_ spi_mem0.spi_clk spi_mem0.latency\[5\] _0372_ _0370_ vssd1 vssd1 vccd1 vccd1
+ _0404_ sky130_fd_sc_hd__o31a_1
XFILLER_0_2_48 vssd1 vssd1 vccd1 vccd1 sky130_fd_sc_hd__fill_1
XFILLER_0_82_380 vssd1 vssd1 vccd1 vccd1 sky130_fd_sc_hd__fill_2
XFILLER_0_6_102 vssd1 vssd1 vccd1 vccd1 sky130_fd_sc_hd__fill_1
XFILLER_0_12_60 vssd1 vssd1 vccd1 vccd1 sky130_fd_sc_hd__decap_4
XFILLER_0_2_385 vssd1 vssd1 vccd1 vccd1 sky130_fd_sc_hd__fill_2
X_1508_ net433 spi_mem1.data_ready _0981_ vssd1 vssd1 vccd1 vccd1 _0629_ sky130_fd_sc_hd__o21bai_4
X_1439_ net127 net126 vssd1 vssd1 vccd1 vccd1 _0574_ sky130_fd_sc_hd__or2_1
XFILLER_0_77_130 vssd1 vssd1 vccd1 vccd1 sky130_ef_sc_hd__decap_12
Xfanout371 _0689_ vssd1 vssd1 vccd1 vccd1 net371 sky130_fd_sc_hd__clkbuf_2
Xfanout393 _0345_ vssd1 vssd1 vccd1 vccd1 net393 sky130_fd_sc_hd__buf_4
Xfanout382 net383 vssd1 vssd1 vccd1 vccd1 net382 sky130_fd_sc_hd__clkbuf_2
Xinput13 spi2_miso_i[0] vssd1 vssd1 vccd1 vccd1 net13 sky130_fd_sc_hd__clkbuf_1
XFILLER_0_68_141 vssd1 vssd1 vccd1 vccd1 sky130_fd_sc_hd__decap_3
X_1790_ _0960_ _0361_ net392 vssd1 vssd1 vccd1 vccd1 _0807_ sky130_fd_sc_hd__o21ai_1
XFILLER_0_58_56 vssd1 vssd1 vccd1 vccd1 sky130_ef_sc_hd__decap_12
Xinput79 sport0_i[66] vssd1 vssd1 vccd1 vccd1 net79 sky130_fd_sc_hd__clkbuf_2
Xinput35 sport0_i[26] vssd1 vssd1 vccd1 vccd1 net35 sky130_fd_sc_hd__buf_1
Xinput24 sport0_i[16] vssd1 vssd1 vccd1 vccd1 net24 sky130_fd_sc_hd__buf_1
Xinput46 sport0_i[36] vssd1 vssd1 vccd1 vccd1 net46 sky130_fd_sc_hd__clkbuf_1
Xinput57 sport0_i[46] vssd1 vssd1 vccd1 vccd1 net57 sky130_fd_sc_hd__buf_1
Xinput68 sport0_i[56] vssd1 vssd1 vccd1 vccd1 net68 sky130_fd_sc_hd__clkbuf_1
X_2342_ net259 vssd1 vssd1 vccd1 vccd1 net258 sky130_fd_sc_hd__clkbuf_1
X_1224_ net648 net284 net388 vssd1 vssd1 vccd1 vccd1 _0086_ sky130_fd_sc_hd__mux2_1
X_2273_ clknet_leaf_37_clk_i net663 net445 vssd1 vssd1 vccd1 vccd1 net336 sky130_fd_sc_hd__dfrtp_1
XFILLER_0_74_133 vssd1 vssd1 vccd1 vccd1 sky130_fd_sc_hd__decap_6
X_1086_ _0953_ _0958_ _0959_ vssd1 vssd1 vccd1 vccd1 net251 sky130_fd_sc_hd__or3b_2
X_1155_ net409 _0365_ vssd1 vssd1 vccd1 vccd1 _0390_ sky130_fd_sc_hd__and2_1
XFILLER_0_55_391 vssd1 vssd1 vccd1 vccd1 sky130_fd_sc_hd__fill_1
XFILLER_0_30_269 vssd1 vssd1 vccd1 vccd1 sky130_fd_sc_hd__fill_2
XFILLER_0_65_177 vssd1 vssd1 vccd1 vccd1 sky130_ef_sc_hd__decap_12
XFILLER_0_53_317 vssd1 vssd1 vccd1 vccd1 sky130_fd_sc_hd__fill_2
XFILLER_0_21_225 vssd1 vssd1 vccd1 vccd1 sky130_ef_sc_hd__decap_12
XTAP_409 vssd1 vccd1 sky130_fd_sc_hd__tapvpwrvgnd_1
XFILLER_0_71_169 vssd1 vssd1 vccd1 vccd1 sky130_ef_sc_hd__decap_12
XFILLER_0_71_147 vssd1 vssd1 vccd1 vccd1 sky130_ef_sc_hd__decap_12
XFILLER_0_60_79 vssd1 vssd1 vccd1 vccd1 sky130_fd_sc_hd__decap_4
XFILLER_0_60_35 vssd1 vssd1 vccd1 vccd1 sky130_fd_sc_hd__fill_1
XFILLER_0_52_350 vssd1 vssd1 vccd1 vccd1 sky130_fd_sc_hd__fill_2
XFILLER_0_44_317 vssd1 vssd1 vccd1 vccd1 sky130_fd_sc_hd__fill_2
X_1842_ _0821_ _0822_ _0927_ vssd1 vssd1 vccd1 vccd1 _0823_ sky130_fd_sc_hd__mux2_1
X_1773_ net190 net189 net191 vssd1 vssd1 vccd1 vccd1 _0790_ sky130_fd_sc_hd__a21o_1
X_1911_ _0968_ _0879_ net366 vssd1 vssd1 vccd1 vccd1 _0880_ sky130_fd_sc_hd__o21ai_2
XFILLER_0_69_44 vssd1 vssd1 vccd1 vccd1 sky130_ef_sc_hd__decap_12
X_2187_ clknet_leaf_11_clk_i _0201_ net477 vssd1 vssd1 vccd1 vccd1 spi_mem1.data_byte\[1\]
+ sky130_fd_sc_hd__dfrtp_4
X_1207_ net765 net768 net390 vssd1 vssd1 vccd1 vccd1 _0069_ sky130_fd_sc_hd__mux2_1
X_2325_ clknet_leaf_31_clk_i _0333_ net457 vssd1 vssd1 vccd1 vccd1 spi_mem2.data_buf\[23\]
+ sky130_fd_sc_hd__dfrtp_1
X_2256_ clknet_leaf_39_clk_i net642 net444 vssd1 vssd1 vccd1 vccd1 net328 sky130_fd_sc_hd__dfrtp_1
XFILLER_0_19_3 vssd1 vssd1 vccd1 vccd1 sky130_fd_sc_hd__decap_4
X_1069_ net432 _0964_ vssd1 vssd1 vccd1 vccd1 _0981_ sky130_fd_sc_hd__nand2_2
XFILLER_0_62_114 vssd1 vssd1 vccd1 vccd1 sky130_ef_sc_hd__decap_12
XFILLER_0_47_155 vssd1 vssd1 vccd1 vccd1 sky130_ef_sc_hd__decap_12
XFILLER_0_47_111 vssd1 vssd1 vccd1 vccd1 sky130_fd_sc_hd__fill_1
XFILLER_0_35_317 vssd1 vssd1 vccd1 vccd1 sky130_fd_sc_hd__decap_8
X_1138_ net47 net583 net408 vssd1 vssd1 vccd1 vccd1 _0031_ sky130_fd_sc_hd__mux2_1
XFILLER_0_50_309 vssd1 vssd1 vccd1 vccd1 sky130_ef_sc_hd__decap_12
XFILLER_0_43_350 vssd1 vssd1 vccd1 vccd1 sky130_fd_sc_hd__decap_4
Xinput203 sport2_i[53] vssd1 vssd1 vccd1 vccd1 net203 sky130_fd_sc_hd__buf_1
Xinput214 sport2_i[63] vssd1 vssd1 vccd1 vccd1 net214 sky130_fd_sc_hd__clkbuf_1
XFILLER_0_53_125 vssd1 vssd1 vccd1 vccd1 sky130_fd_sc_hd__decap_4
XFILLER_0_38_166 vssd1 vssd1 vccd1 vccd1 sky130_fd_sc_hd__decap_3
XFILLER_0_38_133 vssd1 vssd1 vccd1 vccd1 sky130_fd_sc_hd__decap_6
XFILLER_0_30_49 vssd1 vssd1 vccd1 vccd1 sky130_fd_sc_hd__fill_2
XFILLER_0_30_27 vssd1 vssd1 vccd1 vccd1 sky130_fd_sc_hd__fill_1
XFILLER_0_19_391 vssd1 vssd1 vccd1 vccd1 sky130_fd_sc_hd__fill_1
XFILLER_0_39_69 vssd1 vssd1 vccd1 vccd1 sky130_fd_sc_hd__decap_8
XTAP_206 vssd1 vccd1 sky130_fd_sc_hd__tapvpwrvgnd_1
XTAP_217 vssd1 vccd1 sky130_fd_sc_hd__tapvpwrvgnd_1
XTAP_228 vssd1 vccd1 sky130_fd_sc_hd__tapvpwrvgnd_1
XTAP_239 vssd1 vccd1 sky130_fd_sc_hd__tapvpwrvgnd_1
X_2110_ clknet_leaf_11_clk_i _0130_ net475 vssd1 vssd1 vccd1 vccd1 spi_mem1.latency\[3\]
+ sky130_fd_sc_hd__dfrtp_1
Xhold2 spi_mem2.latency\[5\] vssd1 vssd1 vccd1 vccd1 net506 sky130_fd_sc_hd__dlygate4sd3_1
XFILLER_0_55_57 vssd1 vssd1 vccd1 vccd1 sky130_fd_sc_hd__decap_6
X_2041_ clknet_leaf_7_clk_i _0067_ net467 vssd1 vssd1 vccd1 vccd1 net263 sky130_fd_sc_hd__dfrtp_1
XFILLER_0_29_133 vssd1 vssd1 vccd1 vccd1 sky130_fd_sc_hd__fill_1
XFILLER_0_29_122 vssd1 vssd1 vccd1 vccd1 sky130_fd_sc_hd__decap_3
XFILLER_0_29_111 vssd1 vssd1 vccd1 vccd1 sky130_fd_sc_hd__fill_1
XFILLER_0_40_342 vssd1 vssd1 vccd1 vccd1 sky130_ef_sc_hd__decap_12
XFILLER_0_32_309 vssd1 vssd1 vccd1 vccd1 sky130_ef_sc_hd__decap_12
X_1756_ net556 _0779_ _0962_ vssd1 vssd1 vccd1 vccd1 _0259_ sky130_fd_sc_hd__mux2_1
X_1825_ net596 net342 net381 vssd1 vssd1 vccd1 vccd1 _0292_ sky130_fd_sc_hd__mux2_1
XTAP_751 vssd1 vccd1 sky130_fd_sc_hd__tapvpwrvgnd_1
XTAP_740 vssd1 vccd1 sky130_fd_sc_hd__tapvpwrvgnd_1
X_1687_ net109 net397 _0696_ _0734_ vssd1 vssd1 vccd1 vccd1 _0738_ sky130_fd_sc_hd__a22o_1
XFILLER_0_29_91 vssd1 vssd1 vccd1 vccd1 sky130_ef_sc_hd__decap_12
X_2308_ clknet_leaf_0_clk_i _0316_ net446 vssd1 vssd1 vccd1 vccd1 spi_mem2.data_buf\[6\]
+ sky130_fd_sc_hd__dfrtp_1
X_2239_ clknet_leaf_28_clk_i _0253_ net460 vssd1 vssd1 vccd1 vccd1 spi_mem2.address\[12\]
+ sky130_fd_sc_hd__dfrtp_1
XFILLER_0_35_125 vssd1 vssd1 vccd1 vccd1 sky130_fd_sc_hd__fill_2
XFILLER_0_8_3 vssd1 vssd1 vccd1 vccd1 sky130_fd_sc_hd__fill_1
XFILLER_0_16_383 vssd1 vssd1 vccd1 vccd1 sky130_fd_sc_hd__fill_1
XFILLER_0_25_16 vssd1 vssd1 vccd1 vccd1 sky130_ef_sc_hd__decap_12
XFILLER_0_58_217 vssd1 vssd1 vccd1 vccd1 sky130_fd_sc_hd__fill_1
XFILLER_0_25_49 vssd1 vssd1 vccd1 vccd1 sky130_fd_sc_hd__decap_6
X_1610_ net394 _0690_ net370 vssd1 vssd1 vccd1 vccd1 _0691_ sky130_fd_sc_hd__o21ai_2
XFILLER_0_26_136 vssd1 vssd1 vccd1 vccd1 sky130_fd_sc_hd__decap_4
XFILLER_0_14_309 vssd1 vssd1 vccd1 vccd1 sky130_ef_sc_hd__decap_12
X_1541_ spi_mem1.state\[1\] net434 spi_mem1.spi_clk _0936_ vssd1 vssd1 vccd1 vccd1
+ _0630_ sky130_fd_sc_hd__and4b_1
XFILLER_0_66_45 vssd1 vssd1 vccd1 vccd1 sky130_fd_sc_hd__decap_8
X_1472_ net137 _0596_ vssd1 vssd1 vccd1 vccd1 _0597_ sky130_fd_sc_hd__xnor2_1
XFILLER_0_82_77 vssd1 vssd1 vccd1 vccd1 sky130_fd_sc_hd__fill_1
XFILLER_0_82_33 vssd1 vssd1 vccd1 vccd1 sky130_fd_sc_hd__decap_4
X_2024_ clknet_leaf_24_clk_i _0050_ net463 vssd1 vssd1 vccd1 vccd1 spi_mem0.address_nibble\[2\]
+ sky130_fd_sc_hd__dfstp_1
XFILLER_0_10_7 vssd1 vssd1 vccd1 vccd1 sky130_fd_sc_hd__fill_1
XFILLER_0_9_369 vssd1 vssd1 vccd1 vccd1 sky130_ef_sc_hd__decap_12
Xhold232 net327 vssd1 vssd1 vccd1 vccd1 net736 sky130_fd_sc_hd__dlygate4sd3_1
Xhold254 spi_mem1.data_buf\[29\] vssd1 vssd1 vccd1 vccd1 net758 sky130_fd_sc_hd__dlygate4sd3_1
Xhold276 spi_mem1.data_buf\[19\] vssd1 vssd1 vccd1 vccd1 net780 sky130_fd_sc_hd__dlygate4sd3_1
XFILLER_0_40_194 vssd1 vssd1 vccd1 vccd1 sky130_fd_sc_hd__fill_2
Xhold265 net262 vssd1 vssd1 vccd1 vccd1 net769 sky130_fd_sc_hd__dlygate4sd3_1
Xhold210 _0076_ vssd1 vssd1 vccd1 vccd1 net714 sky130_fd_sc_hd__dlygate4sd3_1
Xhold287 spi_mem2.data_buf\[30\] vssd1 vssd1 vccd1 vccd1 net791 sky130_fd_sc_hd__dlygate4sd3_1
X_1739_ net194 _0765_ vssd1 vssd1 vccd1 vccd1 _0768_ sky130_fd_sc_hd__and2_1
X_1808_ spi_mem2.data_buf\[5\] net734 net382 vssd1 vssd1 vccd1 vccd1 _0275_ sky130_fd_sc_hd__mux2_1
Xhold221 _0077_ vssd1 vssd1 vccd1 vccd1 net725 sky130_fd_sc_hd__dlygate4sd3_1
Xhold243 _0084_ vssd1 vssd1 vccd1 vccd1 net747 sky130_fd_sc_hd__dlygate4sd3_1
XTAP_592 vssd1 vccd1 sky130_fd_sc_hd__tapvpwrvgnd_1
XTAP_581 vssd1 vccd1 sky130_fd_sc_hd__tapvpwrvgnd_1
XTAP_570 vssd1 vccd1 sky130_fd_sc_hd__tapvpwrvgnd_1
Xhold298 net305 vssd1 vssd1 vccd1 vccd1 net802 sky130_fd_sc_hd__dlygate4sd3_1
XFILLER_0_36_401 vssd1 vssd1 vccd1 vccd1 sky130_fd_sc_hd__decap_6
XFILLER_0_48_294 vssd1 vssd1 vccd1 vccd1 sky130_fd_sc_hd__fill_1
XFILLER_0_54_253 vssd1 vssd1 vccd1 vccd1 sky130_ef_sc_hd__decap_12
XFILLER_0_54_297 vssd1 vssd1 vccd1 vccd1 sky130_fd_sc_hd__decap_8
X_1524_ net772 net300 net386 vssd1 vssd1 vccd1 vccd1 _0177_ sky130_fd_sc_hd__mux2_1
Xoutput304 net304 vssd1 vssd1 vccd1 vccd1 sport1_o[19] sky130_fd_sc_hd__clkbuf_4
Xoutput348 net348 vssd1 vssd1 vccd1 vccd1 sport2_o[28] sky130_fd_sc_hd__clkbuf_4
Xoutput337 net337 vssd1 vssd1 vccd1 vccd1 sport2_o[18] sky130_fd_sc_hd__clkbuf_4
Xoutput359 net359 vssd1 vssd1 vccd1 vccd1 sport2_o[7] sky130_fd_sc_hd__clkbuf_4
Xoutput326 net326 vssd1 vssd1 vccd1 vccd1 sport1_o[8] sky130_fd_sc_hd__clkbuf_4
Xoutput315 net315 vssd1 vssd1 vccd1 vccd1 sport1_o[29] sky130_fd_sc_hd__clkbuf_4
X_1386_ spi_mem1.latency\[5\] _0941_ _0540_ _0537_ vssd1 vssd1 vccd1 vccd1 _0542_
+ sky130_fd_sc_hd__o31a_2
X_1455_ net129 _0579_ _0585_ vssd1 vssd1 vccd1 vccd1 _0586_ sky130_fd_sc_hd__o21ai_2
Xclkbuf_leaf_5_clk_i clknet_2_2__leaf_clk_i vssd1 vssd1 vccd1 vccd1 clknet_leaf_5_clk_i
+ sky130_fd_sc_hd__clkbuf_16
XFILLER_0_77_345 vssd1 vssd1 vccd1 vccd1 sky130_fd_sc_hd__fill_2
XFILLER_0_77_323 vssd1 vssd1 vccd1 vccd1 sky130_ef_sc_hd__decap_12
X_2007_ clknet_leaf_31_clk_i _0033_ net457 vssd1 vssd1 vccd1 vccd1 spi_mem0.address\[7\]
+ sky130_fd_sc_hd__dfrtp_1
XFILLER_0_45_253 vssd1 vssd1 vccd1 vccd1 sky130_fd_sc_hd__decap_8
XFILLER_0_68_301 vssd1 vssd1 vccd1 vccd1 sky130_fd_sc_hd__decap_6
XPHY_95 vssd1 vssd1 vccd1 vccd1 sky130_fd_sc_hd__decap_3
XPHY_84 vssd1 vssd1 vccd1 vccd1 sky130_fd_sc_hd__decap_3
XPHY_73 vssd1 vssd1 vccd1 vccd1 sky130_fd_sc_hd__decap_3
XFILLER_0_36_253 vssd1 vssd1 vccd1 vccd1 sky130_ef_sc_hd__decap_12
XPHY_62 vssd1 vssd1 vccd1 vccd1 sky130_fd_sc_hd__decap_3
XPHY_51 vssd1 vssd1 vccd1 vccd1 sky130_fd_sc_hd__decap_3
XPHY_40 vssd1 vssd1 vccd1 vccd1 sky130_fd_sc_hd__decap_3
XFILLER_0_51_223 vssd1 vssd1 vccd1 vccd1 sky130_fd_sc_hd__fill_1
XFILLER_0_24_404 vssd1 vssd1 vccd1 vccd1 sky130_fd_sc_hd__decap_3
XFILLER_0_11_109 vssd1 vssd1 vccd1 vccd1 sky130_fd_sc_hd__decap_3
XFILLER_0_47_69 vssd1 vssd1 vccd1 vccd1 sky130_fd_sc_hd__fill_1
X_1240_ net61 _0368_ _0435_ _0364_ vssd1 vssd1 vccd1 vccd1 _0436_ sky130_fd_sc_hd__a22o_1
X_1171_ _0399_ _0400_ _0401_ _0402_ _0948_ vssd1 vssd1 vccd1 vccd1 _0403_ sky130_fd_sc_hd__o41a_1
XFILLER_0_42_245 vssd1 vssd1 vccd1 vccd1 sky130_fd_sc_hd__fill_1
X_1507_ spi_mem1.state\[3\] _0628_ _0622_ vssd1 vssd1 vccd1 vccd1 _0161_ sky130_fd_sc_hd__mux2_1
XFILLER_0_2_320 vssd1 vssd1 vccd1 vccd1 sky130_fd_sc_hd__decap_6
XFILLER_0_69_109 vssd1 vssd1 vccd1 vccd1 sky130_fd_sc_hd__decap_3
X_1438_ net126 _0568_ net127 vssd1 vssd1 vccd1 vccd1 _0573_ sky130_fd_sc_hd__o21a_1
XFILLER_0_49_3 vssd1 vssd1 vccd1 vccd1 sky130_ef_sc_hd__decap_12
X_1369_ net38 net415 _0486_ _0526_ vssd1 vssd1 vccd1 vccd1 _0529_ sky130_fd_sc_hd__a22o_1
XFILLER_0_10_197 vssd1 vssd1 vccd1 vccd1 sky130_fd_sc_hd__decap_8
XFILLER_0_80_307 vssd1 vssd1 vccd1 vccd1 sky130_fd_sc_hd__fill_1
XFILLER_0_77_142 vssd1 vssd1 vccd1 vccd1 sky130_ef_sc_hd__decap_12
XFILLER_0_65_337 vssd1 vssd1 vccd1 vccd1 sky130_fd_sc_hd__decap_4
XFILLER_0_18_253 vssd1 vssd1 vccd1 vccd1 sky130_ef_sc_hd__decap_12
XFILLER_0_33_223 vssd1 vssd1 vccd1 vccd1 sky130_fd_sc_hd__fill_1
Xfanout372 net373 vssd1 vssd1 vccd1 vccd1 net372 sky130_fd_sc_hd__buf_2
Xfanout383 _0815_ vssd1 vssd1 vccd1 vccd1 net383 sky130_fd_sc_hd__buf_2
Xfanout394 _0983_ vssd1 vssd1 vccd1 vccd1 net394 sky130_fd_sc_hd__buf_4
Xinput14 spi2_miso_i[1] vssd1 vssd1 vccd1 vccd1 net14 sky130_fd_sc_hd__clkbuf_1
XFILLER_0_56_326 vssd1 vssd1 vccd1 vccd1 sky130_fd_sc_hd__fill_1
Xinput36 sport0_i[27] vssd1 vssd1 vccd1 vccd1 net36 sky130_fd_sc_hd__buf_1
Xinput25 sport0_i[17] vssd1 vssd1 vccd1 vccd1 net25 sky130_fd_sc_hd__buf_1
X_2341_ net259 vssd1 vssd1 vccd1 vccd1 net257 sky130_fd_sc_hd__clkbuf_1
XFILLER_0_58_68 vssd1 vssd1 vccd1 vccd1 sky130_fd_sc_hd__decap_8
Xinput69 sport0_i[57] vssd1 vssd1 vccd1 vccd1 net69 sky130_fd_sc_hd__clkbuf_1
Xinput47 sport0_i[37] vssd1 vssd1 vccd1 vccd1 net47 sky130_fd_sc_hd__buf_1
Xinput58 sport0_i[47] vssd1 vssd1 vccd1 vccd1 net58 sky130_fd_sc_hd__buf_1
X_1223_ net715 net283 net388 vssd1 vssd1 vccd1 vccd1 _0085_ sky130_fd_sc_hd__mux2_1
X_2272_ clknet_leaf_39_clk_i net625 net445 vssd1 vssd1 vccd1 vccd1 net335 sky130_fd_sc_hd__dfrtp_1
X_1154_ net65 net573 net407 vssd1 vssd1 vccd1 vccd1 _0047_ sky130_fd_sc_hd__mux2_1
X_1085_ _0934_ _0939_ _0938_ vssd1 vssd1 vccd1 vccd1 net239 sky130_fd_sc_hd__or3b_1
XFILLER_0_59_175 vssd1 vssd1 vccd1 vccd1 sky130_ef_sc_hd__decap_12
XFILLER_0_47_337 vssd1 vssd1 vccd1 vccd1 sky130_fd_sc_hd__decap_4
Xclkbuf_leaf_23_clk_i clknet_2_3__leaf_clk_i vssd1 vssd1 vccd1 vccd1 clknet_leaf_23_clk_i
+ sky130_fd_sc_hd__clkbuf_16
XFILLER_0_15_223 vssd1 vssd1 vccd1 vccd1 sky130_fd_sc_hd__fill_1
XFILLER_0_15_256 vssd1 vssd1 vccd1 vccd1 sky130_fd_sc_hd__decap_6
XFILLER_0_15_289 vssd1 vssd1 vccd1 vccd1 sky130_fd_sc_hd__decap_3
XFILLER_0_30_259 vssd1 vssd1 vccd1 vccd1 sky130_fd_sc_hd__fill_1
Xclkbuf_leaf_38_clk_i clknet_2_0__leaf_clk_i vssd1 vssd1 vccd1 vccd1 clknet_leaf_38_clk_i
+ sky130_fd_sc_hd__clkbuf_16
XFILLER_0_65_189 vssd1 vssd1 vccd1 vccd1 sky130_fd_sc_hd__decap_4
XFILLER_0_46_381 vssd1 vssd1 vccd1 vccd1 sky130_fd_sc_hd__decap_3
XFILLER_0_21_237 vssd1 vssd1 vccd1 vccd1 sky130_ef_sc_hd__decap_12
XFILLER_0_44_15 vssd1 vssd1 vccd1 vccd1 sky130_ef_sc_hd__decap_12
XFILLER_0_28_27 vssd1 vssd1 vccd1 vccd1 sky130_fd_sc_hd__fill_1
X_1910_ net421 net424 _0927_ vssd1 vssd1 vccd1 vccd1 _0879_ sky130_fd_sc_hd__and3b_2
XFILLER_0_71_159 vssd1 vssd1 vccd1 vccd1 sky130_fd_sc_hd__decap_8
XFILLER_0_37_381 vssd1 vssd1 vccd1 vccd1 sky130_fd_sc_hd__decap_8
X_1772_ _0747_ _0787_ _0789_ net814 vssd1 vssd1 vccd1 vccd1 _0265_ sky130_fd_sc_hd__a22o_1
X_1841_ spi_mem2.data_buf\[0\] spi_mem2.data_buf\[4\] spi_mem2.data_buf\[8\] spi_mem2.data_buf\[12\]
+ net424 net421 vssd1 vssd1 vccd1 vccd1 _0822_ sky130_fd_sc_hd__mux4_1
XFILLER_0_40_7 vssd1 vssd1 vccd1 vccd1 sky130_fd_sc_hd__fill_1
X_2324_ clknet_leaf_32_clk_i _0332_ net458 vssd1 vssd1 vccd1 vccd1 spi_mem2.data_buf\[22\]
+ sky130_fd_sc_hd__dfrtp_1
X_2186_ clknet_leaf_11_clk_i _0200_ net475 vssd1 vssd1 vccd1 vccd1 spi_mem1.data_byte\[0\]
+ sky130_fd_sc_hd__dfrtp_1
X_2255_ clknet_leaf_21_clk_i _0269_ net482 vssd1 vssd1 vccd1 vccd1 spi_mem2.state\[3\]
+ sky130_fd_sc_hd__dfrtp_4
X_1206_ net700 net264 net390 vssd1 vssd1 vccd1 vccd1 _0068_ sky130_fd_sc_hd__mux2_1
X_1137_ net46 net548 net407 vssd1 vssd1 vccd1 vccd1 _0030_ sky130_fd_sc_hd__mux2_1
X_1068_ net148 net149 _0977_ _0979_ vssd1 vssd1 vccd1 vccd1 _0980_ sky130_fd_sc_hd__and4_1
XFILLER_0_62_148 vssd1 vssd1 vccd1 vccd1 sky130_ef_sc_hd__decap_12
XFILLER_0_62_126 vssd1 vssd1 vccd1 vccd1 sky130_ef_sc_hd__decap_12
XFILLER_0_47_167 vssd1 vssd1 vccd1 vccd1 sky130_fd_sc_hd__fill_1
XFILLER_0_50_80 vssd1 vssd1 vccd1 vccd1 sky130_fd_sc_hd__decap_4
Xinput204 sport2_i[54] vssd1 vssd1 vccd1 vccd1 net204 sky130_fd_sc_hd__buf_1
Xinput215 sport2_i[64] vssd1 vssd1 vccd1 vccd1 net215 sky130_fd_sc_hd__clkbuf_2
XFILLER_0_11_281 vssd1 vssd1 vccd1 vccd1 sky130_fd_sc_hd__fill_2
XFILLER_0_11_292 vssd1 vssd1 vccd1 vccd1 sky130_fd_sc_hd__decap_6
XFILLER_0_14_29 vssd1 vssd1 vccd1 vccd1 sky130_fd_sc_hd__decap_3
XFILLER_0_26_329 vssd1 vssd1 vccd1 vccd1 sky130_fd_sc_hd__decap_3
XFILLER_0_26_307 vssd1 vssd1 vccd1 vccd1 sky130_fd_sc_hd__fill_1
XFILLER_0_39_15 vssd1 vssd1 vccd1 vccd1 sky130_fd_sc_hd__decap_8
XTAP_207 vssd1 vccd1 sky130_fd_sc_hd__tapvpwrvgnd_1
XTAP_218 vssd1 vccd1 sky130_fd_sc_hd__tapvpwrvgnd_1
XTAP_229 vssd1 vccd1 sky130_fd_sc_hd__tapvpwrvgnd_1
Xhold3 spi_mem1.latency\[4\] vssd1 vssd1 vccd1 vccd1 net507 sky130_fd_sc_hd__dlygate4sd3_1
X_2040_ clknet_leaf_3_clk_i _0066_ net453 vssd1 vssd1 vccd1 vccd1 net262 sky130_fd_sc_hd__dfrtp_1
XFILLER_0_44_137 vssd1 vssd1 vccd1 vccd1 sky130_fd_sc_hd__decap_3
X_1686_ net758 _0735_ _0737_ net370 vssd1 vssd1 vccd1 vccd1 _0231_ sky130_fd_sc_hd__a22o_1
XFILLER_0_52_181 vssd1 vssd1 vccd1 vccd1 sky130_fd_sc_hd__fill_1
XFILLER_0_40_365 vssd1 vssd1 vccd1 vccd1 sky130_fd_sc_hd__decap_8
XFILLER_0_40_354 vssd1 vssd1 vccd1 vccd1 sky130_fd_sc_hd__decap_8
XFILLER_0_40_321 vssd1 vssd1 vccd1 vccd1 sky130_fd_sc_hd__fill_1
X_1755_ net200 _0777_ vssd1 vssd1 vccd1 vccd1 _0779_ sky130_fd_sc_hd__xnor2_1
X_1824_ net657 net341 net380 vssd1 vssd1 vccd1 vccd1 _0291_ sky130_fd_sc_hd__mux2_1
XTAP_752 vssd1 vccd1 sky130_fd_sc_hd__tapvpwrvgnd_1
XTAP_741 vssd1 vccd1 sky130_fd_sc_hd__tapvpwrvgnd_1
XTAP_730 vssd1 vccd1 sky130_fd_sc_hd__tapvpwrvgnd_1
XFILLER_0_31_3 vssd1 vssd1 vccd1 vccd1 sky130_ef_sc_hd__decap_12
X_2307_ clknet_leaf_35_clk_i _0315_ net449 vssd1 vssd1 vccd1 vccd1 spi_mem2.data_buf\[5\]
+ sky130_fd_sc_hd__dfrtp_1
X_2238_ clknet_leaf_28_clk_i _0252_ net460 vssd1 vssd1 vccd1 vccd1 spi_mem2.address\[11\]
+ sky130_fd_sc_hd__dfrtp_1
X_2169_ clknet_leaf_5_clk_i _0189_ net471 vssd1 vssd1 vccd1 vccd1 net313 sky130_fd_sc_hd__dfrtp_1
XFILLER_0_0_93 vssd1 vssd1 vccd1 vccd1 sky130_fd_sc_hd__fill_2
XFILLER_0_9_80 vssd1 vssd1 vccd1 vccd1 sky130_fd_sc_hd__decap_4
XFILLER_0_25_28 vssd1 vssd1 vccd1 vccd1 sky130_fd_sc_hd__decap_4
XFILLER_0_66_262 vssd1 vssd1 vccd1 vccd1 sky130_fd_sc_hd__fill_2
XFILLER_0_66_251 vssd1 vssd1 vccd1 vccd1 sky130_fd_sc_hd__fill_1
X_1540_ net534 net318 net385 vssd1 vssd1 vccd1 vccd1 _0193_ sky130_fd_sc_hd__mux2_1
XFILLER_0_22_321 vssd1 vssd1 vccd1 vccd1 sky130_ef_sc_hd__decap_12
XFILLER_0_1_259 vssd1 vssd1 vccd1 vccd1 sky130_fd_sc_hd__fill_1
XFILLER_0_5_27 vssd1 vssd1 vccd1 vccd1 sky130_fd_sc_hd__fill_1
X_1471_ net136 net135 _0590_ vssd1 vssd1 vccd1 vccd1 _0596_ sky130_fd_sc_hd__or3_1
XFILLER_0_82_12 vssd1 vssd1 vccd1 vccd1 sky130_fd_sc_hd__fill_2
X_2023_ clknet_leaf_25_clk_i _0049_ net465 vssd1 vssd1 vccd1 vccd1 spi_mem0.address_nibble\[1\]
+ sky130_fd_sc_hd__dfstp_2
X_1807_ spi_mem2.data_buf\[4\] net709 net379 vssd1 vssd1 vccd1 vccd1 _0274_ sky130_fd_sc_hd__mux2_1
XFILLER_0_79_3 vssd1 vssd1 vccd1 vccd1 sky130_ef_sc_hd__decap_12
Xhold277 net253 vssd1 vssd1 vccd1 vccd1 net781 sky130_fd_sc_hd__dlygate4sd3_1
Xhold244 spi_mem1.data_buf\[4\] vssd1 vssd1 vccd1 vccd1 net748 sky130_fd_sc_hd__dlygate4sd3_1
Xhold200 _0187_ vssd1 vssd1 vccd1 vccd1 net704 sky130_fd_sc_hd__dlygate4sd3_1
Xhold233 spi_mem1.data_buf\[0\] vssd1 vssd1 vccd1 vccd1 net737 sky130_fd_sc_hd__dlygate4sd3_1
Xhold222 spi_mem1.data_buf\[3\] vssd1 vssd1 vccd1 vccd1 net726 sky130_fd_sc_hd__dlygate4sd3_1
Xhold255 _0191_ vssd1 vssd1 vccd1 vccd1 net759 sky130_fd_sc_hd__dlygate4sd3_1
Xhold299 _0163_ vssd1 vssd1 vccd1 vccd1 net803 sky130_fd_sc_hd__dlygate4sd3_1
X_1669_ net509 _0724_ _0727_ net369 vssd1 vssd1 vccd1 vccd1 _0224_ sky130_fd_sc_hd__a22o_1
Xhold288 net297 vssd1 vssd1 vccd1 vccd1 net792 sky130_fd_sc_hd__dlygate4sd3_1
Xhold211 spi_mem0.data_buf\[30\] vssd1 vssd1 vccd1 vccd1 net715 sky130_fd_sc_hd__dlygate4sd3_1
Xhold266 spi_mem2.data_buf\[19\] vssd1 vssd1 vccd1 vccd1 net770 sky130_fd_sc_hd__dlygate4sd3_1
X_1738_ net689 net405 _0766_ _0767_ vssd1 vssd1 vccd1 vccd1 _0253_ sky130_fd_sc_hd__a22o_1
XTAP_593 vssd1 vccd1 sky130_fd_sc_hd__tapvpwrvgnd_1
XTAP_582 vssd1 vccd1 sky130_fd_sc_hd__tapvpwrvgnd_1
XTAP_571 vssd1 vccd1 sky130_fd_sc_hd__tapvpwrvgnd_1
XTAP_560 vssd1 vccd1 sky130_fd_sc_hd__tapvpwrvgnd_1
XFILLER_0_63_210 vssd1 vssd1 vccd1 vccd1 sky130_fd_sc_hd__decap_6
XFILLER_0_36_27 vssd1 vssd1 vccd1 vccd1 sky130_fd_sc_hd__fill_1
XFILLER_0_54_265 vssd1 vssd1 vccd1 vccd1 sky130_fd_sc_hd__decap_4
XFILLER_0_54_210 vssd1 vssd1 vccd1 vccd1 sky130_fd_sc_hd__decap_4
XFILLER_0_77_78 vssd1 vssd1 vccd1 vccd1 sky130_fd_sc_hd__fill_2
X_1454_ net132 net131 vssd1 vssd1 vccd1 vccd1 _0585_ sky130_fd_sc_hd__and2_1
X_1523_ net777 net299 net386 vssd1 vssd1 vccd1 vccd1 _0176_ sky130_fd_sc_hd__mux2_1
XFILLER_0_22_184 vssd1 vssd1 vccd1 vccd1 sky130_fd_sc_hd__fill_2
Xoutput349 net349 vssd1 vssd1 vccd1 vccd1 sport2_o[29] sky130_fd_sc_hd__clkbuf_4
Xoutput327 net327 vssd1 vssd1 vccd1 vccd1 sport1_o[9] sky130_fd_sc_hd__clkbuf_4
Xoutput338 net338 vssd1 vssd1 vccd1 vccd1 sport2_o[19] sky130_fd_sc_hd__clkbuf_4
Xoutput316 net316 vssd1 vssd1 vccd1 vccd1 sport1_o[2] sky130_fd_sc_hd__clkbuf_4
Xoutput305 net305 vssd1 vssd1 vccd1 vccd1 sport1_o[1] sky130_fd_sc_hd__clkbuf_4
X_1385_ _0540_ vssd1 vssd1 vccd1 vccd1 _0541_ sky130_fd_sc_hd__inv_2
XFILLER_0_77_89 vssd1 vssd1 vccd1 vccd1 sky130_fd_sc_hd__decap_6
XFILLER_0_77_335 vssd1 vssd1 vccd1 vccd1 sky130_fd_sc_hd__fill_1
XFILLER_0_77_313 vssd1 vssd1 vccd1 vccd1 sky130_fd_sc_hd__fill_1
X_2006_ clknet_leaf_25_clk_i _0032_ net462 vssd1 vssd1 vccd1 vccd1 spi_mem0.address\[6\]
+ sky130_fd_sc_hd__dfrtp_1
XFILLER_0_26_82 vssd1 vssd1 vccd1 vccd1 sky130_fd_sc_hd__fill_2
XFILLER_0_68_346 vssd1 vssd1 vccd1 vccd1 sky130_ef_sc_hd__decap_12
XFILLER_0_68_324 vssd1 vssd1 vccd1 vccd1 sky130_fd_sc_hd__fill_2
XTAP_390 vssd1 vccd1 sky130_fd_sc_hd__tapvpwrvgnd_1
XPHY_30 vssd1 vssd1 vccd1 vccd1 sky130_fd_sc_hd__decap_3
XPHY_96 vssd1 vssd1 vccd1 vccd1 sky130_fd_sc_hd__decap_3
XPHY_85 vssd1 vssd1 vccd1 vccd1 sky130_fd_sc_hd__decap_3
XPHY_74 vssd1 vssd1 vccd1 vccd1 sky130_fd_sc_hd__decap_3
XFILLER_0_36_265 vssd1 vssd1 vccd1 vccd1 sky130_fd_sc_hd__decap_8
XFILLER_0_36_221 vssd1 vssd1 vccd1 vccd1 sky130_fd_sc_hd__decap_3
XPHY_63 vssd1 vssd1 vccd1 vccd1 sky130_fd_sc_hd__decap_3
XPHY_52 vssd1 vssd1 vccd1 vccd1 sky130_fd_sc_hd__decap_3
XPHY_41 vssd1 vssd1 vccd1 vccd1 sky130_fd_sc_hd__decap_3
XFILLER_0_47_15 vssd1 vssd1 vccd1 vccd1 sky130_ef_sc_hd__decap_12
X_1170_ _0000_ net71 net70 net77 vssd1 vssd1 vccd1 vccd1 _0402_ sky130_fd_sc_hd__or4b_1
XFILLER_0_74_316 vssd1 vssd1 vccd1 vccd1 sky130_fd_sc_hd__fill_2
XFILLER_0_59_324 vssd1 vssd1 vccd1 vccd1 sky130_fd_sc_hd__fill_1
X_1506_ _0938_ _0940_ net395 net150 _0627_ vssd1 vssd1 vccd1 vccd1 _0628_ sky130_fd_sc_hd__a221o_1
X_1437_ net617 net413 _0571_ _0572_ vssd1 vssd1 vccd1 vccd1 _0147_ sky130_fd_sc_hd__o22a_1
XFILLER_0_77_121 vssd1 vssd1 vccd1 vccd1 sky130_fd_sc_hd__decap_3
XFILLER_0_77_110 vssd1 vssd1 vccd1 vccd1 sky130_fd_sc_hd__fill_2
X_1368_ net679 _0527_ _0528_ net375 vssd1 vssd1 vccd1 vccd1 _0122_ sky130_fd_sc_hd__a22o_1
X_1299_ net28 net414 _0482_ _0486_ vssd1 vssd1 vccd1 vccd1 _0487_ sky130_fd_sc_hd__a22o_1
XFILLER_0_77_154 vssd1 vssd1 vccd1 vccd1 sky130_ef_sc_hd__decap_12
XFILLER_0_18_265 vssd1 vssd1 vccd1 vccd1 sky130_ef_sc_hd__decap_12
XFILLER_0_73_393 vssd1 vssd1 vccd1 vccd1 sky130_ef_sc_hd__decap_12
XFILLER_0_5_181 vssd1 vssd1 vccd1 vccd1 sky130_fd_sc_hd__fill_2
Xfanout395 _0532_ vssd1 vssd1 vccd1 vccd1 net395 sky130_fd_sc_hd__clkbuf_4
Xfanout373 _0481_ vssd1 vssd1 vccd1 vccd1 net373 sky130_fd_sc_hd__clkbuf_2
Xfanout362 net363 vssd1 vssd1 vccd1 vccd1 net362 sky130_fd_sc_hd__clkbuf_4
XFILLER_0_33_28 vssd1 vssd1 vccd1 vccd1 sky130_fd_sc_hd__decap_6
Xinput15 spi2_miso_i[2] vssd1 vssd1 vccd1 vccd1 net15 sky130_fd_sc_hd__clkbuf_1
Xclkbuf_leaf_4_clk_i clknet_2_0__leaf_clk_i vssd1 vssd1 vccd1 vccd1 clknet_leaf_4_clk_i
+ sky130_fd_sc_hd__clkbuf_16
Xinput59 sport0_i[48] vssd1 vssd1 vccd1 vccd1 net59 sky130_fd_sc_hd__buf_1
Xinput37 sport0_i[28] vssd1 vssd1 vccd1 vccd1 net37 sky130_fd_sc_hd__buf_1
Xinput26 sport0_i[18] vssd1 vssd1 vccd1 vccd1 net26 sky130_fd_sc_hd__buf_1
Xinput48 sport0_i[38] vssd1 vssd1 vccd1 vccd1 net48 sky130_fd_sc_hd__buf_1
X_2340_ net259 vssd1 vssd1 vccd1 vccd1 net256 sky130_fd_sc_hd__clkbuf_1
XFILLER_0_32_290 vssd1 vssd1 vccd1 vccd1 sky130_fd_sc_hd__decap_4
X_2271_ clknet_leaf_38_clk_i net577 net445 vssd1 vssd1 vccd1 vccd1 net334 sky130_fd_sc_hd__dfrtp_1
X_1084_ spi_mem0.state\[2\] _0921_ _0945_ _0950_ vssd1 vssd1 vccd1 vccd1 net227 sky130_fd_sc_hd__or4_4
X_1153_ net64 net599 net409 vssd1 vssd1 vccd1 vccd1 _0046_ sky130_fd_sc_hd__mux2_1
X_1222_ net746 net281 net388 vssd1 vssd1 vccd1 vccd1 _0084_ sky130_fd_sc_hd__mux2_1
XFILLER_0_74_124 vssd1 vssd1 vccd1 vccd1 sky130_fd_sc_hd__fill_1
XFILLER_0_59_187 vssd1 vssd1 vccd1 vccd1 sky130_fd_sc_hd__decap_8
XFILLER_0_70_385 vssd1 vssd1 vccd1 vccd1 sky130_fd_sc_hd__fill_2
XFILLER_0_61_3 vssd1 vssd1 vccd1 vccd1 sky130_ef_sc_hd__decap_12
XFILLER_0_80_138 vssd1 vssd1 vccd1 vccd1 sky130_fd_sc_hd__fill_2
XFILLER_0_61_341 vssd1 vssd1 vccd1 vccd1 sky130_fd_sc_hd__fill_1
XFILLER_0_21_249 vssd1 vssd1 vccd1 vccd1 sky130_fd_sc_hd__decap_4
XFILLER_0_44_38 vssd1 vssd1 vccd1 vccd1 sky130_fd_sc_hd__decap_4
XFILLER_0_44_27 vssd1 vssd1 vccd1 vccd1 sky130_fd_sc_hd__fill_1
XFILLER_0_60_15 vssd1 vssd1 vccd1 vccd1 sky130_ef_sc_hd__decap_12
XFILLER_0_56_157 vssd1 vssd1 vccd1 vccd1 sky130_fd_sc_hd__fill_1
X_1840_ spi_mem2.data_buf\[16\] spi_mem2.data_buf\[20\] spi_mem2.data_buf\[24\] spi_mem2.data_buf\[28\]
+ net423 net420 vssd1 vssd1 vccd1 vccd1 _0821_ sky130_fd_sc_hd__mux4_1
XFILLER_0_69_57 vssd1 vssd1 vccd1 vccd1 sky130_ef_sc_hd__decap_12
XFILLER_0_52_363 vssd1 vssd1 vccd1 vccd1 sky130_fd_sc_hd__fill_1
XFILLER_0_37_393 vssd1 vssd1 vccd1 vccd1 sky130_ef_sc_hd__decap_12
X_1771_ _0746_ _0787_ vssd1 vssd1 vccd1 vccd1 _0789_ sky130_fd_sc_hd__nand2_1
X_2254_ clknet_leaf_22_clk_i _0268_ net481 vssd1 vssd1 vccd1 vccd1 spi_mem2.state\[2\]
+ sky130_fd_sc_hd__dfrtp_4
XFILLER_0_33_7 vssd1 vssd1 vccd1 vccd1 sky130_fd_sc_hd__fill_1
X_2323_ clknet_leaf_31_clk_i _0331_ net457 vssd1 vssd1 vccd1 vccd1 spi_mem2.data_buf\[21\]
+ sky130_fd_sc_hd__dfrtp_1
X_2185_ clknet_leaf_12_clk_i _0199_ net477 vssd1 vssd1 vccd1 vccd1 spi_mem1.data_nibble
+ sky130_fd_sc_hd__dfrtp_2
X_1067_ spi_mem1.data_byte\[1\] _0978_ vssd1 vssd1 vccd1 vccd1 _0979_ sky130_fd_sc_hd__and2_2
XFILLER_0_47_113 vssd1 vssd1 vccd1 vccd1 sky130_fd_sc_hd__fill_1
X_1205_ net514 net263 net390 vssd1 vssd1 vccd1 vccd1 _0067_ sky130_fd_sc_hd__mux2_1
X_1136_ net45 net533 net407 vssd1 vssd1 vccd1 vccd1 _0029_ sky130_fd_sc_hd__mux2_1
XFILLER_0_18_72 vssd1 vssd1 vccd1 vccd1 sky130_fd_sc_hd__decap_4
XFILLER_0_62_138 vssd1 vssd1 vccd1 vccd1 sky130_fd_sc_hd__fill_2
X_1969_ _0968_ _0913_ net364 vssd1 vssd1 vccd1 vccd1 _0914_ sky130_fd_sc_hd__o21ai_2
Xinput205 sport2_i[55] vssd1 vssd1 vccd1 vccd1 net205 sky130_fd_sc_hd__buf_1
Xinput216 sport2_i[65] vssd1 vssd1 vccd1 vccd1 net216 sky130_fd_sc_hd__buf_1
XFILLER_0_34_363 vssd1 vssd1 vccd1 vccd1 sky130_fd_sc_hd__fill_1
XFILLER_0_34_330 vssd1 vssd1 vccd1 vccd1 sky130_fd_sc_hd__fill_1
Xhold4 spi_mem0.latency\[4\] vssd1 vssd1 vccd1 vccd1 net508 sky130_fd_sc_hd__dlygate4sd3_1
XFILLER_0_55_15 vssd1 vssd1 vccd1 vccd1 sky130_ef_sc_hd__decap_12
XTAP_208 vssd1 vccd1 sky130_fd_sc_hd__tapvpwrvgnd_1
XTAP_219 vssd1 vccd1 sky130_fd_sc_hd__tapvpwrvgnd_1
XFILLER_0_71_47 vssd1 vssd1 vccd1 vccd1 sky130_fd_sc_hd__decap_3
Xclkbuf_leaf_22_clk_i clknet_2_3__leaf_clk_i vssd1 vssd1 vccd1 vccd1 clknet_leaf_22_clk_i
+ sky130_fd_sc_hd__clkbuf_16
XFILLER_0_44_116 vssd1 vssd1 vccd1 vccd1 sky130_fd_sc_hd__decap_6
X_1823_ spi_mem2.data_buf\[20\] net632 net380 vssd1 vssd1 vccd1 vccd1 _0290_ sky130_fd_sc_hd__mux2_1
Xclkbuf_leaf_37_clk_i clknet_2_0__leaf_clk_i vssd1 vssd1 vccd1 vccd1 clknet_leaf_37_clk_i
+ sky130_fd_sc_hd__clkbuf_16
X_1685_ net107 net397 _0694_ _0734_ vssd1 vssd1 vccd1 vccd1 _0737_ sky130_fd_sc_hd__a22o_1
X_1754_ _0777_ _0778_ net582 net404 vssd1 vssd1 vccd1 vccd1 _0258_ sky130_fd_sc_hd__a2bb2o_1
XFILLER_0_20_73 vssd1 vssd1 vccd1 vccd1 sky130_fd_sc_hd__decap_8
XTAP_753 vssd1 vccd1 sky130_fd_sc_hd__tapvpwrvgnd_1
XTAP_742 vssd1 vccd1 sky130_fd_sc_hd__tapvpwrvgnd_1
XTAP_731 vssd1 vccd1 sky130_fd_sc_hd__tapvpwrvgnd_1
XTAP_720 vssd1 vccd1 sky130_fd_sc_hd__tapvpwrvgnd_1
X_2237_ clknet_leaf_27_clk_i _0251_ net464 vssd1 vssd1 vccd1 vccd1 spi_mem2.address\[10\]
+ sky130_fd_sc_hd__dfrtp_1
XFILLER_0_24_3 vssd1 vssd1 vccd1 vccd1 sky130_fd_sc_hd__fill_1
X_2306_ clknet_leaf_0_clk_i _0314_ net446 vssd1 vssd1 vccd1 vccd1 spi_mem2.data_buf\[4\]
+ sky130_fd_sc_hd__dfrtp_1
X_1985__9 clknet_leaf_19_clk_i vssd1 vssd1 vccd1 vccd1 net498 sky130_fd_sc_hd__inv_2
X_1119_ _0381_ net818 _0377_ vssd1 vssd1 vccd1 vccd1 _0020_ sky130_fd_sc_hd__mux2_1
X_2168_ clknet_leaf_5_clk_i _0188_ net471 vssd1 vssd1 vccd1 vccd1 net312 sky130_fd_sc_hd__dfrtp_2
X_2099_ clknet_leaf_34_clk_i _0119_ net455 vssd1 vssd1 vccd1 vccd1 spi_mem0.data_buf\[25\]
+ sky130_fd_sc_hd__dfrtp_1
XFILLER_0_61_80 vssd1 vssd1 vccd1 vccd1 sky130_fd_sc_hd__decap_4
XFILLER_0_31_333 vssd1 vssd1 vccd1 vccd1 sky130_fd_sc_hd__decap_3
XFILLER_0_16_374 vssd1 vssd1 vccd1 vccd1 sky130_fd_sc_hd__fill_2
XFILLER_0_81_233 vssd1 vssd1 vccd1 vccd1 sky130_fd_sc_hd__decap_3
XFILLER_0_34_193 vssd1 vssd1 vccd1 vccd1 sky130_fd_sc_hd__decap_3
XFILLER_0_22_355 vssd1 vssd1 vccd1 vccd1 sky130_fd_sc_hd__decap_8
XFILLER_0_22_333 vssd1 vssd1 vccd1 vccd1 sky130_ef_sc_hd__decap_12
X_1470_ net135 _0590_ vssd1 vssd1 vccd1 vccd1 _0595_ sky130_fd_sc_hd__nor2_1
XFILLER_0_82_68 vssd1 vssd1 vccd1 vccd1 sky130_fd_sc_hd__fill_2
XFILLER_0_82_57 vssd1 vssd1 vccd1 vccd1 sky130_fd_sc_hd__decap_4
X_2022_ clknet_leaf_25_clk_i _0048_ net465 vssd1 vssd1 vccd1 vccd1 spi_mem0.address_nibble\[0\]
+ sky130_fd_sc_hd__dfstp_4
XFILLER_0_57_296 vssd1 vssd1 vccd1 vccd1 sky130_fd_sc_hd__decap_3
X_1806_ spi_mem2.data_buf\[3\] net634 net379 vssd1 vssd1 vccd1 vccd1 _0273_ sky130_fd_sc_hd__mux2_1
Xhold201 spi_mem2.address\[11\] vssd1 vssd1 vccd1 vccd1 net705 sky130_fd_sc_hd__dlygate4sd3_1
Xhold278 spi_mem1.latency\[3\] vssd1 vssd1 vccd1 vccd1 net782 sky130_fd_sc_hd__dlygate4sd3_1
X_1599_ _0977_ _0982_ net430 vssd1 vssd1 vccd1 vccd1 _0683_ sky130_fd_sc_hd__o21ba_1
Xhold234 _0162_ vssd1 vssd1 vccd1 vccd1 net738 sky130_fd_sc_hd__dlygate4sd3_1
Xhold223 _0165_ vssd1 vssd1 vccd1 vccd1 net727 sky130_fd_sc_hd__dlygate4sd3_1
XTAP_561 vssd1 vccd1 sky130_fd_sc_hd__tapvpwrvgnd_1
XTAP_550 vssd1 vccd1 sky130_fd_sc_hd__tapvpwrvgnd_1
Xhold267 spi_mem1.data_buf\[27\] vssd1 vssd1 vccd1 vccd1 net771 sky130_fd_sc_hd__buf_1
X_1668_ net100 net397 _0696_ _0723_ vssd1 vssd1 vccd1 vccd1 _0727_ sky130_fd_sc_hd__a22o_1
Xhold289 _0174_ vssd1 vssd1 vccd1 vccd1 net793 sky130_fd_sc_hd__dlygate4sd3_1
Xhold212 _0085_ vssd1 vssd1 vccd1 vccd1 net716 sky130_fd_sc_hd__dlygate4sd3_1
Xhold245 spi_mem2.data_buf\[0\] vssd1 vssd1 vccd1 vccd1 net749 sky130_fd_sc_hd__dlygate4sd3_1
X_1737_ net405 _0765_ vssd1 vssd1 vccd1 vccd1 _0767_ sky130_fd_sc_hd__nor2_1
Xhold256 net271 vssd1 vssd1 vccd1 vccd1 net760 sky130_fd_sc_hd__dlygate4sd3_1
XTAP_594 vssd1 vccd1 sky130_fd_sc_hd__tapvpwrvgnd_1
XTAP_583 vssd1 vccd1 sky130_fd_sc_hd__tapvpwrvgnd_1
XTAP_572 vssd1 vccd1 sky130_fd_sc_hd__tapvpwrvgnd_1
XFILLER_0_63_288 vssd1 vssd1 vccd1 vccd1 sky130_fd_sc_hd__fill_1
XFILLER_0_63_277 vssd1 vssd1 vccd1 vccd1 sky130_fd_sc_hd__decap_3
XFILLER_0_51_406 vssd1 vssd1 vccd1 vccd1 sky130_fd_sc_hd__fill_1
XFILLER_0_31_196 vssd1 vssd1 vccd1 vccd1 sky130_ef_sc_hd__decap_12
XFILLER_0_31_152 vssd1 vssd1 vccd1 vccd1 sky130_ef_sc_hd__decap_12
XFILLER_0_77_57 vssd1 vssd1 vccd1 vccd1 sky130_fd_sc_hd__decap_8
XFILLER_0_77_35 vssd1 vssd1 vccd1 vccd1 sky130_fd_sc_hd__fill_2
X_1453_ net522 net411 _0584_ vssd1 vssd1 vccd1 vccd1 _0151_ sky130_fd_sc_hd__a21o_1
XFILLER_0_58_9 vssd1 vssd1 vccd1 vccd1 sky130_fd_sc_hd__fill_1
X_1522_ net661 net298 net386 vssd1 vssd1 vccd1 vccd1 _0175_ sky130_fd_sc_hd__mux2_1
Xoutput317 net317 vssd1 vssd1 vccd1 vccd1 sport1_o[30] sky130_fd_sc_hd__clkbuf_4
Xoutput339 net339 vssd1 vssd1 vccd1 vccd1 sport2_o[1] sky130_fd_sc_hd__clkbuf_4
Xoutput328 net328 vssd1 vssd1 vccd1 vccd1 sport2_o[0] sky130_fd_sc_hd__clkbuf_4
Xoutput306 net306 vssd1 vssd1 vccd1 vccd1 sport1_o[20] sky130_fd_sc_hd__clkbuf_4
XFILLER_0_22_141 vssd1 vssd1 vccd1 vccd1 sky130_fd_sc_hd__decap_6
X_1384_ spi_mem1.latency\[3\] spi_mem1.latency\[4\] _0539_ vssd1 vssd1 vccd1 vccd1
+ _0540_ sky130_fd_sc_hd__or3_1
X_2005_ clknet_leaf_32_clk_i _0031_ net462 vssd1 vssd1 vccd1 vccd1 spi_mem0.address\[5\]
+ sky130_fd_sc_hd__dfrtp_1
XFILLER_0_45_222 vssd1 vssd1 vccd1 vccd1 sky130_fd_sc_hd__fill_2
XFILLER_0_33_406 vssd1 vssd1 vccd1 vccd1 sky130_fd_sc_hd__fill_1
XFILLER_0_67_90 vssd1 vssd1 vccd1 vccd1 sky130_ef_sc_hd__decap_12
XTAP_391 vssd1 vccd1 sky130_fd_sc_hd__tapvpwrvgnd_1
XTAP_380 vssd1 vccd1 sky130_fd_sc_hd__tapvpwrvgnd_1
X_1005__1 clknet_leaf_12_clk_i vssd1 vssd1 vccd1 vccd1 net490 sky130_fd_sc_hd__inv_2
XFILLER_0_68_358 vssd1 vssd1 vccd1 vccd1 sky130_fd_sc_hd__decap_6
XPHY_64 vssd1 vssd1 vccd1 vccd1 sky130_fd_sc_hd__decap_3
XPHY_53 vssd1 vssd1 vccd1 vccd1 sky130_fd_sc_hd__decap_3
XPHY_20 vssd1 vssd1 vccd1 vccd1 sky130_fd_sc_hd__decap_3
XPHY_31 vssd1 vssd1 vccd1 vccd1 sky130_fd_sc_hd__decap_3
XPHY_42 vssd1 vssd1 vccd1 vccd1 sky130_fd_sc_hd__decap_3
XPHY_97 vssd1 vssd1 vccd1 vccd1 sky130_fd_sc_hd__decap_3
XPHY_86 vssd1 vssd1 vccd1 vccd1 sky130_fd_sc_hd__decap_3
XPHY_75 vssd1 vssd1 vccd1 vccd1 sky130_fd_sc_hd__decap_3
XFILLER_0_47_27 vssd1 vssd1 vccd1 vccd1 sky130_fd_sc_hd__decap_8
XFILLER_0_2_29 vssd1 vssd1 vccd1 vccd1 sky130_fd_sc_hd__fill_2
XFILLER_0_67_391 vssd1 vssd1 vccd1 vccd1 sky130_fd_sc_hd__fill_1
XFILLER_0_12_85 vssd1 vssd1 vccd1 vccd1 sky130_fd_sc_hd__decap_3
XFILLER_0_15_406 vssd1 vssd1 vccd1 vccd1 sky130_fd_sc_hd__fill_1
X_1505_ net432 net434 _0964_ _0623_ vssd1 vssd1 vccd1 vccd1 _0627_ sky130_fd_sc_hd__a31o_1
X_1436_ net126 _0568_ net412 vssd1 vssd1 vccd1 vccd1 _0572_ sky130_fd_sc_hd__o21ai_1
X_1367_ net37 net415 _0484_ _0526_ vssd1 vssd1 vccd1 vccd1 _0528_ sky130_fd_sc_hd__a22o_1
XFILLER_0_10_155 vssd1 vssd1 vccd1 vccd1 sky130_fd_sc_hd__fill_2
XFILLER_0_77_166 vssd1 vssd1 vccd1 vccd1 sky130_fd_sc_hd__fill_2
X_1298_ spi_mem0.delayed_miso\[1\] _0344_ vssd1 vssd1 vccd1 vccd1 _0486_ sky130_fd_sc_hd__and2_2
Xfanout396 net397 vssd1 vssd1 vccd1 vccd1 net396 sky130_fd_sc_hd__clkbuf_4
Xfanout385 net386 vssd1 vssd1 vccd1 vccd1 net385 sky130_fd_sc_hd__clkbuf_4
Xfanout374 net376 vssd1 vssd1 vccd1 vccd1 net374 sky130_fd_sc_hd__buf_4
Xfanout363 _0868_ vssd1 vssd1 vccd1 vccd1 net363 sky130_fd_sc_hd__clkbuf_2
XFILLER_0_68_100 vssd1 vssd1 vccd1 vccd1 sky130_fd_sc_hd__decap_8
XFILLER_0_49_391 vssd1 vssd1 vccd1 vccd1 sky130_fd_sc_hd__fill_1
Xinput16 spi2_miso_i[3] vssd1 vssd1 vccd1 vccd1 net16 sky130_fd_sc_hd__clkbuf_1
Xinput49 sport0_i[39] vssd1 vssd1 vccd1 vccd1 net49 sky130_fd_sc_hd__clkbuf_1
Xinput27 sport0_i[19] vssd1 vssd1 vccd1 vccd1 net27 sky130_fd_sc_hd__buf_1
Xinput38 sport0_i[29] vssd1 vssd1 vccd1 vccd1 net38 sky130_fd_sc_hd__buf_1
XFILLER_0_58_26 vssd1 vssd1 vccd1 vccd1 sky130_fd_sc_hd__fill_2
X_1221_ net679 net280 net389 vssd1 vssd1 vccd1 vccd1 _0083_ sky130_fd_sc_hd__mux2_1
X_2270_ clknet_leaf_38_clk_i net611 net447 vssd1 vssd1 vccd1 vccd1 net333 sky130_fd_sc_hd__dfrtp_1
X_1083_ net542 _0344_ _0347_ _0351_ vssd1 vssd1 vccd1 vccd1 _0984_ sky130_fd_sc_hd__a22o_1
X_1152_ net63 net688 net407 vssd1 vssd1 vccd1 vccd1 _0045_ sky130_fd_sc_hd__mux2_1
XFILLER_0_74_147 vssd1 vssd1 vccd1 vccd1 sky130_ef_sc_hd__decap_12
XFILLER_0_59_166 vssd1 vssd1 vccd1 vccd1 sky130_fd_sc_hd__fill_2
XFILLER_0_55_383 vssd1 vssd1 vccd1 vccd1 sky130_fd_sc_hd__decap_8
XFILLER_0_55_361 vssd1 vssd1 vccd1 vccd1 sky130_fd_sc_hd__fill_2
XFILLER_0_2_141 vssd1 vssd1 vccd1 vccd1 sky130_fd_sc_hd__fill_1
X_1419_ _0924_ net584 net410 vssd1 vssd1 vccd1 vccd1 _0141_ sky130_fd_sc_hd__mux2_1
XFILLER_0_54_3 vssd1 vssd1 vccd1 vccd1 sky130_ef_sc_hd__decap_12
XFILLER_0_48_92 vssd1 vssd1 vccd1 vccd1 sky130_fd_sc_hd__fill_2
XFILLER_0_65_103 vssd1 vssd1 vccd1 vccd1 sky130_fd_sc_hd__decap_4
XFILLER_0_80_106 vssd1 vssd1 vccd1 vccd1 sky130_fd_sc_hd__decap_3
XFILLER_0_60_27 vssd1 vssd1 vccd1 vccd1 sky130_fd_sc_hd__fill_1
XFILLER_0_56_125 vssd1 vssd1 vccd1 vccd1 sky130_ef_sc_hd__decap_12
XFILLER_0_44_309 vssd1 vssd1 vccd1 vccd1 sky130_fd_sc_hd__decap_8
X_1770_ _0740_ _0742_ _0788_ spi_mem2.address_nibble\[1\] vssd1 vssd1 vccd1 vccd1
+ _0264_ sky130_fd_sc_hd__o2bb2a_1
XFILLER_0_69_69 vssd1 vssd1 vccd1 vccd1 sky130_fd_sc_hd__decap_4
XFILLER_0_12_206 vssd1 vssd1 vccd1 vccd1 sky130_fd_sc_hd__decap_6
X_2184_ net499 _0002_ net486 vssd1 vssd1 vccd1 vccd1 spi_mem1.spi_clk sky130_fd_sc_hd__dfrtp_4
X_2253_ clknet_leaf_22_clk_i _0267_ net481 vssd1 vssd1 vccd1 vccd1 spi_mem2.state\[1\]
+ sky130_fd_sc_hd__dfrtp_4
X_1204_ net723 net769 net390 vssd1 vssd1 vccd1 vccd1 _0066_ sky130_fd_sc_hd__mux2_1
X_2322_ clknet_leaf_31_clk_i _0330_ net457 vssd1 vssd1 vccd1 vccd1 spi_mem2.data_buf\[20\]
+ sky130_fd_sc_hd__dfrtp_1
X_1066_ net430 net428 vssd1 vssd1 vccd1 vccd1 _0978_ sky130_fd_sc_hd__nor2_2
X_1135_ net44 net591 net409 vssd1 vssd1 vccd1 vccd1 _0028_ sky130_fd_sc_hd__mux2_1
XFILLER_0_47_169 vssd1 vssd1 vccd1 vccd1 sky130_fd_sc_hd__decap_4
XFILLER_0_28_372 vssd1 vssd1 vccd1 vccd1 sky130_fd_sc_hd__fill_2
X_1899_ net155 net400 _0869_ _0871_ vssd1 vssd1 vccd1 vccd1 _0872_ sky130_fd_sc_hd__a22o_1
X_1968_ net425 spi_mem2.data_byte\[1\] net422 vssd1 vssd1 vccd1 vccd1 _0913_ sky130_fd_sc_hd__and3_2
XFILLER_0_59_91 vssd1 vssd1 vccd1 vccd1 sky130_fd_sc_hd__fill_1
Xinput217 sport2_i[66] vssd1 vssd1 vccd1 vccd1 net217 sky130_fd_sc_hd__buf_1
Xinput206 sport2_i[56] vssd1 vssd1 vccd1 vccd1 net206 sky130_fd_sc_hd__clkbuf_1
Xclkbuf_leaf_3_clk_i clknet_2_0__leaf_clk_i vssd1 vssd1 vccd1 vccd1 clknet_leaf_3_clk_i
+ sky130_fd_sc_hd__clkbuf_16
Xhold5 spi_mem1.data_buf\[22\] vssd1 vssd1 vccd1 vccd1 net509 sky130_fd_sc_hd__dlygate4sd3_1
XTAP_209 vssd1 vccd1 sky130_fd_sc_hd__tapvpwrvgnd_1
XFILLER_0_71_15 vssd1 vssd1 vccd1 vccd1 sky130_ef_sc_hd__decap_12
XFILLER_0_29_103 vssd1 vssd1 vccd1 vccd1 sky130_fd_sc_hd__decap_8
X_1822_ spi_mem2.data_buf\[19\] net622 net380 vssd1 vssd1 vccd1 vccd1 _0289_ sky130_fd_sc_hd__mux2_1
X_1753_ net198 net197 _0774_ net406 vssd1 vssd1 vccd1 vccd1 _0778_ sky130_fd_sc_hd__o31ai_1
XTAP_743 vssd1 vccd1 sky130_fd_sc_hd__tapvpwrvgnd_1
XTAP_732 vssd1 vccd1 sky130_fd_sc_hd__tapvpwrvgnd_1
XTAP_721 vssd1 vccd1 sky130_fd_sc_hd__tapvpwrvgnd_1
XTAP_710 vssd1 vccd1 sky130_fd_sc_hd__tapvpwrvgnd_1
X_1684_ net696 _0735_ _0736_ net369 vssd1 vssd1 vccd1 vccd1 _0230_ sky130_fd_sc_hd__a22o_1
XFILLER_0_20_85 vssd1 vssd1 vccd1 vccd1 sky130_ef_sc_hd__decap_12
XTAP_754 vssd1 vccd1 sky130_fd_sc_hd__tapvpwrvgnd_1
X_2167_ clknet_leaf_12_clk_i net704 net478 vssd1 vssd1 vccd1 vccd1 net311 sky130_fd_sc_hd__dfrtp_2
X_2305_ clknet_leaf_39_clk_i _0313_ net444 vssd1 vssd1 vccd1 vccd1 spi_mem2.data_buf\[3\]
+ sky130_fd_sc_hd__dfrtp_1
X_2236_ clknet_leaf_28_clk_i _0250_ net460 vssd1 vssd1 vccd1 vccd1 spi_mem2.address\[9\]
+ sky130_fd_sc_hd__dfrtp_1
XFILLER_0_75_264 vssd1 vssd1 vccd1 vccd1 sky130_fd_sc_hd__decap_6
X_1118_ _0380_ vssd1 vssd1 vccd1 vccd1 _0381_ sky130_fd_sc_hd__inv_2
X_1049_ _0954_ _0965_ vssd1 vssd1 vccd1 vccd1 net259 sky130_fd_sc_hd__and2_2
X_2098_ clknet_leaf_34_clk_i _0118_ net455 vssd1 vssd1 vccd1 vccd1 spi_mem0.data_buf\[24\]
+ sky130_fd_sc_hd__dfrtp_1
XFILLER_0_0_51 vssd1 vssd1 vccd1 vccd1 sky130_fd_sc_hd__fill_2
XFILLER_0_28_180 vssd1 vssd1 vccd1 vccd1 sky130_fd_sc_hd__decap_4
XFILLER_0_58_209 vssd1 vssd1 vccd1 vccd1 sky130_fd_sc_hd__decap_8
XFILLER_0_81_289 vssd1 vssd1 vccd1 vccd1 sky130_fd_sc_hd__fill_1
XFILLER_0_81_223 vssd1 vssd1 vccd1 vccd1 sky130_fd_sc_hd__fill_1
XFILLER_0_34_150 vssd1 vssd1 vccd1 vccd1 sky130_fd_sc_hd__decap_8
XFILLER_0_66_15 vssd1 vssd1 vccd1 vccd1 sky130_fd_sc_hd__decap_4
XFILLER_0_22_345 vssd1 vssd1 vccd1 vccd1 sky130_fd_sc_hd__decap_6
X_2021_ clknet_leaf_30_clk_i _0047_ net461 vssd1 vssd1 vccd1 vccd1 spi_mem0.address\[21\]
+ sky130_fd_sc_hd__dfrtp_1
XFILLER_0_15_30 vssd1 vssd1 vccd1 vccd1 sky130_fd_sc_hd__fill_2
XFILLER_0_40_153 vssd1 vssd1 vccd1 vccd1 sky130_fd_sc_hd__decap_4
XFILLER_0_40_120 vssd1 vssd1 vccd1 vccd1 sky130_ef_sc_hd__decap_12
XFILLER_0_31_51 vssd1 vssd1 vccd1 vccd1 sky130_fd_sc_hd__decap_4
Xhold213 spi_mem2.data_buf\[31\] vssd1 vssd1 vccd1 vccd1 net717 sky130_fd_sc_hd__dlygate4sd3_1
Xhold202 net347 vssd1 vssd1 vccd1 vccd1 net706 sky130_fd_sc_hd__dlygate4sd3_1
X_1805_ spi_mem2.data_buf\[2\] net607 net379 vssd1 vssd1 vccd1 vccd1 _0272_ sky130_fd_sc_hd__mux2_1
Xhold235 spi_mem2.data_buf\[13\] vssd1 vssd1 vccd1 vccd1 net739 sky130_fd_sc_hd__dlygate4sd3_1
X_1736_ net190 net193 net192 net191 vssd1 vssd1 vccd1 vccd1 _0766_ sky130_fd_sc_hd__or4_1
Xhold224 spi_mem2.address\[2\] vssd1 vssd1 vccd1 vccd1 net728 sky130_fd_sc_hd__dlygate4sd3_1
X_1598_ _0976_ net394 _0538_ _0542_ vssd1 vssd1 vccd1 vccd1 _0682_ sky130_fd_sc_hd__a31o_1
XTAP_584 vssd1 vccd1 sky130_fd_sc_hd__tapvpwrvgnd_1
XTAP_573 vssd1 vccd1 sky130_fd_sc_hd__tapvpwrvgnd_1
XTAP_562 vssd1 vccd1 sky130_fd_sc_hd__tapvpwrvgnd_1
X_1667_ net571 _0724_ _0726_ net369 vssd1 vssd1 vccd1 vccd1 _0223_ sky130_fd_sc_hd__a22o_1
XTAP_551 vssd1 vccd1 sky130_fd_sc_hd__tapvpwrvgnd_1
XTAP_540 vssd1 vccd1 sky130_fd_sc_hd__tapvpwrvgnd_1
Xhold268 spi_mem1.data_buf\[15\] vssd1 vssd1 vccd1 vccd1 net772 sky130_fd_sc_hd__dlygate4sd3_1
XFILLER_0_40_197 vssd1 vssd1 vccd1 vccd1 sky130_ef_sc_hd__decap_12
Xhold246 spi_mem0.data_buf\[2\] vssd1 vssd1 vccd1 vccd1 net750 sky130_fd_sc_hd__dlygate4sd3_1
Xhold257 _0056_ vssd1 vssd1 vccd1 vccd1 net761 sky130_fd_sc_hd__dlygate4sd3_1
Xhold279 spi_mem2.data_buf\[20\] vssd1 vssd1 vccd1 vccd1 net783 sky130_fd_sc_hd__dlygate4sd3_1
XTAP_595 vssd1 vccd1 sky130_fd_sc_hd__tapvpwrvgnd_1
X_2219_ clknet_leaf_24_clk_i _0233_ net479 vssd1 vssd1 vccd1 vccd1 spi_mem1.data_buf\[31\]
+ sky130_fd_sc_hd__dfrtp_1
XFILLER_0_63_245 vssd1 vssd1 vccd1 vccd1 sky130_ef_sc_hd__decap_12
XFILLER_0_48_253 vssd1 vssd1 vccd1 vccd1 sky130_fd_sc_hd__fill_1
XFILLER_0_8_372 vssd1 vssd1 vccd1 vccd1 sky130_ef_sc_hd__decap_12
Xclkbuf_leaf_21_clk_i clknet_2_3__leaf_clk_i vssd1 vssd1 vccd1 vccd1 clknet_leaf_21_clk_i
+ sky130_fd_sc_hd__clkbuf_16
XFILLER_0_31_164 vssd1 vssd1 vccd1 vccd1 sky130_fd_sc_hd__decap_4
XFILLER_0_31_131 vssd1 vssd1 vccd1 vccd1 sky130_fd_sc_hd__decap_6
XFILLER_0_6_3 vssd1 vssd1 vccd1 vccd1 sky130_fd_sc_hd__decap_4
XFILLER_0_16_161 vssd1 vssd1 vccd1 vccd1 sky130_fd_sc_hd__decap_8
XFILLER_0_36_29 vssd1 vssd1 vccd1 vccd1 sky130_fd_sc_hd__decap_4
Xclkbuf_leaf_36_clk_i clknet_2_0__leaf_clk_i vssd1 vssd1 vccd1 vccd1 clknet_leaf_36_clk_i
+ sky130_fd_sc_hd__clkbuf_16
Xoutput307 net307 vssd1 vssd1 vccd1 vccd1 sport1_o[21] sky130_fd_sc_hd__clkbuf_4
X_1383_ spi_mem1.latency\[0\] spi_mem1.latency\[1\] spi_mem1.latency\[2\] vssd1 vssd1
+ vccd1 vccd1 _0539_ sky130_fd_sc_hd__or3_2
X_1452_ _0583_ net412 _0582_ vssd1 vssd1 vccd1 vccd1 _0584_ sky130_fd_sc_hd__and3b_1
X_1521_ spi_mem1.data_buf\[12\] net792 net386 vssd1 vssd1 vccd1 vccd1 _0174_ sky130_fd_sc_hd__mux2_1
XFILLER_0_22_197 vssd1 vssd1 vccd1 vccd1 sky130_ef_sc_hd__decap_12
XFILLER_0_22_164 vssd1 vssd1 vccd1 vccd1 sky130_ef_sc_hd__decap_12
Xoutput318 net318 vssd1 vssd1 vccd1 vccd1 sport1_o[31] sky130_fd_sc_hd__clkbuf_4
Xoutput329 net329 vssd1 vssd1 vccd1 vccd1 sport2_o[10] sky130_fd_sc_hd__clkbuf_4
XFILLER_0_77_337 vssd1 vssd1 vccd1 vccd1 sky130_fd_sc_hd__decap_8
X_2004_ clknet_leaf_30_clk_i _0030_ net458 vssd1 vssd1 vccd1 vccd1 spi_mem0.address\[4\]
+ sky130_fd_sc_hd__dfrtp_1
XFILLER_0_9_169 vssd1 vssd1 vccd1 vccd1 sky130_fd_sc_hd__fill_2
X_1719_ _0748_ _0761_ net506 vssd1 vssd1 vccd1 vccd1 _0240_ sky130_fd_sc_hd__o21a_1
XFILLER_0_45_289 vssd1 vssd1 vccd1 vccd1 sky130_fd_sc_hd__fill_2
XFILLER_0_13_153 vssd1 vssd1 vccd1 vccd1 sky130_fd_sc_hd__decap_3
XFILLER_0_13_164 vssd1 vssd1 vccd1 vccd1 sky130_fd_sc_hd__decap_4
XTAP_392 vssd1 vccd1 sky130_fd_sc_hd__tapvpwrvgnd_1
XTAP_381 vssd1 vccd1 sky130_fd_sc_hd__tapvpwrvgnd_1
XTAP_370 vssd1 vccd1 sky130_fd_sc_hd__tapvpwrvgnd_1
XPHY_98 vssd1 vssd1 vccd1 vccd1 sky130_fd_sc_hd__decap_3
XPHY_87 vssd1 vssd1 vccd1 vccd1 sky130_fd_sc_hd__decap_3
XPHY_76 vssd1 vssd1 vccd1 vccd1 sky130_fd_sc_hd__decap_3
XPHY_65 vssd1 vssd1 vccd1 vccd1 sky130_fd_sc_hd__decap_3
XPHY_54 vssd1 vssd1 vccd1 vccd1 sky130_fd_sc_hd__decap_3
XPHY_10 vssd1 vssd1 vccd1 vccd1 sky130_fd_sc_hd__decap_3
XPHY_21 vssd1 vssd1 vccd1 vccd1 sky130_fd_sc_hd__decap_3
XPHY_32 vssd1 vssd1 vccd1 vccd1 sky130_fd_sc_hd__decap_3
XPHY_43 vssd1 vssd1 vccd1 vccd1 sky130_fd_sc_hd__decap_3
XFILLER_0_59_304 vssd1 vssd1 vccd1 vccd1 sky130_fd_sc_hd__fill_1
XFILLER_0_74_307 vssd1 vssd1 vccd1 vccd1 sky130_fd_sc_hd__fill_1
XFILLER_0_27_278 vssd1 vssd1 vccd1 vccd1 sky130_fd_sc_hd__fill_2
XFILLER_0_27_267 vssd1 vssd1 vccd1 vccd1 sky130_fd_sc_hd__decap_3
XFILLER_0_27_223 vssd1 vssd1 vccd1 vccd1 sky130_fd_sc_hd__fill_1
XFILLER_0_82_373 vssd1 vssd1 vccd1 vccd1 sky130_fd_sc_hd__fill_1
X_1504_ spi_mem1.state\[2\] _0626_ _0622_ vssd1 vssd1 vccd1 vccd1 _0160_ sky130_fd_sc_hd__mux2_1
X_1435_ net126 _0568_ vssd1 vssd1 vccd1 vccd1 _0571_ sky130_fd_sc_hd__and2_1
X_1366_ net393 _0526_ net375 vssd1 vssd1 vccd1 vccd1 _0527_ sky130_fd_sc_hd__o21ai_2
X_1297_ net790 _0483_ _0485_ net372 vssd1 vssd1 vccd1 vccd1 _0094_ sky130_fd_sc_hd__a22o_1
XFILLER_0_18_201 vssd1 vssd1 vccd1 vccd1 sky130_fd_sc_hd__fill_2
XFILLER_0_33_248 vssd1 vssd1 vccd1 vccd1 sky130_ef_sc_hd__decap_12
XFILLER_0_18_212 vssd1 vssd1 vccd1 vccd1 sky130_fd_sc_hd__fill_2
Xfanout397 net399 vssd1 vssd1 vccd1 vccd1 net397 sky130_fd_sc_hd__clkbuf_4
Xfanout386 net387 vssd1 vssd1 vccd1 vccd1 net386 sky130_fd_sc_hd__clkbuf_4
Xfanout375 net376 vssd1 vssd1 vccd1 vccd1 net375 sky130_fd_sc_hd__clkbuf_4
Xfanout364 _0868_ vssd1 vssd1 vccd1 vccd1 net364 sky130_fd_sc_hd__clkbuf_4
XFILLER_0_56_307 vssd1 vssd1 vccd1 vccd1 sky130_fd_sc_hd__fill_1
XFILLER_0_49_381 vssd1 vssd1 vccd1 vccd1 sky130_fd_sc_hd__decap_4
Xinput28 sport0_i[1] vssd1 vssd1 vccd1 vccd1 net28 sky130_fd_sc_hd__buf_1
Xinput39 sport0_i[2] vssd1 vssd1 vccd1 vccd1 net39 sky130_fd_sc_hd__buf_1
Xinput17 sport0_i[0] vssd1 vssd1 vccd1 vccd1 net17 sky130_fd_sc_hd__buf_1
XFILLER_0_74_15 vssd1 vssd1 vccd1 vccd1 sky130_ef_sc_hd__decap_12
X_1220_ net557 net279 net391 vssd1 vssd1 vccd1 vccd1 _0082_ sky130_fd_sc_hd__mux2_1
X_1151_ net62 net609 net408 vssd1 vssd1 vccd1 vccd1 _0044_ sky130_fd_sc_hd__mux2_1
X_1082_ net79 net80 _0350_ vssd1 vssd1 vccd1 vccd1 _0351_ sky130_fd_sc_hd__and3_1
XFILLER_0_82_181 vssd1 vssd1 vccd1 vccd1 sky130_fd_sc_hd__fill_1
XFILLER_0_74_159 vssd1 vssd1 vccd1 vccd1 sky130_fd_sc_hd__decap_4
XFILLER_0_30_229 vssd1 vssd1 vccd1 vccd1 sky130_fd_sc_hd__decap_3
XFILLER_0_23_281 vssd1 vssd1 vccd1 vccd1 sky130_ef_sc_hd__decap_12
X_1418_ net118 net647 net410 vssd1 vssd1 vccd1 vccd1 _0140_ sky130_fd_sc_hd__mux2_1
XFILLER_0_47_3 vssd1 vssd1 vccd1 vccd1 sky130_ef_sc_hd__decap_12
X_1349_ net628 _0516_ _0517_ net375 vssd1 vssd1 vccd1 vccd1 _0114_ sky130_fd_sc_hd__a22o_1
XFILLER_0_46_373 vssd1 vssd1 vccd1 vccd1 sky130_fd_sc_hd__decap_8
XFILLER_0_29_318 vssd1 vssd1 vccd1 vccd1 sky130_ef_sc_hd__decap_12
XFILLER_0_29_307 vssd1 vssd1 vccd1 vccd1 sky130_fd_sc_hd__fill_2
XFILLER_0_71_107 vssd1 vssd1 vccd1 vccd1 sky130_fd_sc_hd__decap_4
XFILLER_0_56_137 vssd1 vssd1 vccd1 vccd1 sky130_fd_sc_hd__decap_3
XFILLER_0_8_29 vssd1 vssd1 vccd1 vccd1 sky130_fd_sc_hd__fill_2
XFILLER_0_69_15 vssd1 vssd1 vccd1 vccd1 sky130_fd_sc_hd__fill_1
XFILLER_0_52_365 vssd1 vssd1 vccd1 vccd1 sky130_fd_sc_hd__decap_4
X_2321_ clknet_leaf_36_clk_i _0329_ net449 vssd1 vssd1 vccd1 vccd1 spi_mem2.data_buf\[19\]
+ sky130_fd_sc_hd__dfrtp_1
XFILLER_0_20_251 vssd1 vssd1 vccd1 vccd1 sky130_fd_sc_hd__fill_1
X_2183_ net498 net11 net486 vssd1 vssd1 vccd1 vccd1 spi_mem1.delayed_miso\[3\] sky130_fd_sc_hd__dfrtp_1
X_2252_ clknet_leaf_21_clk_i _0266_ net481 vssd1 vssd1 vccd1 vccd1 spi_mem2.state\[0\]
+ sky130_fd_sc_hd__dfrtp_1
X_1203_ net699 net719 net389 vssd1 vssd1 vccd1 vccd1 _0065_ sky130_fd_sc_hd__mux2_1
XFILLER_0_18_85 vssd1 vssd1 vccd1 vccd1 sky130_fd_sc_hd__decap_4
X_1134_ net43 net594 net408 vssd1 vssd1 vccd1 vccd1 _0027_ sky130_fd_sc_hd__mux2_1
X_1065_ _0919_ net434 _0938_ vssd1 vssd1 vccd1 vccd1 _0977_ sky130_fd_sc_hd__and3_2
XFILLER_0_7_223 vssd1 vssd1 vccd1 vccd1 sky130_fd_sc_hd__fill_1
XFILLER_0_19_7 vssd1 vssd1 vccd1 vccd1 sky130_fd_sc_hd__fill_1
XFILLER_0_70_162 vssd1 vssd1 vccd1 vccd1 sky130_ef_sc_hd__decap_12
XFILLER_0_43_398 vssd1 vssd1 vccd1 vccd1 sky130_fd_sc_hd__decap_8
X_1898_ spi_mem2.delayed_miso\[0\] _0967_ vssd1 vssd1 vccd1 vccd1 _0871_ sky130_fd_sc_hd__and2_4
X_1967_ net806 _0908_ _0912_ net365 vssd1 vssd1 vccd1 vccd1 _0337_ sky130_fd_sc_hd__a22o_1
Xinput207 sport2_i[57] vssd1 vssd1 vccd1 vccd1 net207 sky130_fd_sc_hd__clkbuf_1
Xinput218 sport2_i[67] vssd1 vssd1 vccd1 vccd1 net218 sky130_fd_sc_hd__buf_1
XFILLER_0_78_251 vssd1 vssd1 vccd1 vccd1 sky130_fd_sc_hd__fill_1
XFILLER_0_34_365 vssd1 vssd1 vccd1 vccd1 sky130_fd_sc_hd__decap_8
Xhold6 _0184_ vssd1 vssd1 vccd1 vccd1 net510 sky130_fd_sc_hd__dlygate4sd3_1
XFILLER_0_72_405 vssd1 vssd1 vccd1 vccd1 sky130_fd_sc_hd__fill_2
XFILLER_0_71_27 vssd1 vssd1 vccd1 vccd1 sky130_ef_sc_hd__decap_12
X_1990__14 clknet_leaf_19_clk_i vssd1 vssd1 vccd1 vccd1 net503 sky130_fd_sc_hd__inv_2
XFILLER_0_52_195 vssd1 vssd1 vccd1 vccd1 sky130_fd_sc_hd__fill_1
X_1683_ net106 net397 _0692_ _0734_ vssd1 vssd1 vccd1 vccd1 _0736_ sky130_fd_sc_hd__a22o_1
XFILLER_0_25_387 vssd1 vssd1 vccd1 vccd1 sky130_fd_sc_hd__decap_4
X_1752_ net197 _0774_ net198 vssd1 vssd1 vccd1 vccd1 _0777_ sky130_fd_sc_hd__o21a_2
X_1821_ net550 net337 net381 vssd1 vssd1 vccd1 vccd1 _0288_ sky130_fd_sc_hd__mux2_1
XTAP_755 vssd1 vccd1 sky130_fd_sc_hd__tapvpwrvgnd_1
XTAP_744 vssd1 vccd1 sky130_fd_sc_hd__tapvpwrvgnd_1
XTAP_733 vssd1 vccd1 sky130_fd_sc_hd__tapvpwrvgnd_1
XTAP_722 vssd1 vccd1 sky130_fd_sc_hd__tapvpwrvgnd_1
XTAP_711 vssd1 vccd1 sky130_fd_sc_hd__tapvpwrvgnd_1
XTAP_700 vssd1 vccd1 sky130_fd_sc_hd__tapvpwrvgnd_1
X_2304_ clknet_leaf_0_clk_i _0312_ net446 vssd1 vssd1 vccd1 vccd1 spi_mem2.data_buf\[2\]
+ sky130_fd_sc_hd__dfrtp_1
XFILLER_0_20_97 vssd1 vssd1 vccd1 vccd1 sky130_fd_sc_hd__decap_4
X_2166_ clknet_leaf_12_clk_i net744 net478 vssd1 vssd1 vccd1 vccd1 net310 sky130_fd_sc_hd__dfrtp_4
X_1117_ spi_mem0.latency\[0\] _0369_ _0379_ vssd1 vssd1 vccd1 vccd1 _0380_ sky130_fd_sc_hd__o21ba_1
X_2097_ clknet_leaf_33_clk_i _0117_ net462 vssd1 vssd1 vccd1 vccd1 spi_mem0.data_buf\[23\]
+ sky130_fd_sc_hd__dfrtp_1
X_2235_ clknet_leaf_28_clk_i _0249_ net460 vssd1 vssd1 vccd1 vccd1 spi_mem2.address\[8\]
+ sky130_fd_sc_hd__dfrtp_1
XFILLER_0_75_287 vssd1 vssd1 vccd1 vccd1 sky130_fd_sc_hd__fill_1
XFILLER_0_63_405 vssd1 vssd1 vccd1 vccd1 sky130_fd_sc_hd__fill_2
X_1048_ spi_mem2.state\[3\] spi_mem2.state\[2\] vssd1 vssd1 vccd1 vccd1 _0965_ sky130_fd_sc_hd__and2b_1
XFILLER_0_28_192 vssd1 vssd1 vccd1 vccd1 sky130_fd_sc_hd__decap_4
XFILLER_0_16_365 vssd1 vssd1 vccd1 vccd1 sky130_fd_sc_hd__decap_3
XFILLER_0_66_221 vssd1 vssd1 vccd1 vccd1 sky130_ef_sc_hd__decap_12
XFILLER_0_34_173 vssd1 vssd1 vccd1 vccd1 sky130_ef_sc_hd__decap_12
XFILLER_0_66_27 vssd1 vssd1 vccd1 vccd1 sky130_fd_sc_hd__fill_1
XFILLER_0_82_37 vssd1 vssd1 vccd1 vccd1 sky130_fd_sc_hd__fill_1
X_2020_ clknet_leaf_25_clk_i _0046_ net465 vssd1 vssd1 vccd1 vccd1 spi_mem0.address\[20\]
+ sky130_fd_sc_hd__dfrtp_1
XFILLER_0_57_221 vssd1 vssd1 vccd1 vccd1 sky130_fd_sc_hd__decap_3
XFILLER_0_72_268 vssd1 vssd1 vccd1 vccd1 sky130_ef_sc_hd__decap_12
Xhold214 spi_mem1.data_buf\[10\] vssd1 vssd1 vccd1 vccd1 net718 sky130_fd_sc_hd__dlygate4sd3_1
Xhold247 spi_mem1.data_buf\[2\] vssd1 vssd1 vccd1 vccd1 net751 sky130_fd_sc_hd__dlygate4sd3_1
X_1666_ net99 net397 _0694_ _0723_ vssd1 vssd1 vccd1 vccd1 _0726_ sky130_fd_sc_hd__a22o_1
Xhold269 _0177_ vssd1 vssd1 vccd1 vccd1 net773 sky130_fd_sc_hd__dlygate4sd3_1
Xhold225 spi_mem0.spi_clk vssd1 vssd1 vccd1 vccd1 net729 sky130_fd_sc_hd__dlygate4sd3_1
XFILLER_0_40_165 vssd1 vssd1 vccd1 vccd1 sky130_fd_sc_hd__decap_3
XFILLER_0_40_132 vssd1 vssd1 vccd1 vccd1 sky130_fd_sc_hd__decap_8
Xclkbuf_leaf_2_clk_i clknet_2_0__leaf_clk_i vssd1 vssd1 vccd1 vccd1 clknet_leaf_2_clk_i
+ sky130_fd_sc_hd__clkbuf_16
XFILLER_0_31_74 vssd1 vssd1 vccd1 vccd1 sky130_ef_sc_hd__decap_12
Xhold236 net352 vssd1 vssd1 vccd1 vccd1 net740 sky130_fd_sc_hd__dlygate4sd3_1
Xhold203 _0297_ vssd1 vssd1 vccd1 vccd1 net707 sky130_fd_sc_hd__dlygate4sd3_1
X_1804_ spi_mem2.data_buf\[1\] net653 net379 vssd1 vssd1 vccd1 vccd1 _0271_ sky130_fd_sc_hd__mux2_1
X_1735_ net190 net192 net191 net193 vssd1 vssd1 vccd1 vccd1 _0765_ sky130_fd_sc_hd__o31a_2
Xhold258 net287 vssd1 vssd1 vccd1 vccd1 net762 sky130_fd_sc_hd__dlygate4sd3_1
XTAP_596 vssd1 vccd1 sky130_fd_sc_hd__tapvpwrvgnd_1
XTAP_585 vssd1 vccd1 sky130_fd_sc_hd__tapvpwrvgnd_1
XTAP_574 vssd1 vccd1 sky130_fd_sc_hd__tapvpwrvgnd_1
XFILLER_0_56_82 vssd1 vssd1 vccd1 vccd1 sky130_fd_sc_hd__fill_2
XTAP_563 vssd1 vccd1 sky130_fd_sc_hd__tapvpwrvgnd_1
XTAP_552 vssd1 vccd1 sky130_fd_sc_hd__tapvpwrvgnd_1
XTAP_541 vssd1 vccd1 sky130_fd_sc_hd__tapvpwrvgnd_1
XTAP_530 vssd1 vccd1 sky130_fd_sc_hd__tapvpwrvgnd_1
X_1597_ _0345_ _0480_ _0681_ net542 vssd1 vssd1 vccd1 vccd1 _0198_ sky130_fd_sc_hd__a2bb2o_1
XFILLER_0_0_251 vssd1 vssd1 vccd1 vccd1 sky130_fd_sc_hd__fill_1
X_2149_ clknet_leaf_6_clk_i net691 net469 vssd1 vssd1 vccd1 vccd1 net325 sky130_fd_sc_hd__dfrtp_1
X_2218_ clknet_leaf_24_clk_i _0232_ net479 vssd1 vssd1 vccd1 vccd1 spi_mem1.data_buf\[30\]
+ sky130_fd_sc_hd__dfrtp_1
XFILLER_0_48_221 vssd1 vssd1 vccd1 vccd1 sky130_fd_sc_hd__fill_1
XFILLER_0_63_257 vssd1 vssd1 vccd1 vccd1 sky130_ef_sc_hd__decap_12
XFILLER_0_8_384 vssd1 vssd1 vccd1 vccd1 sky130_fd_sc_hd__fill_1
XFILLER_0_31_121 vssd1 vssd1 vccd1 vccd1 sky130_fd_sc_hd__decap_3
XFILLER_0_16_195 vssd1 vssd1 vccd1 vccd1 sky130_fd_sc_hd__fill_1
XFILLER_0_52_29 vssd1 vssd1 vccd1 vccd1 sky130_ef_sc_hd__decap_12
XFILLER_0_77_15 vssd1 vssd1 vccd1 vccd1 sky130_ef_sc_hd__decap_12
X_1520_ net515 net296 net386 vssd1 vssd1 vccd1 vccd1 _0173_ sky130_fd_sc_hd__mux2_1
XFILLER_0_54_279 vssd1 vssd1 vccd1 vccd1 sky130_fd_sc_hd__decap_4
XFILLER_0_22_176 vssd1 vssd1 vccd1 vccd1 sky130_fd_sc_hd__decap_8
Xoutput319 net319 vssd1 vssd1 vccd1 vccd1 sport1_o[32] sky130_fd_sc_hd__clkbuf_4
Xoutput308 net308 vssd1 vssd1 vccd1 vccd1 sport1_o[22] sky130_fd_sc_hd__clkbuf_4
XFILLER_0_22_110 vssd1 vssd1 vccd1 vccd1 sky130_fd_sc_hd__decap_6
X_1382_ _0537_ vssd1 vssd1 vccd1 vccd1 _0538_ sky130_fd_sc_hd__inv_2
X_1451_ net129 _0579_ net131 vssd1 vssd1 vccd1 vccd1 _0583_ sky130_fd_sc_hd__o21a_1
XFILLER_0_77_305 vssd1 vssd1 vccd1 vccd1 sky130_fd_sc_hd__decap_8
XFILLER_0_26_85 vssd1 vssd1 vccd1 vccd1 sky130_fd_sc_hd__fill_1
XFILLER_0_26_74 vssd1 vssd1 vccd1 vccd1 sky130_fd_sc_hd__decap_8
XFILLER_0_26_52 vssd1 vssd1 vccd1 vccd1 sky130_fd_sc_hd__fill_2
X_2003_ clknet_leaf_31_clk_i _0029_ net457 vssd1 vssd1 vccd1 vccd1 spi_mem0.address\[3\]
+ sky130_fd_sc_hd__dfrtp_1
XFILLER_0_45_268 vssd1 vssd1 vccd1 vccd1 sky130_ef_sc_hd__decap_12
XFILLER_0_45_202 vssd1 vssd1 vccd1 vccd1 sky130_ef_sc_hd__decap_12
XFILLER_0_18_405 vssd1 vssd1 vccd1 vccd1 sky130_fd_sc_hd__fill_2
XFILLER_0_77_3 vssd1 vssd1 vccd1 vccd1 sky130_ef_sc_hd__decap_12
X_1718_ spi_mem2.latency\[3\] spi_mem2.latency\[4\] _0359_ _0357_ vssd1 vssd1 vccd1
+ vccd1 _0761_ sky130_fd_sc_hd__o31a_1
X_1649_ net91 net396 _0696_ _0712_ vssd1 vssd1 vccd1 vccd1 _0716_ sky130_fd_sc_hd__a22o_1
XTAP_393 vssd1 vccd1 sky130_fd_sc_hd__tapvpwrvgnd_1
XTAP_382 vssd1 vccd1 sky130_fd_sc_hd__tapvpwrvgnd_1
XTAP_371 vssd1 vccd1 sky130_fd_sc_hd__tapvpwrvgnd_1
XTAP_360 vssd1 vccd1 sky130_fd_sc_hd__tapvpwrvgnd_1
XFILLER_0_68_316 vssd1 vssd1 vccd1 vccd1 sky130_fd_sc_hd__decap_8
XPHY_99 vssd1 vssd1 vccd1 vccd1 sky130_fd_sc_hd__decap_3
XPHY_88 vssd1 vssd1 vccd1 vccd1 sky130_fd_sc_hd__decap_3
XPHY_77 vssd1 vssd1 vccd1 vccd1 sky130_fd_sc_hd__decap_3
XPHY_66 vssd1 vssd1 vccd1 vccd1 sky130_fd_sc_hd__decap_3
XPHY_55 vssd1 vssd1 vccd1 vccd1 sky130_fd_sc_hd__decap_3
XPHY_11 vssd1 vssd1 vccd1 vccd1 sky130_fd_sc_hd__decap_3
XPHY_22 vssd1 vssd1 vccd1 vccd1 sky130_fd_sc_hd__decap_3
XPHY_33 vssd1 vssd1 vccd1 vccd1 sky130_fd_sc_hd__decap_3
XPHY_44 vssd1 vssd1 vccd1 vccd1 sky130_fd_sc_hd__decap_3
XFILLER_0_51_205 vssd1 vssd1 vccd1 vccd1 sky130_ef_sc_hd__decap_12
XFILLER_0_44_290 vssd1 vssd1 vccd1 vccd1 sky130_fd_sc_hd__fill_1
XFILLER_0_82_396 vssd1 vssd1 vccd1 vccd1 sky130_fd_sc_hd__fill_2
XFILLER_0_67_393 vssd1 vssd1 vccd1 vccd1 sky130_ef_sc_hd__decap_12
X_1503_ _0940_ _0964_ net395 _0933_ _0623_ vssd1 vssd1 vccd1 vccd1 _0626_ sky130_fd_sc_hd__a221o_1
XFILLER_0_10_113 vssd1 vssd1 vccd1 vccd1 sky130_fd_sc_hd__decap_4
X_1434_ net530 _0570_ net412 vssd1 vssd1 vccd1 vccd1 _0146_ sky130_fd_sc_hd__mux2_1
X_1365_ net440 net436 net438 vssd1 vssd1 vccd1 vccd1 _0526_ sky130_fd_sc_hd__and3_2
X_1296_ net17 net414 _0482_ _0484_ vssd1 vssd1 vccd1 vccd1 _0485_ sky130_fd_sc_hd__a22o_1
XFILLER_0_77_113 vssd1 vssd1 vccd1 vccd1 sky130_fd_sc_hd__decap_8
Xclkbuf_leaf_20_clk_i clknet_2_3__leaf_clk_i vssd1 vssd1 vccd1 vccd1 clknet_leaf_20_clk_i
+ sky130_fd_sc_hd__clkbuf_16
Xclkbuf_leaf_35_clk_i clknet_2_0__leaf_clk_i vssd1 vssd1 vccd1 vccd1 clknet_leaf_35_clk_i
+ sky130_fd_sc_hd__clkbuf_16
XFILLER_0_78_80 vssd1 vssd1 vccd1 vccd1 sky130_fd_sc_hd__decap_4
XFILLER_0_1_390 vssd1 vssd1 vccd1 vccd1 sky130_fd_sc_hd__fill_2
Xfanout365 _0868_ vssd1 vssd1 vccd1 vccd1 net365 sky130_fd_sc_hd__clkbuf_2
Xfanout387 _0629_ vssd1 vssd1 vccd1 vccd1 net387 sky130_fd_sc_hd__clkbuf_4
Xfanout398 net399 vssd1 vssd1 vccd1 vccd1 net398 sky130_fd_sc_hd__buf_2
Xfanout376 _0481_ vssd1 vssd1 vccd1 vccd1 net376 sky130_fd_sc_hd__clkbuf_2
XTAP_190 vssd1 vccd1 sky130_fd_sc_hd__tapvpwrvgnd_1
XFILLER_0_64_363 vssd1 vssd1 vccd1 vccd1 sky130_fd_sc_hd__fill_1
XFILLER_0_49_393 vssd1 vssd1 vccd1 vccd1 sky130_ef_sc_hd__decap_12
Xinput18 sport0_i[10] vssd1 vssd1 vccd1 vccd1 net18 sky130_fd_sc_hd__buf_1
Xinput29 sport0_i[20] vssd1 vssd1 vccd1 vccd1 net29 sky130_fd_sc_hd__buf_1
XFILLER_0_74_49 vssd1 vssd1 vccd1 vccd1 sky130_ef_sc_hd__decap_12
XFILLER_0_74_27 vssd1 vssd1 vccd1 vccd1 sky130_fd_sc_hd__fill_1
X_1150_ net60 net590 net407 vssd1 vssd1 vccd1 vccd1 _0043_ sky130_fd_sc_hd__mux2_1
XFILLER_0_59_113 vssd1 vssd1 vccd1 vccd1 sky130_fd_sc_hd__decap_4
X_1081_ net435 _0349_ vssd1 vssd1 vccd1 vccd1 _0350_ sky130_fd_sc_hd__and2_2
XFILLER_0_7_405 vssd1 vssd1 vccd1 vccd1 sky130_fd_sc_hd__fill_2
XFILLER_0_15_205 vssd1 vssd1 vccd1 vccd1 sky130_ef_sc_hd__decap_12
X_1417_ net117 net616 net410 vssd1 vssd1 vccd1 vccd1 _0139_ sky130_fd_sc_hd__mux2_1
XFILLER_0_48_50 vssd1 vssd1 vccd1 vccd1 sky130_fd_sc_hd__decap_3
XFILLER_0_23_293 vssd1 vssd1 vccd1 vccd1 sky130_fd_sc_hd__decap_4
X_1279_ net83 _0368_ _0470_ _0471_ _0421_ vssd1 vssd1 vccd1 vccd1 _0472_ sky130_fd_sc_hd__a221o_1
X_1348_ net29 net415 _0484_ _0515_ vssd1 vssd1 vccd1 vccd1 _0517_ sky130_fd_sc_hd__a22o_1
XFILLER_0_46_363 vssd1 vssd1 vccd1 vccd1 sky130_fd_sc_hd__fill_1
XFILLER_0_61_333 vssd1 vssd1 vccd1 vccd1 sky130_fd_sc_hd__decap_3
XFILLER_0_14_293 vssd1 vssd1 vccd1 vccd1 sky130_fd_sc_hd__decap_3
XFILLER_0_56_116 vssd1 vssd1 vccd1 vccd1 sky130_fd_sc_hd__decap_3
XFILLER_0_71_119 vssd1 vssd1 vccd1 vccd1 sky130_fd_sc_hd__fill_1
XFILLER_0_64_171 vssd1 vssd1 vccd1 vccd1 sky130_fd_sc_hd__decap_4
XFILLER_0_60_29 vssd1 vssd1 vccd1 vccd1 sky130_fd_sc_hd__decap_6
XFILLER_0_49_190 vssd1 vssd1 vccd1 vccd1 sky130_fd_sc_hd__decap_6
X_2251_ clknet_leaf_26_clk_i _0265_ net465 vssd1 vssd1 vccd1 vccd1 spi_mem2.address_nibble\[2\]
+ sky130_fd_sc_hd__dfstp_2
X_2320_ clknet_leaf_32_clk_i _0328_ net450 vssd1 vssd1 vccd1 vccd1 spi_mem2.data_buf\[18\]
+ sky130_fd_sc_hd__dfrtp_1
X_2182_ net497 net10 net484 vssd1 vssd1 vccd1 vccd1 spi_mem1.delayed_miso\[2\] sky130_fd_sc_hd__dfrtp_1
X_1064_ net432 spi_mem1.state\[2\] spi_mem1.state\[3\] vssd1 vssd1 vccd1 vccd1 _0976_
+ sky130_fd_sc_hd__or3b_2
X_1202_ net559 net293 net388 vssd1 vssd1 vccd1 vccd1 _0064_ sky130_fd_sc_hd__mux2_1
X_1133_ net42 net585 net408 vssd1 vssd1 vccd1 vccd1 _0026_ sky130_fd_sc_hd__mux2_1
XFILLER_0_18_97 vssd1 vssd1 vccd1 vccd1 sky130_fd_sc_hd__decap_6
XFILLER_0_28_341 vssd1 vssd1 vccd1 vccd1 sky130_fd_sc_hd__decap_8
X_1966_ net174 net402 _0353_ _0877_ vssd1 vssd1 vccd1 vccd1 _0912_ sky130_fd_sc_hd__a22o_1
XFILLER_0_70_174 vssd1 vssd1 vccd1 vccd1 sky130_fd_sc_hd__fill_2
XFILLER_0_70_141 vssd1 vssd1 vccd1 vccd1 sky130_fd_sc_hd__decap_3
X_1897_ _0968_ _0869_ net366 vssd1 vssd1 vccd1 vccd1 _0870_ sky130_fd_sc_hd__o21ai_2
Xinput219 sport2_i[68] vssd1 vssd1 vccd1 vccd1 net219 sky130_fd_sc_hd__clkbuf_2
Xinput208 sport2_i[58] vssd1 vssd1 vccd1 vccd1 net208 sky130_fd_sc_hd__clkbuf_1
XFILLER_0_78_296 vssd1 vssd1 vccd1 vccd1 sky130_ef_sc_hd__decap_12
XFILLER_0_78_285 vssd1 vssd1 vccd1 vccd1 sky130_fd_sc_hd__fill_2
XFILLER_0_46_193 vssd1 vssd1 vccd1 vccd1 sky130_fd_sc_hd__decap_3
Xhold7 spi_mem2.data_buf\[26\] vssd1 vssd1 vccd1 vccd1 net511 sky130_fd_sc_hd__dlygate4sd3_1
XFILLER_0_71_39 vssd1 vssd1 vccd1 vccd1 sky130_fd_sc_hd__decap_8
XFILLER_0_69_263 vssd1 vssd1 vccd1 vccd1 sky130_fd_sc_hd__decap_6
XFILLER_0_29_149 vssd1 vssd1 vccd1 vccd1 sky130_fd_sc_hd__fill_2
X_1820_ spi_mem2.data_buf\[17\] net662 net380 vssd1 vssd1 vccd1 vccd1 _0287_ sky130_fd_sc_hd__mux2_1
X_1682_ net394 _0734_ net369 vssd1 vssd1 vccd1 vccd1 _0735_ sky130_fd_sc_hd__o21ai_2
X_1751_ net532 _0776_ _0962_ vssd1 vssd1 vccd1 vccd1 _0257_ sky130_fd_sc_hd__mux2_1
XFILLER_0_4_238 vssd1 vssd1 vccd1 vccd1 sky130_fd_sc_hd__fill_1
XFILLER_0_4_205 vssd1 vssd1 vccd1 vccd1 sky130_fd_sc_hd__fill_2
XFILLER_0_20_10 vssd1 vssd1 vccd1 vccd1 sky130_fd_sc_hd__fill_1
XFILLER_0_20_21 vssd1 vssd1 vccd1 vccd1 sky130_fd_sc_hd__fill_1
XFILLER_0_20_43 vssd1 vssd1 vccd1 vccd1 sky130_fd_sc_hd__decap_4
XTAP_756 vssd1 vccd1 sky130_fd_sc_hd__tapvpwrvgnd_1
XTAP_745 vssd1 vccd1 sky130_fd_sc_hd__tapvpwrvgnd_1
XTAP_734 vssd1 vccd1 sky130_fd_sc_hd__tapvpwrvgnd_1
XTAP_723 vssd1 vccd1 sky130_fd_sc_hd__tapvpwrvgnd_1
XTAP_712 vssd1 vccd1 sky130_fd_sc_hd__tapvpwrvgnd_1
XTAP_701 vssd1 vccd1 sky130_fd_sc_hd__tapvpwrvgnd_1
XFILLER_0_29_52 vssd1 vssd1 vccd1 vccd1 sky130_fd_sc_hd__decap_4
X_2234_ clknet_leaf_30_clk_i _0248_ net461 vssd1 vssd1 vccd1 vccd1 spi_mem2.address\[7\]
+ sky130_fd_sc_hd__dfrtp_1
X_2303_ clknet_leaf_35_clk_i _0311_ net449 vssd1 vssd1 vccd1 vccd1 spi_mem2.data_buf\[1\]
+ sky130_fd_sc_hd__dfrtp_1
X_1047_ _0935_ _0964_ vssd1 vssd1 vccd1 vccd1 net247 sky130_fd_sc_hd__and2_2
X_1116_ spi_mem0.has_2lc _0370_ vssd1 vssd1 vccd1 vccd1 _0379_ sky130_fd_sc_hd__nor2_1
X_2165_ clknet_leaf_5_clk_i _0185_ net471 vssd1 vssd1 vccd1 vccd1 net309 sky130_fd_sc_hd__dfrtp_1
X_2096_ clknet_leaf_33_clk_i _0116_ net462 vssd1 vssd1 vccd1 vccd1 spi_mem0.data_buf\[22\]
+ sky130_fd_sc_hd__dfrtp_1
X_1949_ net420 spi_mem2.data_byte\[1\] net423 vssd1 vssd1 vccd1 vccd1 _0902_ sky130_fd_sc_hd__and3b_2
XFILLER_0_9_84 vssd1 vssd1 vccd1 vccd1 sky130_fd_sc_hd__fill_1
XFILLER_0_66_233 vssd1 vssd1 vccd1 vccd1 sky130_ef_sc_hd__decap_12
XFILLER_0_54_406 vssd1 vssd1 vccd1 vccd1 sky130_fd_sc_hd__fill_1
XFILLER_0_81_225 vssd1 vssd1 vccd1 vccd1 sky130_fd_sc_hd__decap_8
XFILLER_0_34_185 vssd1 vssd1 vccd1 vccd1 sky130_fd_sc_hd__decap_8
XFILLER_0_34_141 vssd1 vssd1 vccd1 vccd1 sky130_fd_sc_hd__fill_1
XFILLER_0_57_288 vssd1 vssd1 vccd1 vccd1 sky130_fd_sc_hd__decap_8
XFILLER_0_57_277 vssd1 vssd1 vccd1 vccd1 sky130_fd_sc_hd__decap_3
XFILLER_0_45_406 vssd1 vssd1 vccd1 vccd1 sky130_fd_sc_hd__fill_1
X_1803_ spi_mem2.data_buf\[0\] net641 net379 vssd1 vssd1 vccd1 vccd1 _0270_ sky130_fd_sc_hd__mux2_1
Xhold248 _0164_ vssd1 vssd1 vccd1 vccd1 net752 sky130_fd_sc_hd__dlygate4sd3_1
X_1665_ net524 _0724_ _0725_ net369 vssd1 vssd1 vccd1 vccd1 _0222_ sky130_fd_sc_hd__a22o_1
Xhold237 spi_mem0.data_buf\[6\] vssd1 vssd1 vccd1 vccd1 net741 sky130_fd_sc_hd__dlygate4sd3_1
X_1596_ _0345_ _0369_ _0404_ vssd1 vssd1 vccd1 vccd1 _0681_ sky130_fd_sc_hd__a21o_1
Xhold226 spi_mem0.data_buf\[5\] vssd1 vssd1 vccd1 vccd1 net730 sky130_fd_sc_hd__dlygate4sd3_1
Xhold215 net261 vssd1 vssd1 vccd1 vccd1 net719 sky130_fd_sc_hd__dlygate4sd3_1
XFILLER_0_25_185 vssd1 vssd1 vccd1 vccd1 sky130_ef_sc_hd__decap_12
Xhold204 spi_mem2.data_buf\[12\] vssd1 vssd1 vccd1 vccd1 net708 sky130_fd_sc_hd__dlygate4sd3_1
XFILLER_0_13_358 vssd1 vssd1 vccd1 vccd1 sky130_fd_sc_hd__decap_4
X_1734_ _0763_ _0764_ net705 _0962_ vssd1 vssd1 vccd1 vccd1 _0252_ sky130_fd_sc_hd__o2bb2a_1
XFILLER_0_21_391 vssd1 vssd1 vccd1 vccd1 sky130_fd_sc_hd__fill_1
Xhold259 _0058_ vssd1 vssd1 vccd1 vccd1 net763 sky130_fd_sc_hd__dlygate4sd3_1
XTAP_597 vssd1 vccd1 sky130_fd_sc_hd__tapvpwrvgnd_1
XTAP_586 vssd1 vccd1 sky130_fd_sc_hd__tapvpwrvgnd_1
XTAP_575 vssd1 vccd1 sky130_fd_sc_hd__tapvpwrvgnd_1
XTAP_564 vssd1 vccd1 sky130_fd_sc_hd__tapvpwrvgnd_1
X_2217_ clknet_leaf_16_clk_i _0231_ net480 vssd1 vssd1 vccd1 vccd1 spi_mem1.data_buf\[29\]
+ sky130_fd_sc_hd__dfrtp_1
XTAP_553 vssd1 vccd1 sky130_fd_sc_hd__tapvpwrvgnd_1
XTAP_542 vssd1 vccd1 sky130_fd_sc_hd__tapvpwrvgnd_1
XTAP_531 vssd1 vccd1 sky130_fd_sc_hd__tapvpwrvgnd_1
XTAP_520 vssd1 vccd1 sky130_fd_sc_hd__tapvpwrvgnd_1
XFILLER_0_22_3 vssd1 vssd1 vccd1 vccd1 sky130_fd_sc_hd__decap_3
XFILLER_0_72_82 vssd1 vssd1 vccd1 vccd1 sky130_fd_sc_hd__fill_2
X_2148_ clknet_leaf_11_clk_i net695 net474 vssd1 vssd1 vccd1 vccd1 net324 sky130_fd_sc_hd__dfrtp_2
X_2079_ clknet_leaf_2_clk_i _0099_ net453 vssd1 vssd1 vccd1 vccd1 spi_mem0.data_buf\[5\]
+ sky130_fd_sc_hd__dfrtp_1
XFILLER_0_63_269 vssd1 vssd1 vccd1 vccd1 sky130_fd_sc_hd__decap_8
XFILLER_0_48_288 vssd1 vssd1 vccd1 vccd1 sky130_fd_sc_hd__decap_6
XFILLER_0_54_269 vssd1 vssd1 vccd1 vccd1 sky130_fd_sc_hd__fill_1
XFILLER_0_54_214 vssd1 vssd1 vccd1 vccd1 sky130_fd_sc_hd__fill_1
XFILLER_0_77_27 vssd1 vssd1 vccd1 vccd1 sky130_fd_sc_hd__decap_8
XFILLER_0_62_280 vssd1 vssd1 vccd1 vccd1 sky130_ef_sc_hd__decap_12
X_1450_ net129 net131 _0579_ vssd1 vssd1 vccd1 vccd1 _0582_ sky130_fd_sc_hd__or3_1
XFILLER_0_10_306 vssd1 vssd1 vccd1 vccd1 sky130_fd_sc_hd__fill_2
Xoutput309 net309 vssd1 vssd1 vccd1 vccd1 sport1_o[23] sky130_fd_sc_hd__clkbuf_4
X_1381_ _0934_ _0964_ _0536_ vssd1 vssd1 vccd1 vccd1 _0537_ sky130_fd_sc_hd__a21o_2
X_2002_ clknet_leaf_33_clk_i _0028_ net462 vssd1 vssd1 vccd1 vccd1 spi_mem0.address\[2\]
+ sky130_fd_sc_hd__dfrtp_1
XFILLER_0_45_225 vssd1 vssd1 vccd1 vccd1 sky130_ef_sc_hd__decap_12
XFILLER_0_45_214 vssd1 vssd1 vccd1 vccd1 sky130_fd_sc_hd__decap_8
XFILLER_0_42_63 vssd1 vssd1 vccd1 vccd1 sky130_fd_sc_hd__fill_1
XFILLER_0_13_122 vssd1 vssd1 vccd1 vccd1 sky130_fd_sc_hd__decap_3
X_1579_ spi_mem1.address\[11\] _0545_ _0641_ spi_mem1.address\[15\] vssd1 vssd1 vccd1
+ vccd1 _0666_ sky130_fd_sc_hd__a22o_1
X_1717_ _0357_ _0360_ _0749_ _0760_ vssd1 vssd1 vccd1 vccd1 _0239_ sky130_fd_sc_hd__a31o_1
X_1648_ net661 _0713_ _0715_ net368 vssd1 vssd1 vccd1 vccd1 _0215_ sky130_fd_sc_hd__a22o_1
XTAP_350 vssd1 vccd1 sky130_fd_sc_hd__tapvpwrvgnd_1
XFILLER_0_6_85 vssd1 vssd1 vccd1 vccd1 sky130_fd_sc_hd__decap_4
XFILLER_0_13_177 vssd1 vssd1 vccd1 vccd1 sky130_fd_sc_hd__decap_3
XFILLER_0_13_188 vssd1 vssd1 vccd1 vccd1 sky130_fd_sc_hd__decap_3
XTAP_394 vssd1 vccd1 sky130_fd_sc_hd__tapvpwrvgnd_1
XTAP_383 vssd1 vccd1 sky130_fd_sc_hd__tapvpwrvgnd_1
XTAP_372 vssd1 vccd1 sky130_fd_sc_hd__tapvpwrvgnd_1
XTAP_361 vssd1 vccd1 sky130_fd_sc_hd__tapvpwrvgnd_1
XPHY_12 vssd1 vssd1 vccd1 vccd1 sky130_fd_sc_hd__decap_3
XFILLER_0_76_361 vssd1 vssd1 vccd1 vccd1 sky130_fd_sc_hd__decap_3
XPHY_89 vssd1 vssd1 vccd1 vccd1 sky130_fd_sc_hd__decap_3
XPHY_78 vssd1 vssd1 vccd1 vccd1 sky130_fd_sc_hd__decap_3
XPHY_67 vssd1 vssd1 vccd1 vccd1 sky130_fd_sc_hd__decap_3
XPHY_56 vssd1 vssd1 vccd1 vccd1 sky130_fd_sc_hd__decap_3
XPHY_45 vssd1 vssd1 vccd1 vccd1 sky130_fd_sc_hd__decap_3
XPHY_23 vssd1 vssd1 vccd1 vccd1 sky130_fd_sc_hd__decap_3
XPHY_34 vssd1 vssd1 vccd1 vccd1 sky130_fd_sc_hd__decap_3
XFILLER_0_51_217 vssd1 vssd1 vccd1 vccd1 sky130_fd_sc_hd__decap_6
XFILLER_0_67_350 vssd1 vssd1 vccd1 vccd1 sky130_fd_sc_hd__fill_1
Xclkbuf_leaf_1_clk_i clknet_2_0__leaf_clk_i vssd1 vssd1 vccd1 vccd1 clknet_leaf_1_clk_i
+ sky130_fd_sc_hd__clkbuf_16
Xclkbuf_2_1__f_clk_i clknet_0_clk_i vssd1 vssd1 vccd1 vccd1 clknet_2_1__leaf_clk_i
+ sky130_fd_sc_hd__clkbuf_16
XFILLER_0_27_225 vssd1 vssd1 vccd1 vccd1 sky130_ef_sc_hd__decap_12
XFILLER_0_27_203 vssd1 vssd1 vccd1 vccd1 sky130_ef_sc_hd__decap_12
X_1502_ net432 _0625_ _0622_ vssd1 vssd1 vccd1 vccd1 _0159_ sky130_fd_sc_hd__mux2_1
X_1433_ _0568_ _0569_ vssd1 vssd1 vccd1 vccd1 _0570_ sky130_fd_sc_hd__nand2_1
XFILLER_0_77_103 vssd1 vssd1 vccd1 vccd1 sky130_fd_sc_hd__decap_4
X_1295_ spi_mem0.delayed_miso\[0\] _0344_ vssd1 vssd1 vccd1 vccd1 _0484_ sky130_fd_sc_hd__and2_2
X_1364_ net557 _0521_ _0525_ net376 vssd1 vssd1 vccd1 vccd1 _0121_ sky130_fd_sc_hd__a22o_1
XFILLER_0_77_169 vssd1 vssd1 vccd1 vccd1 sky130_ef_sc_hd__decap_12
XFILLER_0_33_217 vssd1 vssd1 vccd1 vccd1 sky130_fd_sc_hd__decap_6
Xfanout399 _0975_ vssd1 vssd1 vccd1 vccd1 net399 sky130_fd_sc_hd__buf_2
Xfanout388 net389 vssd1 vssd1 vccd1 vccd1 net388 sky130_fd_sc_hd__clkbuf_4
XTAP_191 vssd1 vccd1 sky130_fd_sc_hd__tapvpwrvgnd_1
XTAP_180 vssd1 vccd1 sky130_fd_sc_hd__tapvpwrvgnd_1
Xfanout366 _0868_ vssd1 vssd1 vccd1 vccd1 net366 sky130_fd_sc_hd__buf_4
XFILLER_0_68_158 vssd1 vssd1 vccd1 vccd1 sky130_fd_sc_hd__fill_1
Xinput19 sport0_i[11] vssd1 vssd1 vccd1 vccd1 net19 sky130_fd_sc_hd__buf_1
XFILLER_0_32_294 vssd1 vssd1 vccd1 vccd1 sky130_fd_sc_hd__fill_1
XFILLER_0_20_401 vssd1 vssd1 vccd1 vccd1 sky130_fd_sc_hd__decap_6
X_1080_ net439 net437 vssd1 vssd1 vccd1 vccd1 _0349_ sky130_fd_sc_hd__nor2_4
XFILLER_0_74_139 vssd1 vssd1 vccd1 vccd1 sky130_fd_sc_hd__fill_1
XFILLER_0_67_191 vssd1 vssd1 vccd1 vccd1 sky130_fd_sc_hd__fill_1
XFILLER_0_59_125 vssd1 vssd1 vccd1 vccd1 sky130_ef_sc_hd__decap_12
XFILLER_0_55_331 vssd1 vssd1 vccd1 vccd1 sky130_fd_sc_hd__decap_4
XFILLER_0_30_209 vssd1 vssd1 vccd1 vccd1 sky130_fd_sc_hd__decap_4
XFILLER_0_15_217 vssd1 vssd1 vccd1 vccd1 sky130_fd_sc_hd__decap_6
X_1416_ net116 net595 net410 vssd1 vssd1 vccd1 vccd1 _0138_ sky130_fd_sc_hd__mux2_1
XFILLER_0_48_62 vssd1 vssd1 vccd1 vccd1 sky130_fd_sc_hd__decap_4
X_1347_ net393 _0515_ net375 vssd1 vssd1 vccd1 vccd1 _0516_ sky130_fd_sc_hd__o21ai_2
XFILLER_0_78_401 vssd1 vssd1 vccd1 vccd1 sky130_fd_sc_hd__decap_6
X_1278_ spi_mem0.address_nibble\[2\] _0469_ _0365_ vssd1 vssd1 vccd1 vccd1 _0471_
+ sky130_fd_sc_hd__a21oi_1
XFILLER_0_73_183 vssd1 vssd1 vccd1 vccd1 sky130_fd_sc_hd__fill_2
XFILLER_0_65_139 vssd1 vssd1 vccd1 vccd1 sky130_fd_sc_hd__decap_6
XFILLER_0_46_331 vssd1 vssd1 vccd1 vccd1 sky130_ef_sc_hd__decap_12
X_2250_ clknet_leaf_26_clk_i _0264_ net464 vssd1 vssd1 vccd1 vccd1 spi_mem2.address_nibble\[1\]
+ sky130_fd_sc_hd__dfstp_2
X_1201_ net520 net292 net389 vssd1 vssd1 vccd1 vccd1 _0063_ sky130_fd_sc_hd__mux2_1
XFILLER_0_18_43 vssd1 vssd1 vccd1 vccd1 sky130_fd_sc_hd__fill_1
X_2181_ net496 net9 net483 vssd1 vssd1 vccd1 vccd1 spi_mem1.delayed_miso\[1\] sky130_fd_sc_hd__dfrtp_1
X_1063_ _0919_ _0938_ vssd1 vssd1 vccd1 vccd1 _0975_ sky130_fd_sc_hd__and2_1
X_1132_ _0377_ _0389_ net721 vssd1 vssd1 vccd1 vccd1 _0025_ sky130_fd_sc_hd__o21a_1
Xclkbuf_leaf_34_clk_i clknet_2_1__leaf_clk_i vssd1 vssd1 vccd1 vccd1 clknet_leaf_34_clk_i
+ sky130_fd_sc_hd__clkbuf_16
XFILLER_0_34_53 vssd1 vssd1 vccd1 vccd1 sky130_ef_sc_hd__decap_12
XFILLER_0_50_85 vssd1 vssd1 vccd1 vccd1 sky130_ef_sc_hd__decap_12
X_1965_ net511 _0908_ _0911_ net365 vssd1 vssd1 vccd1 vccd1 _0336_ sky130_fd_sc_hd__a22o_1
XFILLER_0_70_197 vssd1 vssd1 vccd1 vccd1 sky130_fd_sc_hd__decap_6
X_1896_ _0927_ _0971_ vssd1 vssd1 vccd1 vccd1 _0869_ sky130_fd_sc_hd__and2_1
XFILLER_0_52_3 vssd1 vssd1 vccd1 vccd1 sky130_fd_sc_hd__decap_4
Xinput209 sport2_i[59] vssd1 vssd1 vccd1 vccd1 net209 sky130_fd_sc_hd__clkbuf_1
XFILLER_0_78_253 vssd1 vssd1 vccd1 vccd1 sky130_ef_sc_hd__decap_12
XFILLER_0_78_231 vssd1 vssd1 vccd1 vccd1 sky130_ef_sc_hd__decap_12
XFILLER_0_38_139 vssd1 vssd1 vccd1 vccd1 sky130_fd_sc_hd__fill_1
XFILLER_0_34_301 vssd1 vssd1 vccd1 vccd1 sky130_fd_sc_hd__decap_6
XFILLER_0_69_253 vssd1 vssd1 vccd1 vccd1 sky130_fd_sc_hd__fill_1
Xhold8 _0296_ vssd1 vssd1 vccd1 vccd1 net512 sky130_fd_sc_hd__dlygate4sd3_1
XFILLER_0_25_301 vssd1 vssd1 vccd1 vccd1 sky130_fd_sc_hd__fill_1
X_1750_ net197 _0774_ vssd1 vssd1 vccd1 vccd1 _0776_ sky130_fd_sc_hd__xnor2_1
XFILLER_0_52_131 vssd1 vssd1 vccd1 vccd1 sky130_fd_sc_hd__fill_1
X_1681_ net431 spi_mem1.data_byte\[1\] net429 vssd1 vssd1 vccd1 vccd1 _0734_ sky130_fd_sc_hd__and3_2
XTAP_757 vssd1 vccd1 sky130_fd_sc_hd__tapvpwrvgnd_1
XTAP_746 vssd1 vccd1 sky130_fd_sc_hd__tapvpwrvgnd_1
XTAP_735 vssd1 vccd1 sky130_fd_sc_hd__tapvpwrvgnd_1
XTAP_724 vssd1 vccd1 sky130_fd_sc_hd__tapvpwrvgnd_1
XTAP_713 vssd1 vccd1 sky130_fd_sc_hd__tapvpwrvgnd_1
XTAP_702 vssd1 vccd1 sky130_fd_sc_hd__tapvpwrvgnd_1
X_2164_ clknet_leaf_6_clk_i net510 net471 vssd1 vssd1 vccd1 vccd1 net308 sky130_fd_sc_hd__dfrtp_1
X_2233_ clknet_leaf_25_clk_i _0247_ net464 vssd1 vssd1 vccd1 vccd1 spi_mem2.address\[6\]
+ sky130_fd_sc_hd__dfrtp_1
X_2302_ clknet_leaf_39_clk_i _0310_ net444 vssd1 vssd1 vccd1 vccd1 spi_mem2.data_buf\[0\]
+ sky130_fd_sc_hd__dfrtp_1
XFILLER_0_75_223 vssd1 vssd1 vccd1 vccd1 sky130_fd_sc_hd__fill_1
X_1046_ spi_mem1.state\[3\] spi_mem1.state\[2\] vssd1 vssd1 vccd1 vccd1 _0964_ sky130_fd_sc_hd__and2b_1
X_1115_ _0377_ vssd1 vssd1 vccd1 vccd1 _0378_ sky130_fd_sc_hd__inv_2
XFILLER_0_45_85 vssd1 vssd1 vccd1 vccd1 sky130_fd_sc_hd__fill_2
X_2095_ clknet_leaf_34_clk_i _0115_ net462 vssd1 vssd1 vccd1 vccd1 spi_mem0.data_buf\[21\]
+ sky130_fd_sc_hd__dfrtp_1
XFILLER_0_75_278 vssd1 vssd1 vccd1 vccd1 sky130_fd_sc_hd__fill_2
XFILLER_0_61_84 vssd1 vssd1 vccd1 vccd1 sky130_fd_sc_hd__fill_1
X_1879_ net426 _0969_ _0856_ vssd1 vssd1 vccd1 vccd1 _0857_ sky130_fd_sc_hd__and3_1
X_1948_ net770 _0897_ _0901_ net366 vssd1 vssd1 vccd1 vccd1 _0329_ sky130_fd_sc_hd__a22o_1
XFILLER_0_43_197 vssd1 vssd1 vccd1 vccd1 sky130_fd_sc_hd__decap_3
XFILLER_0_31_337 vssd1 vssd1 vccd1 vccd1 sky130_ef_sc_hd__decap_12
XFILLER_0_81_215 vssd1 vssd1 vccd1 vccd1 sky130_fd_sc_hd__decap_8
XFILLER_0_66_245 vssd1 vssd1 vccd1 vccd1 sky130_fd_sc_hd__decap_6
XFILLER_0_15_77 vssd1 vssd1 vccd1 vccd1 sky130_fd_sc_hd__fill_1
XFILLER_0_72_204 vssd1 vssd1 vccd1 vccd1 sky130_ef_sc_hd__decap_12
X_1802_ net426 spi_mem2.data_ready _0966_ vssd1 vssd1 vccd1 vccd1 _0815_ sky130_fd_sc_hd__o21bai_2
XFILLER_0_13_304 vssd1 vssd1 vccd1 vccd1 sky130_ef_sc_hd__decap_12
X_1733_ net190 net192 net191 net406 vssd1 vssd1 vccd1 vccd1 _0764_ sky130_fd_sc_hd__o31a_1
X_1595_ net813 _0632_ _0679_ _0680_ vssd1 vssd1 vccd1 vccd1 _0197_ sky130_fd_sc_hd__a22o_1
Xhold249 net322 vssd1 vssd1 vccd1 vccd1 net753 sky130_fd_sc_hd__dlygate4sd3_1
Xhold216 net326 vssd1 vssd1 vccd1 vccd1 net720 sky130_fd_sc_hd__dlygate4sd3_1
XTAP_543 vssd1 vccd1 sky130_fd_sc_hd__tapvpwrvgnd_1
X_1664_ net98 net397 _0692_ _0723_ vssd1 vssd1 vccd1 vccd1 _0725_ sky130_fd_sc_hd__a22o_1
XTAP_532 vssd1 vccd1 sky130_fd_sc_hd__tapvpwrvgnd_1
XTAP_521 vssd1 vccd1 sky130_fd_sc_hd__tapvpwrvgnd_1
XTAP_510 vssd1 vccd1 sky130_fd_sc_hd__tapvpwrvgnd_1
Xhold238 _0061_ vssd1 vssd1 vccd1 vccd1 net742 sky130_fd_sc_hd__dlygate4sd3_1
Xhold227 _0060_ vssd1 vssd1 vccd1 vccd1 net731 sky130_fd_sc_hd__dlygate4sd3_1
XFILLER_0_25_197 vssd1 vssd1 vccd1 vccd1 sky130_fd_sc_hd__decap_6
XFILLER_0_13_337 vssd1 vssd1 vccd1 vccd1 sky130_ef_sc_hd__decap_12
Xhold205 net356 vssd1 vssd1 vccd1 vccd1 net709 sky130_fd_sc_hd__dlygate4sd3_1
X_2147_ clknet_leaf_11_clk_i net779 net475 vssd1 vssd1 vccd1 vccd1 net323 sky130_fd_sc_hd__dfrtp_2
XTAP_598 vssd1 vccd1 sky130_fd_sc_hd__tapvpwrvgnd_1
XTAP_587 vssd1 vccd1 sky130_fd_sc_hd__tapvpwrvgnd_1
XTAP_576 vssd1 vccd1 sky130_fd_sc_hd__tapvpwrvgnd_1
XTAP_565 vssd1 vccd1 sky130_fd_sc_hd__tapvpwrvgnd_1
X_2216_ clknet_leaf_16_clk_i _0230_ net480 vssd1 vssd1 vccd1 vccd1 spi_mem1.data_buf\[28\]
+ sky130_fd_sc_hd__dfrtp_1
XTAP_554 vssd1 vccd1 sky130_fd_sc_hd__tapvpwrvgnd_1
XFILLER_0_15_3 vssd1 vssd1 vccd1 vccd1 sky130_fd_sc_hd__fill_1
X_1029_ net441 spi_mem0.state\[3\] _0945_ vssd1 vssd1 vccd1 vccd1 _0952_ sky130_fd_sc_hd__nand3_1
X_2078_ clknet_leaf_2_clk_i _0098_ net453 vssd1 vssd1 vccd1 vccd1 spi_mem0.data_buf\[4\]
+ sky130_fd_sc_hd__dfrtp_1
XFILLER_0_8_320 vssd1 vssd1 vccd1 vccd1 sky130_fd_sc_hd__decap_6
XFILLER_0_71_281 vssd1 vssd1 vccd1 vccd1 sky130_fd_sc_hd__decap_3
XFILLER_0_16_131 vssd1 vssd1 vccd1 vccd1 sky130_fd_sc_hd__decap_8
XFILLER_0_16_197 vssd1 vssd1 vccd1 vccd1 sky130_ef_sc_hd__decap_12
XFILLER_0_12_381 vssd1 vssd1 vccd1 vccd1 sky130_fd_sc_hd__decap_3
XFILLER_0_62_270 vssd1 vssd1 vccd1 vccd1 sky130_fd_sc_hd__fill_1
XFILLER_0_22_101 vssd1 vssd1 vccd1 vccd1 sky130_fd_sc_hd__fill_1
X_1380_ net433 _0976_ vssd1 vssd1 vccd1 vccd1 _0536_ sky130_fd_sc_hd__nor2_2
XFILLER_0_62_292 vssd1 vssd1 vccd1 vccd1 sky130_ef_sc_hd__decap_12
XFILLER_0_22_156 vssd1 vssd1 vccd1 vccd1 sky130_fd_sc_hd__fill_1
XFILLER_0_26_43 vssd1 vssd1 vccd1 vccd1 sky130_fd_sc_hd__fill_2
X_2001_ clknet_leaf_32_clk_i _0027_ net458 vssd1 vssd1 vccd1 vccd1 spi_mem0.address\[1\]
+ sky130_fd_sc_hd__dfrtp_1
XFILLER_0_45_237 vssd1 vssd1 vccd1 vccd1 sky130_ef_sc_hd__decap_12
X_1716_ _0748_ _0757_ spi_mem2.latency\[4\] vssd1 vssd1 vccd1 vccd1 _0760_ sky130_fd_sc_hd__o21a_1
XFILLER_0_53_281 vssd1 vssd1 vccd1 vccd1 sky130_ef_sc_hd__decap_12
X_1578_ spi_mem1.data_buf\[2\] _0978_ _0664_ spi_mem1.data_byte\[1\] vssd1 vssd1 vccd1
+ vccd1 _0665_ sky130_fd_sc_hd__a211o_1
X_1647_ net90 net396 _0694_ _0712_ vssd1 vssd1 vccd1 vccd1 _0715_ sky130_fd_sc_hd__a22o_1
XTAP_384 vssd1 vccd1 sky130_fd_sc_hd__tapvpwrvgnd_1
XTAP_373 vssd1 vccd1 sky130_fd_sc_hd__tapvpwrvgnd_1
XTAP_362 vssd1 vccd1 sky130_fd_sc_hd__tapvpwrvgnd_1
XTAP_351 vssd1 vccd1 sky130_fd_sc_hd__tapvpwrvgnd_1
XTAP_340 vssd1 vccd1 sky130_fd_sc_hd__tapvpwrvgnd_1
XFILLER_0_68_307 vssd1 vssd1 vccd1 vccd1 sky130_fd_sc_hd__fill_1
XTAP_395 vssd1 vccd1 sky130_fd_sc_hd__tapvpwrvgnd_1
XPHY_46 vssd1 vssd1 vccd1 vccd1 sky130_fd_sc_hd__decap_3
XPHY_13 vssd1 vssd1 vccd1 vccd1 sky130_fd_sc_hd__decap_3
XPHY_24 vssd1 vssd1 vccd1 vccd1 sky130_fd_sc_hd__decap_3
XPHY_35 vssd1 vssd1 vccd1 vccd1 sky130_fd_sc_hd__decap_3
XPHY_79 vssd1 vssd1 vccd1 vccd1 sky130_fd_sc_hd__decap_3
XFILLER_0_36_204 vssd1 vssd1 vccd1 vccd1 sky130_ef_sc_hd__decap_12
XPHY_68 vssd1 vssd1 vccd1 vccd1 sky130_fd_sc_hd__decap_3
XPHY_57 vssd1 vssd1 vccd1 vccd1 sky130_fd_sc_hd__decap_3
XFILLER_0_4_3 vssd1 vssd1 vccd1 vccd1 sky130_fd_sc_hd__decap_3
XFILLER_0_27_215 vssd1 vssd1 vccd1 vccd1 sky130_fd_sc_hd__decap_8
XFILLER_0_82_365 vssd1 vssd1 vccd1 vccd1 sky130_fd_sc_hd__fill_1
XFILLER_0_82_332 vssd1 vssd1 vccd1 vccd1 sky130_fd_sc_hd__decap_4
XFILLER_0_50_251 vssd1 vssd1 vccd1 vccd1 sky130_fd_sc_hd__fill_1
XFILLER_0_35_270 vssd1 vssd1 vccd1 vccd1 sky130_fd_sc_hd__decap_8
XFILLER_0_27_237 vssd1 vssd1 vccd1 vccd1 sky130_fd_sc_hd__decap_3
XFILLER_0_12_23 vssd1 vssd1 vccd1 vccd1 sky130_fd_sc_hd__decap_4
X_1501_ spi_mem1.state\[2\] _0940_ _0942_ _0935_ vssd1 vssd1 vccd1 vccd1 _0625_ sky130_fd_sc_hd__o211a_1
X_1432_ net124 _0564_ net125 vssd1 vssd1 vccd1 vccd1 _0569_ sky130_fd_sc_hd__o21ai_1
X_1363_ net36 net417 _0479_ _0490_ vssd1 vssd1 vccd1 vccd1 _0525_ sky130_fd_sc_hd__a22o_1
XFILLER_0_53_52 vssd1 vssd1 vccd1 vccd1 sky130_fd_sc_hd__decap_4
X_1294_ net393 _0482_ net374 vssd1 vssd1 vccd1 vccd1 _0483_ sky130_fd_sc_hd__o21ai_2
XFILLER_0_18_248 vssd1 vssd1 vccd1 vccd1 sky130_fd_sc_hd__decap_4
XFILLER_0_82_3 vssd1 vssd1 vccd1 vccd1 sky130_fd_sc_hd__decap_3
XFILLER_0_33_229 vssd1 vssd1 vccd1 vccd1 sky130_ef_sc_hd__decap_12
Xfanout367 net368 vssd1 vssd1 vccd1 vccd1 net367 sky130_fd_sc_hd__clkbuf_4
Xfanout389 net391 vssd1 vssd1 vccd1 vccd1 net389 sky130_fd_sc_hd__clkbuf_4
XTAP_192 vssd1 vccd1 sky130_fd_sc_hd__tapvpwrvgnd_1
XTAP_181 vssd1 vccd1 sky130_fd_sc_hd__tapvpwrvgnd_1
XTAP_170 vssd1 vccd1 sky130_fd_sc_hd__tapvpwrvgnd_1
XFILLER_0_64_365 vssd1 vssd1 vccd1 vccd1 sky130_fd_sc_hd__fill_1
XFILLER_0_64_321 vssd1 vssd1 vccd1 vccd1 sky130_ef_sc_hd__decap_12
XFILLER_0_32_251 vssd1 vssd1 vccd1 vccd1 sky130_fd_sc_hd__fill_1
XFILLER_0_17_281 vssd1 vssd1 vccd1 vccd1 sky130_fd_sc_hd__decap_4
XFILLER_0_59_137 vssd1 vssd1 vccd1 vccd1 sky130_fd_sc_hd__decap_8
XFILLER_0_74_118 vssd1 vssd1 vccd1 vccd1 sky130_fd_sc_hd__decap_6
XFILLER_0_55_321 vssd1 vssd1 vccd1 vccd1 sky130_fd_sc_hd__decap_3
XFILLER_0_70_324 vssd1 vssd1 vccd1 vccd1 sky130_ef_sc_hd__decap_12
X_1415_ net115 net630 net410 vssd1 vssd1 vccd1 vccd1 _0137_ sky130_fd_sc_hd__mux2_1
X_1346_ net438 net436 net440 vssd1 vssd1 vccd1 vccd1 _0515_ sky130_fd_sc_hd__and3b_2
XFILLER_0_65_107 vssd1 vssd1 vccd1 vccd1 sky130_fd_sc_hd__fill_1
X_1277_ spi_mem0.address\[6\] _0366_ _0392_ spi_mem0.address\[2\] net443 vssd1 vssd1
+ vccd1 vccd1 _0470_ sky130_fd_sc_hd__a221o_1
XFILLER_0_80_94 vssd1 vssd1 vccd1 vccd1 sky130_ef_sc_hd__decap_12
XFILLER_0_73_162 vssd1 vssd1 vccd1 vccd1 sky130_fd_sc_hd__fill_1
XFILLER_0_46_343 vssd1 vssd1 vccd1 vccd1 sky130_fd_sc_hd__decap_6
Xclkbuf_leaf_0_clk_i clknet_2_0__leaf_clk_i vssd1 vssd1 vccd1 vccd1 clknet_leaf_0_clk_i
+ sky130_fd_sc_hd__clkbuf_16
XFILLER_0_14_273 vssd1 vssd1 vccd1 vccd1 sky130_ef_sc_hd__decap_12
XFILLER_0_69_402 vssd1 vssd1 vccd1 vccd1 sky130_fd_sc_hd__decap_4
X_1978__2 clknet_leaf_13_clk_i vssd1 vssd1 vccd1 vccd1 net491 sky130_fd_sc_hd__inv_2
X_1987__11 clknet_leaf_13_clk_i vssd1 vssd1 vccd1 vccd1 net500 sky130_fd_sc_hd__inv_2
XFILLER_0_64_195 vssd1 vssd1 vccd1 vccd1 sky130_fd_sc_hd__fill_1
X_2180_ net495 net8 net477 vssd1 vssd1 vccd1 vccd1 spi_mem1.delayed_miso\[0\] sky130_fd_sc_hd__dfrtp_1
X_1200_ net665 net291 net390 vssd1 vssd1 vccd1 vccd1 _0062_ sky130_fd_sc_hd__mux2_1
XFILLER_0_75_405 vssd1 vssd1 vccd1 vccd1 sky130_fd_sc_hd__fill_2
X_1131_ _0369_ _0373_ vssd1 vssd1 vccd1 vccd1 _0389_ sky130_fd_sc_hd__nor2_1
X_1062_ spi_mem0.state\[3\] _0946_ _0948_ vssd1 vssd1 vccd1 vccd1 net226 sky130_fd_sc_hd__a21oi_4
XFILLER_0_34_98 vssd1 vssd1 vccd1 vccd1 sky130_fd_sc_hd__decap_8
XFILLER_0_34_65 vssd1 vssd1 vccd1 vccd1 sky130_ef_sc_hd__decap_12
XFILLER_0_70_132 vssd1 vssd1 vccd1 vccd1 sky130_fd_sc_hd__decap_8
XFILLER_0_55_162 vssd1 vssd1 vccd1 vccd1 sky130_fd_sc_hd__decap_6
XFILLER_0_50_97 vssd1 vssd1 vccd1 vccd1 sky130_fd_sc_hd__decap_4
XFILLER_0_43_335 vssd1 vssd1 vccd1 vccd1 sky130_fd_sc_hd__fill_1
X_1895_ _0970_ _0354_ _0745_ vssd1 vssd1 vccd1 vccd1 _0868_ sky130_fd_sc_hd__a21oi_4
XFILLER_0_7_215 vssd1 vssd1 vccd1 vccd1 sky130_fd_sc_hd__fill_2
X_1964_ net173 net403 _0353_ _0875_ vssd1 vssd1 vccd1 vccd1 _0911_ sky130_fd_sc_hd__a22o_1
XFILLER_0_11_276 vssd1 vssd1 vccd1 vccd1 sky130_fd_sc_hd__decap_4
XFILLER_0_11_298 vssd1 vssd1 vccd1 vccd1 sky130_fd_sc_hd__fill_1
XFILLER_0_78_221 vssd1 vssd1 vccd1 vccd1 sky130_fd_sc_hd__decap_3
XFILLER_0_45_3 vssd1 vssd1 vccd1 vccd1 sky130_ef_sc_hd__decap_12
X_1329_ net20 net416 _0484_ _0504_ vssd1 vssd1 vccd1 vccd1 _0506_ sky130_fd_sc_hd__a22o_1
XFILLER_0_78_265 vssd1 vssd1 vccd1 vccd1 sky130_ef_sc_hd__decap_12
XFILLER_0_78_243 vssd1 vssd1 vccd1 vccd1 sky130_fd_sc_hd__decap_8
XFILLER_0_19_310 vssd1 vssd1 vccd1 vccd1 sky130_fd_sc_hd__decap_6
XFILLER_0_61_165 vssd1 vssd1 vccd1 vccd1 sky130_fd_sc_hd__decap_3
Xhold9 spi_mem1.address\[21\] vssd1 vssd1 vccd1 vccd1 net513 sky130_fd_sc_hd__dlygate4sd3_1
Xoutput290 net290 vssd1 vssd1 vccd1 vccd1 sport0_o[6] sky130_fd_sc_hd__clkbuf_4
XFILLER_0_57_405 vssd1 vssd1 vccd1 vccd1 sky130_fd_sc_hd__fill_2
XFILLER_0_25_335 vssd1 vssd1 vccd1 vccd1 sky130_fd_sc_hd__fill_1
XTAP_725 vssd1 vccd1 sky130_fd_sc_hd__tapvpwrvgnd_1
XTAP_714 vssd1 vccd1 sky130_fd_sc_hd__tapvpwrvgnd_1
XTAP_703 vssd1 vccd1 sky130_fd_sc_hd__tapvpwrvgnd_1
X_1680_ net771 _0729_ _0733_ net369 vssd1 vssd1 vccd1 vccd1 _0229_ sky130_fd_sc_hd__a22o_1
X_2301_ clknet_leaf_26_clk_i _0309_ net465 vssd1 vssd1 vccd1 vccd1 spi_mem2.data_byte\[1\]
+ sky130_fd_sc_hd__dfrtp_4
Xwire384 _0798_ vssd1 vssd1 vccd1 vccd1 net384 sky130_fd_sc_hd__buf_1
XTAP_758 vssd1 vccd1 sky130_fd_sc_hd__tapvpwrvgnd_1
XTAP_747 vssd1 vccd1 sky130_fd_sc_hd__tapvpwrvgnd_1
XTAP_736 vssd1 vccd1 sky130_fd_sc_hd__tapvpwrvgnd_1
X_1114_ spi_mem0.spi_clk _0370_ _0374_ _0365_ _0376_ vssd1 vssd1 vccd1 vccd1 _0377_
+ sky130_fd_sc_hd__a221o_4
X_2163_ clknet_leaf_6_clk_i net572 net472 vssd1 vssd1 vccd1 vccd1 net307 sky130_fd_sc_hd__dfrtp_1
X_2232_ clknet_leaf_28_clk_i _0246_ net460 vssd1 vssd1 vccd1 vccd1 spi_mem2.address\[5\]
+ sky130_fd_sc_hd__dfrtp_1
X_1045_ net441 _0921_ _0946_ vssd1 vssd1 vccd1 vccd1 net235 sky130_fd_sc_hd__and3_2
X_2094_ clknet_leaf_34_clk_i _0114_ net463 vssd1 vssd1 vccd1 vccd1 spi_mem0.data_buf\[20\]
+ sky130_fd_sc_hd__dfrtp_1
XFILLER_0_31_349 vssd1 vssd1 vccd1 vccd1 sky130_ef_sc_hd__decap_12
XFILLER_0_28_184 vssd1 vssd1 vccd1 vccd1 sky130_fd_sc_hd__fill_1
X_1947_ net165 net400 _0972_ _0877_ vssd1 vssd1 vccd1 vccd1 _0901_ sky130_fd_sc_hd__a22o_1
X_1878_ _0854_ _0855_ _0927_ vssd1 vssd1 vccd1 vccd1 _0856_ sky130_fd_sc_hd__mux2_1
XFILLER_0_16_379 vssd1 vssd1 vccd1 vccd1 sky130_fd_sc_hd__decap_4
XFILLER_0_39_405 vssd1 vssd1 vccd1 vccd1 sky130_fd_sc_hd__fill_2
Xclkbuf_leaf_33_clk_i clknet_2_1__leaf_clk_i vssd1 vssd1 vccd1 vccd1 clknet_leaf_33_clk_i
+ sky130_fd_sc_hd__clkbuf_16
XFILLER_0_82_29 vssd1 vssd1 vccd1 vccd1 sky130_fd_sc_hd__fill_1
XFILLER_0_57_257 vssd1 vssd1 vccd1 vccd1 sky130_fd_sc_hd__decap_3
XFILLER_0_57_213 vssd1 vssd1 vccd1 vccd1 sky130_fd_sc_hd__decap_8
XFILLER_0_72_249 vssd1 vssd1 vccd1 vccd1 sky130_fd_sc_hd__decap_3
XFILLER_0_72_216 vssd1 vssd1 vccd1 vccd1 sky130_fd_sc_hd__fill_1
X_1801_ spi_mem2.state\[3\] _0814_ _0808_ vssd1 vssd1 vccd1 vccd1 _0269_ sky130_fd_sc_hd__mux2_1
Xhold217 spi_mem0.latency\[5\] vssd1 vssd1 vccd1 vccd1 net721 sky130_fd_sc_hd__dlygate4sd3_1
X_1663_ net394 _0723_ net369 vssd1 vssd1 vccd1 vccd1 _0724_ sky130_fd_sc_hd__o21ai_2
XFILLER_0_31_55 vssd1 vssd1 vccd1 vccd1 sky130_fd_sc_hd__fill_1
XFILLER_0_25_165 vssd1 vssd1 vccd1 vccd1 sky130_fd_sc_hd__decap_3
XFILLER_0_13_316 vssd1 vssd1 vccd1 vccd1 sky130_ef_sc_hd__decap_12
X_1732_ net190 net191 net192 vssd1 vssd1 vccd1 vccd1 _0763_ sky130_fd_sc_hd__o21ai_1
Xhold206 _0274_ vssd1 vssd1 vccd1 vccd1 net710 sky130_fd_sc_hd__dlygate4sd3_1
X_1594_ net150 _0631_ _0632_ vssd1 vssd1 vccd1 vccd1 _0680_ sky130_fd_sc_hd__a21oi_1
Xhold239 spi_mem1.data_buf\[24\] vssd1 vssd1 vccd1 vccd1 net743 sky130_fd_sc_hd__dlygate4sd3_1
XTAP_566 vssd1 vccd1 sky130_fd_sc_hd__tapvpwrvgnd_1
XTAP_555 vssd1 vccd1 sky130_fd_sc_hd__tapvpwrvgnd_1
XTAP_544 vssd1 vccd1 sky130_fd_sc_hd__tapvpwrvgnd_1
XTAP_533 vssd1 vccd1 sky130_fd_sc_hd__tapvpwrvgnd_1
XTAP_522 vssd1 vccd1 sky130_fd_sc_hd__tapvpwrvgnd_1
XTAP_511 vssd1 vccd1 sky130_fd_sc_hd__tapvpwrvgnd_1
XTAP_500 vssd1 vccd1 sky130_fd_sc_hd__tapvpwrvgnd_1
XFILLER_0_40_157 vssd1 vssd1 vccd1 vccd1 sky130_fd_sc_hd__fill_1
Xhold228 spi_mem0.data_buf\[4\] vssd1 vssd1 vccd1 vccd1 net732 sky130_fd_sc_hd__dlygate4sd3_1
X_2146_ clknet_leaf_9_clk_i _0166_ net474 vssd1 vssd1 vccd1 vccd1 net322 sky130_fd_sc_hd__dfrtp_1
XTAP_599 vssd1 vccd1 sky130_fd_sc_hd__tapvpwrvgnd_1
X_2215_ clknet_leaf_16_clk_i _0229_ net480 vssd1 vssd1 vccd1 vccd1 spi_mem1.data_buf\[27\]
+ sky130_fd_sc_hd__dfrtp_1
XTAP_588 vssd1 vccd1 sky130_fd_sc_hd__tapvpwrvgnd_1
XTAP_577 vssd1 vccd1 sky130_fd_sc_hd__tapvpwrvgnd_1
XFILLER_0_56_85 vssd1 vssd1 vccd1 vccd1 sky130_fd_sc_hd__fill_2
XFILLER_0_56_63 vssd1 vssd1 vccd1 vccd1 sky130_fd_sc_hd__fill_1
X_2077_ clknet_leaf_1_clk_i _0097_ net452 vssd1 vssd1 vccd1 vccd1 spi_mem0.data_buf\[3\]
+ sky130_fd_sc_hd__dfrtp_1
X_1028_ net285 vssd1 vssd1 vccd1 vccd1 net225 sky130_fd_sc_hd__inv_2
XFILLER_0_63_216 vssd1 vssd1 vccd1 vccd1 sky130_fd_sc_hd__fill_1
XFILLER_0_48_257 vssd1 vssd1 vccd1 vccd1 sky130_ef_sc_hd__decap_12
XFILLER_0_31_113 vssd1 vssd1 vccd1 vccd1 sky130_fd_sc_hd__decap_8
XFILLER_0_6_7 vssd1 vssd1 vccd1 vccd1 sky130_fd_sc_hd__fill_1
XFILLER_0_79_393 vssd1 vssd1 vccd1 vccd1 sky130_ef_sc_hd__decap_12
XFILLER_0_39_279 vssd1 vssd1 vccd1 vccd1 sky130_fd_sc_hd__fill_1
X_2000_ clknet_leaf_32_clk_i _0026_ net458 vssd1 vssd1 vccd1 vccd1 spi_mem0.address\[0\]
+ sky130_fd_sc_hd__dfrtp_1
X_1715_ _0759_ net812 _0748_ vssd1 vssd1 vccd1 vccd1 _0238_ sky130_fd_sc_hd__mux2_1
XFILLER_0_53_293 vssd1 vssd1 vccd1 vccd1 sky130_ef_sc_hd__decap_12
X_1646_ net811 _0713_ _0714_ net368 vssd1 vssd1 vccd1 vccd1 _0214_ sky130_fd_sc_hd__a22o_1
XFILLER_0_5_335 vssd1 vssd1 vccd1 vccd1 sky130_fd_sc_hd__fill_1
X_1577_ spi_mem1.data_buf\[10\] _0633_ _0634_ spi_mem1.data_buf\[6\] _0663_ vssd1
+ vssd1 vccd1 vccd1 _0664_ sky130_fd_sc_hd__a221o_1
XTAP_396 vssd1 vccd1 sky130_fd_sc_hd__tapvpwrvgnd_1
XTAP_385 vssd1 vccd1 sky130_fd_sc_hd__tapvpwrvgnd_1
XTAP_374 vssd1 vccd1 sky130_fd_sc_hd__tapvpwrvgnd_1
XTAP_363 vssd1 vccd1 sky130_fd_sc_hd__tapvpwrvgnd_1
XTAP_352 vssd1 vccd1 sky130_fd_sc_hd__tapvpwrvgnd_1
XTAP_341 vssd1 vccd1 sky130_fd_sc_hd__tapvpwrvgnd_1
XTAP_330 vssd1 vccd1 sky130_fd_sc_hd__tapvpwrvgnd_1
XFILLER_0_6_98 vssd1 vssd1 vccd1 vccd1 sky130_fd_sc_hd__decap_4
X_2129_ clknet_leaf_21_clk_i _0149_ net481 vssd1 vssd1 vccd1 vccd1 spi_mem1.address\[16\]
+ sky130_fd_sc_hd__dfrtp_1
XPHY_69 vssd1 vssd1 vccd1 vccd1 sky130_fd_sc_hd__decap_3
XPHY_58 vssd1 vssd1 vccd1 vccd1 sky130_fd_sc_hd__decap_3
XPHY_47 vssd1 vssd1 vccd1 vccd1 sky130_fd_sc_hd__decap_3
XPHY_14 vssd1 vssd1 vccd1 vccd1 sky130_fd_sc_hd__decap_3
XPHY_25 vssd1 vssd1 vccd1 vccd1 sky130_fd_sc_hd__decap_3
XPHY_36 vssd1 vssd1 vccd1 vccd1 sky130_fd_sc_hd__decap_3
XFILLER_0_44_271 vssd1 vssd1 vccd1 vccd1 sky130_fd_sc_hd__decap_4
XFILLER_0_36_238 vssd1 vssd1 vccd1 vccd1 sky130_ef_sc_hd__decap_12
XFILLER_0_36_216 vssd1 vssd1 vccd1 vccd1 sky130_fd_sc_hd__fill_1
XFILLER_0_29_290 vssd1 vssd1 vccd1 vccd1 sky130_ef_sc_hd__decap_12
XFILLER_0_59_308 vssd1 vssd1 vccd1 vccd1 sky130_ef_sc_hd__decap_12
XFILLER_0_82_388 vssd1 vssd1 vccd1 vccd1 sky130_fd_sc_hd__decap_4
X_1500_ net433 _0624_ _0622_ vssd1 vssd1 vccd1 vccd1 _0158_ sky130_fd_sc_hd__mux2_1
XFILLER_0_35_293 vssd1 vssd1 vccd1 vccd1 sky130_ef_sc_hd__decap_12
X_1431_ net125 net124 _0564_ vssd1 vssd1 vccd1 vccd1 _0568_ sky130_fd_sc_hd__or3_2
XFILLER_0_50_296 vssd1 vssd1 vccd1 vccd1 sky130_ef_sc_hd__decap_12
X_1362_ net568 _0521_ _0524_ net376 vssd1 vssd1 vccd1 vccd1 _0120_ sky130_fd_sc_hd__a22o_1
X_1293_ net436 _0349_ vssd1 vssd1 vccd1 vccd1 _0482_ sky130_fd_sc_hd__and2b_1
XFILLER_0_10_138 vssd1 vssd1 vccd1 vccd1 sky130_fd_sc_hd__fill_2
XFILLER_0_53_31 vssd1 vssd1 vccd1 vccd1 sky130_fd_sc_hd__fill_1
Xinput190 sport2_i[41] vssd1 vssd1 vccd1 vccd1 net190 sky130_fd_sc_hd__buf_2
XFILLER_0_73_388 vssd1 vssd1 vccd1 vccd1 sky130_fd_sc_hd__decap_4
XFILLER_0_58_385 vssd1 vssd1 vccd1 vccd1 sky130_ef_sc_hd__decap_12
XFILLER_0_78_61 vssd1 vssd1 vccd1 vccd1 sky130_fd_sc_hd__decap_3
XFILLER_0_75_3 vssd1 vssd1 vccd1 vccd1 sky130_ef_sc_hd__decap_12
X_1629_ net151 net398 _0696_ _0700_ vssd1 vssd1 vccd1 vccd1 _0704_ sky130_fd_sc_hd__a22o_1
XFILLER_0_41_296 vssd1 vssd1 vccd1 vccd1 sky130_fd_sc_hd__decap_8
Xfanout368 _0689_ vssd1 vssd1 vccd1 vccd1 net368 sky130_fd_sc_hd__buf_2
XTAP_193 vssd1 vccd1 sky130_fd_sc_hd__tapvpwrvgnd_1
XTAP_171 vssd1 vccd1 sky130_fd_sc_hd__tapvpwrvgnd_1
XTAP_182 vssd1 vccd1 sky130_fd_sc_hd__tapvpwrvgnd_1
Xfanout379 net382 vssd1 vssd1 vccd1 vccd1 net379 sky130_fd_sc_hd__buf_4
XFILLER_0_64_333 vssd1 vssd1 vccd1 vccd1 sky130_fd_sc_hd__decap_4
XFILLER_0_49_385 vssd1 vssd1 vccd1 vccd1 sky130_fd_sc_hd__fill_1
XFILLER_0_49_363 vssd1 vssd1 vccd1 vccd1 sky130_fd_sc_hd__fill_1
XFILLER_0_49_352 vssd1 vssd1 vccd1 vccd1 sky130_fd_sc_hd__fill_2
XFILLER_0_82_141 vssd1 vssd1 vccd1 vccd1 sky130_fd_sc_hd__fill_1
XFILLER_0_70_336 vssd1 vssd1 vccd1 vccd1 sky130_fd_sc_hd__fill_2
XFILLER_0_70_358 vssd1 vssd1 vccd1 vccd1 sky130_fd_sc_hd__decap_6
X_1414_ net114 net562 net410 vssd1 vssd1 vccd1 vccd1 _0136_ sky130_fd_sc_hd__mux2_1
X_1276_ spi_mem0.address\[20\] _0366_ _0468_ vssd1 vssd1 vccd1 vccd1 _0469_ sky130_fd_sc_hd__a21oi_1
X_1345_ net580 _0510_ _0514_ net374 vssd1 vssd1 vccd1 vccd1 _0113_ sky130_fd_sc_hd__a22o_1
XFILLER_0_3_33 vssd1 vssd1 vccd1 vccd1 sky130_fd_sc_hd__decap_3
XFILLER_0_3_22 vssd1 vssd1 vccd1 vccd1 sky130_fd_sc_hd__fill_2
XFILLER_0_80_51 vssd1 vssd1 vccd1 vccd1 sky130_fd_sc_hd__decap_4
XFILLER_0_3_99 vssd1 vssd1 vccd1 vccd1 sky130_fd_sc_hd__fill_2
XFILLER_0_14_285 vssd1 vssd1 vccd1 vccd1 sky130_fd_sc_hd__decap_8
XFILLER_0_64_141 vssd1 vssd1 vccd1 vccd1 sky130_fd_sc_hd__fill_2
XFILLER_0_37_333 vssd1 vssd1 vccd1 vccd1 sky130_fd_sc_hd__decap_3
XFILLER_0_37_322 vssd1 vssd1 vccd1 vccd1 sky130_fd_sc_hd__decap_3
XFILLER_0_37_300 vssd1 vssd1 vccd1 vccd1 sky130_fd_sc_hd__fill_2
X_1130_ _0370_ _0373_ _0378_ _0388_ net508 vssd1 vssd1 vccd1 vccd1 _0024_ sky130_fd_sc_hd__a32o_1
X_1061_ _0923_ _0956_ _0953_ vssd1 vssd1 vccd1 vccd1 net250 sky130_fd_sc_hd__mux2_2
XFILLER_0_34_77 vssd1 vssd1 vccd1 vccd1 sky130_fd_sc_hd__fill_1
XFILLER_0_55_185 vssd1 vssd1 vccd1 vccd1 sky130_fd_sc_hd__fill_2
XFILLER_0_43_325 vssd1 vssd1 vccd1 vccd1 sky130_fd_sc_hd__fill_1
X_1894_ spi_mem2.data_byte\[1\] _0865_ _0867_ _0745_ vssd1 vssd1 vccd1 vccd1 _0309_
+ sky130_fd_sc_hd__o22a_1
X_1963_ net553 _0908_ _0910_ net365 vssd1 vssd1 vccd1 vccd1 _0335_ sky130_fd_sc_hd__a22o_1
XFILLER_0_59_85 vssd1 vssd1 vccd1 vccd1 sky130_fd_sc_hd__decap_6
XFILLER_0_51_391 vssd1 vssd1 vccd1 vccd1 sky130_fd_sc_hd__fill_1
XFILLER_0_11_222 vssd1 vssd1 vccd1 vccd1 sky130_fd_sc_hd__fill_2
XFILLER_0_11_255 vssd1 vssd1 vccd1 vccd1 sky130_ef_sc_hd__decap_12
X_1328_ net393 _0504_ net374 vssd1 vssd1 vccd1 vccd1 _0505_ sky130_fd_sc_hd__o21ai_2
XFILLER_0_38_3 vssd1 vssd1 vccd1 vccd1 sky130_fd_sc_hd__decap_4
X_1259_ spi_mem0.data_buf\[18\] _0349_ _0425_ spi_mem0.data_buf\[22\] vssd1 vssd1
+ vccd1 vccd1 _0453_ sky130_fd_sc_hd__a22o_1
XFILLER_0_78_277 vssd1 vssd1 vccd1 vccd1 sky130_fd_sc_hd__decap_8
XFILLER_0_61_111 vssd1 vssd1 vccd1 vccd1 sky130_fd_sc_hd__fill_1
XFILLER_0_46_141 vssd1 vssd1 vccd1 vccd1 sky130_fd_sc_hd__decap_3
XFILLER_0_19_355 vssd1 vssd1 vccd1 vccd1 sky130_fd_sc_hd__fill_1
XFILLER_0_61_188 vssd1 vssd1 vccd1 vccd1 sky130_ef_sc_hd__decap_12
X_1980__4 clknet_leaf_19_clk_i vssd1 vssd1 vccd1 vccd1 net493 sky130_fd_sc_hd__inv_2
Xoutput280 net280 vssd1 vssd1 vccd1 vccd1 sport0_o[28] sky130_fd_sc_hd__clkbuf_4
Xoutput291 net291 vssd1 vssd1 vccd1 vccd1 sport0_o[7] sky130_fd_sc_hd__clkbuf_4
XFILLER_0_69_200 vssd1 vssd1 vccd1 vccd1 sky130_fd_sc_hd__decap_6
XFILLER_0_52_166 vssd1 vssd1 vccd1 vccd1 sky130_fd_sc_hd__decap_8
XFILLER_0_40_306 vssd1 vssd1 vccd1 vccd1 sky130_fd_sc_hd__fill_2
XTAP_759 vssd1 vccd1 sky130_fd_sc_hd__tapvpwrvgnd_1
XTAP_748 vssd1 vccd1 sky130_fd_sc_hd__tapvpwrvgnd_1
XTAP_737 vssd1 vccd1 sky130_fd_sc_hd__tapvpwrvgnd_1
XTAP_726 vssd1 vccd1 sky130_fd_sc_hd__tapvpwrvgnd_1
XTAP_715 vssd1 vccd1 sky130_fd_sc_hd__tapvpwrvgnd_1
XTAP_704 vssd1 vccd1 sky130_fd_sc_hd__tapvpwrvgnd_1
X_2300_ clknet_leaf_26_clk_i _0308_ net465 vssd1 vssd1 vccd1 vccd1 spi_mem2.data_byte\[0\]
+ sky130_fd_sc_hd__dfrtp_1
XFILLER_0_33_391 vssd1 vssd1 vccd1 vccd1 sky130_fd_sc_hd__fill_1
X_2231_ clknet_leaf_30_clk_i _0245_ net460 vssd1 vssd1 vccd1 vccd1 spi_mem2.address\[4\]
+ sky130_fd_sc_hd__dfrtp_1
X_2162_ clknet_leaf_6_clk_i net525 net472 vssd1 vssd1 vccd1 vccd1 net306 sky130_fd_sc_hd__dfrtp_1
X_1044_ spi_mem2.spi_clk net353 net405 vssd1 vssd1 vccd1 vccd1 net248 sky130_fd_sc_hd__and3_2
XFILLER_0_45_65 vssd1 vssd1 vccd1 vccd1 sky130_ef_sc_hd__decap_12
X_1113_ spi_mem0.address_nibble\[0\] spi_mem0.address_nibble\[1\] net443 _0364_ vssd1
+ vssd1 vccd1 vccd1 _0376_ sky130_fd_sc_hd__o31a_1
X_2093_ clknet_leaf_34_clk_i _0113_ net454 vssd1 vssd1 vccd1 vccd1 spi_mem0.data_buf\[19\]
+ sky130_fd_sc_hd__dfrtp_1
XFILLER_0_75_247 vssd1 vssd1 vccd1 vccd1 sky130_fd_sc_hd__decap_8
XFILLER_0_75_225 vssd1 vssd1 vccd1 vccd1 sky130_fd_sc_hd__fill_2
XFILLER_0_75_203 vssd1 vssd1 vccd1 vccd1 sky130_ef_sc_hd__decap_12
XFILLER_0_43_177 vssd1 vssd1 vccd1 vccd1 sky130_ef_sc_hd__decap_12
X_1877_ spi_mem2.data_buf\[3\] spi_mem2.data_buf\[7\] spi_mem2.data_buf\[11\] spi_mem2.data_buf\[15\]
+ net424 net421 vssd1 vssd1 vccd1 vccd1 _0855_ sky130_fd_sc_hd__mux4_1
X_1946_ net550 _0897_ _0900_ net366 vssd1 vssd1 vccd1 vccd1 _0328_ sky130_fd_sc_hd__a22o_1
XFILLER_0_16_358 vssd1 vssd1 vccd1 vccd1 sky130_fd_sc_hd__decap_6
XFILLER_0_81_239 vssd1 vssd1 vccd1 vccd1 sky130_fd_sc_hd__fill_1
XFILLER_0_22_306 vssd1 vssd1 vccd1 vccd1 sky130_fd_sc_hd__fill_2
XFILLER_0_19_130 vssd1 vssd1 vccd1 vccd1 sky130_fd_sc_hd__fill_1
XFILLER_0_19_141 vssd1 vssd1 vccd1 vccd1 sky130_fd_sc_hd__fill_1
XFILLER_0_15_391 vssd1 vssd1 vccd1 vccd1 sky130_fd_sc_hd__fill_1
XFILLER_0_57_225 vssd1 vssd1 vccd1 vccd1 sky130_ef_sc_hd__decap_12
X_1800_ _0957_ _0959_ _0740_ net219 _0813_ vssd1 vssd1 vccd1 vccd1 _0814_ sky130_fd_sc_hd__a221o_1
XFILLER_0_80_250 vssd1 vssd1 vccd1 vccd1 sky130_fd_sc_hd__fill_2
Xhold218 net295 vssd1 vssd1 vccd1 vccd1 net722 sky130_fd_sc_hd__dlygate4sd3_1
Xhold207 spi_mem1.data_buf\[9\] vssd1 vssd1 vccd1 vccd1 net711 sky130_fd_sc_hd__dlygate4sd3_1
X_1662_ net429 spi_mem1.data_byte\[1\] net431 vssd1 vssd1 vccd1 vccd1 _0723_ sky130_fd_sc_hd__and3b_2
Xhold229 _0059_ vssd1 vssd1 vccd1 vccd1 net733 sky130_fd_sc_hd__dlygate4sd3_1
XFILLER_0_25_177 vssd1 vssd1 vccd1 vccd1 sky130_fd_sc_hd__fill_1
XFILLER_0_25_111 vssd1 vssd1 vccd1 vccd1 sky130_fd_sc_hd__fill_1
X_1731_ net540 _0762_ net406 vssd1 vssd1 vccd1 vccd1 _0251_ sky130_fd_sc_hd__mux2_1
XFILLER_0_13_328 vssd1 vssd1 vccd1 vccd1 sky130_fd_sc_hd__decap_8
X_1593_ net152 _0536_ _0631_ _0678_ vssd1 vssd1 vccd1 vccd1 _0679_ sky130_fd_sc_hd__a211o_1
XTAP_589 vssd1 vccd1 sky130_fd_sc_hd__tapvpwrvgnd_1
X_2214_ clknet_leaf_15_clk_i _0228_ net480 vssd1 vssd1 vccd1 vccd1 spi_mem1.data_buf\[26\]
+ sky130_fd_sc_hd__dfrtp_1
XTAP_578 vssd1 vccd1 sky130_fd_sc_hd__tapvpwrvgnd_1
XTAP_567 vssd1 vccd1 sky130_fd_sc_hd__tapvpwrvgnd_1
XTAP_556 vssd1 vccd1 sky130_fd_sc_hd__tapvpwrvgnd_1
XTAP_545 vssd1 vccd1 sky130_fd_sc_hd__tapvpwrvgnd_1
XTAP_534 vssd1 vccd1 sky130_fd_sc_hd__tapvpwrvgnd_1
XTAP_523 vssd1 vccd1 sky130_fd_sc_hd__tapvpwrvgnd_1
XTAP_512 vssd1 vccd1 sky130_fd_sc_hd__tapvpwrvgnd_1
XTAP_501 vssd1 vccd1 sky130_fd_sc_hd__tapvpwrvgnd_1
XFILLER_0_72_85 vssd1 vssd1 vccd1 vccd1 sky130_ef_sc_hd__decap_12
XFILLER_0_72_74 vssd1 vssd1 vccd1 vccd1 sky130_fd_sc_hd__decap_8
X_2145_ clknet_leaf_8_clk_i net727 net469 vssd1 vssd1 vccd1 vccd1 net321 sky130_fd_sc_hd__dfrtp_1
X_1027_ _0949_ _0950_ _0948_ vssd1 vssd1 vccd1 vccd1 net285 sky130_fd_sc_hd__a21oi_4
X_2076_ clknet_leaf_1_clk_i _0096_ net451 vssd1 vssd1 vccd1 vccd1 spi_mem0.data_buf\[2\]
+ sky130_fd_sc_hd__dfrtp_1
XFILLER_0_48_269 vssd1 vssd1 vccd1 vccd1 sky130_ef_sc_hd__decap_12
X_1929_ net646 _0886_ _0890_ net362 vssd1 vssd1 vccd1 vccd1 _0321_ sky130_fd_sc_hd__a22o_1
XFILLER_0_31_169 vssd1 vssd1 vccd1 vccd1 sky130_ef_sc_hd__decap_12
XFILLER_0_16_177 vssd1 vssd1 vccd1 vccd1 sky130_ef_sc_hd__decap_12
XFILLER_0_50_401 vssd1 vssd1 vccd1 vccd1 sky130_fd_sc_hd__decap_6
XFILLER_0_22_147 vssd1 vssd1 vccd1 vccd1 sky130_fd_sc_hd__fill_1
Xhold90 spi_mem0.address\[1\] vssd1 vssd1 vccd1 vccd1 net594 sky130_fd_sc_hd__dlygate4sd3_1
XFILLER_0_60_209 vssd1 vssd1 vccd1 vccd1 sky130_ef_sc_hd__decap_12
XFILLER_0_42_99 vssd1 vssd1 vccd1 vccd1 sky130_ef_sc_hd__decap_12
X_1714_ _0757_ _0758_ _0750_ vssd1 vssd1 vccd1 vccd1 _0759_ sky130_fd_sc_hd__a21oi_1
X_1576_ net430 net428 spi_mem1.data_buf\[14\] vssd1 vssd1 vccd1 vccd1 _0663_ sky130_fd_sc_hd__and3_1
X_1645_ net89 net396 _0692_ _0712_ vssd1 vssd1 vccd1 vccd1 _0714_ sky130_fd_sc_hd__a22o_1
XFILLER_0_13_169 vssd1 vssd1 vccd1 vccd1 sky130_fd_sc_hd__fill_2
XTAP_397 vssd1 vccd1 sky130_fd_sc_hd__tapvpwrvgnd_1
XTAP_386 vssd1 vccd1 sky130_fd_sc_hd__tapvpwrvgnd_1
XTAP_375 vssd1 vccd1 sky130_fd_sc_hd__tapvpwrvgnd_1
XTAP_364 vssd1 vccd1 sky130_fd_sc_hd__tapvpwrvgnd_1
XTAP_353 vssd1 vccd1 sky130_fd_sc_hd__tapvpwrvgnd_1
XTAP_342 vssd1 vccd1 sky130_fd_sc_hd__tapvpwrvgnd_1
XTAP_331 vssd1 vccd1 sky130_fd_sc_hd__tapvpwrvgnd_1
Xclkbuf_leaf_32_clk_i clknet_2_1__leaf_clk_i vssd1 vssd1 vccd1 vccd1 clknet_leaf_32_clk_i
+ sky130_fd_sc_hd__clkbuf_16
XFILLER_0_20_3 vssd1 vssd1 vccd1 vccd1 sky130_fd_sc_hd__fill_1
XTAP_320 vssd1 vccd1 sky130_fd_sc_hd__tapvpwrvgnd_1
X_2128_ clknet_leaf_16_clk_i _0148_ net485 vssd1 vssd1 vccd1 vccd1 spi_mem1.address\[15\]
+ sky130_fd_sc_hd__dfrtp_1
XPHY_59 vssd1 vssd1 vccd1 vccd1 sky130_fd_sc_hd__decap_3
X_2059_ clknet_leaf_35_clk_i net716 net454 vssd1 vssd1 vccd1 vccd1 net283 sky130_fd_sc_hd__dfrtp_1
XPHY_48 vssd1 vssd1 vccd1 vccd1 sky130_fd_sc_hd__decap_3
XPHY_15 vssd1 vssd1 vccd1 vccd1 sky130_fd_sc_hd__decap_3
XPHY_26 vssd1 vssd1 vccd1 vccd1 sky130_fd_sc_hd__decap_3
XPHY_37 vssd1 vssd1 vccd1 vccd1 sky130_fd_sc_hd__decap_3
XFILLER_0_8_174 vssd1 vssd1 vccd1 vccd1 sky130_fd_sc_hd__fill_1
XFILLER_0_82_356 vssd1 vssd1 vccd1 vccd1 sky130_fd_sc_hd__fill_2
XFILLER_0_82_301 vssd1 vssd1 vccd1 vccd1 sky130_fd_sc_hd__fill_1
XFILLER_0_67_342 vssd1 vssd1 vccd1 vccd1 sky130_fd_sc_hd__decap_8
XFILLER_0_42_209 vssd1 vssd1 vccd1 vccd1 sky130_fd_sc_hd__decap_3
X_1430_ net549 _0567_ net413 vssd1 vssd1 vccd1 vccd1 _0145_ sky130_fd_sc_hd__mux2_1
XFILLER_0_50_253 vssd1 vssd1 vccd1 vccd1 sky130_fd_sc_hd__decap_6
XFILLER_0_2_328 vssd1 vssd1 vccd1 vccd1 sky130_fd_sc_hd__fill_2
XFILLER_0_10_117 vssd1 vssd1 vccd1 vccd1 sky130_fd_sc_hd__fill_1
X_1292_ _0347_ _0480_ _0474_ vssd1 vssd1 vccd1 vccd1 _0481_ sky130_fd_sc_hd__a21oi_2
XFILLER_0_37_77 vssd1 vssd1 vccd1 vccd1 sky130_fd_sc_hd__decap_6
X_1361_ net35 net417 _0479_ _0488_ vssd1 vssd1 vccd1 vccd1 _0524_ sky130_fd_sc_hd__a22o_1
Xinput180 sport2_i[32] vssd1 vssd1 vccd1 vccd1 net180 sky130_fd_sc_hd__buf_1
XFILLER_0_53_65 vssd1 vssd1 vccd1 vccd1 sky130_ef_sc_hd__decap_12
Xinput191 sport2_i[42] vssd1 vssd1 vccd1 vccd1 net191 sky130_fd_sc_hd__clkbuf_2
XFILLER_0_73_334 vssd1 vssd1 vccd1 vccd1 sky130_fd_sc_hd__fill_2
XFILLER_0_58_397 vssd1 vssd1 vccd1 vccd1 sky130_fd_sc_hd__decap_8
XFILLER_0_5_111 vssd1 vssd1 vccd1 vccd1 sky130_fd_sc_hd__fill_1
X_1559_ _0647_ net575 _0632_ vssd1 vssd1 vccd1 vccd1 _0194_ sky130_fd_sc_hd__mux2_1
X_1628_ net778 _0701_ _0703_ net367 vssd1 vssd1 vccd1 vccd1 _0207_ sky130_fd_sc_hd__a22o_1
XFILLER_0_41_264 vssd1 vssd1 vccd1 vccd1 sky130_fd_sc_hd__fill_1
Xfanout369 net370 vssd1 vssd1 vccd1 vccd1 net369 sky130_fd_sc_hd__clkbuf_4
XTAP_194 vssd1 vccd1 sky130_fd_sc_hd__tapvpwrvgnd_1
XTAP_172 vssd1 vccd1 sky130_fd_sc_hd__tapvpwrvgnd_1
XTAP_183 vssd1 vccd1 sky130_fd_sc_hd__tapvpwrvgnd_1
XFILLER_0_76_150 vssd1 vssd1 vccd1 vccd1 sky130_fd_sc_hd__fill_2
XFILLER_0_32_253 vssd1 vssd1 vccd1 vccd1 sky130_ef_sc_hd__decap_12
XFILLER_0_32_231 vssd1 vssd1 vccd1 vccd1 sky130_ef_sc_hd__decap_12
XFILLER_0_74_109 vssd1 vssd1 vccd1 vccd1 sky130_fd_sc_hd__decap_3
XFILLER_0_59_117 vssd1 vssd1 vccd1 vccd1 sky130_fd_sc_hd__fill_1
XFILLER_0_82_197 vssd1 vssd1 vccd1 vccd1 sky130_fd_sc_hd__fill_1
XFILLER_0_82_164 vssd1 vssd1 vccd1 vccd1 sky130_fd_sc_hd__decap_4
XFILLER_0_67_183 vssd1 vssd1 vccd1 vccd1 sky130_fd_sc_hd__decap_8
XFILLER_0_23_231 vssd1 vssd1 vccd1 vccd1 sky130_fd_sc_hd__decap_3
XFILLER_0_23_57 vssd1 vssd1 vccd1 vccd1 sky130_fd_sc_hd__decap_4
X_1413_ net113 net631 net410 vssd1 vssd1 vccd1 vccd1 _0135_ sky130_fd_sc_hd__mux2_1
XFILLER_0_48_76 vssd1 vssd1 vccd1 vccd1 sky130_fd_sc_hd__decap_8
XFILLER_0_23_297 vssd1 vssd1 vccd1 vccd1 sky130_fd_sc_hd__fill_1
X_1275_ spi_mem0.address\[12\] _0375_ _0392_ spi_mem0.address\[16\] vssd1 vssd1 vccd1
+ vccd1 _0468_ sky130_fd_sc_hd__a22o_1
X_1344_ net27 net415 _0350_ _0490_ vssd1 vssd1 vccd1 vccd1 _0514_ sky130_fd_sc_hd__a22o_1
XFILLER_0_61_337 vssd1 vssd1 vccd1 vccd1 sky130_fd_sc_hd__decap_4
XFILLER_0_64_175 vssd1 vssd1 vccd1 vccd1 sky130_fd_sc_hd__fill_1
XFILLER_0_64_164 vssd1 vssd1 vccd1 vccd1 sky130_fd_sc_hd__fill_2
XFILLER_0_52_326 vssd1 vssd1 vccd1 vccd1 sky130_ef_sc_hd__decap_12
XFILLER_0_37_389 vssd1 vssd1 vccd1 vccd1 sky130_fd_sc_hd__decap_3
XFILLER_0_37_356 vssd1 vssd1 vccd1 vccd1 sky130_fd_sc_hd__fill_2
XFILLER_0_9_291 vssd1 vssd1 vccd1 vccd1 sky130_fd_sc_hd__fill_1
XFILLER_0_20_201 vssd1 vssd1 vccd1 vccd1 sky130_fd_sc_hd__fill_1
X_1060_ spi_mem1.state\[3\] _0935_ net820 vssd1 vssd1 vccd1 vccd1 net238 sky130_fd_sc_hd__a21oi_2
XFILLER_0_28_301 vssd1 vssd1 vccd1 vccd1 sky130_fd_sc_hd__decap_6
X_1962_ net172 net403 _0353_ _0873_ vssd1 vssd1 vccd1 vccd1 _0910_ sky130_fd_sc_hd__a22o_1
XFILLER_0_59_31 vssd1 vssd1 vccd1 vccd1 sky130_ef_sc_hd__decap_12
XFILLER_0_43_337 vssd1 vssd1 vccd1 vccd1 sky130_fd_sc_hd__decap_8
X_1893_ _0353_ _0744_ vssd1 vssd1 vccd1 vccd1 _0867_ sky130_fd_sc_hd__and2b_1
XFILLER_0_11_201 vssd1 vssd1 vccd1 vccd1 sky130_ef_sc_hd__decap_12
X_1189_ _0949_ _0951_ _0342_ spi_mem0.state\[0\] vssd1 vssd1 vccd1 vccd1 _0418_ sky130_fd_sc_hd__a22o_1
X_1327_ net436 net438 net440 vssd1 vssd1 vccd1 vccd1 _0504_ sky130_fd_sc_hd__and3b_1
XFILLER_0_38_109 vssd1 vssd1 vccd1 vccd1 sky130_fd_sc_hd__decap_4
X_1258_ spi_mem0.data_buf\[26\] _0423_ net435 vssd1 vssd1 vccd1 vccd1 _0452_ sky130_fd_sc_hd__a21bo_1
XFILLER_0_46_153 vssd1 vssd1 vccd1 vccd1 sky130_ef_sc_hd__decap_12
XFILLER_0_46_120 vssd1 vssd1 vccd1 vccd1 sky130_ef_sc_hd__decap_12
Xoutput270 net270 vssd1 vssd1 vccd1 vccd1 sport0_o[19] sky130_fd_sc_hd__clkbuf_4
Xoutput281 net281 vssd1 vssd1 vccd1 vccd1 sport0_o[29] sky130_fd_sc_hd__clkbuf_4
Xoutput292 net292 vssd1 vssd1 vccd1 vccd1 sport0_o[8] sky130_fd_sc_hd__clkbuf_4
XFILLER_0_69_289 vssd1 vssd1 vccd1 vccd1 sky130_fd_sc_hd__decap_3
XFILLER_0_69_278 vssd1 vssd1 vccd1 vccd1 sky130_fd_sc_hd__fill_2
XFILLER_0_69_223 vssd1 vssd1 vccd1 vccd1 sky130_fd_sc_hd__fill_1
XFILLER_0_37_142 vssd1 vssd1 vccd1 vccd1 sky130_fd_sc_hd__decap_4
XFILLER_0_52_189 vssd1 vssd1 vccd1 vccd1 sky130_fd_sc_hd__decap_6
XFILLER_0_33_370 vssd1 vssd1 vccd1 vccd1 sky130_fd_sc_hd__decap_8
XFILLER_0_25_359 vssd1 vssd1 vccd1 vccd1 sky130_fd_sc_hd__decap_8
XFILLER_0_25_337 vssd1 vssd1 vccd1 vccd1 sky130_ef_sc_hd__decap_12
XTAP_749 vssd1 vccd1 sky130_fd_sc_hd__tapvpwrvgnd_1
XTAP_738 vssd1 vccd1 sky130_fd_sc_hd__tapvpwrvgnd_1
XTAP_727 vssd1 vccd1 sky130_fd_sc_hd__tapvpwrvgnd_1
XTAP_716 vssd1 vccd1 sky130_fd_sc_hd__tapvpwrvgnd_1
XTAP_705 vssd1 vccd1 sky130_fd_sc_hd__tapvpwrvgnd_1
XFILLER_0_29_34 vssd1 vssd1 vccd1 vccd1 sky130_fd_sc_hd__decap_3
XFILLER_0_29_23 vssd1 vssd1 vccd1 vccd1 sky130_fd_sc_hd__decap_3
X_2230_ clknet_leaf_30_clk_i _0244_ net460 vssd1 vssd1 vccd1 vccd1 spi_mem2.address\[3\]
+ sky130_fd_sc_hd__dfrtp_1
X_1043_ _0954_ _0961_ vssd1 vssd1 vccd1 vccd1 _0963_ sky130_fd_sc_hd__or2_1
XFILLER_0_45_77 vssd1 vssd1 vccd1 vccd1 sky130_fd_sc_hd__decap_8
XFILLER_0_45_44 vssd1 vssd1 vccd1 vccd1 sky130_fd_sc_hd__decap_3
X_2161_ clknet_leaf_5_clk_i _0181_ net468 vssd1 vssd1 vccd1 vccd1 net304 sky130_fd_sc_hd__dfrtp_2
X_2092_ clknet_leaf_34_clk_i _0112_ net454 vssd1 vssd1 vccd1 vccd1 spi_mem0.data_buf\[18\]
+ sky130_fd_sc_hd__dfrtp_1
X_1112_ spi_mem0.address_nibble\[0\] spi_mem0.address_nibble\[1\] vssd1 vssd1 vccd1
+ vccd1 _0375_ sky130_fd_sc_hd__nor2_1
XFILLER_0_75_215 vssd1 vssd1 vccd1 vccd1 sky130_fd_sc_hd__decap_8
XFILLER_0_28_197 vssd1 vssd1 vccd1 vccd1 sky130_fd_sc_hd__decap_6
X_1945_ net164 net401 _0972_ _0875_ vssd1 vssd1 vccd1 vccd1 _0900_ sky130_fd_sc_hd__a22o_1
XFILLER_0_43_189 vssd1 vssd1 vccd1 vccd1 sky130_fd_sc_hd__decap_8
XFILLER_0_43_167 vssd1 vssd1 vccd1 vccd1 sky130_fd_sc_hd__fill_1
X_1876_ spi_mem2.data_buf\[19\] spi_mem2.data_buf\[23\] spi_mem2.data_buf\[27\] spi_mem2.data_buf\[31\]
+ net425 net422 vssd1 vssd1 vccd1 vccd1 _0854_ sky130_fd_sc_hd__mux4_1
XFILLER_0_3_275 vssd1 vssd1 vccd1 vccd1 sky130_fd_sc_hd__fill_1
XFILLER_0_3_253 vssd1 vssd1 vccd1 vccd1 sky130_fd_sc_hd__fill_2
XFILLER_0_50_3 vssd1 vssd1 vccd1 vccd1 sky130_ef_sc_hd__decap_12
XFILLER_0_30_362 vssd1 vssd1 vccd1 vccd1 sky130_fd_sc_hd__fill_2
XFILLER_0_15_47 vssd1 vssd1 vccd1 vccd1 sky130_fd_sc_hd__decap_3
XFILLER_0_72_229 vssd1 vssd1 vccd1 vccd1 sky130_ef_sc_hd__decap_12
XFILLER_0_65_281 vssd1 vssd1 vccd1 vccd1 sky130_fd_sc_hd__decap_4
XFILLER_0_57_237 vssd1 vssd1 vccd1 vccd1 sky130_ef_sc_hd__decap_12
XFILLER_0_31_57 vssd1 vssd1 vccd1 vccd1 sky130_fd_sc_hd__decap_8
Xhold208 spi_mem1.spi_clk vssd1 vssd1 vccd1 vccd1 net712 sky130_fd_sc_hd__dlygate4sd3_1
X_1592_ _0532_ _0675_ _0677_ _0674_ vssd1 vssd1 vccd1 vccd1 _0678_ sky130_fd_sc_hd__a31o_1
X_1661_ net780 _0718_ _0722_ net370 vssd1 vssd1 vccd1 vccd1 _0221_ sky130_fd_sc_hd__a22o_1
Xhold219 spi_mem0.data_buf\[11\] vssd1 vssd1 vccd1 vccd1 net723 sky130_fd_sc_hd__dlygate4sd3_1
X_1730_ net190 net191 vssd1 vssd1 vccd1 vccd1 _0762_ sky130_fd_sc_hd__xnor2_1
XFILLER_0_21_373 vssd1 vssd1 vccd1 vccd1 sky130_ef_sc_hd__decap_12
X_2213_ clknet_leaf_16_clk_i _0227_ net484 vssd1 vssd1 vccd1 vccd1 spi_mem1.data_buf\[25\]
+ sky130_fd_sc_hd__dfrtp_1
X_2144_ clknet_leaf_8_clk_i net752 net469 vssd1 vssd1 vccd1 vccd1 net316 sky130_fd_sc_hd__dfrtp_1
XTAP_579 vssd1 vccd1 sky130_fd_sc_hd__tapvpwrvgnd_1
XTAP_568 vssd1 vccd1 sky130_fd_sc_hd__tapvpwrvgnd_1
XTAP_557 vssd1 vccd1 sky130_fd_sc_hd__tapvpwrvgnd_1
XTAP_546 vssd1 vccd1 sky130_fd_sc_hd__tapvpwrvgnd_1
XTAP_535 vssd1 vccd1 sky130_fd_sc_hd__tapvpwrvgnd_1
XTAP_524 vssd1 vccd1 sky130_fd_sc_hd__tapvpwrvgnd_1
XTAP_513 vssd1 vccd1 sky130_fd_sc_hd__tapvpwrvgnd_1
XTAP_502 vssd1 vccd1 sky130_fd_sc_hd__tapvpwrvgnd_1
XFILLER_0_72_97 vssd1 vssd1 vccd1 vccd1 sky130_fd_sc_hd__fill_2
X_1026_ spi_mem0.state\[1\] spi_mem0.state\[0\] vssd1 vssd1 vccd1 vccd1 _0951_ sky130_fd_sc_hd__nand2_1
X_2075_ clknet_leaf_1_clk_i _0095_ net451 vssd1 vssd1 vccd1 vccd1 spi_mem0.data_buf\[1\]
+ sky130_fd_sc_hd__dfrtp_1
X_1859_ spi_mem2.address\[18\] _0742_ _0838_ _0926_ vssd1 vssd1 vccd1 vccd1 _0839_
+ sky130_fd_sc_hd__a211o_1
X_1928_ net157 net400 _0877_ _0885_ vssd1 vssd1 vccd1 vccd1 _0890_ sky130_fd_sc_hd__a22o_1
XFILLER_0_16_189 vssd1 vssd1 vccd1 vccd1 sky130_fd_sc_hd__decap_6
XFILLER_0_21_90 vssd1 vssd1 vccd1 vccd1 sky130_ef_sc_hd__decap_12
XFILLER_0_12_373 vssd1 vssd1 vccd1 vccd1 sky130_fd_sc_hd__decap_8
XFILLER_0_47_281 vssd1 vssd1 vccd1 vccd1 sky130_ef_sc_hd__decap_12
XFILLER_0_39_259 vssd1 vssd1 vccd1 vccd1 sky130_ef_sc_hd__decap_12
XFILLER_0_62_262 vssd1 vssd1 vccd1 vccd1 sky130_fd_sc_hd__decap_8
XFILLER_0_22_126 vssd1 vssd1 vccd1 vccd1 sky130_ef_sc_hd__decap_12
XFILLER_0_26_24 vssd1 vssd1 vccd1 vccd1 sky130_fd_sc_hd__decap_4
Xhold91 spi_mem1.address\[5\] vssd1 vssd1 vccd1 vccd1 net595 sky130_fd_sc_hd__dlygate4sd3_1
Xhold80 spi_mem1.address\[8\] vssd1 vssd1 vccd1 vccd1 net584 sky130_fd_sc_hd__dlygate4sd3_1
XFILLER_0_26_35 vssd1 vssd1 vccd1 vccd1 sky130_fd_sc_hd__fill_1
X_1713_ spi_mem2.latency\[3\] _0359_ vssd1 vssd1 vccd1 vccd1 _0758_ sky130_fd_sc_hd__nand2_1
XFILLER_0_67_20 vssd1 vssd1 vccd1 vccd1 sky130_fd_sc_hd__fill_2
X_1575_ _0931_ _0661_ vssd1 vssd1 vccd1 vccd1 _0662_ sky130_fd_sc_hd__or2_1
X_1644_ net394 _0712_ net370 vssd1 vssd1 vccd1 vccd1 _0713_ sky130_fd_sc_hd__o21ai_2
XTAP_332 vssd1 vccd1 sky130_fd_sc_hd__tapvpwrvgnd_1
XFILLER_0_6_89 vssd1 vssd1 vccd1 vccd1 sky130_fd_sc_hd__fill_1
XTAP_310 vssd1 vccd1 sky130_fd_sc_hd__tapvpwrvgnd_1
XTAP_321 vssd1 vccd1 sky130_fd_sc_hd__tapvpwrvgnd_1
X_2127_ clknet_leaf_20_clk_i _0147_ net485 vssd1 vssd1 vccd1 vccd1 spi_mem1.address\[14\]
+ sky130_fd_sc_hd__dfrtp_1
XTAP_398 vssd1 vccd1 sky130_fd_sc_hd__tapvpwrvgnd_1
XTAP_387 vssd1 vccd1 sky130_fd_sc_hd__tapvpwrvgnd_1
XTAP_376 vssd1 vccd1 sky130_fd_sc_hd__tapvpwrvgnd_1
XTAP_365 vssd1 vccd1 sky130_fd_sc_hd__tapvpwrvgnd_1
XTAP_354 vssd1 vccd1 sky130_fd_sc_hd__tapvpwrvgnd_1
XTAP_343 vssd1 vccd1 sky130_fd_sc_hd__tapvpwrvgnd_1
XFILLER_0_76_365 vssd1 vssd1 vccd1 vccd1 sky130_ef_sc_hd__decap_12
X_1009_ net432 net433 spi_mem1.state\[2\] spi_mem1.state\[3\] vssd1 vssd1 vccd1 vccd1
+ _0937_ sky130_fd_sc_hd__nor4_1
XPHY_49 vssd1 vssd1 vccd1 vccd1 sky130_fd_sc_hd__decap_3
XPHY_16 vssd1 vssd1 vccd1 vccd1 sky130_fd_sc_hd__decap_3
XPHY_27 vssd1 vssd1 vccd1 vccd1 sky130_fd_sc_hd__decap_3
XPHY_38 vssd1 vssd1 vccd1 vccd1 sky130_fd_sc_hd__decap_3
X_2058_ clknet_leaf_35_clk_i net747 net449 vssd1 vssd1 vccd1 vccd1 net281 sky130_fd_sc_hd__dfrtp_1
XFILLER_0_12_181 vssd1 vssd1 vccd1 vccd1 sky130_ef_sc_hd__decap_12
XFILLER_0_67_321 vssd1 vssd1 vccd1 vccd1 sky130_fd_sc_hd__fill_1
XFILLER_0_23_402 vssd1 vssd1 vccd1 vccd1 sky130_fd_sc_hd__decap_4
XFILLER_0_50_221 vssd1 vssd1 vccd1 vccd1 sky130_fd_sc_hd__decap_4
X_1360_ net637 _0521_ _0523_ net374 vssd1 vssd1 vccd1 vccd1 _0119_ sky130_fd_sc_hd__a22o_1
X_1291_ net78 _0479_ net79 net80 vssd1 vssd1 vccd1 vccd1 _0480_ sky130_fd_sc_hd__nand4b_2
Xinput170 sport2_i[23] vssd1 vssd1 vccd1 vccd1 net170 sky130_fd_sc_hd__clkbuf_1
Xinput192 sport2_i[43] vssd1 vssd1 vccd1 vccd1 net192 sky130_fd_sc_hd__clkbuf_2
Xinput181 sport2_i[33] vssd1 vssd1 vccd1 vccd1 net181 sky130_fd_sc_hd__buf_1
XFILLER_0_58_343 vssd1 vssd1 vccd1 vccd1 sky130_ef_sc_hd__decap_12
XFILLER_0_53_77 vssd1 vssd1 vccd1 vccd1 sky130_ef_sc_hd__decap_12
XFILLER_0_78_85 vssd1 vssd1 vccd1 vccd1 sky130_ef_sc_hd__decap_12
X_1627_ net141 net398 _0694_ _0700_ vssd1 vssd1 vccd1 vccd1 _0703_ sky130_fd_sc_hd__a22o_1
X_1558_ _0977_ _0637_ _0640_ _0646_ vssd1 vssd1 vccd1 vccd1 _0647_ sky130_fd_sc_hd__a31o_1
X_1489_ net148 net147 vssd1 vssd1 vccd1 vccd1 _0614_ sky130_fd_sc_hd__nand2_1
XTAP_173 vssd1 vccd1 sky130_fd_sc_hd__tapvpwrvgnd_1
XTAP_184 vssd1 vccd1 sky130_fd_sc_hd__tapvpwrvgnd_1
XTAP_195 vssd1 vccd1 sky130_fd_sc_hd__tapvpwrvgnd_1
XFILLER_0_76_195 vssd1 vssd1 vccd1 vccd1 sky130_fd_sc_hd__fill_1
XFILLER_0_64_357 vssd1 vssd1 vccd1 vccd1 sky130_fd_sc_hd__decap_6
XFILLER_0_32_265 vssd1 vssd1 vccd1 vccd1 sky130_fd_sc_hd__decap_4
XFILLER_0_32_243 vssd1 vssd1 vccd1 vccd1 sky130_fd_sc_hd__decap_8
XFILLER_0_2_3 vssd1 vssd1 vccd1 vccd1 sky130_fd_sc_hd__decap_4
XFILLER_0_55_335 vssd1 vssd1 vccd1 vccd1 sky130_fd_sc_hd__fill_1
XFILLER_0_55_313 vssd1 vssd1 vccd1 vccd1 sky130_fd_sc_hd__decap_8
XFILLER_0_23_25 vssd1 vssd1 vccd1 vccd1 sky130_fd_sc_hd__decap_4
XFILLER_0_23_254 vssd1 vssd1 vccd1 vccd1 sky130_ef_sc_hd__decap_12
Xclkbuf_leaf_31_clk_i clknet_2_1__leaf_clk_i vssd1 vssd1 vccd1 vccd1 clknet_leaf_31_clk_i
+ sky130_fd_sc_hd__clkbuf_16
XFILLER_0_11_405 vssd1 vssd1 vccd1 vccd1 sky130_fd_sc_hd__fill_2
X_1412_ net112 net621 net410 vssd1 vssd1 vccd1 vccd1 _0134_ sky130_fd_sc_hd__mux2_1
XFILLER_0_48_66 vssd1 vssd1 vccd1 vccd1 sky130_fd_sc_hd__fill_1
X_1343_ net686 _0510_ _0513_ net374 vssd1 vssd1 vccd1 vccd1 _0112_ sky130_fd_sc_hd__a22o_1
X_1274_ _0465_ _0466_ _0347_ _0463_ vssd1 vssd1 vccd1 vccd1 _0467_ sky130_fd_sc_hd__o211a_1
XFILLER_0_3_57 vssd1 vssd1 vccd1 vccd1 sky130_fd_sc_hd__fill_1
XFILLER_0_58_184 vssd1 vssd1 vccd1 vccd1 sky130_ef_sc_hd__decap_12
XFILLER_0_58_173 vssd1 vssd1 vccd1 vccd1 sky130_fd_sc_hd__fill_2
XFILLER_0_46_302 vssd1 vssd1 vccd1 vccd1 sky130_fd_sc_hd__decap_3
XFILLER_0_80_3 vssd1 vssd1 vccd1 vccd1 sky130_ef_sc_hd__decap_12
X_0989_ spi_mem0.state\[1\] vssd1 vssd1 vccd1 vccd1 _0920_ sky130_fd_sc_hd__inv_2
XFILLER_0_52_338 vssd1 vssd1 vccd1 vccd1 sky130_ef_sc_hd__decap_12
XFILLER_0_9_281 vssd1 vssd1 vccd1 vccd1 sky130_fd_sc_hd__fill_1
XFILLER_0_18_25 vssd1 vssd1 vccd1 vccd1 sky130_fd_sc_hd__decap_3
XFILLER_0_43_305 vssd1 vssd1 vccd1 vccd1 sky130_ef_sc_hd__decap_12
X_1892_ _0865_ _0866_ vssd1 vssd1 vccd1 vccd1 _0308_ sky130_fd_sc_hd__nor2_1
X_1961_ net805 _0908_ _0909_ net365 vssd1 vssd1 vccd1 vccd1 _0334_ sky130_fd_sc_hd__a22o_1
XFILLER_0_59_65 vssd1 vssd1 vccd1 vccd1 sky130_ef_sc_hd__decap_12
XFILLER_0_59_43 vssd1 vssd1 vccd1 vccd1 sky130_fd_sc_hd__decap_4
XFILLER_0_51_382 vssd1 vssd1 vccd1 vccd1 sky130_fd_sc_hd__fill_1
XFILLER_0_11_213 vssd1 vssd1 vccd1 vccd1 sky130_fd_sc_hd__fill_2
XFILLER_0_75_53 vssd1 vssd1 vccd1 vccd1 sky130_fd_sc_hd__decap_3
X_1326_ net723 _0499_ _0503_ net372 vssd1 vssd1 vccd1 vccd1 _0105_ sky130_fd_sc_hd__a22o_1
X_1188_ net441 _0417_ net378 vssd1 vssd1 vccd1 vccd1 _0053_ sky130_fd_sc_hd__mux2_1
X_1257_ spi_mem0.data_buf\[2\] spi_mem0.data_buf\[6\] spi_mem0.data_buf\[10\] spi_mem0.data_buf\[14\]
+ net439 net437 vssd1 vssd1 vccd1 vccd1 _0451_ sky130_fd_sc_hd__mux4_1
XFILLER_0_61_113 vssd1 vssd1 vccd1 vccd1 sky130_ef_sc_hd__decap_12
XFILLER_0_46_165 vssd1 vssd1 vccd1 vccd1 sky130_fd_sc_hd__decap_6
XFILLER_0_46_132 vssd1 vssd1 vccd1 vccd1 sky130_fd_sc_hd__decap_8
Xoutput260 net260 vssd1 vssd1 vccd1 vccd1 sport0_o[0] sky130_fd_sc_hd__clkbuf_4
Xoutput282 net282 vssd1 vssd1 vccd1 vccd1 sport0_o[2] sky130_fd_sc_hd__clkbuf_4
Xoutput271 net271 vssd1 vssd1 vccd1 vccd1 sport0_o[1] sky130_fd_sc_hd__clkbuf_4
Xoutput293 net293 vssd1 vssd1 vccd1 vccd1 sport0_o[9] sky130_fd_sc_hd__clkbuf_4
XFILLER_0_37_176 vssd1 vssd1 vccd1 vccd1 sky130_fd_sc_hd__fill_2
XFILLER_0_37_154 vssd1 vssd1 vccd1 vccd1 sky130_ef_sc_hd__decap_12
XFILLER_0_33_393 vssd1 vssd1 vccd1 vccd1 sky130_fd_sc_hd__fill_1
XFILLER_0_25_349 vssd1 vssd1 vccd1 vccd1 sky130_fd_sc_hd__fill_2
XFILLER_0_25_327 vssd1 vssd1 vccd1 vccd1 sky130_fd_sc_hd__fill_2
XTAP_739 vssd1 vccd1 sky130_fd_sc_hd__tapvpwrvgnd_1
XTAP_728 vssd1 vccd1 sky130_fd_sc_hd__tapvpwrvgnd_1
XTAP_717 vssd1 vccd1 sky130_fd_sc_hd__tapvpwrvgnd_1
XTAP_706 vssd1 vccd1 sky130_fd_sc_hd__tapvpwrvgnd_1
X_2160_ clknet_leaf_5_clk_i _0180_ net468 vssd1 vssd1 vccd1 vccd1 net303 sky130_fd_sc_hd__dfrtp_1
XFILLER_0_29_68 vssd1 vssd1 vccd1 vccd1 sky130_fd_sc_hd__decap_3
XFILLER_0_29_57 vssd1 vssd1 vccd1 vccd1 sky130_fd_sc_hd__decap_4
Xmax_cap1 _0937_ vssd1 vssd1 vccd1 vccd1 net820 sky130_fd_sc_hd__clkbuf_1
X_1111_ spi_mem0.latency\[5\] _0372_ _0370_ vssd1 vssd1 vccd1 vccd1 _0374_ sky130_fd_sc_hd__o21ai_1
X_1042_ _0954_ _0961_ vssd1 vssd1 vccd1 vccd1 _0962_ sky130_fd_sc_hd__nor2_2
X_2091_ clknet_leaf_35_clk_i _0111_ net454 vssd1 vssd1 vccd1 vccd1 spi_mem0.data_buf\[17\]
+ sky130_fd_sc_hd__dfrtp_1
XFILLER_0_0_47 vssd1 vssd1 vccd1 vccd1 sky130_fd_sc_hd__fill_2
X_1875_ net523 _0818_ _0853_ vssd1 vssd1 vccd1 vccd1 _0304_ sky130_fd_sc_hd__a21o_1
XFILLER_0_43_113 vssd1 vssd1 vccd1 vccd1 sky130_ef_sc_hd__decap_12
X_1944_ net784 _0897_ _0899_ net366 vssd1 vssd1 vccd1 vccd1 _0327_ sky130_fd_sc_hd__a22o_1
XFILLER_0_10_92 vssd1 vssd1 vccd1 vccd1 sky130_fd_sc_hd__fill_1
X_2289_ clknet_leaf_13_clk_i _0302_ net477 vssd1 vssd1 vccd1 vccd1 net252 sky130_fd_sc_hd__dfrtp_1
XFILLER_0_43_3 vssd1 vssd1 vccd1 vccd1 sky130_fd_sc_hd__decap_4
X_1309_ net61 net416 _0484_ _0492_ vssd1 vssd1 vccd1 vccd1 _0494_ sky130_fd_sc_hd__a22o_1
XFILLER_0_30_385 vssd1 vssd1 vccd1 vccd1 sky130_fd_sc_hd__fill_1
XFILLER_0_57_249 vssd1 vssd1 vccd1 vccd1 sky130_fd_sc_hd__decap_8
XFILLER_0_25_113 vssd1 vssd1 vccd1 vccd1 sky130_ef_sc_hd__decap_12
X_1591_ spi_mem1.address\[20\] _0534_ _0676_ _0930_ vssd1 vssd1 vccd1 vccd1 _0677_
+ sky130_fd_sc_hd__a211o_1
XTAP_525 vssd1 vccd1 sky130_fd_sc_hd__tapvpwrvgnd_1
XTAP_514 vssd1 vccd1 sky130_fd_sc_hd__tapvpwrvgnd_1
X_1660_ net96 net396 _0979_ _0698_ vssd1 vssd1 vccd1 vccd1 _0722_ sky130_fd_sc_hd__a22o_1
XTAP_503 vssd1 vccd1 sky130_fd_sc_hd__tapvpwrvgnd_1
Xhold209 spi_mem0.data_buf\[21\] vssd1 vssd1 vccd1 vccd1 net713 sky130_fd_sc_hd__dlygate4sd3_1
XFILLER_0_21_363 vssd1 vssd1 vccd1 vccd1 sky130_fd_sc_hd__fill_1
XFILLER_0_21_385 vssd1 vssd1 vccd1 vccd1 sky130_fd_sc_hd__decap_6
X_2212_ clknet_leaf_16_clk_i _0226_ net484 vssd1 vssd1 vccd1 vccd1 spi_mem1.data_buf\[24\]
+ sky130_fd_sc_hd__dfrtp_1
XTAP_569 vssd1 vccd1 sky130_fd_sc_hd__tapvpwrvgnd_1
XFILLER_0_56_33 vssd1 vssd1 vccd1 vccd1 sky130_fd_sc_hd__fill_1
XTAP_558 vssd1 vccd1 sky130_fd_sc_hd__tapvpwrvgnd_1
XTAP_547 vssd1 vccd1 sky130_fd_sc_hd__tapvpwrvgnd_1
X_2143_ clknet_leaf_8_clk_i net803 net469 vssd1 vssd1 vccd1 vccd1 net305 sky130_fd_sc_hd__dfrtp_1
XTAP_536 vssd1 vccd1 sky130_fd_sc_hd__tapvpwrvgnd_1
X_1025_ spi_mem0.state\[1\] net442 vssd1 vssd1 vccd1 vccd1 _0950_ sky130_fd_sc_hd__and2_2
XFILLER_0_48_249 vssd1 vssd1 vccd1 vccd1 sky130_fd_sc_hd__decap_3
X_2074_ clknet_leaf_1_clk_i _0094_ net451 vssd1 vssd1 vccd1 vccd1 spi_mem0.data_buf\[0\]
+ sky130_fd_sc_hd__dfrtp_1
XFILLER_0_71_274 vssd1 vssd1 vccd1 vccd1 sky130_fd_sc_hd__decap_6
X_1858_ spi_mem2.address\[10\] _0746_ _0824_ spi_mem2.address\[14\] vssd1 vssd1 vccd1
+ vccd1 _0838_ sky130_fd_sc_hd__a22o_1
X_1927_ net756 _0886_ _0889_ net362 vssd1 vssd1 vccd1 vccd1 _0320_ sky130_fd_sc_hd__a22o_1
X_1789_ _0744_ _0802_ _0803_ _0805_ vssd1 vssd1 vccd1 vccd1 _0806_ sky130_fd_sc_hd__a211o_1
XFILLER_0_39_216 vssd1 vssd1 vccd1 vccd1 sky130_fd_sc_hd__decap_8
XFILLER_0_54_219 vssd1 vssd1 vccd1 vccd1 sky130_fd_sc_hd__decap_4
XFILLER_0_47_293 vssd1 vssd1 vccd1 vccd1 sky130_fd_sc_hd__decap_3
XFILLER_0_30_171 vssd1 vssd1 vccd1 vccd1 sky130_fd_sc_hd__decap_8
XFILLER_0_22_116 vssd1 vssd1 vccd1 vccd1 sky130_fd_sc_hd__fill_1
XFILLER_0_22_138 vssd1 vssd1 vccd1 vccd1 sky130_fd_sc_hd__fill_2
Xhold70 spi_mem1.address\[17\] vssd1 vssd1 vccd1 vccd1 net574 sky130_fd_sc_hd__dlygate4sd3_1
Xhold92 spi_mem2.data_buf\[22\] vssd1 vssd1 vccd1 vccd1 net596 sky130_fd_sc_hd__dlygate4sd3_1
Xhold81 spi_mem0.address\[0\] vssd1 vssd1 vccd1 vccd1 net585 sky130_fd_sc_hd__dlygate4sd3_1
X_1712_ spi_mem2.latency\[3\] _0359_ _0357_ vssd1 vssd1 vccd1 vccd1 _0757_ sky130_fd_sc_hd__o21a_1
X_1643_ net431 _0931_ net428 vssd1 vssd1 vccd1 vccd1 _0712_ sky130_fd_sc_hd__and3_2
XANTENNA_1 sport0_i[1] vssd1 vssd1 vccd1 vccd1 sky130_fd_sc_hd__diode_2
X_1574_ spi_mem1.data_buf\[18\] spi_mem1.data_buf\[22\] spi_mem1.data_buf\[26\] spi_mem1.data_buf\[30\]
+ net431 net428 vssd1 vssd1 vccd1 vccd1 _0661_ sky130_fd_sc_hd__mux4_1
XTAP_366 vssd1 vccd1 sky130_fd_sc_hd__tapvpwrvgnd_1
XTAP_355 vssd1 vccd1 sky130_fd_sc_hd__tapvpwrvgnd_1
XTAP_344 vssd1 vccd1 sky130_fd_sc_hd__tapvpwrvgnd_1
XTAP_333 vssd1 vccd1 sky130_fd_sc_hd__tapvpwrvgnd_1
XTAP_300 vssd1 vccd1 sky130_fd_sc_hd__tapvpwrvgnd_1
XTAP_311 vssd1 vccd1 sky130_fd_sc_hd__tapvpwrvgnd_1
XTAP_322 vssd1 vccd1 sky130_fd_sc_hd__tapvpwrvgnd_1
X_2126_ clknet_leaf_21_clk_i _0146_ net485 vssd1 vssd1 vccd1 vccd1 spi_mem1.address\[13\]
+ sky130_fd_sc_hd__dfrtp_1
XTAP_399 vssd1 vccd1 sky130_fd_sc_hd__tapvpwrvgnd_1
XTAP_388 vssd1 vccd1 sky130_fd_sc_hd__tapvpwrvgnd_1
XTAP_377 vssd1 vccd1 sky130_fd_sc_hd__tapvpwrvgnd_1
X_2057_ clknet_leaf_4_clk_i net680 net454 vssd1 vssd1 vccd1 vccd1 net280 sky130_fd_sc_hd__dfrtp_1
XPHY_17 vssd1 vssd1 vccd1 vccd1 sky130_fd_sc_hd__decap_3
XPHY_28 vssd1 vssd1 vccd1 vccd1 sky130_fd_sc_hd__decap_3
XFILLER_0_76_377 vssd1 vssd1 vccd1 vccd1 sky130_ef_sc_hd__decap_12
X_1008_ spi_mem1.state\[2\] spi_mem1.state\[3\] vssd1 vssd1 vccd1 vccd1 _0936_ sky130_fd_sc_hd__nor2_2
XFILLER_0_16_91 vssd1 vssd1 vccd1 vccd1 sky130_fd_sc_hd__fill_1
XPHY_39 vssd1 vssd1 vccd1 vccd1 sky130_fd_sc_hd__decap_3
XFILLER_0_12_193 vssd1 vssd1 vccd1 vccd1 sky130_fd_sc_hd__decap_3
XFILLER_0_82_369 vssd1 vssd1 vccd1 vccd1 sky130_fd_sc_hd__decap_4
XFILLER_0_82_325 vssd1 vssd1 vccd1 vccd1 sky130_fd_sc_hd__fill_1
XFILLER_0_50_233 vssd1 vssd1 vccd1 vccd1 sky130_ef_sc_hd__decap_12
XFILLER_0_12_27 vssd1 vssd1 vccd1 vccd1 sky130_fd_sc_hd__fill_1
X_1290_ net440 _0407_ vssd1 vssd1 vccd1 vccd1 _0479_ sky130_fd_sc_hd__nor2_2
Xinput171 sport2_i[24] vssd1 vssd1 vccd1 vccd1 net171 sky130_fd_sc_hd__clkbuf_1
Xinput160 sport2_i[14] vssd1 vssd1 vccd1 vccd1 net160 sky130_fd_sc_hd__clkbuf_1
Xinput182 sport2_i[34] vssd1 vssd1 vccd1 vccd1 net182 sky130_fd_sc_hd__clkbuf_1
Xinput193 sport2_i[44] vssd1 vssd1 vccd1 vccd1 net193 sky130_fd_sc_hd__buf_1
XFILLER_0_58_355 vssd1 vssd1 vccd1 vccd1 sky130_fd_sc_hd__fill_2
XFILLER_0_53_89 vssd1 vssd1 vccd1 vccd1 sky130_fd_sc_hd__decap_3
XFILLER_0_78_75 vssd1 vssd1 vccd1 vccd1 sky130_fd_sc_hd__fill_2
X_1626_ net748 _0701_ _0702_ net367 vssd1 vssd1 vccd1 vccd1 _0206_ sky130_fd_sc_hd__a22o_1
XFILLER_0_41_288 vssd1 vssd1 vccd1 vccd1 sky130_fd_sc_hd__fill_1
XFILLER_0_41_200 vssd1 vssd1 vccd1 vccd1 sky130_ef_sc_hd__decap_12
XFILLER_0_26_241 vssd1 vssd1 vccd1 vccd1 sky130_fd_sc_hd__decap_8
XFILLER_0_5_113 vssd1 vssd1 vccd1 vccd1 sky130_fd_sc_hd__decap_3
XFILLER_0_78_97 vssd1 vssd1 vccd1 vccd1 sky130_fd_sc_hd__decap_4
X_1488_ spi_mem1.spi_clk _0936_ _0938_ _0612_ vssd1 vssd1 vccd1 vccd1 _0613_ sky130_fd_sc_hd__a22o_1
X_1557_ net130 _0536_ _0645_ net395 vssd1 vssd1 vccd1 vccd1 _0646_ sky130_fd_sc_hd__a22o_1
XTAP_196 vssd1 vccd1 sky130_fd_sc_hd__tapvpwrvgnd_1
XTAP_185 vssd1 vccd1 sky130_fd_sc_hd__tapvpwrvgnd_1
XTAP_174 vssd1 vccd1 sky130_fd_sc_hd__tapvpwrvgnd_1
X_2109_ clknet_leaf_10_clk_i _0129_ net475 vssd1 vssd1 vccd1 vccd1 spi_mem1.latency\[2\]
+ sky130_fd_sc_hd__dfrtp_1
XFILLER_0_68_108 vssd1 vssd1 vccd1 vccd1 sky130_fd_sc_hd__fill_1
XFILLER_0_49_344 vssd1 vssd1 vccd1 vccd1 sky130_fd_sc_hd__decap_8
XFILLER_0_64_303 vssd1 vssd1 vccd1 vccd1 sky130_fd_sc_hd__decap_4
XFILLER_0_17_285 vssd1 vssd1 vccd1 vccd1 sky130_fd_sc_hd__fill_1
XFILLER_0_82_133 vssd1 vssd1 vccd1 vccd1 sky130_fd_sc_hd__fill_1
XFILLER_0_82_100 vssd1 vssd1 vccd1 vccd1 sky130_fd_sc_hd__fill_2
XFILLER_0_82_188 vssd1 vssd1 vccd1 vccd1 sky130_fd_sc_hd__fill_2
XFILLER_0_23_266 vssd1 vssd1 vccd1 vccd1 sky130_ef_sc_hd__decap_12
XFILLER_0_2_127 vssd1 vssd1 vccd1 vccd1 sky130_fd_sc_hd__fill_1
X_1411_ net111 net667 net410 vssd1 vssd1 vccd1 vccd1 _0133_ sky130_fd_sc_hd__mux2_1
X_1273_ spi_mem0.data_buf\[19\] _0349_ _0425_ spi_mem0.data_buf\[23\] _0464_ vssd1
+ vssd1 vccd1 vccd1 _0466_ sky130_fd_sc_hd__a221o_1
X_1342_ net26 net414 _0350_ _0488_ vssd1 vssd1 vccd1 vccd1 _0513_ sky130_fd_sc_hd__a22o_1
X_0988_ net712 vssd1 vssd1 vccd1 vccd1 _0002_ sky130_fd_sc_hd__inv_2
XFILLER_0_73_122 vssd1 vssd1 vccd1 vccd1 sky130_ef_sc_hd__decap_12
XFILLER_0_73_111 vssd1 vssd1 vccd1 vccd1 sky130_fd_sc_hd__fill_1
XFILLER_0_73_3 vssd1 vssd1 vccd1 vccd1 sky130_fd_sc_hd__decap_8
X_1609_ _0931_ _0978_ vssd1 vssd1 vccd1 vccd1 _0690_ sky130_fd_sc_hd__and2_2
XFILLER_0_69_406 vssd1 vssd1 vccd1 vccd1 sky130_fd_sc_hd__fill_1
XFILLER_0_64_100 vssd1 vssd1 vccd1 vccd1 sky130_fd_sc_hd__fill_1
XFILLER_0_49_196 vssd1 vssd1 vccd1 vccd1 sky130_fd_sc_hd__fill_1
XFILLER_0_37_314 vssd1 vssd1 vccd1 vccd1 sky130_fd_sc_hd__decap_8
XFILLER_0_64_155 vssd1 vssd1 vccd1 vccd1 sky130_fd_sc_hd__fill_2
XFILLER_0_52_306 vssd1 vssd1 vccd1 vccd1 sky130_fd_sc_hd__fill_2
XFILLER_0_20_214 vssd1 vssd1 vccd1 vccd1 sky130_ef_sc_hd__decap_12
XFILLER_0_20_247 vssd1 vssd1 vccd1 vccd1 sky130_fd_sc_hd__decap_4
XFILLER_0_55_177 vssd1 vssd1 vccd1 vccd1 sky130_fd_sc_hd__fill_1
XFILLER_0_55_111 vssd1 vssd1 vccd1 vccd1 sky130_fd_sc_hd__fill_1
XFILLER_0_43_317 vssd1 vssd1 vccd1 vccd1 sky130_fd_sc_hd__decap_8
X_1891_ _0954_ _0864_ net422 vssd1 vssd1 vccd1 vccd1 _0866_ sky130_fd_sc_hd__a21oi_1
XFILLER_0_7_208 vssd1 vssd1 vccd1 vccd1 sky130_fd_sc_hd__fill_1
X_1960_ net171 net402 _0353_ _0871_ vssd1 vssd1 vccd1 vccd1 _0909_ sky130_fd_sc_hd__a22o_1
XFILLER_0_59_77 vssd1 vssd1 vccd1 vccd1 sky130_fd_sc_hd__fill_1
XFILLER_0_11_225 vssd1 vssd1 vccd1 vccd1 sky130_ef_sc_hd__decap_12
X_1256_ _0450_ net745 _0422_ vssd1 vssd1 vccd1 vccd1 _0088_ sky130_fd_sc_hd__mux2_1
X_1325_ net19 net414 _0490_ _0498_ vssd1 vssd1 vccd1 vccd1 _0503_ sky130_fd_sc_hd__a22o_1
X_1187_ net441 _0921_ _0951_ _0414_ _0416_ vssd1 vssd1 vccd1 vccd1 _0417_ sky130_fd_sc_hd__a311o_1
XFILLER_0_61_169 vssd1 vssd1 vccd1 vccd1 sky130_fd_sc_hd__decap_4
XFILLER_0_61_125 vssd1 vssd1 vccd1 vccd1 sky130_ef_sc_hd__decap_12
XFILLER_0_42_350 vssd1 vssd1 vccd1 vccd1 sky130_fd_sc_hd__fill_1
Xoutput250 net250 vssd1 vssd1 vccd1 vccd1 spi2_dqsm_en_o sky130_fd_sc_hd__clkbuf_4
Xoutput272 net272 vssd1 vssd1 vccd1 vccd1 sport0_o[20] sky130_fd_sc_hd__clkbuf_4
Xoutput283 net283 vssd1 vssd1 vccd1 vccd1 sport0_o[30] sky130_fd_sc_hd__clkbuf_4
Xoutput261 net261 vssd1 vssd1 vccd1 vccd1 sport0_o[10] sky130_fd_sc_hd__clkbuf_4
Xoutput294 net294 vssd1 vssd1 vccd1 vccd1 sport1_o[0] sky130_fd_sc_hd__clkbuf_4
XFILLER_0_69_225 vssd1 vssd1 vccd1 vccd1 sky130_ef_sc_hd__decap_12
Xclkbuf_leaf_30_clk_i clknet_2_1__leaf_clk_i vssd1 vssd1 vccd1 vccd1 clknet_leaf_30_clk_i
+ sky130_fd_sc_hd__clkbuf_16
XFILLER_0_37_166 vssd1 vssd1 vccd1 vccd1 sky130_fd_sc_hd__fill_2
XFILLER_0_37_111 vssd1 vssd1 vccd1 vccd1 sky130_fd_sc_hd__fill_1
XTAP_707 vssd1 vccd1 sky130_fd_sc_hd__tapvpwrvgnd_1
XFILLER_0_52_158 vssd1 vssd1 vccd1 vccd1 sky130_fd_sc_hd__fill_1
XFILLER_0_40_309 vssd1 vssd1 vccd1 vccd1 sky130_ef_sc_hd__decap_12
XTAP_729 vssd1 vccd1 sky130_fd_sc_hd__tapvpwrvgnd_1
XTAP_718 vssd1 vccd1 sky130_fd_sc_hd__tapvpwrvgnd_1
X_1110_ _0372_ vssd1 vssd1 vccd1 vccd1 _0373_ sky130_fd_sc_hd__inv_2
X_2090_ clknet_leaf_34_clk_i _0110_ net455 vssd1 vssd1 vccd1 vccd1 spi_mem0.data_buf\[16\]
+ sky130_fd_sc_hd__dfrtp_1
X_1041_ spi_mem2.state\[3\] spi_mem2.state\[2\] vssd1 vssd1 vccd1 vccd1 _0961_ sky130_fd_sc_hd__nand2_2
X_1874_ _0848_ _0852_ _0818_ vssd1 vssd1 vccd1 vccd1 _0853_ sky130_fd_sc_hd__o21ba_1
X_1943_ net163 net400 _0972_ _0873_ vssd1 vssd1 vccd1 vccd1 _0899_ sky130_fd_sc_hd__a22o_1
XFILLER_0_24_383 vssd1 vssd1 vccd1 vccd1 sky130_fd_sc_hd__fill_1
X_1308_ net393 _0492_ net374 vssd1 vssd1 vccd1 vccd1 _0493_ sky130_fd_sc_hd__o21ai_2
X_2288_ clknet_leaf_26_clk_i _0986_ net465 vssd1 vssd1 vccd1 vccd1 net354 sky130_fd_sc_hd__dfrtp_1
X_1239_ net443 _0434_ _0433_ vssd1 vssd1 vccd1 vccd1 _0435_ sky130_fd_sc_hd__a21o_1
XFILLER_0_74_294 vssd1 vssd1 vccd1 vccd1 sky130_fd_sc_hd__decap_4
XFILLER_0_62_401 vssd1 vssd1 vccd1 vccd1 sky130_fd_sc_hd__decap_6
XFILLER_0_19_111 vssd1 vssd1 vccd1 vccd1 sky130_fd_sc_hd__fill_1
XFILLER_0_22_309 vssd1 vssd1 vccd1 vccd1 sky130_ef_sc_hd__decap_12
XFILLER_0_80_253 vssd1 vssd1 vccd1 vccd1 sky130_fd_sc_hd__decap_6
XFILLER_0_31_15 vssd1 vssd1 vccd1 vccd1 sky130_ef_sc_hd__decap_12
XFILLER_0_25_169 vssd1 vssd1 vccd1 vccd1 sky130_fd_sc_hd__decap_8
XFILLER_0_25_147 vssd1 vssd1 vccd1 vccd1 sky130_fd_sc_hd__decap_3
XFILLER_0_25_125 vssd1 vssd1 vccd1 vccd1 sky130_fd_sc_hd__fill_2
X_1590_ spi_mem1.address\[12\] _0545_ _0641_ spi_mem1.address\[16\] vssd1 vssd1 vccd1
+ vccd1 _0676_ sky130_fd_sc_hd__a22o_1
XFILLER_0_56_23 vssd1 vssd1 vccd1 vccd1 sky130_fd_sc_hd__decap_4
XTAP_548 vssd1 vccd1 sky130_fd_sc_hd__tapvpwrvgnd_1
XTAP_537 vssd1 vccd1 sky130_fd_sc_hd__tapvpwrvgnd_1
XTAP_526 vssd1 vccd1 sky130_fd_sc_hd__tapvpwrvgnd_1
XTAP_515 vssd1 vccd1 sky130_fd_sc_hd__tapvpwrvgnd_1
XTAP_504 vssd1 vccd1 sky130_fd_sc_hd__tapvpwrvgnd_1
XFILLER_0_21_331 vssd1 vssd1 vccd1 vccd1 sky130_fd_sc_hd__decap_4
X_2142_ clknet_leaf_8_clk_i net738 net474 vssd1 vssd1 vccd1 vccd1 net294 sky130_fd_sc_hd__dfrtp_1
XTAP_559 vssd1 vccd1 sky130_fd_sc_hd__tapvpwrvgnd_1
X_1024_ net441 _0921_ vssd1 vssd1 vccd1 vccd1 _0949_ sky130_fd_sc_hd__nor2_2
X_2211_ clknet_leaf_15_clk_i _0225_ net473 vssd1 vssd1 vccd1 vccd1 spi_mem1.data_buf\[23\]
+ sky130_fd_sc_hd__dfrtp_1
X_2073_ clknet_leaf_34_clk_i _0093_ net463 vssd1 vssd1 vccd1 vccd1 spi_mem0.data_byte\[1\]
+ sky130_fd_sc_hd__dfrtp_1
XFILLER_0_48_217 vssd1 vssd1 vccd1 vccd1 sky130_fd_sc_hd__decap_4
XFILLER_0_8_347 vssd1 vssd1 vccd1 vccd1 sky130_ef_sc_hd__decap_12
XFILLER_0_71_264 vssd1 vssd1 vccd1 vccd1 sky130_fd_sc_hd__fill_2
X_1788_ spi_mem2.state\[1\] net427 net215 _0957_ _0804_ vssd1 vssd1 vccd1 vccd1 _0805_
+ sky130_fd_sc_hd__a41o_1
XFILLER_0_31_106 vssd1 vssd1 vccd1 vccd1 sky130_fd_sc_hd__decap_6
X_1926_ net156 net401 _0875_ _0885_ vssd1 vssd1 vccd1 vccd1 _0889_ sky130_fd_sc_hd__a22o_1
XFILLER_0_16_169 vssd1 vssd1 vccd1 vccd1 sky130_fd_sc_hd__fill_1
X_1857_ _0834_ _0836_ _0970_ _0833_ vssd1 vssd1 vccd1 vccd1 _0837_ sky130_fd_sc_hd__o211a_1
XFILLER_0_62_253 vssd1 vssd1 vccd1 vccd1 sky130_fd_sc_hd__fill_1
XFILLER_0_7_391 vssd1 vssd1 vccd1 vccd1 sky130_fd_sc_hd__fill_1
Xhold71 net240 vssd1 vssd1 vccd1 vccd1 net575 sky130_fd_sc_hd__dlygate4sd3_1
XFILLER_0_26_15 vssd1 vssd1 vccd1 vccd1 sky130_fd_sc_hd__fill_1
Xhold60 _0277_ vssd1 vssd1 vccd1 vccd1 net564 sky130_fd_sc_hd__dlygate4sd3_1
Xhold82 spi_mem0.address\[8\] vssd1 vssd1 vccd1 vccd1 net586 sky130_fd_sc_hd__dlygate4sd3_1
Xhold93 _0292_ vssd1 vssd1 vccd1 vccd1 net597 sky130_fd_sc_hd__dlygate4sd3_1
X_1711_ _0756_ net656 _0748_ vssd1 vssd1 vccd1 vccd1 _0237_ sky130_fd_sc_hd__mux2_1
X_1642_ net515 _0707_ _0711_ net367 vssd1 vssd1 vccd1 vccd1 _0213_ sky130_fd_sc_hd__a22o_1
XANTENNA_2 sport2_i[17] vssd1 vssd1 vccd1 vccd1 sky130_fd_sc_hd__diode_2
X_1573_ _0660_ net612 _0632_ vssd1 vssd1 vccd1 vccd1 _0195_ sky130_fd_sc_hd__mux2_1
XFILLER_0_67_66 vssd1 vssd1 vccd1 vccd1 sky130_ef_sc_hd__decap_12
XFILLER_0_67_55 vssd1 vssd1 vccd1 vccd1 sky130_fd_sc_hd__fill_1
XTAP_389 vssd1 vccd1 sky130_fd_sc_hd__tapvpwrvgnd_1
XTAP_378 vssd1 vccd1 sky130_fd_sc_hd__tapvpwrvgnd_1
XTAP_367 vssd1 vccd1 sky130_fd_sc_hd__tapvpwrvgnd_1
XTAP_356 vssd1 vccd1 sky130_fd_sc_hd__tapvpwrvgnd_1
XTAP_345 vssd1 vccd1 sky130_fd_sc_hd__tapvpwrvgnd_1
XTAP_334 vssd1 vccd1 sky130_fd_sc_hd__tapvpwrvgnd_1
XTAP_301 vssd1 vccd1 sky130_fd_sc_hd__tapvpwrvgnd_1
XTAP_312 vssd1 vccd1 sky130_fd_sc_hd__tapvpwrvgnd_1
XTAP_323 vssd1 vccd1 sky130_fd_sc_hd__tapvpwrvgnd_1
XFILLER_0_76_301 vssd1 vssd1 vccd1 vccd1 sky130_fd_sc_hd__decap_6
X_1007_ net432 net433 vssd1 vssd1 vccd1 vccd1 _0935_ sky130_fd_sc_hd__or2_2
X_2125_ clknet_leaf_18_clk_i _0145_ net485 vssd1 vssd1 vccd1 vccd1 spi_mem1.address\[12\]
+ sky130_fd_sc_hd__dfrtp_1
X_2056_ clknet_leaf_4_clk_i net558 net455 vssd1 vssd1 vccd1 vccd1 net279 sky130_fd_sc_hd__dfrtp_1
XPHY_18 vssd1 vssd1 vccd1 vccd1 sky130_fd_sc_hd__decap_3
XPHY_29 vssd1 vssd1 vccd1 vccd1 sky130_fd_sc_hd__decap_3
XFILLER_0_76_389 vssd1 vssd1 vccd1 vccd1 sky130_ef_sc_hd__decap_12
XFILLER_0_44_275 vssd1 vssd1 vccd1 vccd1 sky130_fd_sc_hd__fill_1
XFILLER_0_29_261 vssd1 vssd1 vccd1 vccd1 sky130_ef_sc_hd__decap_12
X_1909_ net676 _0870_ _0878_ net362 vssd1 vssd1 vccd1 vccd1 _0313_ sky130_fd_sc_hd__a22o_1
XFILLER_0_8_188 vssd1 vssd1 vccd1 vccd1 sky130_fd_sc_hd__fill_1
XFILLER_0_44_286 vssd1 vssd1 vccd1 vccd1 sky130_fd_sc_hd__decap_4
XFILLER_0_79_161 vssd1 vssd1 vccd1 vccd1 sky130_fd_sc_hd__fill_1
XFILLER_0_50_245 vssd1 vssd1 vccd1 vccd1 sky130_fd_sc_hd__decap_6
XFILLER_0_2_309 vssd1 vssd1 vccd1 vccd1 sky130_fd_sc_hd__fill_2
Xinput150 sport1_i[68] vssd1 vssd1 vccd1 vccd1 net150 sky130_fd_sc_hd__buf_2
Xinput194 sport2_i[45] vssd1 vssd1 vccd1 vccd1 net194 sky130_fd_sc_hd__dlymetal6s2s_1
Xinput183 sport2_i[35] vssd1 vssd1 vccd1 vccd1 net183 sky130_fd_sc_hd__clkbuf_1
Xinput172 sport2_i[25] vssd1 vssd1 vccd1 vccd1 net172 sky130_fd_sc_hd__clkbuf_1
Xinput161 sport2_i[15] vssd1 vssd1 vccd1 vccd1 net161 sky130_fd_sc_hd__clkbuf_1
XFILLER_0_73_337 vssd1 vssd1 vccd1 vccd1 sky130_fd_sc_hd__decap_4
XFILLER_0_26_253 vssd1 vssd1 vccd1 vccd1 sky130_fd_sc_hd__decap_8
XFILLER_0_81_381 vssd1 vssd1 vccd1 vccd1 sky130_fd_sc_hd__decap_8
X_1625_ net130 net398 _0692_ _0700_ vssd1 vssd1 vccd1 vccd1 _0702_ sky130_fd_sc_hd__a22o_1
X_1556_ spi_mem1.address_nibble\[2\] _0644_ _0643_ vssd1 vssd1 vccd1 vccd1 _0645_
+ sky130_fd_sc_hd__a21o_1
XFILLER_0_41_278 vssd1 vssd1 vccd1 vccd1 sky130_fd_sc_hd__fill_2
XFILLER_0_41_256 vssd1 vssd1 vccd1 vccd1 sky130_fd_sc_hd__decap_8
XFILLER_0_41_212 vssd1 vssd1 vccd1 vccd1 sky130_ef_sc_hd__decap_12
XFILLER_0_1_353 vssd1 vssd1 vccd1 vccd1 sky130_fd_sc_hd__fill_2
X_1487_ net148 net149 _0931_ _0610_ net430 vssd1 vssd1 vccd1 vccd1 _0612_ sky130_fd_sc_hd__a311o_1
XTAP_197 vssd1 vccd1 sky130_fd_sc_hd__tapvpwrvgnd_1
XFILLER_0_1_397 vssd1 vssd1 vccd1 vccd1 sky130_fd_sc_hd__fill_2
XTAP_186 vssd1 vccd1 sky130_fd_sc_hd__tapvpwrvgnd_1
XTAP_175 vssd1 vccd1 sky130_fd_sc_hd__tapvpwrvgnd_1
X_2108_ clknet_leaf_10_clk_i _0128_ net475 vssd1 vssd1 vccd1 vccd1 spi_mem1.latency\[1\]
+ sky130_fd_sc_hd__dfrtp_1
XFILLER_0_49_334 vssd1 vssd1 vccd1 vccd1 sky130_fd_sc_hd__fill_2
X_2039_ clknet_leaf_1_clk_i _0065_ net451 vssd1 vssd1 vccd1 vccd1 net261 sky130_fd_sc_hd__dfrtp_1
X_1983__7 clknet_leaf_17_clk_i vssd1 vssd1 vccd1 vccd1 net496 sky130_fd_sc_hd__inv_2
XFILLER_0_72_381 vssd1 vssd1 vccd1 vccd1 sky130_ef_sc_hd__decap_12
XFILLER_0_17_242 vssd1 vssd1 vccd1 vccd1 sky130_fd_sc_hd__fill_2
XFILLER_0_17_264 vssd1 vssd1 vccd1 vccd1 sky130_ef_sc_hd__decap_12
XFILLER_0_32_278 vssd1 vssd1 vccd1 vccd1 sky130_ef_sc_hd__decap_12
XFILLER_0_82_156 vssd1 vssd1 vccd1 vccd1 sky130_fd_sc_hd__fill_2
XFILLER_0_67_131 vssd1 vssd1 vccd1 vccd1 sky130_ef_sc_hd__decap_12
XFILLER_0_55_337 vssd1 vssd1 vccd1 vccd1 sky130_ef_sc_hd__decap_12
X_1410_ net529 _0560_ vssd1 vssd1 vccd1 vccd1 _0132_ sky130_fd_sc_hd__and2_1
XFILLER_0_23_278 vssd1 vssd1 vccd1 vccd1 sky130_fd_sc_hd__fill_2
XFILLER_0_23_223 vssd1 vssd1 vccd1 vccd1 sky130_fd_sc_hd__fill_1
X_1272_ spi_mem0.data_buf\[27\] _0423_ net435 vssd1 vssd1 vccd1 vccd1 _0465_ sky130_fd_sc_hd__a21bo_1
X_1341_ net766 _0510_ _0512_ net374 vssd1 vssd1 vccd1 vccd1 _0111_ sky130_fd_sc_hd__a22o_1
XFILLER_0_80_55 vssd1 vssd1 vccd1 vccd1 sky130_fd_sc_hd__fill_1
XFILLER_0_73_134 vssd1 vssd1 vccd1 vccd1 sky130_ef_sc_hd__decap_12
X_0987_ net432 vssd1 vssd1 vccd1 vccd1 _0919_ sky130_fd_sc_hd__inv_2
XFILLER_0_58_197 vssd1 vssd1 vccd1 vccd1 sky130_ef_sc_hd__decap_12
X_1608_ _0977_ _0611_ _0682_ vssd1 vssd1 vccd1 vccd1 _0689_ sky130_fd_sc_hd__a21oi_1
XFILLER_0_66_3 vssd1 vssd1 vccd1 vccd1 sky130_ef_sc_hd__decap_12
X_1539_ net565 net317 net385 vssd1 vssd1 vccd1 vccd1 _0192_ sky130_fd_sc_hd__mux2_1
XFILLER_0_20_226 vssd1 vssd1 vccd1 vccd1 sky130_fd_sc_hd__decap_4
XFILLER_0_20_237 vssd1 vssd1 vccd1 vccd1 sky130_fd_sc_hd__decap_6
Xhold190 spi_mem1.data_buf\[6\] vssd1 vssd1 vccd1 vccd1 net694 sky130_fd_sc_hd__dlygate4sd3_1
XFILLER_0_34_26 vssd1 vssd1 vccd1 vccd1 sky130_fd_sc_hd__fill_2
XFILLER_0_70_148 vssd1 vssd1 vccd1 vccd1 sky130_fd_sc_hd__decap_6
XFILLER_0_70_126 vssd1 vssd1 vccd1 vccd1 sky130_fd_sc_hd__fill_1
XFILLER_0_43_329 vssd1 vssd1 vccd1 vccd1 sky130_fd_sc_hd__decap_6
X_1890_ net422 _0864_ vssd1 vssd1 vccd1 vccd1 _0865_ sky130_fd_sc_hd__and2_1
XFILLER_0_11_237 vssd1 vssd1 vccd1 vccd1 sky130_ef_sc_hd__decap_12
XFILLER_0_75_77 vssd1 vssd1 vccd1 vccd1 sky130_fd_sc_hd__decap_3
X_1186_ net81 _0365_ vssd1 vssd1 vccd1 vccd1 _0416_ sky130_fd_sc_hd__nor2_1
XFILLER_0_38_7 vssd1 vssd1 vccd1 vccd1 sky130_fd_sc_hd__fill_1
X_1255_ _0421_ _0444_ _0449_ vssd1 vssd1 vccd1 vccd1 _0450_ sky130_fd_sc_hd__or3_1
X_1324_ net699 _0499_ _0502_ net372 vssd1 vssd1 vccd1 vccd1 _0104_ sky130_fd_sc_hd__a22o_1
XFILLER_0_34_307 vssd1 vssd1 vccd1 vccd1 sky130_fd_sc_hd__fill_1
XFILLER_0_19_337 vssd1 vssd1 vccd1 vccd1 sky130_ef_sc_hd__decap_12
XFILLER_0_61_137 vssd1 vssd1 vccd1 vccd1 sky130_fd_sc_hd__decap_8
XFILLER_0_6_286 vssd1 vssd1 vccd1 vccd1 sky130_fd_sc_hd__fill_2
Xoutput240 net240 vssd1 vssd1 vccd1 vccd1 spi1_mosi_o[0] sky130_fd_sc_hd__clkbuf_4
Xoutput251 net251 vssd1 vssd1 vccd1 vccd1 spi2_dqsm_o sky130_fd_sc_hd__clkbuf_4
Xoutput284 net284 vssd1 vssd1 vccd1 vccd1 sport0_o[31] sky130_fd_sc_hd__clkbuf_4
Xoutput273 net273 vssd1 vssd1 vccd1 vccd1 sport0_o[21] sky130_fd_sc_hd__clkbuf_4
Xoutput295 net295 vssd1 vssd1 vccd1 vccd1 sport1_o[10] sky130_fd_sc_hd__clkbuf_4
Xoutput262 net262 vssd1 vssd1 vccd1 vccd1 sport0_o[11] sky130_fd_sc_hd__clkbuf_4
XFILLER_0_69_237 vssd1 vssd1 vccd1 vccd1 sky130_ef_sc_hd__decap_12
XFILLER_0_77_281 vssd1 vssd1 vccd1 vccd1 sky130_ef_sc_hd__decap_12
XFILLER_0_20_17 vssd1 vssd1 vccd1 vccd1 sky130_fd_sc_hd__decap_4
XTAP_719 vssd1 vccd1 sky130_fd_sc_hd__tapvpwrvgnd_1
XTAP_708 vssd1 vccd1 sky130_fd_sc_hd__tapvpwrvgnd_1
XFILLER_0_60_170 vssd1 vssd1 vccd1 vccd1 sky130_fd_sc_hd__fill_1
Xwire378 _0412_ vssd1 vssd1 vccd1 vccd1 net378 sky130_fd_sc_hd__buf_1
XFILLER_0_29_15 vssd1 vssd1 vccd1 vccd1 sky130_fd_sc_hd__decap_8
X_1040_ spi_mem2.spi_clk net353 vssd1 vssd1 vccd1 vccd1 _0960_ sky130_fd_sc_hd__and2_1
XFILLER_0_61_57 vssd1 vssd1 vccd1 vccd1 sky130_fd_sc_hd__fill_2
X_1942_ net788 _0897_ _0898_ net366 vssd1 vssd1 vccd1 vccd1 _0326_ sky130_fd_sc_hd__a22o_1
XFILLER_0_16_307 vssd1 vssd1 vccd1 vccd1 sky130_fd_sc_hd__fill_1
XFILLER_0_51_181 vssd1 vssd1 vccd1 vccd1 sky130_fd_sc_hd__decap_6
XFILLER_0_24_373 vssd1 vssd1 vccd1 vccd1 sky130_fd_sc_hd__decap_3
X_1873_ _0740_ _0850_ _0851_ _0355_ net220 vssd1 vssd1 vccd1 vccd1 _0852_ sky130_fd_sc_hd__a32o_1
XFILLER_0_9_25 vssd1 vssd1 vccd1 vccd1 sky130_fd_sc_hd__fill_1
X_1307_ net436 net438 net440 vssd1 vssd1 vccd1 vccd1 _0492_ sky130_fd_sc_hd__nor3b_2
XFILLER_0_29_3 vssd1 vssd1 vccd1 vccd1 sky130_ef_sc_hd__decap_12
X_1169_ net69 net68 net76 net75 vssd1 vssd1 vccd1 vccd1 _0401_ sky130_fd_sc_hd__or4_1
X_2287_ clknet_leaf_31_clk_i _0301_ net457 vssd1 vssd1 vccd1 vccd1 net352 sky130_fd_sc_hd__dfrtp_1
X_1238_ spi_mem0.address\[9\] spi_mem0.address\[13\] spi_mem0.address\[17\] spi_mem0.address\[21\]
+ spi_mem0.address_nibble\[0\] spi_mem0.address_nibble\[1\] vssd1 vssd1 vccd1 vccd1
+ _0434_ sky130_fd_sc_hd__mux4_1
XFILLER_0_34_137 vssd1 vssd1 vccd1 vccd1 sky130_fd_sc_hd__decap_3
XFILLER_0_19_167 vssd1 vssd1 vccd1 vccd1 sky130_fd_sc_hd__fill_1
XFILLER_0_30_365 vssd1 vssd1 vccd1 vccd1 sky130_ef_sc_hd__decap_12
XFILLER_0_15_373 vssd1 vssd1 vccd1 vccd1 sky130_ef_sc_hd__decap_12
XFILLER_0_33_181 vssd1 vssd1 vccd1 vccd1 sky130_ef_sc_hd__decap_12
XFILLER_0_31_27 vssd1 vssd1 vccd1 vccd1 sky130_ef_sc_hd__decap_12
XTAP_549 vssd1 vccd1 sky130_fd_sc_hd__tapvpwrvgnd_1
XTAP_538 vssd1 vccd1 sky130_fd_sc_hd__tapvpwrvgnd_1
XTAP_527 vssd1 vccd1 sky130_fd_sc_hd__tapvpwrvgnd_1
XTAP_516 vssd1 vccd1 sky130_fd_sc_hd__tapvpwrvgnd_1
X_2210_ clknet_leaf_15_clk_i _0224_ net471 vssd1 vssd1 vccd1 vccd1 spi_mem1.data_buf\[22\]
+ sky130_fd_sc_hd__dfrtp_1
XTAP_505 vssd1 vccd1 sky130_fd_sc_hd__tapvpwrvgnd_1
X_2141_ clknet_leaf_17_clk_i _0161_ net483 vssd1 vssd1 vccd1 vccd1 spi_mem1.state\[3\]
+ sky130_fd_sc_hd__dfrtp_4
X_1023_ _0945_ _0947_ vssd1 vssd1 vccd1 vccd1 _0948_ sky130_fd_sc_hd__and2_2
X_2072_ clknet_leaf_24_clk_i _0092_ net479 vssd1 vssd1 vccd1 vccd1 spi_mem0.data_byte\[0\]
+ sky130_fd_sc_hd__dfrtp_1
XFILLER_0_56_251 vssd1 vssd1 vccd1 vccd1 sky130_fd_sc_hd__fill_1
XFILLER_0_8_326 vssd1 vssd1 vccd1 vccd1 sky130_fd_sc_hd__fill_1
X_1925_ net787 _0886_ _0888_ net366 vssd1 vssd1 vccd1 vccd1 _0319_ sky130_fd_sc_hd__a22o_1
XFILLER_0_71_298 vssd1 vssd1 vccd1 vccd1 sky130_fd_sc_hd__decap_4
X_1787_ spi_mem2.state\[1\] net426 _0955_ spi_mem2.spi_clk vssd1 vssd1 vccd1 vccd1
+ _0804_ sky130_fd_sc_hd__and4b_1
XFILLER_0_12_365 vssd1 vssd1 vccd1 vccd1 sky130_fd_sc_hd__fill_1
X_1856_ spi_mem2.data_buf\[1\] _0971_ _0820_ spi_mem2.data_buf\[5\] _0835_ vssd1 vssd1
+ vccd1 vccd1 _0836_ sky130_fd_sc_hd__a221o_1
X_2339_ net247 vssd1 vssd1 vccd1 vccd1 net246 sky130_fd_sc_hd__clkbuf_1
XFILLER_0_62_232 vssd1 vssd1 vccd1 vccd1 sky130_ef_sc_hd__decap_12
XFILLER_0_47_262 vssd1 vssd1 vccd1 vccd1 sky130_fd_sc_hd__fill_2
XFILLER_0_15_181 vssd1 vssd1 vccd1 vccd1 sky130_ef_sc_hd__decap_12
XFILLER_0_30_195 vssd1 vssd1 vccd1 vccd1 sky130_fd_sc_hd__fill_1
Xhold61 spi_mem1.data_buf\[30\] vssd1 vssd1 vccd1 vccd1 net565 sky130_fd_sc_hd__dlygate4sd3_1
Xhold94 spi_mem2.address\[1\] vssd1 vssd1 vccd1 vccd1 net598 sky130_fd_sc_hd__dlygate4sd3_1
Xhold72 spi_mem2.data_buf\[15\] vssd1 vssd1 vccd1 vccd1 net576 sky130_fd_sc_hd__dlygate4sd3_1
Xhold83 spi_mem0.address\[7\] vssd1 vssd1 vccd1 vccd1 net587 sky130_fd_sc_hd__dlygate4sd3_1
Xhold50 _0295_ vssd1 vssd1 vccd1 vccd1 net554 sky130_fd_sc_hd__dlygate4sd3_1
XFILLER_0_42_15 vssd1 vssd1 vccd1 vccd1 sky130_ef_sc_hd__decap_12
XFILLER_0_38_240 vssd1 vssd1 vccd1 vccd1 sky130_ef_sc_hd__decap_12
X_1710_ _0359_ _0755_ net392 vssd1 vssd1 vccd1 vccd1 _0756_ sky130_fd_sc_hd__a21boi_1
X_1572_ _0631_ _0654_ _0659_ vssd1 vssd1 vccd1 vccd1 _0660_ sky130_fd_sc_hd__or3_1
X_1641_ net88 net398 _0698_ _0706_ vssd1 vssd1 vccd1 vccd1 _0711_ sky130_fd_sc_hd__a22o_1
XFILLER_0_41_405 vssd1 vssd1 vccd1 vccd1 sky130_fd_sc_hd__fill_2
XANTENNA_3 net64 vssd1 vssd1 vccd1 vccd1 sky130_fd_sc_hd__diode_2
X_2124_ clknet_leaf_18_clk_i _0144_ net485 vssd1 vssd1 vccd1 vccd1 spi_mem1.address\[11\]
+ sky130_fd_sc_hd__dfrtp_1
XFILLER_0_67_78 vssd1 vssd1 vccd1 vccd1 sky130_ef_sc_hd__decap_12
XTAP_379 vssd1 vccd1 sky130_fd_sc_hd__tapvpwrvgnd_1
XTAP_368 vssd1 vccd1 sky130_fd_sc_hd__tapvpwrvgnd_1
XTAP_357 vssd1 vccd1 sky130_fd_sc_hd__tapvpwrvgnd_1
XTAP_346 vssd1 vccd1 sky130_fd_sc_hd__tapvpwrvgnd_1
XTAP_335 vssd1 vccd1 sky130_fd_sc_hd__tapvpwrvgnd_1
XTAP_302 vssd1 vccd1 sky130_fd_sc_hd__tapvpwrvgnd_1
XTAP_313 vssd1 vccd1 sky130_fd_sc_hd__tapvpwrvgnd_1
XTAP_324 vssd1 vccd1 sky130_fd_sc_hd__tapvpwrvgnd_1
X_1006_ net432 net433 vssd1 vssd1 vccd1 vccd1 _0934_ sky130_fd_sc_hd__nor2_1
X_2055_ clknet_leaf_4_clk_i _0081_ net455 vssd1 vssd1 vccd1 vccd1 net278 sky130_fd_sc_hd__dfrtp_1
XPHY_19 vssd1 vssd1 vccd1 vccd1 sky130_fd_sc_hd__decap_3
XFILLER_0_29_273 vssd1 vssd1 vccd1 vccd1 sky130_fd_sc_hd__decap_6
X_1908_ net188 net400 _0869_ _0877_ vssd1 vssd1 vccd1 vccd1 _0878_ sky130_fd_sc_hd__a22o_1
X_1839_ net420 net423 vssd1 vssd1 vccd1 vccd1 _0820_ sky130_fd_sc_hd__and2b_1
XFILLER_0_4_362 vssd1 vssd1 vccd1 vccd1 sky130_fd_sc_hd__fill_2
XFILLER_0_12_173 vssd1 vssd1 vccd1 vccd1 sky130_fd_sc_hd__decap_3
XFILLER_0_82_349 vssd1 vssd1 vccd1 vccd1 sky130_fd_sc_hd__fill_1
XFILLER_0_67_313 vssd1 vssd1 vccd1 vccd1 sky130_fd_sc_hd__fill_1
XFILLER_0_12_29 vssd1 vssd1 vccd1 vccd1 sky130_fd_sc_hd__fill_1
XFILLER_0_37_48 vssd1 vssd1 vccd1 vccd1 sky130_fd_sc_hd__decap_8
XFILLER_0_37_37 vssd1 vssd1 vccd1 vccd1 sky130_fd_sc_hd__decap_4
XFILLER_0_37_15 vssd1 vssd1 vccd1 vccd1 sky130_fd_sc_hd__fill_2
Xinput140 sport1_i[59] vssd1 vssd1 vccd1 vccd1 net140 sky130_fd_sc_hd__clkbuf_1
Xinput162 sport2_i[16] vssd1 vssd1 vccd1 vccd1 net162 sky130_fd_sc_hd__clkbuf_1
Xinput151 sport1_i[6] vssd1 vssd1 vccd1 vccd1 net151 sky130_fd_sc_hd__clkbuf_2
Xinput184 sport2_i[36] vssd1 vssd1 vccd1 vccd1 net184 sky130_fd_sc_hd__clkbuf_1
Xinput195 sport2_i[46] vssd1 vssd1 vccd1 vccd1 net195 sky130_fd_sc_hd__buf_1
Xinput173 sport2_i[26] vssd1 vssd1 vccd1 vccd1 net173 sky130_fd_sc_hd__clkbuf_1
XFILLER_0_81_393 vssd1 vssd1 vccd1 vccd1 sky130_fd_sc_hd__decap_8
XFILLER_0_73_349 vssd1 vssd1 vccd1 vccd1 sky130_fd_sc_hd__fill_1
X_1624_ _0983_ _0700_ net368 vssd1 vssd1 vccd1 vccd1 _0701_ sky130_fd_sc_hd__o21ai_2
X_1555_ spi_mem1.address\[9\] spi_mem1.address\[13\] spi_mem1.address\[17\] spi_mem1.address\[21\]
+ spi_mem1.address_nibble\[0\] spi_mem1.address_nibble\[1\] vssd1 vssd1 vccd1 vccd1
+ _0644_ sky130_fd_sc_hd__mux4_1
X_2107_ clknet_leaf_10_clk_i _0127_ net475 vssd1 vssd1 vccd1 vccd1 spi_mem1.latency\[0\]
+ sky130_fd_sc_hd__dfrtp_2
X_1486_ _0610_ vssd1 vssd1 vccd1 vccd1 _0611_ sky130_fd_sc_hd__inv_2
XTAP_198 vssd1 vccd1 sky130_fd_sc_hd__tapvpwrvgnd_1
XTAP_187 vssd1 vccd1 sky130_fd_sc_hd__tapvpwrvgnd_1
XTAP_176 vssd1 vccd1 sky130_fd_sc_hd__tapvpwrvgnd_1
XFILLER_0_76_187 vssd1 vssd1 vccd1 vccd1 sky130_fd_sc_hd__decap_8
XFILLER_0_76_110 vssd1 vssd1 vccd1 vccd1 sky130_fd_sc_hd__fill_1
XFILLER_0_11_3 vssd1 vssd1 vccd1 vccd1 sky130_fd_sc_hd__decap_4
X_2038_ clknet_leaf_1_clk_i net560 net452 vssd1 vssd1 vccd1 vccd1 net293 sky130_fd_sc_hd__dfrtp_1
XFILLER_0_72_393 vssd1 vssd1 vccd1 vccd1 sky130_ef_sc_hd__decap_12
XFILLER_0_17_276 vssd1 vssd1 vccd1 vccd1 sky130_fd_sc_hd__decap_4
XFILLER_0_67_143 vssd1 vssd1 vccd1 vccd1 sky130_ef_sc_hd__decap_12
XFILLER_0_67_121 vssd1 vssd1 vccd1 vccd1 sky130_fd_sc_hd__fill_1
XFILLER_0_67_110 vssd1 vssd1 vccd1 vccd1 sky130_fd_sc_hd__fill_2
XFILLER_0_82_124 vssd1 vssd1 vccd1 vccd1 sky130_fd_sc_hd__fill_2
XFILLER_0_82_113 vssd1 vssd1 vccd1 vccd1 sky130_fd_sc_hd__fill_2
XFILLER_0_67_198 vssd1 vssd1 vccd1 vccd1 sky130_ef_sc_hd__decap_12
XFILLER_0_63_371 vssd1 vssd1 vccd1 vccd1 sky130_fd_sc_hd__decap_4
XFILLER_0_55_349 vssd1 vssd1 vccd1 vccd1 sky130_ef_sc_hd__decap_12
XFILLER_0_63_393 vssd1 vssd1 vccd1 vccd1 sky130_ef_sc_hd__decap_12
X_1340_ net25 net414 _0350_ _0486_ vssd1 vssd1 vccd1 vccd1 _0512_ sky130_fd_sc_hd__a22o_1
X_1271_ net439 net437 spi_mem0.data_buf\[31\] vssd1 vssd1 vccd1 vccd1 _0464_ sky130_fd_sc_hd__and3_1
XFILLER_0_46_349 vssd1 vssd1 vccd1 vccd1 sky130_fd_sc_hd__fill_1
XFILLER_0_39_390 vssd1 vssd1 vccd1 vccd1 sky130_fd_sc_hd__fill_2
XFILLER_0_73_146 vssd1 vssd1 vccd1 vccd1 sky130_ef_sc_hd__decap_12
X_1469_ _0547_ _0592_ _0594_ spi_mem1.address_nibble\[2\] vssd1 vssd1 vccd1 vccd1
+ _0157_ sky130_fd_sc_hd__a22o_1
X_1607_ spi_mem1.data_byte\[1\] _0688_ _0685_ vssd1 vssd1 vccd1 vccd1 _0201_ sky130_fd_sc_hd__mux2_1
X_1538_ net758 net315 net387 vssd1 vssd1 vccd1 vccd1 _0191_ sky130_fd_sc_hd__mux2_1
XFILLER_0_60_363 vssd1 vssd1 vccd1 vccd1 sky130_fd_sc_hd__fill_1
Xhold180 _0071_ vssd1 vssd1 vccd1 vccd1 net684 sky130_fd_sc_hd__dlygate4sd3_1
Xhold191 _0168_ vssd1 vssd1 vccd1 vccd1 net695 sky130_fd_sc_hd__dlygate4sd3_1
XFILLER_0_0_3 vssd1 vssd1 vccd1 vccd1 sky130_fd_sc_hd__fill_1
XFILLER_0_50_15 vssd1 vssd1 vccd1 vccd1 sky130_ef_sc_hd__decap_12
XFILLER_0_28_349 vssd1 vssd1 vccd1 vccd1 sky130_fd_sc_hd__decap_3
XFILLER_0_75_23 vssd1 vssd1 vccd1 vccd1 sky130_fd_sc_hd__fill_1
X_1323_ net18 net414 _0488_ _0498_ vssd1 vssd1 vccd1 vccd1 _0502_ sky130_fd_sc_hd__a22o_1
X_1185_ net795 _0413_ vssd1 vssd1 vccd1 vccd1 _0052_ sky130_fd_sc_hd__xnor2_1
X_1254_ _0364_ _0446_ _0448_ _0368_ net72 vssd1 vssd1 vccd1 vccd1 _0449_ sky130_fd_sc_hd__a32o_1
XFILLER_0_61_105 vssd1 vssd1 vccd1 vccd1 sky130_fd_sc_hd__decap_6
XFILLER_0_19_349 vssd1 vssd1 vccd1 vccd1 sky130_fd_sc_hd__decap_6
Xoutput230 net230 vssd1 vssd1 vccd1 vccd1 spi0_mosi_o[2] sky130_fd_sc_hd__clkbuf_4
Xoutput241 net241 vssd1 vssd1 vccd1 vccd1 spi1_mosi_o[1] sky130_fd_sc_hd__clkbuf_4
Xoutput252 net252 vssd1 vssd1 vccd1 vccd1 spi2_mosi_o[0] sky130_fd_sc_hd__clkbuf_4
XFILLER_0_54_190 vssd1 vssd1 vccd1 vccd1 sky130_fd_sc_hd__decap_6
XFILLER_0_27_393 vssd1 vssd1 vccd1 vccd1 sky130_fd_sc_hd__decap_6
Xoutput285 net285 vssd1 vssd1 vccd1 vccd1 sport0_o[32] sky130_fd_sc_hd__clkbuf_4
Xoutput296 net296 vssd1 vssd1 vccd1 vccd1 sport1_o[11] sky130_fd_sc_hd__clkbuf_4
Xoutput263 net263 vssd1 vssd1 vccd1 vccd1 sport0_o[12] sky130_fd_sc_hd__clkbuf_4
Xoutput274 net274 vssd1 vssd1 vccd1 vccd1 sport0_o[22] sky130_fd_sc_hd__clkbuf_4
XFILLER_0_77_293 vssd1 vssd1 vccd1 vccd1 sky130_ef_sc_hd__decap_12
XFILLER_0_77_271 vssd1 vssd1 vccd1 vccd1 sky130_fd_sc_hd__decap_8
XFILLER_0_69_249 vssd1 vssd1 vccd1 vccd1 sky130_fd_sc_hd__decap_4
XFILLER_0_80_403 vssd1 vssd1 vccd1 vccd1 sky130_fd_sc_hd__decap_4
XFILLER_0_52_127 vssd1 vssd1 vccd1 vccd1 sky130_fd_sc_hd__decap_4
XFILLER_0_45_190 vssd1 vssd1 vccd1 vccd1 sky130_ef_sc_hd__decap_12
XFILLER_0_33_341 vssd1 vssd1 vccd1 vccd1 sky130_fd_sc_hd__fill_1
XTAP_709 vssd1 vccd1 sky130_fd_sc_hd__tapvpwrvgnd_1
XFILLER_0_60_193 vssd1 vssd1 vccd1 vccd1 sky130_fd_sc_hd__decap_3
XFILLER_0_45_15 vssd1 vssd1 vccd1 vccd1 sky130_fd_sc_hd__fill_1
XFILLER_0_28_146 vssd1 vssd1 vccd1 vccd1 sky130_fd_sc_hd__decap_6
X_1872_ spi_mem2.address\[5\] _0742_ _0824_ spi_mem2.address\[1\] spi_mem2.address_nibble\[2\]
+ vssd1 vssd1 vccd1 vccd1 _0851_ sky130_fd_sc_hd__a221o_1
X_1941_ net162 net400 _0972_ _0871_ vssd1 vssd1 vccd1 vccd1 _0898_ sky130_fd_sc_hd__a22o_1
XFILLER_0_51_193 vssd1 vssd1 vccd1 vccd1 sky130_fd_sc_hd__decap_4
XFILLER_0_10_73 vssd1 vssd1 vccd1 vccd1 sky130_fd_sc_hd__decap_3
X_1306_ net786 _0483_ _0491_ net372 vssd1 vssd1 vccd1 vccd1 _0097_ sky130_fd_sc_hd__a22o_1
X_2286_ clknet_leaf_37_clk_i net627 net448 vssd1 vssd1 vccd1 vccd1 net351 sky130_fd_sc_hd__dfrtp_1
X_1099_ _0968_ _0354_ _0363_ net764 vssd1 vssd1 vccd1 vccd1 _0018_ sky130_fd_sc_hd__a2bb2o_1
XFILLER_0_35_81 vssd1 vssd1 vccd1 vccd1 sky130_fd_sc_hd__decap_8
X_1168_ net74 net73 net67 net66 vssd1 vssd1 vccd1 vccd1 _0400_ sky130_fd_sc_hd__or4_1
X_1237_ net443 _0432_ spi_mem0.address_nibble\[1\] vssd1 vssd1 vccd1 vccd1 _0433_
+ sky130_fd_sc_hd__and3b_1
XFILLER_0_74_241 vssd1 vssd1 vccd1 vccd1 sky130_fd_sc_hd__decap_8
XFILLER_0_19_135 vssd1 vssd1 vccd1 vccd1 sky130_fd_sc_hd__decap_6
XFILLER_0_30_377 vssd1 vssd1 vccd1 vccd1 sky130_fd_sc_hd__decap_3
XFILLER_0_15_385 vssd1 vssd1 vccd1 vccd1 sky130_fd_sc_hd__decap_6
XFILLER_0_31_39 vssd1 vssd1 vccd1 vccd1 sky130_ef_sc_hd__decap_12
XFILLER_0_25_105 vssd1 vssd1 vccd1 vccd1 sky130_fd_sc_hd__decap_6
XFILLER_0_80_299 vssd1 vssd1 vccd1 vccd1 sky130_fd_sc_hd__decap_8
XFILLER_0_40_108 vssd1 vssd1 vccd1 vccd1 sky130_ef_sc_hd__decap_12
XFILLER_0_33_193 vssd1 vssd1 vccd1 vccd1 sky130_fd_sc_hd__decap_4
X_2140_ clknet_leaf_13_clk_i _0160_ net483 vssd1 vssd1 vccd1 vccd1 spi_mem1.state\[2\]
+ sky130_fd_sc_hd__dfrtp_4
XTAP_539 vssd1 vccd1 sky130_fd_sc_hd__tapvpwrvgnd_1
XTAP_528 vssd1 vccd1 sky130_fd_sc_hd__tapvpwrvgnd_1
XTAP_517 vssd1 vccd1 sky130_fd_sc_hd__tapvpwrvgnd_1
XTAP_506 vssd1 vccd1 sky130_fd_sc_hd__tapvpwrvgnd_1
XFILLER_0_21_399 vssd1 vssd1 vccd1 vccd1 sky130_fd_sc_hd__decap_8
X_1022_ net441 spi_mem0.state\[3\] vssd1 vssd1 vccd1 vccd1 _0947_ sky130_fd_sc_hd__nor2_2
X_2071_ clknet_leaf_24_clk_i _0091_ net463 vssd1 vssd1 vccd1 vccd1 spi_mem0.data_nibble
+ sky130_fd_sc_hd__dfrtp_1
XFILLER_0_56_274 vssd1 vssd1 vccd1 vccd1 sky130_ef_sc_hd__decap_12
X_1924_ net223 net400 _0873_ _0885_ vssd1 vssd1 vccd1 vccd1 _0888_ sky130_fd_sc_hd__a22o_1
X_1855_ net423 net420 spi_mem2.data_buf\[13\] vssd1 vssd1 vccd1 vccd1 _0835_ sky130_fd_sc_hd__and3_1
XFILLER_0_16_149 vssd1 vssd1 vccd1 vccd1 sky130_ef_sc_hd__decap_12
X_1786_ _0953_ _0961_ _0747_ vssd1 vssd1 vccd1 vccd1 _0803_ sky130_fd_sc_hd__o21ai_1
X_2338_ net247 vssd1 vssd1 vccd1 vccd1 net245 sky130_fd_sc_hd__clkbuf_1
XFILLER_0_41_3 vssd1 vssd1 vccd1 vccd1 sky130_fd_sc_hd__fill_1
X_2269_ clknet_leaf_37_clk_i _0283_ net447 vssd1 vssd1 vccd1 vccd1 net332 sky130_fd_sc_hd__dfrtp_1
XFILLER_0_79_377 vssd1 vssd1 vccd1 vccd1 sky130_ef_sc_hd__decap_12
XFILLER_0_62_200 vssd1 vssd1 vccd1 vccd1 sky130_fd_sc_hd__decap_8
XFILLER_0_47_274 vssd1 vssd1 vccd1 vccd1 sky130_fd_sc_hd__decap_6
XFILLER_0_62_244 vssd1 vssd1 vccd1 vccd1 sky130_fd_sc_hd__decap_8
XFILLER_0_7_382 vssd1 vssd1 vccd1 vccd1 sky130_fd_sc_hd__fill_1
XFILLER_0_7_393 vssd1 vssd1 vccd1 vccd1 sky130_fd_sc_hd__fill_1
XFILLER_0_15_193 vssd1 vssd1 vccd1 vccd1 sky130_ef_sc_hd__decap_12
Xhold40 _0079_ vssd1 vssd1 vccd1 vccd1 net544 sky130_fd_sc_hd__dlygate4sd3_1
XFILLER_0_30_141 vssd1 vssd1 vccd1 vccd1 sky130_ef_sc_hd__decap_12
Xhold62 _0192_ vssd1 vssd1 vccd1 vccd1 net566 sky130_fd_sc_hd__dlygate4sd3_1
Xhold95 spi_mem0.address\[20\] vssd1 vssd1 vccd1 vccd1 net599 sky130_fd_sc_hd__dlygate4sd3_1
Xhold73 _0285_ vssd1 vssd1 vccd1 vccd1 net577 sky130_fd_sc_hd__dlygate4sd3_1
Xhold84 net348 vssd1 vssd1 vccd1 vccd1 net588 sky130_fd_sc_hd__dlygate4sd3_1
Xhold51 spi_mem2.address\[4\] vssd1 vssd1 vccd1 vccd1 net555 sky130_fd_sc_hd__dlygate4sd3_1
XFILLER_0_53_233 vssd1 vssd1 vccd1 vccd1 sky130_ef_sc_hd__decap_12
XFILLER_0_42_27 vssd1 vssd1 vccd1 vccd1 sky130_fd_sc_hd__fill_1
XFILLER_0_38_285 vssd1 vssd1 vccd1 vccd1 sky130_fd_sc_hd__fill_2
X_1571_ net395 _0656_ _0658_ _0536_ net141 vssd1 vssd1 vccd1 vccd1 _0659_ sky130_fd_sc_hd__a32o_1
X_1640_ net718 _0707_ _0710_ net367 vssd1 vssd1 vccd1 vccd1 _0212_ sky130_fd_sc_hd__a22o_1
XANTENNA_4 net102 vssd1 vssd1 vccd1 vccd1 sky130_fd_sc_hd__diode_2
XFILLER_0_53_277 vssd1 vssd1 vccd1 vccd1 sky130_fd_sc_hd__decap_3
XFILLER_0_13_108 vssd1 vssd1 vccd1 vccd1 sky130_fd_sc_hd__decap_4
XTAP_303 vssd1 vccd1 sky130_fd_sc_hd__tapvpwrvgnd_1
XTAP_314 vssd1 vccd1 sky130_fd_sc_hd__tapvpwrvgnd_1
X_2123_ clknet_leaf_16_clk_i _0143_ net484 vssd1 vssd1 vccd1 vccd1 spi_mem1.address\[10\]
+ sky130_fd_sc_hd__dfrtp_1
XTAP_369 vssd1 vccd1 sky130_fd_sc_hd__tapvpwrvgnd_1
XTAP_358 vssd1 vccd1 sky130_fd_sc_hd__tapvpwrvgnd_1
XTAP_347 vssd1 vccd1 sky130_fd_sc_hd__tapvpwrvgnd_1
XTAP_336 vssd1 vccd1 sky130_fd_sc_hd__tapvpwrvgnd_1
XTAP_325 vssd1 vccd1 sky130_fd_sc_hd__tapvpwrvgnd_1
X_2054_ clknet_leaf_4_clk_i net638 net455 vssd1 vssd1 vccd1 vccd1 net277 sky130_fd_sc_hd__dfrtp_1
XFILLER_0_29_241 vssd1 vssd1 vccd1 vccd1 sky130_fd_sc_hd__fill_2
XFILLER_0_16_83 vssd1 vssd1 vccd1 vccd1 sky130_fd_sc_hd__fill_1
X_1907_ spi_mem2.delayed_miso\[3\] _0967_ vssd1 vssd1 vccd1 vccd1 _0877_ sky130_fd_sc_hd__and2_4
XFILLER_0_4_374 vssd1 vssd1 vccd1 vccd1 sky130_fd_sc_hd__fill_1
X_1838_ net423 net420 vssd1 vssd1 vccd1 vccd1 _0819_ sky130_fd_sc_hd__and2b_1
X_1769_ spi_mem2.address_nibble\[0\] _0740_ _0787_ vssd1 vssd1 vccd1 vccd1 _0788_
+ sky130_fd_sc_hd__a21boi_1
XFILLER_0_12_141 vssd1 vssd1 vccd1 vccd1 sky130_fd_sc_hd__decap_4
XFILLER_0_12_152 vssd1 vssd1 vccd1 vccd1 sky130_ef_sc_hd__decap_12
XFILLER_0_75_391 vssd1 vssd1 vccd1 vccd1 sky130_fd_sc_hd__fill_1
XFILLER_0_35_200 vssd1 vssd1 vccd1 vccd1 sky130_fd_sc_hd__decap_8
XFILLER_0_23_406 vssd1 vssd1 vccd1 vccd1 sky130_fd_sc_hd__fill_1
XFILLER_0_50_225 vssd1 vssd1 vccd1 vccd1 sky130_fd_sc_hd__fill_1
Xinput152 sport1_i[7] vssd1 vssd1 vccd1 vccd1 net152 sky130_fd_sc_hd__clkbuf_2
Xinput163 sport2_i[17] vssd1 vssd1 vccd1 vccd1 net163 sky130_fd_sc_hd__buf_1
Xinput141 sport1_i[5] vssd1 vssd1 vccd1 vccd1 net141 sky130_fd_sc_hd__clkbuf_2
Xinput196 sport2_i[47] vssd1 vssd1 vccd1 vccd1 net196 sky130_fd_sc_hd__buf_1
Xinput130 sport1_i[4] vssd1 vssd1 vccd1 vccd1 net130 sky130_fd_sc_hd__clkbuf_2
Xinput185 sport2_i[37] vssd1 vssd1 vccd1 vccd1 net185 sky130_fd_sc_hd__clkbuf_1
Xinput174 sport2_i[27] vssd1 vssd1 vccd1 vccd1 net174 sky130_fd_sc_hd__clkbuf_1
XFILLER_0_53_15 vssd1 vssd1 vccd1 vccd1 sky130_ef_sc_hd__decap_12
XFILLER_0_66_391 vssd1 vssd1 vccd1 vccd1 sky130_fd_sc_hd__decap_8
XFILLER_0_41_225 vssd1 vssd1 vccd1 vccd1 sky130_ef_sc_hd__decap_12
XFILLER_0_78_67 vssd1 vssd1 vccd1 vccd1 sky130_fd_sc_hd__decap_8
X_1554_ _0930_ spi_mem1.address_nibble\[1\] _0642_ vssd1 vssd1 vccd1 vccd1 _0643_
+ sky130_fd_sc_hd__and3_1
X_1623_ spi_mem1.data_byte\[0\] spi_mem1.data_nibble _0931_ vssd1 vssd1 vccd1 vccd1
+ _0700_ sky130_fd_sc_hd__and3b_2
X_1485_ net147 _0609_ net148 net149 vssd1 vssd1 vccd1 vccd1 _0610_ sky130_fd_sc_hd__and4b_1
XFILLER_0_1_311 vssd1 vssd1 vccd1 vccd1 sky130_fd_sc_hd__decap_3
XTAP_166 vssd1 vccd1 sky130_fd_sc_hd__tapvpwrvgnd_1
.ends
