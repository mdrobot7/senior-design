* NGSPICE file created from CF_SRAM_1024x32_wrapper.ext - technology: sky130A

* Black-box entry subcircuit for sky130_ef_sc_hd__decap_12 abstract view
.subckt sky130_ef_sc_hd__decap_12 VGND VNB VPB VPWR
.ends

* Black-box entry subcircuit for sky130_fd_sc_hd__fill_1 abstract view
.subckt sky130_fd_sc_hd__fill_1 VGND VNB VPB VPWR
.ends

* Black-box entry subcircuit for sky130_fd_sc_hd__decap_6 abstract view
.subckt sky130_fd_sc_hd__decap_6 VGND VNB VPB VPWR
.ends

* Black-box entry subcircuit for sky130_fd_sc_hd__decap_4 abstract view
.subckt sky130_fd_sc_hd__decap_4 VGND VNB VPB VPWR
.ends

* Black-box entry subcircuit for sky130_fd_sc_hd__decap_8 abstract view
.subckt sky130_fd_sc_hd__decap_8 VGND VNB VPB VPWR
.ends

* Black-box entry subcircuit for sky130_fd_sc_hd__tapvpwrvgnd_1 abstract view
.subckt sky130_fd_sc_hd__tapvpwrvgnd_1 VGND VPWR
.ends

* Black-box entry subcircuit for sky130_fd_sc_hd__diode_2 abstract view
.subckt sky130_fd_sc_hd__diode_2 DIODE VGND VNB VPB VPWR
.ends

* Black-box entry subcircuit for sky130_fd_sc_hd__clkbuf_4 abstract view
.subckt sky130_fd_sc_hd__clkbuf_4 A VGND VNB VPB VPWR X
.ends

* Black-box entry subcircuit for sky130_fd_sc_hd__decap_3 abstract view
.subckt sky130_fd_sc_hd__decap_3 VGND VNB VPB VPWR
.ends

* Black-box entry subcircuit for sky130_fd_sc_hd__fill_2 abstract view
.subckt sky130_fd_sc_hd__fill_2 VGND VNB VPB VPWR
.ends

* Black-box entry subcircuit for sky130_fd_sc_hd__buf_4 abstract view
.subckt sky130_fd_sc_hd__buf_4 A VGND VNB VPB VPWR X
.ends

* Black-box entry subcircuit for sky130_fd_sc_hd__buf_2 abstract view
.subckt sky130_fd_sc_hd__buf_2 A VGND VNB VPB VPWR X
.ends

* Black-box entry subcircuit for sky130_fd_sc_hd__clkbuf_2 abstract view
.subckt sky130_fd_sc_hd__clkbuf_2 A VGND VNB VPB VPWR X
.ends

* Black-box entry subcircuit for sky130_fd_sc_hd__buf_6 abstract view
.subckt sky130_fd_sc_hd__buf_6 A VGND VNB VPB VPWR X
.ends

* Black-box entry subcircuit for sky130_fd_sc_hd__clkbuf_8 abstract view
.subckt sky130_fd_sc_hd__clkbuf_8 A VGND VNB VPB VPWR X
.ends

* Black-box entry subcircuit for CF_SRAM_1024x32 abstract view
.subckt CF_SRAM_1024x32 DO[16] BEN[16] DO[17] BEN[17] DO[18] BEN[18] DO[19] BEN[19]
+ DO[20] BEN[20] DO[21] BEN[21] DO[22] BEN[22] DO[23] BEN[23] DO[24] BEN[24] DO[25]
+ BEN[25] DO[26] BEN[26] DO[27] BEN[27] DO[28] BEN[28] DO[29] BEN[29] DO[30] BEN[30]
+ DO[31] BEN[31] AD[0] AD[1] AD[2] WLBI WLOFF CLKin EN R_WB SM TM ScanInDR ScanOutCC
+ ScanInDL DO[9] BEN[9] DO[10] BEN[10] DO[11] BEN[11] DO[12] BEN[12] DO[13] BEN[13]
+ DO[14] BEN[14] DO[15] BEN[15] BEN[8] AD[3] AD[4] AD[5] AD[6] AD[7] AD[8] AD[9] ScanInCC
+ DO[0] BEN[0] DO[1] BEN[1] DO[2] BEN[2] DO[3] BEN[3] DO[4] BEN[4] DO[5] BEN[5] DO[6]
+ BEN[6] DO[7] BEN[7] DO[8] DI[3] DI[12] DI[0] DI[4] DI[14] DI[11] DI[5] DI[1] DI[9]
+ DI[6] DI[15] DI[2] DI[7] DI[13] DI[10] DI[8] DI[23] DI[27] DI[19] DI[21] DI[28]
+ DI[24] DI[18] DI[29] DI[16] DI[25] DI[30] DI[22] DI[20] DI[26] DI[17] DI[31] vnb
+ vpwrm vpwra vpwrp vgnd vpb vpwrpc vpwrac
.ends

.subckt CF_SRAM_1024x32_wrapper AD[0] AD[1] AD[2] AD[3] AD[4] AD[5] AD[6] AD[7] AD[8]
+ AD[9] BEN[0] BEN[10] BEN[11] BEN[12] BEN[13] BEN[14] BEN[15] BEN[16] BEN[17] BEN[18]
+ BEN[19] BEN[1] BEN[20] BEN[21] BEN[22] BEN[23] BEN[24] BEN[25] BEN[26] BEN[27] BEN[28]
+ BEN[29] BEN[2] BEN[30] BEN[31] BEN[3] BEN[4] BEN[5] BEN[6] BEN[7] BEN[8] BEN[9]
+ CLKin DI[0] DI[10] DI[11] DI[12] DI[13] DI[14] DI[15] DI[16] DI[17] DI[18] DI[19]
+ DI[1] DI[20] DI[21] DI[22] DI[23] DI[24] DI[25] DI[26] DI[27] DI[28] DI[29] DI[2]
+ DI[30] DI[31] DI[3] DI[4] DI[5] DI[6] DI[7] DI[8] DI[9] DO[0] DO[10] DO[11] DO[12]
+ DO[13] DO[14] DO[15] DO[16] DO[17] DO[18] DO[19] DO[1] DO[20] DO[21] DO[22] DO[23]
+ DO[24] DO[25] DO[26] DO[27] DO[28] DO[29] DO[2] DO[30] DO[31] DO[3] DO[4] DO[5]
+ DO[6] DO[7] DO[8] DO[9] EN R_WB SM ScanInCC ScanInDL ScanInDR ScanOutCC TM VGND
+ VPWR WLBI WLOFF vpwrac vpwrpc
XFILLER_0_7_81 VGND VGND VPWR VPWR sky130_ef_sc_hd__decap_12
XFILLER_0_33_715 VGND VGND VPWR VPWR sky130_ef_sc_hd__decap_12
XFILLER_0_41_781 VGND VGND VPWR VPWR sky130_ef_sc_hd__decap_12
XFILLER_0_134_783 VGND VGND VPWR VPWR sky130_fd_sc_hd__fill_1
XFILLER_0_3_609 VGND VGND VPWR VPWR sky130_fd_sc_hd__decap_6
XFILLER_0_24_715 VGND VGND VPWR VPWR sky130_ef_sc_hd__decap_12
XFILLER_0_99_781 VGND VGND VPWR VPWR sky130_ef_sc_hd__decap_12
XFILLER_0_117_739 VGND VGND VPWR VPWR sky130_ef_sc_hd__decap_12
XFILLER_0_140_753 VGND VGND VPWR VPWR sky130_ef_sc_hd__decap_12
XFILLER_0_6_469 VGND VGND VPWR VPWR sky130_fd_sc_hd__decap_6
XFILLER_0_15_715 VGND VGND VPWR VPWR sky130_ef_sc_hd__decap_12
XFILLER_0_23_781 VGND VGND VPWR VPWR sky130_ef_sc_hd__decap_12
XFILLER_0_30_729 VGND VGND VPWR VPWR sky130_ef_sc_hd__decap_12
XFILLER_0_140_797 VGND VGND VPWR VPWR sky130_fd_sc_hd__decap_4
XFILLER_0_116_783 VGND VGND VPWR VPWR sky130_fd_sc_hd__fill_1
XFILLER_0_88_729 VGND VGND VPWR VPWR sky130_ef_sc_hd__decap_12
XFILLER_0_122_753 VGND VGND VPWR VPWR sky130_ef_sc_hd__decap_12
XFILLER_0_3_417 VGND VGND VPWR VPWR sky130_ef_sc_hd__decap_12
XFILLER_0_12_729 VGND VGND VPWR VPWR sky130_ef_sc_hd__decap_12
XFILLER_0_122_797 VGND VGND VPWR VPWR sky130_fd_sc_hd__decap_4
XFILLER_0_87_751 VGND VGND VPWR VPWR sky130_fd_sc_hd__decap_4
XFILLER_0_6_233 VGND VGND VPWR VPWR sky130_ef_sc_hd__decap_12
XFILLER_0_6_277 VGND VGND VPWR VPWR sky130_ef_sc_hd__decap_12
XFILLER_0_11_751 VGND VGND VPWR VPWR sky130_fd_sc_hd__decap_4
XFILLER_0_104_753 VGND VGND VPWR VPWR sky130_ef_sc_hd__decap_12
XFILLER_0_104_797 VGND VGND VPWR VPWR sky130_fd_sc_hd__decap_4
XFILLER_0_69_751 VGND VGND VPWR VPWR sky130_fd_sc_hd__decap_4
XFILLER_0_0_29 VGND VGND VPWR VPWR sky130_fd_sc_hd__decap_8
XFILLER_0_84_765 VGND VGND VPWR VPWR sky130_ef_sc_hd__decap_12
XFILLER_0_3_225 VGND VGND VPWR VPWR sky130_ef_sc_hd__decap_12
XFILLER_0_4_737 VGND VGND VPWR VPWR sky130_ef_sc_hd__decap_12
XFILLER_0_7_553 VGND VGND VPWR VPWR sky130_fd_sc_hd__decap_6
XFILLER_0_7_597 VGND VGND VPWR VPWR sky130_ef_sc_hd__decap_12
XFILLER_0_81_757 VGND VGND VPWR VPWR sky130_ef_sc_hd__decap_12
XFILLER_0_66_765 VGND VGND VPWR VPWR sky130_ef_sc_hd__decap_12
XFILLER_0_1_729 VGND VGND VPWR VPWR sky130_ef_sc_hd__decap_12
XTAP_507 VGND VPWR sky130_fd_sc_hd__tapvpwrvgnd_1
XTAP_529 VGND VPWR sky130_fd_sc_hd__tapvpwrvgnd_1
XTAP_518 VGND VPWR sky130_fd_sc_hd__tapvpwrvgnd_1
XFILLER_0_4_501 VGND VGND VPWR VPWR sky130_ef_sc_hd__decap_12
XFILLER_0_4_545 VGND VGND VPWR VPWR sky130_ef_sc_hd__decap_12
XFILLER_0_4_589 VGND VGND VPWR VPWR sky130_ef_sc_hd__decap_12
XFILLER_0_63_757 VGND VGND VPWR VPWR sky130_ef_sc_hd__decap_12
XFILLER_0_48_765 VGND VGND VPWR VPWR sky130_ef_sc_hd__decap_12
XFILLER_0_7_361 VGND VGND VPWR VPWR sky130_ef_sc_hd__decap_12
XANTENNA_5 BEN[13] VGND VGND VPWR VPWR sky130_fd_sc_hd__diode_2
XTAP_337 VGND VPWR sky130_fd_sc_hd__tapvpwrvgnd_1
XFILLER_0_1_559 VGND VGND VPWR VPWR sky130_fd_sc_hd__fill_1
XTAP_348 VGND VPWR sky130_fd_sc_hd__tapvpwrvgnd_1
XTAP_326 VGND VPWR sky130_fd_sc_hd__tapvpwrvgnd_1
XTAP_315 VGND VPWR sky130_fd_sc_hd__tapvpwrvgnd_1
XFILLER_0_6_39 VGND VGND VPWR VPWR sky130_fd_sc_hd__decap_4
XTAP_359 VGND VPWR sky130_fd_sc_hd__tapvpwrvgnd_1
XFILLER_0_8_125 VGND VGND VPWR VPWR sky130_ef_sc_hd__decap_12
XFILLER_0_8_169 VGND VGND VPWR VPWR sky130_ef_sc_hd__decap_12
XFILLER_0_60_727 VGND VGND VPWR VPWR sky130_fd_sc_hd__fill_1
XFILLER_0_45_757 VGND VGND VPWR VPWR sky130_ef_sc_hd__decap_12
XFILLER_0_138_715 VGND VGND VPWR VPWR sky130_ef_sc_hd__decap_12
XFILLER_0_51_727 VGND VGND VPWR VPWR sky130_ef_sc_hd__decap_12
Xoutput97 net97 VGND VGND VPWR VPWR DO[1] sky130_fd_sc_hd__clkbuf_4
Xoutput86 net86 VGND VGND VPWR VPWR DO[0] sky130_fd_sc_hd__clkbuf_4
XFILLER_0_129_715 VGND VGND VPWR VPWR sky130_ef_sc_hd__decap_12
XPHY_170 VGND VGND VPWR VPWR sky130_fd_sc_hd__decap_3
XFILLER_0_152_751 VGND VGND VPWR VPWR sky130_fd_sc_hd__fill_2
XFILLER_0_144_729 VGND VGND VPWR VPWR sky130_ef_sc_hd__decap_12
XFILLER_0_137_781 VGND VGND VPWR VPWR sky130_ef_sc_hd__decap_12
XPHY_192 VGND VGND VPWR VPWR sky130_fd_sc_hd__decap_3
XPHY_181 VGND VGND VPWR VPWR sky130_fd_sc_hd__decap_3
XFILLER_0_27_757 VGND VGND VPWR VPWR sky130_ef_sc_hd__decap_12
XFILLER_0_42_727 VGND VGND VPWR VPWR sky130_fd_sc_hd__fill_1
XFILLER_0_143_751 VGND VGND VPWR VPWR sky130_fd_sc_hd__decap_4
XFILLER_0_33_727 VGND VGND VPWR VPWR sky130_ef_sc_hd__decap_12
XFILLER_0_5_673 VGND VGND VPWR VPWR sky130_ef_sc_hd__decap_12
XFILLER_0_7_93 VGND VGND VPWR VPWR sky130_ef_sc_hd__decap_12
XFILLER_0_41_793 VGND VGND VPWR VPWR sky130_fd_sc_hd__decap_8
XFILLER_0_126_729 VGND VGND VPWR VPWR sky130_ef_sc_hd__decap_12
XFILLER_0_119_781 VGND VGND VPWR VPWR sky130_ef_sc_hd__decap_12
XFILLER_0_2_109 VGND VGND VPWR VPWR sky130_ef_sc_hd__decap_12
XFILLER_0_24_727 VGND VGND VPWR VPWR sky130_fd_sc_hd__fill_1
XFILLER_0_99_793 VGND VGND VPWR VPWR sky130_fd_sc_hd__decap_8
XFILLER_0_3_29 VGND VGND VPWR VPWR sky130_fd_sc_hd__fill_2
XFILLER_0_15_727 VGND VGND VPWR VPWR sky130_ef_sc_hd__decap_12
XFILLER_0_140_765 VGND VGND VPWR VPWR sky130_ef_sc_hd__decap_12
XFILLER_0_140_721 VGND VGND VPWR VPWR sky130_fd_sc_hd__decap_6
XFILLER_0_125_751 VGND VGND VPWR VPWR sky130_fd_sc_hd__decap_4
XFILLER_0_2_643 VGND VGND VPWR VPWR sky130_fd_sc_hd__fill_1
XFILLER_0_23_793 VGND VGND VPWR VPWR sky130_fd_sc_hd__decap_8
XFILLER_0_108_729 VGND VGND VPWR VPWR sky130_ef_sc_hd__decap_12
XFILLER_0_96_741 VGND VGND VPWR VPWR sky130_ef_sc_hd__decap_12
XFILLER_0_96_785 VGND VGND VPWR VPWR sky130_ef_sc_hd__decap_12
XFILLER_0_122_765 VGND VGND VPWR VPWR sky130_ef_sc_hd__decap_12
XFILLER_0_107_751 VGND VGND VPWR VPWR sky130_fd_sc_hd__decap_4
XFILLER_0_3_429 VGND VGND VPWR VPWR sky130_ef_sc_hd__decap_12
XFILLER_0_20_741 VGND VGND VPWR VPWR sky130_ef_sc_hd__decap_12
XFILLER_0_20_785 VGND VGND VPWR VPWR sky130_ef_sc_hd__decap_12
XFILLER_0_6_245 VGND VGND VPWR VPWR sky130_fd_sc_hd__decap_6
XFILLER_0_6_289 VGND VGND VPWR VPWR sky130_ef_sc_hd__decap_12
XFILLER_0_4_83 VGND VGND VPWR VPWR sky130_fd_sc_hd__fill_1
XFILLER_0_93_755 VGND VGND VPWR VPWR sky130_fd_sc_hd__fill_1
XFILLER_0_78_785 VGND VGND VPWR VPWR sky130_ef_sc_hd__decap_12
XFILLER_0_78_741 VGND VGND VPWR VPWR sky130_ef_sc_hd__decap_12
XFILLER_0_104_765 VGND VGND VPWR VPWR sky130_ef_sc_hd__decap_12
XFILLER_0_84_777 VGND VGND VPWR VPWR sky130_fd_sc_hd__decap_6
XFILLER_0_4_749 VGND VGND VPWR VPWR sky130_fd_sc_hd__decap_6
XFILLER_0_3_237 VGND VGND VPWR VPWR sky130_ef_sc_hd__decap_12
XFILLER_0_90_703 VGND VGND VPWR VPWR sky130_ef_sc_hd__decap_12
XFILLER_0_75_755 VGND VGND VPWR VPWR sky130_fd_sc_hd__fill_1
XFILLER_0_101_757 VGND VGND VPWR VPWR sky130_ef_sc_hd__decap_12
XFILLER_0_81_769 VGND VGND VPWR VPWR sky130_ef_sc_hd__decap_12
XFILLER_0_81_703 VGND VGND VPWR VPWR sky130_ef_sc_hd__decap_12
XFILLER_0_66_777 VGND VGND VPWR VPWR sky130_fd_sc_hd__decap_6
XTAP_519 VGND VPWR sky130_fd_sc_hd__tapvpwrvgnd_1
XTAP_508 VGND VPWR sky130_fd_sc_hd__tapvpwrvgnd_1
XFILLER_0_72_703 VGND VGND VPWR VPWR sky130_ef_sc_hd__decap_12
XFILLER_0_57_755 VGND VGND VPWR VPWR sky130_fd_sc_hd__fill_1
XFILLER_0_4_513 VGND VGND VPWR VPWR sky130_ef_sc_hd__decap_12
XFILLER_0_4_557 VGND VGND VPWR VPWR sky130_ef_sc_hd__decap_12
XFILLER_0_0_796 VGND VGND VPWR VPWR sky130_fd_sc_hd__decap_4
XFILLER_0_0_785 VGND VGND VPWR VPWR sky130_fd_sc_hd__decap_4
XFILLER_0_1_51 VGND VGND VPWR VPWR sky130_fd_sc_hd__decap_4
XFILLER_0_63_769 VGND VGND VPWR VPWR sky130_ef_sc_hd__decap_12
XFILLER_0_63_703 VGND VGND VPWR VPWR sky130_ef_sc_hd__decap_12
XFILLER_0_48_777 VGND VGND VPWR VPWR sky130_fd_sc_hd__decap_6
XFILLER_0_7_373 VGND VGND VPWR VPWR sky130_ef_sc_hd__decap_12
XFILLER_0_54_703 VGND VGND VPWR VPWR sky130_ef_sc_hd__decap_12
XFILLER_0_39_755 VGND VGND VPWR VPWR sky130_fd_sc_hd__fill_1
XANTENNA_6 BEN[14] VGND VGND VPWR VPWR sky130_fd_sc_hd__diode_2
XFILLER_0_1_505 VGND VGND VPWR VPWR sky130_ef_sc_hd__decap_12
XTAP_338 VGND VPWR sky130_fd_sc_hd__tapvpwrvgnd_1
XTAP_349 VGND VPWR sky130_fd_sc_hd__tapvpwrvgnd_1
XTAP_327 VGND VPWR sky130_fd_sc_hd__tapvpwrvgnd_1
XTAP_316 VGND VPWR sky130_fd_sc_hd__tapvpwrvgnd_1
XFILLER_0_45_769 VGND VGND VPWR VPWR sky130_ef_sc_hd__decap_12
XFILLER_0_45_703 VGND VGND VPWR VPWR sky130_ef_sc_hd__decap_12
XFILLER_0_8_137 VGND VGND VPWR VPWR sky130_fd_sc_hd__decap_3
XFILLER_0_4_321 VGND VGND VPWR VPWR sky130_ef_sc_hd__decap_12
XFILLER_0_4_365 VGND VGND VPWR VPWR sky130_ef_sc_hd__decap_12
XFILLER_0_0_571 VGND VGND VPWR VPWR sky130_ef_sc_hd__decap_12
XFILLER_0_138_727 VGND VGND VPWR VPWR sky130_fd_sc_hd__fill_1
XFILLER_0_36_703 VGND VGND VPWR VPWR sky130_ef_sc_hd__decap_12
XFILLER_0_51_739 VGND VGND VPWR VPWR sky130_ef_sc_hd__decap_12
XFILLER_0_7_181 VGND VGND VPWR VPWR sky130_ef_sc_hd__decap_12
Xoutput98 net98 VGND VGND VPWR VPWR DO[20] sky130_fd_sc_hd__buf_4
Xoutput87 net87 VGND VGND VPWR VPWR DO[10] sky130_fd_sc_hd__buf_4
XFILLER_0_137_793 VGND VGND VPWR VPWR sky130_fd_sc_hd__decap_8
XFILLER_0_129_727 VGND VGND VPWR VPWR sky130_ef_sc_hd__decap_12
XPHY_193 VGND VGND VPWR VPWR sky130_fd_sc_hd__decap_3
XPHY_182 VGND VGND VPWR VPWR sky130_fd_sc_hd__decap_3
XPHY_171 VGND VGND VPWR VPWR sky130_fd_sc_hd__decap_3
XPHY_160 VGND VGND VPWR VPWR sky130_fd_sc_hd__decap_3
XFILLER_0_27_703 VGND VGND VPWR VPWR sky130_ef_sc_hd__decap_12
XFILLER_0_27_769 VGND VGND VPWR VPWR sky130_ef_sc_hd__decap_12
XFILLER_0_152_785 VGND VGND VPWR VPWR sky130_ef_sc_hd__decap_12
XFILLER_0_50_783 VGND VGND VPWR VPWR sky130_fd_sc_hd__fill_1
XFILLER_0_1_335 VGND VGND VPWR VPWR sky130_fd_sc_hd__fill_1
XFILLER_0_18_703 VGND VGND VPWR VPWR sky130_ef_sc_hd__decap_12
XFILLER_0_5_641 VGND VGND VPWR VPWR sky130_ef_sc_hd__decap_12
XFILLER_0_33_739 VGND VGND VPWR VPWR sky130_ef_sc_hd__decap_12
XFILLER_0_2_9 VGND VGND VPWR VPWR sky130_fd_sc_hd__fill_2
XFILLER_0_4_195 VGND VGND VPWR VPWR sky130_fd_sc_hd__fill_1
XFILLER_0_5_685 VGND VGND VPWR VPWR sky130_ef_sc_hd__decap_12
XTAP_680 VGND VPWR sky130_fd_sc_hd__tapvpwrvgnd_1
XFILLER_0_134_785 VGND VGND VPWR VPWR sky130_fd_sc_hd__decap_8
XFILLER_0_134_741 VGND VGND VPWR VPWR sky130_ef_sc_hd__decap_12
XFILLER_0_119_793 VGND VGND VPWR VPWR sky130_fd_sc_hd__decap_8
XFILLER_0_32_783 VGND VGND VPWR VPWR sky130_fd_sc_hd__fill_1
XFILLER_0_15_739 VGND VGND VPWR VPWR sky130_ef_sc_hd__decap_12
XFILLER_0_140_777 VGND VGND VPWR VPWR sky130_fd_sc_hd__decap_6
XFILLER_0_2_699 VGND VGND VPWR VPWR sky130_fd_sc_hd__fill_1
XFILLER_0_131_755 VGND VGND VPWR VPWR sky130_fd_sc_hd__fill_1
XFILLER_0_116_785 VGND VGND VPWR VPWR sky130_ef_sc_hd__decap_12
XFILLER_0_116_741 VGND VGND VPWR VPWR sky130_ef_sc_hd__decap_12
XFILLER_0_14_783 VGND VGND VPWR VPWR sky130_fd_sc_hd__fill_1
XFILLER_0_96_753 VGND VGND VPWR VPWR sky130_ef_sc_hd__decap_12
XFILLER_0_96_797 VGND VGND VPWR VPWR sky130_fd_sc_hd__decap_4
XFILLER_0_122_777 VGND VGND VPWR VPWR sky130_fd_sc_hd__decap_6
XFILLER_0_20_753 VGND VGND VPWR VPWR sky130_ef_sc_hd__decap_12
XFILLER_0_20_797 VGND VGND VPWR VPWR sky130_fd_sc_hd__decap_4
XFILLER_0_113_755 VGND VGND VPWR VPWR sky130_fd_sc_hd__fill_1
XFILLER_0_4_51 VGND VGND VPWR VPWR sky130_ef_sc_hd__decap_12
XFILLER_0_78_753 VGND VGND VPWR VPWR sky130_ef_sc_hd__decap_12
XFILLER_0_78_797 VGND VGND VPWR VPWR sky130_fd_sc_hd__decap_4
XFILLER_0_104_777 VGND VGND VPWR VPWR sky130_fd_sc_hd__decap_6
XFILLER_0_3_205 VGND VGND VPWR VPWR sky130_ef_sc_hd__decap_12
XFILLER_0_3_249 VGND VGND VPWR VPWR sky130_ef_sc_hd__decap_12
XFILLER_0_110_703 VGND VGND VPWR VPWR sky130_ef_sc_hd__decap_12
XFILLER_0_90_715 VGND VGND VPWR VPWR sky130_ef_sc_hd__decap_12
XFILLER_0_101_703 VGND VGND VPWR VPWR sky130_ef_sc_hd__decap_12
XFILLER_0_3_783 VGND VGND VPWR VPWR sky130_fd_sc_hd__fill_1
XFILLER_0_101_769 VGND VGND VPWR VPWR sky130_ef_sc_hd__decap_12
XFILLER_0_81_715 VGND VGND VPWR VPWR sky130_ef_sc_hd__decap_12
XFILLER_0_1_709 VGND VGND VPWR VPWR sky130_ef_sc_hd__decap_12
XTAP_509 VGND VPWR sky130_fd_sc_hd__tapvpwrvgnd_1
XFILLER_0_72_715 VGND VGND VPWR VPWR sky130_ef_sc_hd__decap_12
XFILLER_0_4_525 VGND VGND VPWR VPWR sky130_fd_sc_hd__decap_6
XFILLER_0_4_569 VGND VGND VPWR VPWR sky130_ef_sc_hd__decap_12
XFILLER_0_71_781 VGND VGND VPWR VPWR sky130_ef_sc_hd__decap_12
XFILLER_0_63_715 VGND VGND VPWR VPWR sky130_ef_sc_hd__decap_12
XFILLER_0_7_385 VGND VGND VPWR VPWR sky130_fd_sc_hd__decap_6
XFILLER_0_54_715 VGND VGND VPWR VPWR sky130_ef_sc_hd__decap_12
XANTENNA_7 BEN[15] VGND VGND VPWR VPWR sky130_fd_sc_hd__diode_2
XFILLER_0_1_517 VGND VGND VPWR VPWR sky130_ef_sc_hd__decap_12
XFILLER_0_6_19 VGND VGND VPWR VPWR sky130_fd_sc_hd__fill_2
XTAP_339 VGND VPWR sky130_fd_sc_hd__tapvpwrvgnd_1
XTAP_328 VGND VPWR sky130_fd_sc_hd__tapvpwrvgnd_1
XTAP_317 VGND VPWR sky130_fd_sc_hd__tapvpwrvgnd_1
XFILLER_0_155_761 VGND VGND VPWR VPWR sky130_fd_sc_hd__fill_2
XFILLER_0_60_729 VGND VGND VPWR VPWR sky130_ef_sc_hd__decap_12
XFILLER_0_45_715 VGND VGND VPWR VPWR sky130_ef_sc_hd__decap_12
XFILLER_0_4_333 VGND VGND VPWR VPWR sky130_ef_sc_hd__decap_12
XFILLER_0_53_781 VGND VGND VPWR VPWR sky130_ef_sc_hd__decap_12
XFILLER_0_0_583 VGND VGND VPWR VPWR sky130_fd_sc_hd__decap_4
XFILLER_0_0_561 VGND VGND VPWR VPWR sky130_fd_sc_hd__decap_4
XFILLER_0_4_377 VGND VGND VPWR VPWR sky130_ef_sc_hd__decap_12
XFILLER_0_36_715 VGND VGND VPWR VPWR sky130_ef_sc_hd__decap_12
XFILLER_0_146_783 VGND VGND VPWR VPWR sky130_fd_sc_hd__fill_1
XFILLER_0_7_193 VGND VGND VPWR VPWR sky130_ef_sc_hd__decap_12
Xoutput99 net99 VGND VGND VPWR VPWR DO[21] sky130_fd_sc_hd__buf_4
Xoutput88 net88 VGND VGND VPWR VPWR DO[11] sky130_fd_sc_hd__buf_4
XFILLER_0_129_739 VGND VGND VPWR VPWR sky130_ef_sc_hd__decap_12
XPHY_194 VGND VGND VPWR VPWR sky130_fd_sc_hd__decap_3
XPHY_183 VGND VGND VPWR VPWR sky130_fd_sc_hd__decap_3
XPHY_172 VGND VGND VPWR VPWR sky130_fd_sc_hd__decap_3
XPHY_161 VGND VGND VPWR VPWR sky130_fd_sc_hd__decap_3
XPHY_150 VGND VGND VPWR VPWR sky130_fd_sc_hd__decap_3
XFILLER_0_27_715 VGND VGND VPWR VPWR sky130_ef_sc_hd__decap_12
XFILLER_0_42_729 VGND VGND VPWR VPWR sky130_ef_sc_hd__decap_12
XFILLER_0_152_797 VGND VGND VPWR VPWR sky130_fd_sc_hd__decap_4
XFILLER_0_35_781 VGND VGND VPWR VPWR sky130_ef_sc_hd__decap_12
XFILLER_0_135_709 VGND VGND VPWR VPWR sky130_ef_sc_hd__decap_12
XFILLER_0_18_715 VGND VGND VPWR VPWR sky130_ef_sc_hd__decap_12
XFILLER_0_128_783 VGND VGND VPWR VPWR sky130_fd_sc_hd__fill_1
XFILLER_0_4_141 VGND VGND VPWR VPWR sky130_ef_sc_hd__decap_12
XFILLER_0_5_653 VGND VGND VPWR VPWR sky130_ef_sc_hd__decap_12
XFILLER_0_5_697 VGND VGND VPWR VPWR sky130_ef_sc_hd__decap_12
XFILLER_0_41_751 VGND VGND VPWR VPWR sky130_fd_sc_hd__decap_4
XTAP_670 VGND VPWR sky130_fd_sc_hd__tapvpwrvgnd_1
XFILLER_0_0_391 VGND VGND VPWR VPWR sky130_fd_sc_hd__fill_1
XTAP_681 VGND VPWR sky130_fd_sc_hd__tapvpwrvgnd_1
XFILLER_0_24_729 VGND VGND VPWR VPWR sky130_ef_sc_hd__decap_12
XFILLER_0_134_753 VGND VGND VPWR VPWR sky130_ef_sc_hd__decap_12
XFILLER_0_17_781 VGND VGND VPWR VPWR sky130_ef_sc_hd__decap_12
XFILLER_0_99_751 VGND VGND VPWR VPWR sky130_fd_sc_hd__decap_4
XFILLER_0_2_601 VGND VGND VPWR VPWR sky130_ef_sc_hd__decap_12
XFILLER_0_23_751 VGND VGND VPWR VPWR sky130_fd_sc_hd__decap_4
XFILLER_0_2_645 VGND VGND VPWR VPWR sky130_ef_sc_hd__decap_12
XFILLER_0_1_111 VGND VGND VPWR VPWR sky130_fd_sc_hd__fill_1
XFILLER_0_116_797 VGND VGND VPWR VPWR sky130_fd_sc_hd__decap_4
XFILLER_0_116_753 VGND VGND VPWR VPWR sky130_ef_sc_hd__decap_12
XFILLER_0_5_461 VGND VGND VPWR VPWR sky130_ef_sc_hd__decap_12
XFILLER_0_96_765 VGND VGND VPWR VPWR sky130_ef_sc_hd__decap_12
XFILLER_0_20_765 VGND VGND VPWR VPWR sky130_ef_sc_hd__decap_12
XFILLER_0_2_475 VGND VGND VPWR VPWR sky130_fd_sc_hd__fill_1
XFILLER_0_4_63 VGND VGND VPWR VPWR sky130_ef_sc_hd__decap_12
XFILLER_0_4_85 VGND VGND VPWR VPWR sky130_ef_sc_hd__decap_12
XFILLER_0_78_765 VGND VGND VPWR VPWR sky130_ef_sc_hd__decap_12
XFILLER_0_93_757 VGND VGND VPWR VPWR sky130_ef_sc_hd__decap_12
XFILLER_0_6_781 VGND VGND VPWR VPWR sky130_ef_sc_hd__decap_12
XFILLER_0_110_715 VGND VGND VPWR VPWR sky130_ef_sc_hd__decap_12
XFILLER_0_3_217 VGND VGND VPWR VPWR sky130_fd_sc_hd__decap_6
XFILLER_0_90_727 VGND VGND VPWR VPWR sky130_fd_sc_hd__fill_1
XFILLER_0_75_757 VGND VGND VPWR VPWR sky130_ef_sc_hd__decap_12
XFILLER_0_101_715 VGND VGND VPWR VPWR sky130_ef_sc_hd__decap_12
XFILLER_0_81_727 VGND VGND VPWR VPWR sky130_ef_sc_hd__decap_12
XFILLER_0_0_209 VGND VGND VPWR VPWR sky130_fd_sc_hd__decap_6
XFILLER_0_72_727 VGND VGND VPWR VPWR sky130_fd_sc_hd__fill_1
XFILLER_0_57_757 VGND VGND VPWR VPWR sky130_ef_sc_hd__decap_12
XFILLER_0_8_309 VGND VGND VPWR VPWR sky130_ef_sc_hd__decap_12
XFILLER_0_0_754 VGND VGND VPWR VPWR sky130_fd_sc_hd__fill_2
XFILLER_0_0_721 VGND VGND VPWR VPWR sky130_fd_sc_hd__decap_6
XFILLER_0_71_793 VGND VGND VPWR VPWR sky130_fd_sc_hd__decap_8
XFILLER_0_63_727 VGND VGND VPWR VPWR sky130_ef_sc_hd__decap_12
XPHY_310 VGND VGND VPWR VPWR sky130_fd_sc_hd__decap_3
XFILLER_0_149_781 VGND VGND VPWR VPWR sky130_ef_sc_hd__decap_12
XFILLER_0_54_727 VGND VGND VPWR VPWR sky130_fd_sc_hd__fill_1
XFILLER_0_39_757 VGND VGND VPWR VPWR sky130_ef_sc_hd__decap_12
XANTENNA_8 BEN[16] VGND VGND VPWR VPWR sky130_fd_sc_hd__diode_2
XFILLER_0_1_529 VGND VGND VPWR VPWR sky130_ef_sc_hd__decap_12
XTAP_329 VGND VPWR sky130_fd_sc_hd__tapvpwrvgnd_1
XTAP_318 VGND VPWR sky130_fd_sc_hd__tapvpwrvgnd_1
XFILLER_0_147_707 VGND VGND VPWR VPWR sky130_fd_sc_hd__fill_2
XFILLER_0_53_793 VGND VGND VPWR VPWR sky130_fd_sc_hd__decap_8
XFILLER_0_45_727 VGND VGND VPWR VPWR sky130_ef_sc_hd__decap_12
XFILLER_0_4_301 VGND VGND VPWR VPWR sky130_fd_sc_hd__decap_6
XFILLER_0_4_345 VGND VGND VPWR VPWR sky130_ef_sc_hd__decap_12
XFILLER_0_4_389 VGND VGND VPWR VPWR sky130_ef_sc_hd__decap_12
XFILLER_0_138_729 VGND VGND VPWR VPWR sky130_ef_sc_hd__decap_12
XFILLER_0_8_673 VGND VGND VPWR VPWR sky130_ef_sc_hd__decap_12
XFILLER_0_36_727 VGND VGND VPWR VPWR sky130_fd_sc_hd__fill_1
XFILLER_0_7_161 VGND VGND VPWR VPWR sky130_fd_sc_hd__decap_6
Xoutput89 net89 VGND VGND VPWR VPWR DO[12] sky130_fd_sc_hd__buf_4
XFILLER_0_152_743 VGND VGND VPWR VPWR sky130_fd_sc_hd__fill_2
XFILLER_0_137_751 VGND VGND VPWR VPWR sky130_fd_sc_hd__decap_4
XPHY_195 VGND VGND VPWR VPWR sky130_fd_sc_hd__decap_3
XPHY_184 VGND VGND VPWR VPWR sky130_fd_sc_hd__decap_3
XPHY_173 VGND VGND VPWR VPWR sky130_fd_sc_hd__decap_3
XPHY_162 VGND VGND VPWR VPWR sky130_fd_sc_hd__decap_3
XPHY_151 VGND VGND VPWR VPWR sky130_fd_sc_hd__decap_3
XPHY_140 VGND VGND VPWR VPWR sky130_fd_sc_hd__decap_3
XFILLER_0_27_727 VGND VGND VPWR VPWR sky130_ef_sc_hd__decap_12
XFILLER_0_35_793 VGND VGND VPWR VPWR sky130_fd_sc_hd__decap_8
XFILLER_0_50_785 VGND VGND VPWR VPWR sky130_ef_sc_hd__decap_12
XFILLER_0_50_741 VGND VGND VPWR VPWR sky130_ef_sc_hd__decap_12
XFILLER_0_1_337 VGND VGND VPWR VPWR sky130_ef_sc_hd__decap_12
XFILLER_0_18_727 VGND VGND VPWR VPWR sky130_fd_sc_hd__fill_1
XFILLER_0_4_153 VGND VGND VPWR VPWR sky130_ef_sc_hd__decap_12
XFILLER_0_4_197 VGND VGND VPWR VPWR sky130_ef_sc_hd__decap_12
XFILLER_0_5_665 VGND VGND VPWR VPWR sky130_fd_sc_hd__decap_6
XFILLER_0_7_41 VGND VGND VPWR VPWR sky130_fd_sc_hd__fill_2
XTAP_682 VGND VPWR sky130_fd_sc_hd__tapvpwrvgnd_1
XTAP_671 VGND VPWR sky130_fd_sc_hd__tapvpwrvgnd_1
XTAP_660 VGND VPWR sky130_fd_sc_hd__tapvpwrvgnd_1
XFILLER_0_134_765 VGND VGND VPWR VPWR sky130_ef_sc_hd__decap_12
XFILLER_0_119_751 VGND VGND VPWR VPWR sky130_fd_sc_hd__decap_4
XFILLER_0_17_793 VGND VGND VPWR VPWR sky130_fd_sc_hd__decap_8
XFILLER_0_32_741 VGND VGND VPWR VPWR sky130_ef_sc_hd__decap_12
XFILLER_0_32_785 VGND VGND VPWR VPWR sky130_ef_sc_hd__decap_12
XFILLER_0_2_657 VGND VGND VPWR VPWR sky130_ef_sc_hd__decap_12
XFILLER_0_2_613 VGND VGND VPWR VPWR sky130_ef_sc_hd__decap_12
XFILLER_0_1_167 VGND VGND VPWR VPWR sky130_fd_sc_hd__fill_1
XFILLER_0_116_765 VGND VGND VPWR VPWR sky130_ef_sc_hd__decap_12
XFILLER_0_131_757 VGND VGND VPWR VPWR sky130_ef_sc_hd__decap_12
XFILLER_0_5_473 VGND VGND VPWR VPWR sky130_ef_sc_hd__decap_12
XFILLER_0_14_741 VGND VGND VPWR VPWR sky130_ef_sc_hd__decap_12
XFILLER_0_14_785 VGND VGND VPWR VPWR sky130_ef_sc_hd__decap_12
XTAP_490 VGND VPWR sky130_fd_sc_hd__tapvpwrvgnd_1
XFILLER_0_96_777 VGND VGND VPWR VPWR sky130_fd_sc_hd__decap_6
XFILLER_0_20_777 VGND VGND VPWR VPWR sky130_fd_sc_hd__decap_6
XFILLER_0_87_755 VGND VGND VPWR VPWR sky130_fd_sc_hd__fill_1
XFILLER_0_7_727 VGND VGND VPWR VPWR sky130_fd_sc_hd__fill_1
XFILLER_0_113_757 VGND VGND VPWR VPWR sky130_ef_sc_hd__decap_12
XFILLER_0_2_421 VGND VGND VPWR VPWR sky130_ef_sc_hd__decap_12
XFILLER_0_11_755 VGND VGND VPWR VPWR sky130_fd_sc_hd__fill_1
XFILLER_0_4_75 VGND VGND VPWR VPWR sky130_fd_sc_hd__decap_8
XFILLER_0_4_97 VGND VGND VPWR VPWR sky130_ef_sc_hd__decap_12
XFILLER_0_93_703 VGND VGND VPWR VPWR sky130_ef_sc_hd__decap_12
XFILLER_0_78_777 VGND VGND VPWR VPWR sky130_fd_sc_hd__decap_6
XFILLER_0_93_769 VGND VGND VPWR VPWR sky130_ef_sc_hd__decap_12
XFILLER_0_5_281 VGND VGND VPWR VPWR sky130_ef_sc_hd__decap_12
XFILLER_0_6_793 VGND VGND VPWR VPWR sky130_fd_sc_hd__fill_2
XFILLER_0_69_755 VGND VGND VPWR VPWR sky130_fd_sc_hd__fill_1
XFILLER_0_84_703 VGND VGND VPWR VPWR sky130_ef_sc_hd__decap_12
XFILLER_0_110_727 VGND VGND VPWR VPWR sky130_fd_sc_hd__fill_1
XFILLER_0_75_703 VGND VGND VPWR VPWR sky130_ef_sc_hd__decap_12
XFILLER_0_75_769 VGND VGND VPWR VPWR sky130_ef_sc_hd__decap_12
XFILLER_0_101_727 VGND VGND VPWR VPWR sky130_ef_sc_hd__decap_12
XFILLER_0_2_251 VGND VGND VPWR VPWR sky130_fd_sc_hd__fill_1
XFILLER_0_3_741 VGND VGND VPWR VPWR sky130_ef_sc_hd__decap_12
XFILLER_0_3_785 VGND VGND VPWR VPWR sky130_ef_sc_hd__decap_12
XFILLER_0_81_739 VGND VGND VPWR VPWR sky130_ef_sc_hd__decap_12
XFILLER_0_66_703 VGND VGND VPWR VPWR sky130_ef_sc_hd__decap_12
XFILLER_0_57_703 VGND VGND VPWR VPWR sky130_ef_sc_hd__decap_12
XFILLER_0_57_769 VGND VGND VPWR VPWR sky130_ef_sc_hd__decap_12
XFILLER_0_80_783 VGND VGND VPWR VPWR sky130_fd_sc_hd__fill_1
XFILLER_0_63_739 VGND VGND VPWR VPWR sky130_ef_sc_hd__decap_12
XFILLER_0_48_703 VGND VGND VPWR VPWR sky130_ef_sc_hd__decap_12
XPHY_300 VGND VGND VPWR VPWR sky130_fd_sc_hd__decap_3
XFILLER_0_39_703 VGND VGND VPWR VPWR sky130_ef_sc_hd__decap_12
XPHY_311 VGND VGND VPWR VPWR sky130_fd_sc_hd__decap_3
XFILLER_0_149_793 VGND VGND VPWR VPWR sky130_fd_sc_hd__decap_8
XFILLER_0_39_769 VGND VGND VPWR VPWR sky130_ef_sc_hd__decap_12
XANTENNA_9 BEN[17] VGND VGND VPWR VPWR sky130_fd_sc_hd__diode_2
XFILLER_0_62_783 VGND VGND VPWR VPWR sky130_fd_sc_hd__fill_1
XTAP_319 VGND VPWR sky130_fd_sc_hd__tapvpwrvgnd_1
XFILLER_0_155_785 VGND VGND VPWR VPWR sky130_fd_sc_hd__fill_2
XFILLER_0_45_739 VGND VGND VPWR VPWR sky130_ef_sc_hd__decap_12
XFILLER_0_4_357 VGND VGND VPWR VPWR sky130_fd_sc_hd__decap_6
XFILLER_0_0_596 VGND VGND VPWR VPWR sky130_ef_sc_hd__decap_12
XFILLER_0_146_785 VGND VGND VPWR VPWR sky130_ef_sc_hd__decap_12
XFILLER_0_146_741 VGND VGND VPWR VPWR sky130_ef_sc_hd__decap_12
XFILLER_0_8_641 VGND VGND VPWR VPWR sky130_fd_sc_hd__decap_3
XFILLER_0_8_685 VGND VGND VPWR VPWR sky130_ef_sc_hd__decap_12
XFILLER_0_44_783 VGND VGND VPWR VPWR sky130_fd_sc_hd__fill_1
XPHY_152 VGND VGND VPWR VPWR sky130_fd_sc_hd__decap_3
XPHY_141 VGND VGND VPWR VPWR sky130_fd_sc_hd__decap_3
XPHY_130 VGND VGND VPWR VPWR sky130_fd_sc_hd__decap_3
XFILLER_0_152_755 VGND VGND VPWR VPWR sky130_fd_sc_hd__fill_2
XPHY_196 VGND VGND VPWR VPWR sky130_fd_sc_hd__decap_3
XPHY_185 VGND VGND VPWR VPWR sky130_fd_sc_hd__decap_3
XPHY_174 VGND VGND VPWR VPWR sky130_fd_sc_hd__decap_3
XPHY_163 VGND VGND VPWR VPWR sky130_fd_sc_hd__decap_3
XFILLER_0_50_753 VGND VGND VPWR VPWR sky130_ef_sc_hd__decap_12
XFILLER_0_1_305 VGND VGND VPWR VPWR sky130_ef_sc_hd__decap_12
XFILLER_0_27_739 VGND VGND VPWR VPWR sky130_ef_sc_hd__decap_12
XFILLER_0_50_797 VGND VGND VPWR VPWR sky130_fd_sc_hd__decap_4
XFILLER_0_1_349 VGND VGND VPWR VPWR sky130_ef_sc_hd__decap_12
XFILLER_0_128_785 VGND VGND VPWR VPWR sky130_ef_sc_hd__decap_12
XFILLER_0_128_741 VGND VGND VPWR VPWR sky130_ef_sc_hd__decap_12
XFILLER_0_143_755 VGND VGND VPWR VPWR sky130_fd_sc_hd__fill_1
XFILLER_0_4_121 VGND VGND VPWR VPWR sky130_ef_sc_hd__decap_12
XFILLER_0_4_165 VGND VGND VPWR VPWR sky130_ef_sc_hd__decap_12
XFILLER_0_7_31 VGND VGND VPWR VPWR sky130_fd_sc_hd__decap_4
XFILLER_0_7_53 VGND VGND VPWR VPWR sky130_fd_sc_hd__decap_3
XFILLER_0_26_783 VGND VGND VPWR VPWR sky130_fd_sc_hd__fill_1
XTAP_683 VGND VPWR sky130_fd_sc_hd__tapvpwrvgnd_1
XTAP_672 VGND VPWR sky130_fd_sc_hd__tapvpwrvgnd_1
XTAP_661 VGND VPWR sky130_fd_sc_hd__tapvpwrvgnd_1
XTAP_650 VGND VPWR sky130_fd_sc_hd__tapvpwrvgnd_1
XFILLER_0_0_371 VGND VGND VPWR VPWR sky130_ef_sc_hd__decap_12
XFILLER_0_134_777 VGND VGND VPWR VPWR sky130_fd_sc_hd__decap_6
XFILLER_0_32_753 VGND VGND VPWR VPWR sky130_ef_sc_hd__decap_12
XFILLER_0_32_797 VGND VGND VPWR VPWR sky130_fd_sc_hd__decap_4
XFILLER_0_6_419 VGND VGND VPWR VPWR sky130_fd_sc_hd__fill_1
XFILLER_0_125_755 VGND VGND VPWR VPWR sky130_fd_sc_hd__fill_1
XFILLER_0_2_669 VGND VGND VPWR VPWR sky130_ef_sc_hd__decap_12
XFILLER_0_2_625 VGND VGND VPWR VPWR sky130_ef_sc_hd__decap_12
XFILLER_0_1_113 VGND VGND VPWR VPWR sky130_ef_sc_hd__decap_12
XFILLER_0_131_703 VGND VGND VPWR VPWR sky130_ef_sc_hd__decap_12
XFILLER_0_116_777 VGND VGND VPWR VPWR sky130_fd_sc_hd__decap_6
XFILLER_0_5_441 VGND VGND VPWR VPWR sky130_fd_sc_hd__decap_6
XFILLER_0_131_769 VGND VGND VPWR VPWR sky130_ef_sc_hd__decap_12
XFILLER_0_0_9 VGND VGND VPWR VPWR sky130_fd_sc_hd__fill_2
XFILLER_0_5_485 VGND VGND VPWR VPWR sky130_ef_sc_hd__decap_12
XFILLER_0_14_753 VGND VGND VPWR VPWR sky130_ef_sc_hd__decap_12
XFILLER_0_14_797 VGND VGND VPWR VPWR sky130_fd_sc_hd__decap_4
XTAP_480 VGND VPWR sky130_fd_sc_hd__tapvpwrvgnd_1
XTAP_491 VGND VPWR sky130_fd_sc_hd__tapvpwrvgnd_1
XFILLER_0_122_703 VGND VGND VPWR VPWR sky130_ef_sc_hd__decap_12
XFILLER_0_107_755 VGND VGND VPWR VPWR sky130_fd_sc_hd__fill_1
XFILLER_0_113_703 VGND VGND VPWR VPWR sky130_ef_sc_hd__decap_12
XFILLER_0_113_769 VGND VGND VPWR VPWR sky130_ef_sc_hd__decap_12
XFILLER_0_2_477 VGND VGND VPWR VPWR sky130_ef_sc_hd__decap_12
XFILLER_0_2_433 VGND VGND VPWR VPWR sky130_ef_sc_hd__decap_12
XFILLER_0_4_21 VGND VGND VPWR VPWR sky130_fd_sc_hd__decap_4
XFILLER_0_4_43 VGND VGND VPWR VPWR sky130_fd_sc_hd__fill_2
XFILLER_0_93_715 VGND VGND VPWR VPWR sky130_ef_sc_hd__decap_12
XFILLER_0_104_703 VGND VGND VPWR VPWR sky130_ef_sc_hd__decap_12
XFILLER_0_5_293 VGND VGND VPWR VPWR sky130_ef_sc_hd__decap_12
XFILLER_0_84_715 VGND VGND VPWR VPWR sky130_ef_sc_hd__decap_12
XFILLER_0_75_715 VGND VGND VPWR VPWR sky130_ef_sc_hd__decap_12
XFILLER_0_7_503 VGND VGND VPWR VPWR sky130_fd_sc_hd__fill_1
XFILLER_0_90_729 VGND VGND VPWR VPWR sky130_ef_sc_hd__decap_12
XFILLER_0_83_781 VGND VGND VPWR VPWR sky130_ef_sc_hd__decap_12
XFILLER_0_3_753 VGND VGND VPWR VPWR sky130_ef_sc_hd__decap_12
XFILLER_0_101_739 VGND VGND VPWR VPWR sky130_ef_sc_hd__decap_12
XFILLER_0_3_797 VGND VGND VPWR VPWR sky130_fd_sc_hd__decap_4
XFILLER_0_66_715 VGND VGND VPWR VPWR sky130_ef_sc_hd__decap_12
XFILLER_0_100_783 VGND VGND VPWR VPWR sky130_fd_sc_hd__fill_1
XFILLER_0_57_715 VGND VGND VPWR VPWR sky130_ef_sc_hd__decap_12
XFILLER_0_72_729 VGND VGND VPWR VPWR sky130_ef_sc_hd__decap_12
XFILLER_0_65_781 VGND VGND VPWR VPWR sky130_ef_sc_hd__decap_12
XFILLER_0_0_789 VGND VGND VPWR VPWR sky130_fd_sc_hd__fill_1
XFILLER_0_0_701 VGND VGND VPWR VPWR sky130_ef_sc_hd__decap_12
XFILLER_0_1_55 VGND VGND VPWR VPWR sky130_fd_sc_hd__fill_1
XFILLER_0_48_715 VGND VGND VPWR VPWR sky130_ef_sc_hd__decap_12
XFILLER_0_71_751 VGND VGND VPWR VPWR sky130_fd_sc_hd__decap_4
XFILLER_0_3_561 VGND VGND VPWR VPWR sky130_ef_sc_hd__decap_12
XPHY_301 VGND VGND VPWR VPWR sky130_fd_sc_hd__decap_3
XFILLER_0_39_715 VGND VGND VPWR VPWR sky130_ef_sc_hd__decap_12
XFILLER_0_54_729 VGND VGND VPWR VPWR sky130_ef_sc_hd__decap_12
XFILLER_0_47_781 VGND VGND VPWR VPWR sky130_ef_sc_hd__decap_12
XFILLER_0_155_753 VGND VGND VPWR VPWR sky130_fd_sc_hd__decap_3
XFILLER_0_53_751 VGND VGND VPWR VPWR sky130_fd_sc_hd__decap_4
XFILLER_0_146_797 VGND VGND VPWR VPWR sky130_fd_sc_hd__decap_4
XFILLER_0_146_753 VGND VGND VPWR VPWR sky130_ef_sc_hd__decap_12
XFILLER_0_8_697 VGND VGND VPWR VPWR sky130_fd_sc_hd__decap_3
XFILLER_0_29_781 VGND VGND VPWR VPWR sky130_ef_sc_hd__decap_12
XFILLER_0_36_729 VGND VGND VPWR VPWR sky130_ef_sc_hd__decap_12
XFILLER_0_3_391 VGND VGND VPWR VPWR sky130_fd_sc_hd__fill_1
XPHY_175 VGND VGND VPWR VPWR sky130_fd_sc_hd__decap_3
XPHY_164 VGND VGND VPWR VPWR sky130_fd_sc_hd__decap_3
XPHY_153 VGND VGND VPWR VPWR sky130_fd_sc_hd__decap_3
XPHY_142 VGND VGND VPWR VPWR sky130_fd_sc_hd__decap_3
XPHY_131 VGND VGND VPWR VPWR sky130_fd_sc_hd__decap_3
XPHY_120 VGND VGND VPWR VPWR sky130_fd_sc_hd__decap_3
XPHY_197 VGND VGND VPWR VPWR sky130_fd_sc_hd__decap_3
XPHY_186 VGND VGND VPWR VPWR sky130_fd_sc_hd__decap_3
XFILLER_0_50_765 VGND VGND VPWR VPWR sky130_ef_sc_hd__decap_12
XFILLER_0_1_317 VGND VGND VPWR VPWR sky130_ef_sc_hd__decap_12
XFILLER_0_35_751 VGND VGND VPWR VPWR sky130_fd_sc_hd__decap_4
XPHY_0 VGND VGND VPWR VPWR sky130_fd_sc_hd__decap_3
XFILLER_0_128_797 VGND VGND VPWR VPWR sky130_fd_sc_hd__decap_4
XFILLER_0_128_753 VGND VGND VPWR VPWR sky130_ef_sc_hd__decap_12
XFILLER_0_4_133 VGND VGND VPWR VPWR sky130_fd_sc_hd__decap_6
XFILLER_0_18_729 VGND VGND VPWR VPWR sky130_ef_sc_hd__decap_12
XFILLER_0_4_177 VGND VGND VPWR VPWR sky130_ef_sc_hd__decap_12
XTAP_684 VGND VPWR sky130_fd_sc_hd__tapvpwrvgnd_1
XTAP_673 VGND VPWR sky130_fd_sc_hd__tapvpwrvgnd_1
XTAP_662 VGND VPWR sky130_fd_sc_hd__tapvpwrvgnd_1
XTAP_651 VGND VPWR sky130_fd_sc_hd__tapvpwrvgnd_1
XTAP_640 VGND VPWR sky130_fd_sc_hd__tapvpwrvgnd_1
XFILLER_0_0_383 VGND VGND VPWR VPWR sky130_fd_sc_hd__decap_8
XFILLER_0_8_461 VGND VGND VPWR VPWR sky130_ef_sc_hd__decap_12
XFILLER_0_17_751 VGND VGND VPWR VPWR sky130_fd_sc_hd__decap_4
XFILLER_0_32_765 VGND VGND VPWR VPWR sky130_ef_sc_hd__decap_12
XFILLER_0_7_3 VGND VGND VPWR VPWR sky130_fd_sc_hd__decap_4
XFILLER_0_2_637 VGND VGND VPWR VPWR sky130_fd_sc_hd__decap_6
XFILLER_0_1_125 VGND VGND VPWR VPWR sky130_ef_sc_hd__decap_12
XFILLER_0_1_169 VGND VGND VPWR VPWR sky130_ef_sc_hd__decap_12
XFILLER_0_131_715 VGND VGND VPWR VPWR sky130_ef_sc_hd__decap_12
XFILLER_0_5_497 VGND VGND VPWR VPWR sky130_fd_sc_hd__decap_6
XFILLER_0_14_765 VGND VGND VPWR VPWR sky130_ef_sc_hd__decap_12
XTAP_470 VGND VPWR sky130_fd_sc_hd__tapvpwrvgnd_1
XTAP_481 VGND VPWR sky130_fd_sc_hd__tapvpwrvgnd_1
XTAP_492 VGND VPWR sky130_fd_sc_hd__tapvpwrvgnd_1
XFILLER_0_9_781 VGND VGND VPWR VPWR sky130_ef_sc_hd__decap_12
XFILLER_0_122_715 VGND VGND VPWR VPWR sky130_ef_sc_hd__decap_12
XFILLER_0_87_757 VGND VGND VPWR VPWR sky130_ef_sc_hd__decap_12
XFILLER_0_113_715 VGND VGND VPWR VPWR sky130_ef_sc_hd__decap_12
XFILLER_0_2_401 VGND VGND VPWR VPWR sky130_ef_sc_hd__decap_12
XFILLER_0_7_729 VGND VGND VPWR VPWR sky130_ef_sc_hd__decap_12
XFILLER_0_121_781 VGND VGND VPWR VPWR sky130_ef_sc_hd__decap_12
XFILLER_0_2_489 VGND VGND VPWR VPWR sky130_ef_sc_hd__decap_12
XFILLER_0_2_445 VGND VGND VPWR VPWR sky130_ef_sc_hd__decap_12
XFILLER_0_11_757 VGND VGND VPWR VPWR sky130_ef_sc_hd__decap_12
XFILLER_0_93_727 VGND VGND VPWR VPWR sky130_ef_sc_hd__decap_12
XFILLER_0_104_715 VGND VGND VPWR VPWR sky130_ef_sc_hd__decap_12
XFILLER_0_5_261 VGND VGND VPWR VPWR sky130_ef_sc_hd__decap_12
XFILLER_0_84_727 VGND VGND VPWR VPWR sky130_fd_sc_hd__fill_1
XFILLER_0_69_757 VGND VGND VPWR VPWR sky130_ef_sc_hd__decap_12
XFILLER_0_110_729 VGND VGND VPWR VPWR sky130_ef_sc_hd__decap_12
XFILLER_0_103_781 VGND VGND VPWR VPWR sky130_ef_sc_hd__decap_12
XFILLER_0_75_727 VGND VGND VPWR VPWR sky130_ef_sc_hd__decap_12
XFILLER_0_83_793 VGND VGND VPWR VPWR sky130_fd_sc_hd__decap_8
XFILLER_0_2_253 VGND VGND VPWR VPWR sky130_ef_sc_hd__decap_12
XFILLER_0_3_721 VGND VGND VPWR VPWR sky130_fd_sc_hd__decap_6
XFILLER_0_3_765 VGND VGND VPWR VPWR sky130_ef_sc_hd__decap_12
XFILLER_0_7_559 VGND VGND VPWR VPWR sky130_fd_sc_hd__fill_1
XFILLER_0_66_727 VGND VGND VPWR VPWR sky130_fd_sc_hd__fill_1
XFILLER_0_6_581 VGND VGND VPWR VPWR sky130_fd_sc_hd__decap_6
XFILLER_0_57_727 VGND VGND VPWR VPWR sky130_ef_sc_hd__decap_12
XFILLER_0_80_785 VGND VGND VPWR VPWR sky130_ef_sc_hd__decap_12
XFILLER_0_80_741 VGND VGND VPWR VPWR sky130_ef_sc_hd__decap_12
XFILLER_0_65_793 VGND VGND VPWR VPWR sky130_fd_sc_hd__decap_8
XFILLER_0_0_713 VGND VGND VPWR VPWR sky130_fd_sc_hd__fill_2
XFILLER_0_0_757 VGND VGND VPWR VPWR sky130_fd_sc_hd__decap_8
XFILLER_0_0_746 VGND VGND VPWR VPWR sky130_fd_sc_hd__decap_8
XFILLER_0_48_727 VGND VGND VPWR VPWR sky130_fd_sc_hd__fill_1
XFILLER_0_3_573 VGND VGND VPWR VPWR sky130_ef_sc_hd__decap_12
XPHY_302 VGND VGND VPWR VPWR sky130_fd_sc_hd__decap_3
XFILLER_0_39_727 VGND VGND VPWR VPWR sky130_ef_sc_hd__decap_12
XFILLER_0_62_785 VGND VGND VPWR VPWR sky130_ef_sc_hd__decap_12
XFILLER_0_62_741 VGND VGND VPWR VPWR sky130_ef_sc_hd__decap_12
XFILLER_0_47_793 VGND VGND VPWR VPWR sky130_fd_sc_hd__decap_8
XFILLER_0_155_765 VGND VGND VPWR VPWR sky130_fd_sc_hd__fill_2
XFILLER_0_8_109 VGND VGND VPWR VPWR sky130_fd_sc_hd__decap_3
XFILLER_0_38_793 VGND VGND VPWR VPWR sky130_fd_sc_hd__fill_2
XFILLER_0_0_521 VGND VGND VPWR VPWR sky130_fd_sc_hd__decap_8
XFILLER_0_0_587 VGND VGND VPWR VPWR sky130_fd_sc_hd__fill_1
XFILLER_0_146_765 VGND VGND VPWR VPWR sky130_ef_sc_hd__decap_12
XFILLER_0_44_785 VGND VGND VPWR VPWR sky130_ef_sc_hd__decap_12
XFILLER_0_44_741 VGND VGND VPWR VPWR sky130_ef_sc_hd__decap_12
XFILLER_0_29_793 VGND VGND VPWR VPWR sky130_fd_sc_hd__decap_8
XPHY_198 VGND VGND VPWR VPWR sky130_fd_sc_hd__decap_3
XPHY_187 VGND VGND VPWR VPWR sky130_fd_sc_hd__decap_3
XPHY_176 VGND VGND VPWR VPWR sky130_fd_sc_hd__decap_3
XPHY_165 VGND VGND VPWR VPWR sky130_fd_sc_hd__decap_3
XPHY_154 VGND VGND VPWR VPWR sky130_fd_sc_hd__decap_3
XPHY_143 VGND VGND VPWR VPWR sky130_fd_sc_hd__decap_3
XPHY_132 VGND VGND VPWR VPWR sky130_fd_sc_hd__decap_3
XPHY_121 VGND VGND VPWR VPWR sky130_fd_sc_hd__decap_3
XPHY_110 VGND VGND VPWR VPWR sky130_fd_sc_hd__decap_3
XFILLER_0_152_735 VGND VGND VPWR VPWR sky130_fd_sc_hd__fill_2
XFILLER_0_50_777 VGND VGND VPWR VPWR sky130_fd_sc_hd__decap_6
XFILLER_0_1_329 VGND VGND VPWR VPWR sky130_fd_sc_hd__decap_6
XPHY_1 VGND VGND VPWR VPWR sky130_fd_sc_hd__decap_3
XFILLER_0_143_757 VGND VGND VPWR VPWR sky130_ef_sc_hd__decap_12
XFILLER_0_128_765 VGND VGND VPWR VPWR sky130_ef_sc_hd__decap_12
XFILLER_0_26_741 VGND VGND VPWR VPWR sky130_ef_sc_hd__decap_12
XFILLER_0_26_785 VGND VGND VPWR VPWR sky130_ef_sc_hd__decap_12
XTAP_652 VGND VPWR sky130_fd_sc_hd__tapvpwrvgnd_1
XTAP_641 VGND VPWR sky130_fd_sc_hd__tapvpwrvgnd_1
XTAP_630 VGND VPWR sky130_fd_sc_hd__tapvpwrvgnd_1
XFILLER_0_4_189 VGND VGND VPWR VPWR sky130_fd_sc_hd__decap_6
XFILLER_0_41_755 VGND VGND VPWR VPWR sky130_fd_sc_hd__fill_1
XTAP_685 VGND VPWR sky130_fd_sc_hd__tapvpwrvgnd_1
XTAP_674 VGND VPWR sky130_fd_sc_hd__tapvpwrvgnd_1
XTAP_663 VGND VPWR sky130_fd_sc_hd__tapvpwrvgnd_1
XFILLER_0_8_473 VGND VGND VPWR VPWR sky130_fd_sc_hd__decap_3
XFILLER_0_32_777 VGND VGND VPWR VPWR sky130_fd_sc_hd__decap_6
XFILLER_0_99_755 VGND VGND VPWR VPWR sky130_fd_sc_hd__fill_1
XFILLER_0_125_757 VGND VGND VPWR VPWR sky130_ef_sc_hd__decap_12
XFILLER_0_140_727 VGND VGND VPWR VPWR sky130_fd_sc_hd__fill_1
XFILLER_0_1_137 VGND VGND VPWR VPWR sky130_ef_sc_hd__decap_12
XFILLER_0_23_755 VGND VGND VPWR VPWR sky130_fd_sc_hd__fill_1
XFILLER_0_131_727 VGND VGND VPWR VPWR sky130_ef_sc_hd__decap_12
XFILLER_0_14_777 VGND VGND VPWR VPWR sky130_fd_sc_hd__decap_6
XFILLER_0_1_671 VGND VGND VPWR VPWR sky130_fd_sc_hd__fill_1
XTAP_460 VGND VPWR sky130_fd_sc_hd__tapvpwrvgnd_1
XTAP_471 VGND VPWR sky130_fd_sc_hd__tapvpwrvgnd_1
XTAP_482 VGND VPWR sky130_fd_sc_hd__tapvpwrvgnd_1
XTAP_493 VGND VPWR sky130_fd_sc_hd__tapvpwrvgnd_1
XFILLER_0_96_703 VGND VGND VPWR VPWR sky130_ef_sc_hd__decap_12
XFILLER_0_107_757 VGND VGND VPWR VPWR sky130_ef_sc_hd__decap_12
XFILLER_0_8_281 VGND VGND VPWR VPWR sky130_ef_sc_hd__decap_12
XFILLER_0_9_793 VGND VGND VPWR VPWR sky130_fd_sc_hd__decap_8
XFILLER_0_122_727 VGND VGND VPWR VPWR sky130_fd_sc_hd__fill_1
XFILLER_0_20_703 VGND VGND VPWR VPWR sky130_ef_sc_hd__decap_12
XFILLER_0_87_703 VGND VGND VPWR VPWR sky130_ef_sc_hd__decap_12
XFILLER_0_87_769 VGND VGND VPWR VPWR sky130_ef_sc_hd__decap_12
XFILLER_0_113_727 VGND VGND VPWR VPWR sky130_ef_sc_hd__decap_12
XFILLER_0_2_457 VGND VGND VPWR VPWR sky130_ef_sc_hd__decap_12
XFILLER_0_2_413 VGND VGND VPWR VPWR sky130_fd_sc_hd__decap_6
XFILLER_0_11_703 VGND VGND VPWR VPWR sky130_ef_sc_hd__decap_12
XFILLER_0_121_793 VGND VGND VPWR VPWR sky130_fd_sc_hd__decap_8
XFILLER_0_11_769 VGND VGND VPWR VPWR sky130_ef_sc_hd__decap_12
XFILLER_0_78_703 VGND VGND VPWR VPWR sky130_ef_sc_hd__decap_12
XFILLER_0_93_739 VGND VGND VPWR VPWR sky130_ef_sc_hd__decap_12
XFILLER_0_104_727 VGND VGND VPWR VPWR sky130_fd_sc_hd__fill_1
XFILLER_0_5_273 VGND VGND VPWR VPWR sky130_fd_sc_hd__decap_6
XFILLER_0_69_703 VGND VGND VPWR VPWR sky130_ef_sc_hd__decap_12
XFILLER_0_69_769 VGND VGND VPWR VPWR sky130_ef_sc_hd__decap_12
XFILLER_0_92_783 VGND VGND VPWR VPWR sky130_fd_sc_hd__fill_1
XFILLER_0_103_793 VGND VGND VPWR VPWR sky130_fd_sc_hd__decap_8
XFILLER_0_75_739 VGND VGND VPWR VPWR sky130_ef_sc_hd__decap_12
XFILLER_0_7_505 VGND VGND VPWR VPWR sky130_ef_sc_hd__decap_12
XFILLER_0_2_265 VGND VGND VPWR VPWR sky130_ef_sc_hd__decap_12
XFILLER_0_2_221 VGND VGND VPWR VPWR sky130_ef_sc_hd__decap_12
XFILLER_0_3_777 VGND VGND VPWR VPWR sky130_fd_sc_hd__decap_6
XFILLER_0_74_783 VGND VGND VPWR VPWR sky130_fd_sc_hd__fill_1
XFILLER_0_100_785 VGND VGND VPWR VPWR sky130_ef_sc_hd__decap_12
XFILLER_0_100_741 VGND VGND VPWR VPWR sky130_ef_sc_hd__decap_12
XFILLER_0_57_739 VGND VGND VPWR VPWR sky130_ef_sc_hd__decap_12
XFILLER_0_80_797 VGND VGND VPWR VPWR sky130_fd_sc_hd__decap_4
XFILLER_0_80_753 VGND VGND VPWR VPWR sky130_ef_sc_hd__decap_12
XFILLER_0_1_57 VGND VGND VPWR VPWR sky130_ef_sc_hd__decap_12
XFILLER_0_56_783 VGND VGND VPWR VPWR sky130_fd_sc_hd__fill_1
XFILLER_0_7_335 VGND VGND VPWR VPWR sky130_fd_sc_hd__fill_1
XFILLER_0_3_541 VGND VGND VPWR VPWR sky130_ef_sc_hd__decap_12
XFILLER_0_3_585 VGND VGND VPWR VPWR sky130_ef_sc_hd__decap_12
XPHY_303 VGND VGND VPWR VPWR sky130_fd_sc_hd__decap_3
XFILLER_0_39_739 VGND VGND VPWR VPWR sky130_ef_sc_hd__decap_12
XFILLER_0_62_797 VGND VGND VPWR VPWR sky130_fd_sc_hd__decap_4
XFILLER_0_62_753 VGND VGND VPWR VPWR sky130_ef_sc_hd__decap_12
XFILLER_0_155_777 VGND VGND VPWR VPWR sky130_fd_sc_hd__decap_3
XFILLER_0_38_783 VGND VGND VPWR VPWR sky130_fd_sc_hd__fill_1
XFILLER_0_0_533 VGND VGND VPWR VPWR sky130_fd_sc_hd__decap_6
XFILLER_0_146_777 VGND VGND VPWR VPWR sky130_fd_sc_hd__decap_6
XFILLER_0_44_797 VGND VGND VPWR VPWR sky130_fd_sc_hd__decap_4
XFILLER_0_44_753 VGND VGND VPWR VPWR sky130_ef_sc_hd__decap_12
XFILLER_0_3_393 VGND VGND VPWR VPWR sky130_ef_sc_hd__decap_12
XPHY_100 VGND VGND VPWR VPWR sky130_fd_sc_hd__decap_3
XFILLER_0_152_747 VGND VGND VPWR VPWR sky130_fd_sc_hd__fill_2
XFILLER_0_137_755 VGND VGND VPWR VPWR sky130_fd_sc_hd__fill_1
XPHY_199 VGND VGND VPWR VPWR sky130_fd_sc_hd__decap_3
XPHY_188 VGND VGND VPWR VPWR sky130_fd_sc_hd__decap_3
XPHY_177 VGND VGND VPWR VPWR sky130_fd_sc_hd__decap_3
XPHY_166 VGND VGND VPWR VPWR sky130_fd_sc_hd__decap_3
XPHY_155 VGND VGND VPWR VPWR sky130_fd_sc_hd__decap_3
XPHY_144 VGND VGND VPWR VPWR sky130_fd_sc_hd__decap_3
XPHY_133 VGND VGND VPWR VPWR sky130_fd_sc_hd__decap_3
XPHY_122 VGND VGND VPWR VPWR sky130_fd_sc_hd__decap_3
XPHY_111 VGND VGND VPWR VPWR sky130_fd_sc_hd__decap_3
XPHY_2 VGND VGND VPWR VPWR sky130_fd_sc_hd__decap_3
XFILLER_0_143_769 VGND VGND VPWR VPWR sky130_ef_sc_hd__decap_12
XFILLER_0_143_703 VGND VGND VPWR VPWR sky130_ef_sc_hd__decap_12
XFILLER_0_128_777 VGND VGND VPWR VPWR sky130_fd_sc_hd__decap_6
XFILLER_0_7_23 VGND VGND VPWR VPWR sky130_fd_sc_hd__fill_2
XFILLER_0_7_45 VGND VGND VPWR VPWR sky130_fd_sc_hd__fill_2
XFILLER_0_26_753 VGND VGND VPWR VPWR sky130_ef_sc_hd__decap_12
XFILLER_0_26_797 VGND VGND VPWR VPWR sky130_fd_sc_hd__decap_4
XTAP_686 VGND VPWR sky130_fd_sc_hd__tapvpwrvgnd_1
XTAP_675 VGND VPWR sky130_fd_sc_hd__tapvpwrvgnd_1
XTAP_664 VGND VPWR sky130_fd_sc_hd__tapvpwrvgnd_1
XTAP_653 VGND VPWR sky130_fd_sc_hd__tapvpwrvgnd_1
XTAP_642 VGND VPWR sky130_fd_sc_hd__tapvpwrvgnd_1
XTAP_631 VGND VPWR sky130_fd_sc_hd__tapvpwrvgnd_1
XTAP_620 VGND VPWR sky130_fd_sc_hd__tapvpwrvgnd_1
XFILLER_0_134_703 VGND VGND VPWR VPWR sky130_ef_sc_hd__decap_12
XFILLER_0_119_755 VGND VGND VPWR VPWR sky130_fd_sc_hd__fill_1
XFILLER_0_125_769 VGND VGND VPWR VPWR sky130_ef_sc_hd__decap_12
XFILLER_0_125_703 VGND VGND VPWR VPWR sky130_ef_sc_hd__decap_12
XFILLER_0_1_105 VGND VGND VPWR VPWR sky130_fd_sc_hd__decap_6
XFILLER_0_1_149 VGND VGND VPWR VPWR sky130_ef_sc_hd__decap_12
XFILLER_0_116_703 VGND VGND VPWR VPWR sky130_ef_sc_hd__decap_12
XFILLER_0_131_739 VGND VGND VPWR VPWR sky130_ef_sc_hd__decap_12
XTAP_450 VGND VPWR sky130_fd_sc_hd__tapvpwrvgnd_1
XTAP_461 VGND VPWR sky130_fd_sc_hd__tapvpwrvgnd_1
XTAP_472 VGND VPWR sky130_fd_sc_hd__tapvpwrvgnd_1
XTAP_483 VGND VPWR sky130_fd_sc_hd__tapvpwrvgnd_1
XTAP_494 VGND VPWR sky130_fd_sc_hd__tapvpwrvgnd_1
XFILLER_0_96_715 VGND VGND VPWR VPWR sky130_ef_sc_hd__decap_12
XFILLER_0_107_769 VGND VGND VPWR VPWR sky130_ef_sc_hd__decap_12
XFILLER_0_107_703 VGND VGND VPWR VPWR sky130_ef_sc_hd__decap_12
XFILLER_0_8_293 VGND VGND VPWR VPWR sky130_ef_sc_hd__decap_12
XFILLER_0_130_783 VGND VGND VPWR VPWR sky130_fd_sc_hd__fill_1
XFILLER_0_20_715 VGND VGND VPWR VPWR sky130_ef_sc_hd__decap_12
XFILLER_0_87_715 VGND VGND VPWR VPWR sky130_ef_sc_hd__decap_12
XFILLER_0_95_781 VGND VGND VPWR VPWR sky130_ef_sc_hd__decap_12
XFILLER_0_7_709 VGND VGND VPWR VPWR sky130_ef_sc_hd__decap_12
XFILLER_0_113_739 VGND VGND VPWR VPWR sky130_ef_sc_hd__decap_12
XFILLER_0_2_469 VGND VGND VPWR VPWR sky130_fd_sc_hd__decap_6
XFILLER_0_11_715 VGND VGND VPWR VPWR sky130_ef_sc_hd__decap_12
XFILLER_0_4_35 VGND VGND VPWR VPWR sky130_fd_sc_hd__fill_2
XFILLER_0_78_715 VGND VGND VPWR VPWR sky130_ef_sc_hd__decap_12
XFILLER_0_112_783 VGND VGND VPWR VPWR sky130_fd_sc_hd__fill_1
XFILLER_0_69_715 VGND VGND VPWR VPWR sky130_ef_sc_hd__decap_12
XFILLER_0_84_729 VGND VGND VPWR VPWR sky130_ef_sc_hd__decap_12
XFILLER_0_77_781 VGND VGND VPWR VPWR sky130_ef_sc_hd__decap_12
XFILLER_0_83_751 VGND VGND VPWR VPWR sky130_fd_sc_hd__decap_4
XFILLER_0_7_517 VGND VGND VPWR VPWR sky130_ef_sc_hd__decap_12
XFILLER_0_2_277 VGND VGND VPWR VPWR sky130_ef_sc_hd__decap_12
XFILLER_0_2_233 VGND VGND VPWR VPWR sky130_ef_sc_hd__decap_12
XFILLER_0_66_729 VGND VGND VPWR VPWR sky130_ef_sc_hd__decap_12
XFILLER_0_59_781 VGND VGND VPWR VPWR sky130_ef_sc_hd__decap_12
XFILLER_0_100_797 VGND VGND VPWR VPWR sky130_fd_sc_hd__decap_4
XFILLER_0_100_753 VGND VGND VPWR VPWR sky130_ef_sc_hd__decap_12
XFILLER_0_65_751 VGND VGND VPWR VPWR sky130_fd_sc_hd__decap_4
XFILLER_0_80_765 VGND VGND VPWR VPWR sky130_ef_sc_hd__decap_12
XFILLER_0_0_737 VGND VGND VPWR VPWR sky130_fd_sc_hd__decap_3
XFILLER_0_48_729 VGND VGND VPWR VPWR sky130_ef_sc_hd__decap_12
XFILLER_0_1_69 VGND VGND VPWR VPWR sky130_ef_sc_hd__decap_12
XFILLER_0_3_553 VGND VGND VPWR VPWR sky130_fd_sc_hd__decap_6
XFILLER_0_3_597 VGND VGND VPWR VPWR sky130_ef_sc_hd__decap_12
XPHY_304 VGND VGND VPWR VPWR sky130_fd_sc_hd__decap_3
XFILLER_0_47_751 VGND VGND VPWR VPWR sky130_fd_sc_hd__decap_4
XFILLER_0_62_765 VGND VGND VPWR VPWR sky130_ef_sc_hd__decap_12
XFILLER_0_155_789 VGND VGND VPWR VPWR sky130_fd_sc_hd__decap_8
XFILLER_0_155_745 VGND VGND VPWR VPWR sky130_fd_sc_hd__fill_2
XFILLER_0_0_589 VGND VGND VPWR VPWR sky130_fd_sc_hd__fill_1
XFILLER_0_7_111 VGND VGND VPWR VPWR sky130_fd_sc_hd__fill_1
XFILLER_0_8_601 VGND VGND VPWR VPWR sky130_ef_sc_hd__decap_12
XFILLER_0_8_645 VGND VGND VPWR VPWR sky130_ef_sc_hd__decap_12
XFILLER_0_29_751 VGND VGND VPWR VPWR sky130_fd_sc_hd__decap_4
XFILLER_0_44_765 VGND VGND VPWR VPWR sky130_ef_sc_hd__decap_12
XFILLER_0_3_361 VGND VGND VPWR VPWR sky130_ef_sc_hd__decap_12
XPHY_134 VGND VGND VPWR VPWR sky130_fd_sc_hd__decap_3
XPHY_123 VGND VGND VPWR VPWR sky130_fd_sc_hd__decap_3
XPHY_112 VGND VGND VPWR VPWR sky130_fd_sc_hd__decap_3
XPHY_101 VGND VGND VPWR VPWR sky130_fd_sc_hd__decap_3
XFILLER_0_152_759 VGND VGND VPWR VPWR sky130_ef_sc_hd__decap_12
XPHY_189 VGND VGND VPWR VPWR sky130_fd_sc_hd__decap_3
XPHY_178 VGND VGND VPWR VPWR sky130_fd_sc_hd__decap_3
XPHY_167 VGND VGND VPWR VPWR sky130_fd_sc_hd__decap_3
XPHY_156 VGND VGND VPWR VPWR sky130_fd_sc_hd__decap_3
XPHY_145 VGND VGND VPWR VPWR sky130_fd_sc_hd__decap_3
XFILLER_0_143_715 VGND VGND VPWR VPWR sky130_ef_sc_hd__decap_12
XPHY_3 VGND VGND VPWR VPWR sky130_fd_sc_hd__decap_3
XFILLER_0_151_781 VGND VGND VPWR VPWR sky130_ef_sc_hd__decap_12
XFILLER_0_5_615 VGND VGND VPWR VPWR sky130_fd_sc_hd__fill_1
XFILLER_0_7_57 VGND VGND VPWR VPWR sky130_ef_sc_hd__decap_12
XFILLER_0_26_765 VGND VGND VPWR VPWR sky130_ef_sc_hd__decap_12
XFILLER_0_41_757 VGND VGND VPWR VPWR sky130_ef_sc_hd__decap_12
XTAP_687 VGND VPWR sky130_fd_sc_hd__tapvpwrvgnd_1
XTAP_676 VGND VPWR sky130_fd_sc_hd__tapvpwrvgnd_1
XTAP_665 VGND VPWR sky130_fd_sc_hd__tapvpwrvgnd_1
XTAP_654 VGND VPWR sky130_fd_sc_hd__tapvpwrvgnd_1
XTAP_643 VGND VPWR sky130_fd_sc_hd__tapvpwrvgnd_1
XTAP_632 VGND VPWR sky130_fd_sc_hd__tapvpwrvgnd_1
XTAP_621 VGND VPWR sky130_fd_sc_hd__tapvpwrvgnd_1
XTAP_610 VGND VPWR sky130_fd_sc_hd__tapvpwrvgnd_1
XFILLER_0_134_715 VGND VGND VPWR VPWR sky130_ef_sc_hd__decap_12
XFILLER_0_4_681 VGND VGND VPWR VPWR sky130_ef_sc_hd__decap_12
XFILLER_0_99_757 VGND VGND VPWR VPWR sky130_ef_sc_hd__decap_12
XFILLER_0_140_729 VGND VGND VPWR VPWR sky130_ef_sc_hd__decap_12
XFILLER_0_133_781 VGND VGND VPWR VPWR sky130_ef_sc_hd__decap_12
XFILLER_0_125_715 VGND VGND VPWR VPWR sky130_ef_sc_hd__decap_12
XFILLER_0_23_757 VGND VGND VPWR VPWR sky130_ef_sc_hd__decap_12
XFILLER_0_116_715 VGND VGND VPWR VPWR sky130_ef_sc_hd__decap_12
XFILLER_0_1_673 VGND VGND VPWR VPWR sky130_ef_sc_hd__decap_12
XTAP_440 VGND VPWR sky130_fd_sc_hd__tapvpwrvgnd_1
XTAP_451 VGND VPWR sky130_fd_sc_hd__tapvpwrvgnd_1
XTAP_462 VGND VPWR sky130_fd_sc_hd__tapvpwrvgnd_1
XTAP_473 VGND VPWR sky130_fd_sc_hd__tapvpwrvgnd_1
XTAP_484 VGND VPWR sky130_fd_sc_hd__tapvpwrvgnd_1
XTAP_495 VGND VPWR sky130_fd_sc_hd__tapvpwrvgnd_1
XFILLER_0_96_727 VGND VGND VPWR VPWR sky130_fd_sc_hd__fill_1
XFILLER_0_9_751 VGND VGND VPWR VPWR sky130_fd_sc_hd__decap_4
XFILLER_0_122_729 VGND VGND VPWR VPWR sky130_ef_sc_hd__decap_12
XFILLER_0_115_781 VGND VGND VPWR VPWR sky130_ef_sc_hd__decap_12
XFILLER_0_107_715 VGND VGND VPWR VPWR sky130_ef_sc_hd__decap_12
XFILLER_0_20_727 VGND VGND VPWR VPWR sky130_fd_sc_hd__fill_1
XFILLER_0_87_727 VGND VGND VPWR VPWR sky130_ef_sc_hd__decap_12
XFILLER_0_95_793 VGND VGND VPWR VPWR sky130_fd_sc_hd__decap_8
XFILLER_0_6_209 VGND VGND VPWR VPWR sky130_ef_sc_hd__decap_12
XFILLER_0_121_751 VGND VGND VPWR VPWR sky130_fd_sc_hd__decap_4
XFILLER_0_11_727 VGND VGND VPWR VPWR sky130_ef_sc_hd__decap_12
XFILLER_0_4_25 VGND VGND VPWR VPWR sky130_fd_sc_hd__fill_1
XFILLER_0_4_47 VGND VGND VPWR VPWR sky130_fd_sc_hd__fill_2
XFILLER_0_78_727 VGND VGND VPWR VPWR sky130_fd_sc_hd__fill_1
XFILLER_0_104_729 VGND VGND VPWR VPWR sky130_ef_sc_hd__decap_12
XFILLER_0_69_727 VGND VGND VPWR VPWR sky130_ef_sc_hd__decap_12
XFILLER_0_92_785 VGND VGND VPWR VPWR sky130_ef_sc_hd__decap_12
XFILLER_0_92_741 VGND VGND VPWR VPWR sky130_ef_sc_hd__decap_12
XFILLER_0_77_793 VGND VGND VPWR VPWR sky130_fd_sc_hd__decap_8
XFILLER_0_103_751 VGND VGND VPWR VPWR sky130_fd_sc_hd__decap_4
XFILLER_0_7_529 VGND VGND VPWR VPWR sky130_ef_sc_hd__decap_12
XFILLER_0_2_289 VGND VGND VPWR VPWR sky130_ef_sc_hd__decap_12
XFILLER_0_2_245 VGND VGND VPWR VPWR sky130_fd_sc_hd__decap_6
XFILLER_0_74_785 VGND VGND VPWR VPWR sky130_ef_sc_hd__decap_12
XFILLER_0_74_741 VGND VGND VPWR VPWR sky130_ef_sc_hd__decap_12
XFILLER_0_59_793 VGND VGND VPWR VPWR sky130_fd_sc_hd__decap_8
XFILLER_0_100_765 VGND VGND VPWR VPWR sky130_ef_sc_hd__decap_12
XFILLER_0_80_777 VGND VGND VPWR VPWR sky130_fd_sc_hd__decap_6
XFILLER_0_0_727 VGND VGND VPWR VPWR sky130_fd_sc_hd__fill_1
XFILLER_0_1_15 VGND VGND VPWR VPWR sky130_ef_sc_hd__decap_12
XFILLER_0_56_785 VGND VGND VPWR VPWR sky130_ef_sc_hd__decap_12
XFILLER_0_56_741 VGND VGND VPWR VPWR sky130_ef_sc_hd__decap_12
XFILLER_0_7_337 VGND VGND VPWR VPWR sky130_ef_sc_hd__decap_12
XFILLER_0_71_755 VGND VGND VPWR VPWR sky130_fd_sc_hd__fill_1
XPHY_305 VGND VGND VPWR VPWR sky130_fd_sc_hd__decap_3
XFILLER_0_149_732 VGND VGND VPWR VPWR sky130_ef_sc_hd__decap_12
XFILLER_0_62_777 VGND VGND VPWR VPWR sky130_fd_sc_hd__decap_6
XFILLER_0_155_757 VGND VGND VPWR VPWR sky130_fd_sc_hd__fill_2
XFILLER_0_38_741 VGND VGND VPWR VPWR sky130_ef_sc_hd__decap_12
XFILLER_0_53_755 VGND VGND VPWR VPWR sky130_fd_sc_hd__fill_1
XFILLER_0_0_513 VGND VGND VPWR VPWR sky130_fd_sc_hd__fill_2
XFILLER_0_4_307 VGND VGND VPWR VPWR sky130_fd_sc_hd__fill_1
XFILLER_0_38_785 VGND VGND VPWR VPWR sky130_fd_sc_hd__decap_8
XFILLER_0_0_546 VGND VGND VPWR VPWR sky130_ef_sc_hd__decap_12
XFILLER_0_44_777 VGND VGND VPWR VPWR sky130_fd_sc_hd__decap_6
XFILLER_0_7_167 VGND VGND VPWR VPWR sky130_fd_sc_hd__fill_1
XFILLER_0_8_613 VGND VGND VPWR VPWR sky130_fd_sc_hd__decap_3
XFILLER_0_8_657 VGND VGND VPWR VPWR sky130_ef_sc_hd__decap_12
XFILLER_0_3_373 VGND VGND VPWR VPWR sky130_ef_sc_hd__decap_12
XPHY_157 VGND VGND VPWR VPWR sky130_fd_sc_hd__decap_3
XPHY_146 VGND VGND VPWR VPWR sky130_fd_sc_hd__decap_3
XPHY_135 VGND VGND VPWR VPWR sky130_fd_sc_hd__decap_3
XPHY_124 VGND VGND VPWR VPWR sky130_fd_sc_hd__decap_3
XPHY_113 VGND VGND VPWR VPWR sky130_fd_sc_hd__decap_3
XPHY_102 VGND VGND VPWR VPWR sky130_fd_sc_hd__decap_3
XFILLER_0_152_727 VGND VGND VPWR VPWR sky130_fd_sc_hd__fill_1
XFILLER_0_137_757 VGND VGND VPWR VPWR sky130_ef_sc_hd__decap_12
XPHY_179 VGND VGND VPWR VPWR sky130_fd_sc_hd__decap_3
XPHY_168 VGND VGND VPWR VPWR sky130_fd_sc_hd__decap_3
XFILLER_0_50_703 VGND VGND VPWR VPWR sky130_ef_sc_hd__decap_12
XFILLER_0_35_755 VGND VGND VPWR VPWR sky130_fd_sc_hd__fill_1
XFILLER_0_143_727 VGND VGND VPWR VPWR sky130_ef_sc_hd__decap_12
XPHY_4 VGND VGND VPWR VPWR sky130_fd_sc_hd__decap_3
XFILLER_0_151_793 VGND VGND VPWR VPWR sky130_fd_sc_hd__decap_8
XTAP_600 VGND VPWR sky130_fd_sc_hd__tapvpwrvgnd_1
XFILLER_0_0_321 VGND VGND VPWR VPWR sky130_ef_sc_hd__decap_12
XFILLER_0_7_69 VGND VGND VPWR VPWR sky130_ef_sc_hd__decap_12
XFILLER_0_26_777 VGND VGND VPWR VPWR sky130_fd_sc_hd__decap_6
XFILLER_0_41_703 VGND VGND VPWR VPWR sky130_ef_sc_hd__decap_12
XFILLER_0_41_769 VGND VGND VPWR VPWR sky130_ef_sc_hd__decap_12
XTAP_677 VGND VPWR sky130_fd_sc_hd__tapvpwrvgnd_1
XTAP_666 VGND VPWR sky130_fd_sc_hd__tapvpwrvgnd_1
XTAP_655 VGND VPWR sky130_fd_sc_hd__tapvpwrvgnd_1
XTAP_644 VGND VPWR sky130_fd_sc_hd__tapvpwrvgnd_1
XTAP_633 VGND VPWR sky130_fd_sc_hd__tapvpwrvgnd_1
XTAP_622 VGND VPWR sky130_fd_sc_hd__tapvpwrvgnd_1
XTAP_611 VGND VPWR sky130_fd_sc_hd__tapvpwrvgnd_1
XFILLER_0_8_421 VGND VGND VPWR VPWR sky130_ef_sc_hd__decap_12
XFILLER_0_134_727 VGND VGND VPWR VPWR sky130_fd_sc_hd__fill_1
XFILLER_0_119_757 VGND VGND VPWR VPWR sky130_ef_sc_hd__decap_12
XFILLER_0_17_755 VGND VGND VPWR VPWR sky130_fd_sc_hd__fill_1
XFILLER_0_32_703 VGND VGND VPWR VPWR sky130_ef_sc_hd__decap_12
XFILLER_0_3_181 VGND VGND VPWR VPWR sky130_ef_sc_hd__decap_12
XFILLER_0_4_693 VGND VGND VPWR VPWR sky130_fd_sc_hd__decap_6
XFILLER_0_99_769 VGND VGND VPWR VPWR sky130_ef_sc_hd__decap_12
XFILLER_0_99_703 VGND VGND VPWR VPWR sky130_ef_sc_hd__decap_12
XFILLER_0_125_727 VGND VGND VPWR VPWR sky130_ef_sc_hd__decap_12
XFILLER_0_133_793 VGND VGND VPWR VPWR sky130_fd_sc_hd__decap_8
XFILLER_0_23_703 VGND VGND VPWR VPWR sky130_ef_sc_hd__decap_12
XFILLER_0_23_769 VGND VGND VPWR VPWR sky130_ef_sc_hd__decap_12
XFILLER_0_116_727 VGND VGND VPWR VPWR sky130_fd_sc_hd__fill_1
XFILLER_0_14_703 VGND VGND VPWR VPWR sky130_ef_sc_hd__decap_12
XFILLER_0_1_685 VGND VGND VPWR VPWR sky130_ef_sc_hd__decap_12
XFILLER_0_1_641 VGND VGND VPWR VPWR sky130_ef_sc_hd__decap_12
XTAP_441 VGND VPWR sky130_fd_sc_hd__tapvpwrvgnd_1
XTAP_430 VGND VPWR sky130_fd_sc_hd__tapvpwrvgnd_1
XTAP_452 VGND VPWR sky130_fd_sc_hd__tapvpwrvgnd_1
XTAP_463 VGND VPWR sky130_fd_sc_hd__tapvpwrvgnd_1
XTAP_474 VGND VPWR sky130_fd_sc_hd__tapvpwrvgnd_1
XTAP_485 VGND VPWR sky130_fd_sc_hd__tapvpwrvgnd_1
XTAP_496 VGND VPWR sky130_fd_sc_hd__tapvpwrvgnd_1
XFILLER_0_107_727 VGND VGND VPWR VPWR sky130_ef_sc_hd__decap_12
XFILLER_0_130_741 VGND VGND VPWR VPWR sky130_ef_sc_hd__decap_12
XFILLER_0_115_793 VGND VGND VPWR VPWR sky130_fd_sc_hd__decap_8
XFILLER_0_130_785 VGND VGND VPWR VPWR sky130_ef_sc_hd__decap_12
XFILLER_0_87_739 VGND VGND VPWR VPWR sky130_ef_sc_hd__decap_12
XFILLER_0_11_739 VGND VGND VPWR VPWR sky130_ef_sc_hd__decap_12
XFILLER_0_86_783 VGND VGND VPWR VPWR sky130_fd_sc_hd__fill_1
XFILLER_0_112_741 VGND VGND VPWR VPWR sky130_ef_sc_hd__decap_12
XFILLER_0_6_755 VGND VGND VPWR VPWR sky130_fd_sc_hd__fill_1
XFILLER_0_112_785 VGND VGND VPWR VPWR sky130_ef_sc_hd__decap_12
XFILLER_0_10_783 VGND VGND VPWR VPWR sky130_fd_sc_hd__fill_1
XFILLER_0_69_739 VGND VGND VPWR VPWR sky130_ef_sc_hd__decap_12
XFILLER_0_92_797 VGND VGND VPWR VPWR sky130_fd_sc_hd__decap_4
XFILLER_0_92_753 VGND VGND VPWR VPWR sky130_ef_sc_hd__decap_12
XFILLER_0_68_783 VGND VGND VPWR VPWR sky130_fd_sc_hd__fill_1
XFILLER_0_74_797 VGND VGND VPWR VPWR sky130_fd_sc_hd__decap_4
XFILLER_0_74_753 VGND VGND VPWR VPWR sky130_ef_sc_hd__decap_12
XFILLER_0_100_777 VGND VGND VPWR VPWR sky130_fd_sc_hd__decap_6
XFILLER_0_1_27 VGND VGND VPWR VPWR sky130_ef_sc_hd__decap_12
XFILLER_0_56_797 VGND VGND VPWR VPWR sky130_fd_sc_hd__decap_4
XFILLER_0_56_753 VGND VGND VPWR VPWR sky130_ef_sc_hd__decap_12
XFILLER_0_7_305 VGND VGND VPWR VPWR sky130_ef_sc_hd__decap_12
XFILLER_0_7_349 VGND VGND VPWR VPWR sky130_ef_sc_hd__decap_12
XPHY_306 VGND VGND VPWR VPWR sky130_fd_sc_hd__decap_3
XFILLER_0_149_744 VGND VGND VPWR VPWR sky130_ef_sc_hd__decap_12
XFILLER_0_38_753 VGND VGND VPWR VPWR sky130_ef_sc_hd__decap_12
XFILLER_0_0_558 VGND VGND VPWR VPWR sky130_fd_sc_hd__fill_2
XFILLER_0_146_703 VGND VGND VPWR VPWR sky130_fd_sc_hd__fill_2
XFILLER_0_7_113 VGND VGND VPWR VPWR sky130_ef_sc_hd__decap_12
XFILLER_0_8_669 VGND VGND VPWR VPWR sky130_fd_sc_hd__decap_3
XFILLER_0_3_385 VGND VGND VPWR VPWR sky130_fd_sc_hd__decap_6
XFILLER_0_137_769 VGND VGND VPWR VPWR sky130_ef_sc_hd__decap_12
XFILLER_0_137_703 VGND VGND VPWR VPWR sky130_ef_sc_hd__decap_12
XPHY_169 VGND VGND VPWR VPWR sky130_fd_sc_hd__decap_3
XPHY_158 VGND VGND VPWR VPWR sky130_fd_sc_hd__decap_3
XPHY_147 VGND VGND VPWR VPWR sky130_fd_sc_hd__decap_3
XPHY_136 VGND VGND VPWR VPWR sky130_fd_sc_hd__decap_3
XPHY_125 VGND VGND VPWR VPWR sky130_fd_sc_hd__decap_3
XPHY_114 VGND VGND VPWR VPWR sky130_fd_sc_hd__decap_3
XPHY_103 VGND VGND VPWR VPWR sky130_fd_sc_hd__decap_3
XFILLER_0_152_739 VGND VGND VPWR VPWR sky130_fd_sc_hd__fill_2
XFILLER_0_50_715 VGND VGND VPWR VPWR sky130_ef_sc_hd__decap_12
XANTENNA_70 net87 VGND VGND VPWR VPWR sky130_fd_sc_hd__diode_2
XFILLER_0_128_703 VGND VGND VPWR VPWR sky130_ef_sc_hd__decap_12
XPHY_5 VGND VGND VPWR VPWR sky130_fd_sc_hd__decap_3
XFILLER_0_143_739 VGND VGND VPWR VPWR sky130_ef_sc_hd__decap_12
XFILLER_0_5_617 VGND VGND VPWR VPWR sky130_ef_sc_hd__decap_12
XFILLER_0_41_715 VGND VGND VPWR VPWR sky130_ef_sc_hd__decap_12
XTAP_634 VGND VPWR sky130_fd_sc_hd__tapvpwrvgnd_1
XTAP_623 VGND VPWR sky130_fd_sc_hd__tapvpwrvgnd_1
XTAP_612 VGND VPWR sky130_fd_sc_hd__tapvpwrvgnd_1
XTAP_601 VGND VPWR sky130_fd_sc_hd__tapvpwrvgnd_1
XFILLER_0_0_333 VGND VGND VPWR VPWR sky130_fd_sc_hd__decap_3
XFILLER_0_7_37 VGND VGND VPWR VPWR sky130_fd_sc_hd__fill_2
XTAP_678 VGND VPWR sky130_fd_sc_hd__tapvpwrvgnd_1
XTAP_667 VGND VPWR sky130_fd_sc_hd__tapvpwrvgnd_1
XTAP_656 VGND VPWR sky130_fd_sc_hd__tapvpwrvgnd_1
XTAP_645 VGND VPWR sky130_fd_sc_hd__tapvpwrvgnd_1
XFILLER_0_0_399 VGND VGND VPWR VPWR sky130_ef_sc_hd__decap_12
XFILLER_0_119_769 VGND VGND VPWR VPWR sky130_ef_sc_hd__decap_12
XFILLER_0_119_703 VGND VGND VPWR VPWR sky130_ef_sc_hd__decap_12
XFILLER_0_8_433 VGND VGND VPWR VPWR sky130_ef_sc_hd__decap_12
XFILLER_0_142_783 VGND VGND VPWR VPWR sky130_fd_sc_hd__fill_1
XFILLER_0_8_477 VGND VGND VPWR VPWR sky130_ef_sc_hd__decap_12
XFILLER_0_32_715 VGND VGND VPWR VPWR sky130_ef_sc_hd__decap_12
XFILLER_0_3_193 VGND VGND VPWR VPWR sky130_ef_sc_hd__decap_12
XFILLER_0_99_715 VGND VGND VPWR VPWR sky130_ef_sc_hd__decap_12
XFILLER_0_125_739 VGND VGND VPWR VPWR sky130_ef_sc_hd__decap_12
XFILLER_0_23_715 VGND VGND VPWR VPWR sky130_ef_sc_hd__decap_12
XFILLER_0_140_709 VGND VGND VPWR VPWR sky130_ef_sc_hd__decap_12
XFILLER_0_31_781 VGND VGND VPWR VPWR sky130_ef_sc_hd__decap_12
XFILLER_0_124_783 VGND VGND VPWR VPWR sky130_fd_sc_hd__fill_1
XFILLER_0_5_447 VGND VGND VPWR VPWR sky130_fd_sc_hd__fill_1
XFILLER_0_14_715 VGND VGND VPWR VPWR sky130_ef_sc_hd__decap_12
XFILLER_0_1_697 VGND VGND VPWR VPWR sky130_ef_sc_hd__decap_12
XFILLER_0_1_653 VGND VGND VPWR VPWR sky130_ef_sc_hd__decap_12
XTAP_420 VGND VPWR sky130_fd_sc_hd__tapvpwrvgnd_1
XTAP_442 VGND VPWR sky130_fd_sc_hd__tapvpwrvgnd_1
XTAP_453 VGND VPWR sky130_fd_sc_hd__tapvpwrvgnd_1
XTAP_431 VGND VPWR sky130_fd_sc_hd__tapvpwrvgnd_1
XTAP_464 VGND VPWR sky130_fd_sc_hd__tapvpwrvgnd_1
XTAP_475 VGND VPWR sky130_fd_sc_hd__tapvpwrvgnd_1
XFILLER_0_96_729 VGND VGND VPWR VPWR sky130_ef_sc_hd__decap_12
XFILLER_0_89_781 VGND VGND VPWR VPWR sky130_ef_sc_hd__decap_12
XTAP_486 VGND VPWR sky130_fd_sc_hd__tapvpwrvgnd_1
XTAP_497 VGND VPWR sky130_fd_sc_hd__tapvpwrvgnd_1
XFILLER_0_107_739 VGND VGND VPWR VPWR sky130_ef_sc_hd__decap_12
XFILLER_0_130_797 VGND VGND VPWR VPWR sky130_fd_sc_hd__decap_4
XFILLER_0_130_753 VGND VGND VPWR VPWR sky130_ef_sc_hd__decap_12
XFILLER_0_13_781 VGND VGND VPWR VPWR sky130_ef_sc_hd__decap_12
XFILLER_0_20_729 VGND VGND VPWR VPWR sky130_ef_sc_hd__decap_12
XFILLER_0_95_751 VGND VGND VPWR VPWR sky130_fd_sc_hd__decap_4
XFILLER_0_106_783 VGND VGND VPWR VPWR sky130_fd_sc_hd__fill_1
XFILLER_0_78_729 VGND VGND VPWR VPWR sky130_ef_sc_hd__decap_12
XFILLER_0_6_701 VGND VGND VPWR VPWR sky130_ef_sc_hd__decap_12
XFILLER_0_112_753 VGND VGND VPWR VPWR sky130_ef_sc_hd__decap_12
XFILLER_0_1_461 VGND VGND VPWR VPWR sky130_ef_sc_hd__decap_12
XFILLER_0_112_797 VGND VGND VPWR VPWR sky130_fd_sc_hd__decap_4
XFILLER_0_77_751 VGND VGND VPWR VPWR sky130_fd_sc_hd__decap_4
XFILLER_0_92_765 VGND VGND VPWR VPWR sky130_ef_sc_hd__decap_12
XFILLER_0_59_751 VGND VGND VPWR VPWR sky130_fd_sc_hd__decap_4
XFILLER_0_74_765 VGND VGND VPWR VPWR sky130_ef_sc_hd__decap_12
XFILLER_0_6_531 VGND VGND VPWR VPWR sky130_fd_sc_hd__fill_1
XFILLER_0_2_781 VGND VGND VPWR VPWR sky130_ef_sc_hd__decap_12
XFILLER_0_5_81 VGND VGND VPWR VPWR sky130_ef_sc_hd__decap_12
XFILLER_0_0_729 VGND VGND VPWR VPWR sky130_fd_sc_hd__decap_8
XFILLER_0_1_39 VGND VGND VPWR VPWR sky130_ef_sc_hd__decap_12
XFILLER_0_71_757 VGND VGND VPWR VPWR sky130_ef_sc_hd__decap_12
XFILLER_0_56_765 VGND VGND VPWR VPWR sky130_ef_sc_hd__decap_12
XFILLER_0_7_317 VGND VGND VPWR VPWR sky130_ef_sc_hd__decap_12
XPHY_307 VGND VGND VPWR VPWR sky130_fd_sc_hd__decap_3
XFILLER_0_53_757 VGND VGND VPWR VPWR sky130_ef_sc_hd__decap_12
XFILLER_0_4_309 VGND VGND VPWR VPWR sky130_ef_sc_hd__decap_12
XFILLER_0_38_765 VGND VGND VPWR VPWR sky130_ef_sc_hd__decap_12
XFILLER_0_154_770 VGND VGND VPWR VPWR sky130_fd_sc_hd__fill_2
XFILLER_0_7_125 VGND VGND VPWR VPWR sky130_ef_sc_hd__decap_12
XFILLER_0_7_169 VGND VGND VPWR VPWR sky130_ef_sc_hd__decap_12
XFILLER_0_137_715 VGND VGND VPWR VPWR sky130_ef_sc_hd__decap_12
XPHY_159 VGND VGND VPWR VPWR sky130_fd_sc_hd__decap_3
XPHY_148 VGND VGND VPWR VPWR sky130_fd_sc_hd__decap_3
XPHY_137 VGND VGND VPWR VPWR sky130_fd_sc_hd__decap_3
XPHY_126 VGND VGND VPWR VPWR sky130_fd_sc_hd__decap_3
XPHY_115 VGND VGND VPWR VPWR sky130_fd_sc_hd__decap_3
XPHY_104 VGND VGND VPWR VPWR sky130_fd_sc_hd__decap_3
XFILLER_0_35_757 VGND VGND VPWR VPWR sky130_ef_sc_hd__decap_12
XFILLER_0_145_781 VGND VGND VPWR VPWR sky130_ef_sc_hd__decap_12
XFILLER_0_50_727 VGND VGND VPWR VPWR sky130_fd_sc_hd__fill_1
XANTENNA_60 net103 VGND VGND VPWR VPWR sky130_fd_sc_hd__diode_2
XANTENNA_71 net87 VGND VGND VPWR VPWR sky130_fd_sc_hd__diode_2
XFILLER_0_128_715 VGND VGND VPWR VPWR sky130_ef_sc_hd__decap_12
XPHY_6 VGND VGND VPWR VPWR sky130_fd_sc_hd__decap_3
XFILLER_0_4_139 VGND VGND VPWR VPWR sky130_fd_sc_hd__fill_1
XFILLER_0_5_629 VGND VGND VPWR VPWR sky130_ef_sc_hd__decap_12
XFILLER_0_41_727 VGND VGND VPWR VPWR sky130_ef_sc_hd__decap_12
XTAP_668 VGND VPWR sky130_fd_sc_hd__tapvpwrvgnd_1
XTAP_657 VGND VPWR sky130_fd_sc_hd__tapvpwrvgnd_1
XTAP_646 VGND VPWR sky130_fd_sc_hd__tapvpwrvgnd_1
XTAP_635 VGND VPWR sky130_fd_sc_hd__tapvpwrvgnd_1
XTAP_624 VGND VPWR sky130_fd_sc_hd__tapvpwrvgnd_1
XTAP_613 VGND VPWR sky130_fd_sc_hd__tapvpwrvgnd_1
XTAP_602 VGND VPWR sky130_fd_sc_hd__tapvpwrvgnd_1
XTAP_679 VGND VPWR sky130_fd_sc_hd__tapvpwrvgnd_1
XFILLER_0_134_729 VGND VGND VPWR VPWR sky130_ef_sc_hd__decap_12
XFILLER_0_119_715 VGND VGND VPWR VPWR sky130_ef_sc_hd__decap_12
XFILLER_0_8_445 VGND VGND VPWR VPWR sky130_fd_sc_hd__decap_3
XFILLER_0_8_489 VGND VGND VPWR VPWR sky130_ef_sc_hd__decap_12
XFILLER_0_17_757 VGND VGND VPWR VPWR sky130_ef_sc_hd__decap_12
Xinput80 ScanInDR VGND VGND VPWR VPWR net80 sky130_fd_sc_hd__buf_2
XFILLER_0_127_781 VGND VGND VPWR VPWR sky130_ef_sc_hd__decap_12
XFILLER_0_3_161 VGND VGND VPWR VPWR sky130_fd_sc_hd__decap_6
XFILLER_0_32_727 VGND VGND VPWR VPWR sky130_fd_sc_hd__fill_1
XFILLER_0_99_727 VGND VGND VPWR VPWR sky130_ef_sc_hd__decap_12
XFILLER_0_7_9 VGND VGND VPWR VPWR sky130_fd_sc_hd__fill_2
XFILLER_0_133_751 VGND VGND VPWR VPWR sky130_fd_sc_hd__decap_4
XFILLER_0_23_727 VGND VGND VPWR VPWR sky130_ef_sc_hd__decap_12
XFILLER_0_31_793 VGND VGND VPWR VPWR sky130_fd_sc_hd__decap_8
XFILLER_0_116_729 VGND VGND VPWR VPWR sky130_ef_sc_hd__decap_12
XFILLER_0_109_781 VGND VGND VPWR VPWR sky130_ef_sc_hd__decap_12
XFILLER_0_14_727 VGND VGND VPWR VPWR sky130_fd_sc_hd__fill_1
XFILLER_0_1_665 VGND VGND VPWR VPWR sky130_fd_sc_hd__decap_6
XFILLER_0_0_197 VGND VGND VPWR VPWR sky130_ef_sc_hd__decap_12
XFILLER_0_0_175 VGND VGND VPWR VPWR sky130_ef_sc_hd__decap_12
XTAP_410 VGND VPWR sky130_fd_sc_hd__tapvpwrvgnd_1
XTAP_421 VGND VPWR sky130_fd_sc_hd__tapvpwrvgnd_1
XTAP_443 VGND VPWR sky130_fd_sc_hd__tapvpwrvgnd_1
XTAP_454 VGND VPWR sky130_fd_sc_hd__tapvpwrvgnd_1
XTAP_432 VGND VPWR sky130_fd_sc_hd__tapvpwrvgnd_1
XTAP_465 VGND VPWR sky130_fd_sc_hd__tapvpwrvgnd_1
XTAP_476 VGND VPWR sky130_fd_sc_hd__tapvpwrvgnd_1
XFILLER_0_22_793 VGND VGND VPWR VPWR sky130_fd_sc_hd__fill_2
XTAP_487 VGND VPWR sky130_fd_sc_hd__tapvpwrvgnd_1
XTAP_498 VGND VPWR sky130_fd_sc_hd__tapvpwrvgnd_1
XFILLER_0_89_793 VGND VGND VPWR VPWR sky130_fd_sc_hd__decap_8
XFILLER_0_115_751 VGND VGND VPWR VPWR sky130_fd_sc_hd__decap_4
XFILLER_0_8_253 VGND VGND VPWR VPWR sky130_ef_sc_hd__decap_12
XFILLER_0_130_765 VGND VGND VPWR VPWR sky130_ef_sc_hd__decap_12
XFILLER_0_130_721 VGND VGND VPWR VPWR sky130_fd_sc_hd__decap_6
XFILLER_0_8_81 VGND VGND VPWR VPWR sky130_fd_sc_hd__decap_3
XFILLER_0_13_793 VGND VGND VPWR VPWR sky130_fd_sc_hd__decap_8
XFILLER_0_4_39 VGND VGND VPWR VPWR sky130_fd_sc_hd__fill_2
XFILLER_0_86_741 VGND VGND VPWR VPWR sky130_ef_sc_hd__decap_12
XFILLER_0_86_785 VGND VGND VPWR VPWR sky130_ef_sc_hd__decap_12
XFILLER_0_5_223 VGND VGND VPWR VPWR sky130_fd_sc_hd__fill_1
XFILLER_0_6_713 VGND VGND VPWR VPWR sky130_ef_sc_hd__decap_12
XFILLER_0_6_757 VGND VGND VPWR VPWR sky130_ef_sc_hd__decap_12
XFILLER_0_112_765 VGND VGND VPWR VPWR sky130_ef_sc_hd__decap_12
XFILLER_0_1_473 VGND VGND VPWR VPWR sky130_ef_sc_hd__decap_12
XFILLER_0_10_741 VGND VGND VPWR VPWR sky130_ef_sc_hd__decap_12
XFILLER_0_10_785 VGND VGND VPWR VPWR sky130_ef_sc_hd__decap_12
XFILLER_0_92_777 VGND VGND VPWR VPWR sky130_fd_sc_hd__decap_6
XFILLER_0_3_3 VGND VGND VPWR VPWR sky130_fd_sc_hd__fill_2
XFILLER_0_68_741 VGND VGND VPWR VPWR sky130_ef_sc_hd__decap_12
XFILLER_0_83_755 VGND VGND VPWR VPWR sky130_fd_sc_hd__fill_1
XFILLER_0_68_785 VGND VGND VPWR VPWR sky130_ef_sc_hd__decap_12
XFILLER_0_3_727 VGND VGND VPWR VPWR sky130_fd_sc_hd__fill_1
XFILLER_0_74_777 VGND VGND VPWR VPWR sky130_fd_sc_hd__decap_6
XFILLER_0_6_587 VGND VGND VPWR VPWR sky130_fd_sc_hd__fill_1
XFILLER_0_2_793 VGND VGND VPWR VPWR sky130_fd_sc_hd__decap_8
XFILLER_0_1_281 VGND VGND VPWR VPWR sky130_ef_sc_hd__decap_12
XFILLER_0_5_93 VGND VGND VPWR VPWR sky130_ef_sc_hd__decap_12
XFILLER_0_80_703 VGND VGND VPWR VPWR sky130_ef_sc_hd__decap_12
XFILLER_0_65_755 VGND VGND VPWR VPWR sky130_fd_sc_hd__fill_1
XFILLER_0_71_769 VGND VGND VPWR VPWR sky130_ef_sc_hd__decap_12
XFILLER_0_71_703 VGND VGND VPWR VPWR sky130_ef_sc_hd__decap_12
XFILLER_0_56_777 VGND VGND VPWR VPWR sky130_fd_sc_hd__decap_6
XFILLER_0_7_329 VGND VGND VPWR VPWR sky130_fd_sc_hd__decap_6
Xinput1 AD[0] VGND VGND VPWR VPWR net1 sky130_fd_sc_hd__buf_4
XPHY_308 VGND VGND VPWR VPWR sky130_fd_sc_hd__decap_3
XFILLER_0_149_757 VGND VGND VPWR VPWR sky130_ef_sc_hd__decap_12
XFILLER_0_62_703 VGND VGND VPWR VPWR sky130_ef_sc_hd__decap_12
XFILLER_0_47_755 VGND VGND VPWR VPWR sky130_fd_sc_hd__fill_1
XFILLER_0_155_727 VGND VGND VPWR VPWR sky130_fd_sc_hd__fill_1
XFILLER_0_53_769 VGND VGND VPWR VPWR sky130_ef_sc_hd__decap_12
XFILLER_0_53_703 VGND VGND VPWR VPWR sky130_ef_sc_hd__decap_12
XFILLER_0_38_777 VGND VGND VPWR VPWR sky130_fd_sc_hd__decap_6
XFILLER_0_0_505 VGND VGND VPWR VPWR sky130_fd_sc_hd__decap_8
XFILLER_0_146_727 VGND VGND VPWR VPWR sky130_fd_sc_hd__fill_1
XFILLER_0_44_703 VGND VGND VPWR VPWR sky130_ef_sc_hd__decap_12
XFILLER_0_7_137 VGND VGND VPWR VPWR sky130_ef_sc_hd__decap_12
XFILLER_0_29_755 VGND VGND VPWR VPWR sky130_fd_sc_hd__fill_1
XFILLER_0_154_782 VGND VGND VPWR VPWR sky130_fd_sc_hd__fill_2
XPHY_116 VGND VGND VPWR VPWR sky130_fd_sc_hd__decap_3
XPHY_105 VGND VGND VPWR VPWR sky130_fd_sc_hd__decap_3
XFILLER_0_2_83 VGND VGND VPWR VPWR sky130_fd_sc_hd__fill_1
XFILLER_0_152_719 VGND VGND VPWR VPWR sky130_fd_sc_hd__fill_2
XFILLER_0_145_793 VGND VGND VPWR VPWR sky130_fd_sc_hd__decap_8
XFILLER_0_137_727 VGND VGND VPWR VPWR sky130_ef_sc_hd__decap_12
XPHY_149 VGND VGND VPWR VPWR sky130_fd_sc_hd__decap_3
XPHY_138 VGND VGND VPWR VPWR sky130_fd_sc_hd__decap_3
XPHY_127 VGND VGND VPWR VPWR sky130_fd_sc_hd__decap_3
XANTENNA_61 net108 VGND VGND VPWR VPWR sky130_fd_sc_hd__diode_2
XANTENNA_50 net99 VGND VGND VPWR VPWR sky130_fd_sc_hd__diode_2
XANTENNA_72 net117 VGND VGND VPWR VPWR sky130_fd_sc_hd__diode_2
XFILLER_0_7_671 VGND VGND VPWR VPWR sky130_fd_sc_hd__fill_1
XFILLER_0_35_703 VGND VGND VPWR VPWR sky130_ef_sc_hd__decap_12
XFILLER_0_35_769 VGND VGND VPWR VPWR sky130_ef_sc_hd__decap_12
XFILLER_0_128_727 VGND VGND VPWR VPWR sky130_fd_sc_hd__fill_1
XPHY_7 VGND VGND VPWR VPWR sky130_fd_sc_hd__decap_3
XFILLER_0_26_703 VGND VGND VPWR VPWR sky130_ef_sc_hd__decap_12
XFILLER_0_41_739 VGND VGND VPWR VPWR sky130_ef_sc_hd__decap_12
XTAP_669 VGND VPWR sky130_fd_sc_hd__tapvpwrvgnd_1
XTAP_658 VGND VPWR sky130_fd_sc_hd__tapvpwrvgnd_1
XTAP_647 VGND VPWR sky130_fd_sc_hd__tapvpwrvgnd_1
XTAP_636 VGND VPWR sky130_fd_sc_hd__tapvpwrvgnd_1
XTAP_625 VGND VPWR sky130_fd_sc_hd__tapvpwrvgnd_1
XTAP_614 VGND VPWR sky130_fd_sc_hd__tapvpwrvgnd_1
XTAP_603 VGND VPWR sky130_fd_sc_hd__tapvpwrvgnd_1
XFILLER_0_0_346 VGND VGND VPWR VPWR sky130_ef_sc_hd__decap_12
XFILLER_0_127_793 VGND VGND VPWR VPWR sky130_fd_sc_hd__decap_8
XFILLER_0_119_727 VGND VGND VPWR VPWR sky130_ef_sc_hd__decap_12
XFILLER_0_17_703 VGND VGND VPWR VPWR sky130_ef_sc_hd__decap_12
XFILLER_0_17_769 VGND VGND VPWR VPWR sky130_ef_sc_hd__decap_12
Xinput81 TM VGND VGND VPWR VPWR net81 sky130_fd_sc_hd__buf_4
XFILLER_0_142_785 VGND VGND VPWR VPWR sky130_ef_sc_hd__decap_12
XFILLER_0_142_741 VGND VGND VPWR VPWR sky130_ef_sc_hd__decap_12
Xinput70 DI[5] VGND VGND VPWR VPWR net70 sky130_fd_sc_hd__buf_4
XFILLER_0_40_783 VGND VGND VPWR VPWR sky130_fd_sc_hd__fill_1
XFILLER_0_99_739 VGND VGND VPWR VPWR sky130_ef_sc_hd__decap_12
XFILLER_0_118_793 VGND VGND VPWR VPWR sky130_fd_sc_hd__fill_2
XFILLER_0_23_739 VGND VGND VPWR VPWR sky130_ef_sc_hd__decap_12
XFILLER_0_98_783 VGND VGND VPWR VPWR sky130_fd_sc_hd__fill_1
XFILLER_0_109_793 VGND VGND VPWR VPWR sky130_fd_sc_hd__decap_8
XFILLER_0_5_405 VGND VGND VPWR VPWR sky130_ef_sc_hd__decap_12
XFILLER_0_124_785 VGND VGND VPWR VPWR sky130_ef_sc_hd__decap_12
XFILLER_0_124_741 VGND VGND VPWR VPWR sky130_ef_sc_hd__decap_12
XFILLER_0_0_121 VGND VGND VPWR VPWR sky130_ef_sc_hd__decap_12
XTAP_400 VGND VPWR sky130_fd_sc_hd__tapvpwrvgnd_1
XFILLER_0_5_449 VGND VGND VPWR VPWR sky130_ef_sc_hd__decap_12
XFILLER_0_22_783 VGND VGND VPWR VPWR sky130_fd_sc_hd__fill_1
XFILLER_0_0_187 VGND VGND VPWR VPWR sky130_fd_sc_hd__decap_3
XTAP_411 VGND VPWR sky130_fd_sc_hd__tapvpwrvgnd_1
XTAP_422 VGND VPWR sky130_fd_sc_hd__tapvpwrvgnd_1
XTAP_444 VGND VPWR sky130_fd_sc_hd__tapvpwrvgnd_1
XTAP_455 VGND VPWR sky130_fd_sc_hd__tapvpwrvgnd_1
XTAP_433 VGND VPWR sky130_fd_sc_hd__tapvpwrvgnd_1
XTAP_466 VGND VPWR sky130_fd_sc_hd__tapvpwrvgnd_1
XTAP_477 VGND VPWR sky130_fd_sc_hd__tapvpwrvgnd_1
XTAP_488 VGND VPWR sky130_fd_sc_hd__tapvpwrvgnd_1
XTAP_499 VGND VPWR sky130_fd_sc_hd__tapvpwrvgnd_1
XFILLER_0_8_221 VGND VGND VPWR VPWR sky130_fd_sc_hd__decap_3
XFILLER_0_8_265 VGND VGND VPWR VPWR sky130_ef_sc_hd__decap_12
XFILLER_0_9_755 VGND VGND VPWR VPWR sky130_fd_sc_hd__fill_1
XFILLER_0_130_777 VGND VGND VPWR VPWR sky130_fd_sc_hd__decap_6
XFILLER_0_121_755 VGND VGND VPWR VPWR sky130_fd_sc_hd__fill_1
XFILLER_0_106_785 VGND VGND VPWR VPWR sky130_ef_sc_hd__decap_12
XFILLER_0_106_741 VGND VGND VPWR VPWR sky130_ef_sc_hd__decap_12
XFILLER_0_2_419 VGND VGND VPWR VPWR sky130_fd_sc_hd__fill_1
XFILLER_0_4_29 VGND VGND VPWR VPWR sky130_fd_sc_hd__decap_4
XFILLER_0_86_753 VGND VGND VPWR VPWR sky130_ef_sc_hd__decap_12
XFILLER_0_5_279 VGND VGND VPWR VPWR sky130_fd_sc_hd__fill_1
XFILLER_0_6_725 VGND VGND VPWR VPWR sky130_ef_sc_hd__decap_12
XFILLER_0_6_769 VGND VGND VPWR VPWR sky130_ef_sc_hd__decap_12
XFILLER_0_112_777 VGND VGND VPWR VPWR sky130_fd_sc_hd__decap_6
XFILLER_0_1_485 VGND VGND VPWR VPWR sky130_ef_sc_hd__decap_12
XFILLER_0_1_441 VGND VGND VPWR VPWR sky130_fd_sc_hd__decap_6
XFILLER_0_10_753 VGND VGND VPWR VPWR sky130_ef_sc_hd__decap_12
XFILLER_0_10_797 VGND VGND VPWR VPWR sky130_fd_sc_hd__decap_4
XFILLER_0_103_755 VGND VGND VPWR VPWR sky130_fd_sc_hd__fill_1
XFILLER_0_68_753 VGND VGND VPWR VPWR sky130_ef_sc_hd__decap_12
XFILLER_0_68_797 VGND VGND VPWR VPWR sky130_fd_sc_hd__decap_4
XFILLER_0_6_533 VGND VGND VPWR VPWR sky130_ef_sc_hd__decap_12
XFILLER_0_100_703 VGND VGND VPWR VPWR sky130_ef_sc_hd__decap_12
XFILLER_0_1_293 VGND VGND VPWR VPWR sky130_ef_sc_hd__decap_12
XFILLER_0_80_715 VGND VGND VPWR VPWR sky130_ef_sc_hd__decap_12
XFILLER_0_71_715 VGND VGND VPWR VPWR sky130_ef_sc_hd__decap_12
XFILLER_0_3_503 VGND VGND VPWR VPWR sky130_fd_sc_hd__fill_1
Xinput2 AD[1] VGND VGND VPWR VPWR net2 sky130_fd_sc_hd__clkbuf_4
XPHY_309 VGND VGND VPWR VPWR sky130_fd_sc_hd__decap_3
XFILLER_0_149_769 VGND VGND VPWR VPWR sky130_ef_sc_hd__decap_12
XFILLER_0_62_715 VGND VGND VPWR VPWR sky130_ef_sc_hd__decap_12
XFILLER_0_6_363 VGND VGND VPWR VPWR sky130_fd_sc_hd__fill_1
XFILLER_0_61_781 VGND VGND VPWR VPWR sky130_ef_sc_hd__decap_12
XFILLER_0_53_715 VGND VGND VPWR VPWR sky130_ef_sc_hd__decap_12
XFILLER_0_0_539 VGND VGND VPWR VPWR sky130_fd_sc_hd__fill_1
XFILLER_0_44_715 VGND VGND VPWR VPWR sky130_ef_sc_hd__decap_12
XFILLER_0_7_105 VGND VGND VPWR VPWR sky130_fd_sc_hd__decap_6
XFILLER_0_7_149 VGND VGND VPWR VPWR sky130_ef_sc_hd__decap_12
XFILLER_0_8_617 VGND VGND VPWR VPWR sky130_ef_sc_hd__decap_12
XPHY_139 VGND VGND VPWR VPWR sky130_fd_sc_hd__decap_3
XPHY_128 VGND VGND VPWR VPWR sky130_fd_sc_hd__decap_3
XPHY_117 VGND VGND VPWR VPWR sky130_fd_sc_hd__decap_3
XPHY_106 VGND VGND VPWR VPWR sky130_fd_sc_hd__decap_3
XFILLER_0_145_750 VGND VGND VPWR VPWR sky130_fd_sc_hd__decap_6
XFILLER_0_137_739 VGND VGND VPWR VPWR sky130_ef_sc_hd__decap_12
XFILLER_0_50_729 VGND VGND VPWR VPWR sky130_ef_sc_hd__decap_12
XFILLER_0_43_781 VGND VGND VPWR VPWR sky130_ef_sc_hd__decap_12
XANTENNA_62 net111 VGND VGND VPWR VPWR sky130_fd_sc_hd__diode_2
XANTENNA_51 net99 VGND VGND VPWR VPWR sky130_fd_sc_hd__diode_2
XANTENNA_40 net90 VGND VGND VPWR VPWR sky130_fd_sc_hd__diode_2
XFILLER_0_35_715 VGND VGND VPWR VPWR sky130_ef_sc_hd__decap_12
XPHY_8 VGND VGND VPWR VPWR sky130_fd_sc_hd__decap_3
XFILLER_0_5_609 VGND VGND VPWR VPWR sky130_fd_sc_hd__decap_6
XFILLER_0_26_715 VGND VGND VPWR VPWR sky130_ef_sc_hd__decap_12
XFILLER_0_136_783 VGND VGND VPWR VPWR sky130_fd_sc_hd__fill_1
XTAP_659 VGND VPWR sky130_fd_sc_hd__tapvpwrvgnd_1
XTAP_648 VGND VPWR sky130_fd_sc_hd__tapvpwrvgnd_1
XTAP_637 VGND VPWR sky130_fd_sc_hd__tapvpwrvgnd_1
XTAP_626 VGND VPWR sky130_fd_sc_hd__tapvpwrvgnd_1
XTAP_615 VGND VPWR sky130_fd_sc_hd__tapvpwrvgnd_1
XTAP_604 VGND VPWR sky130_fd_sc_hd__tapvpwrvgnd_1
XFILLER_0_0_358 VGND VGND VPWR VPWR sky130_fd_sc_hd__decap_6
XFILLER_0_142_753 VGND VGND VPWR VPWR sky130_ef_sc_hd__decap_12
XFILLER_0_119_739 VGND VGND VPWR VPWR sky130_ef_sc_hd__decap_12
XFILLER_0_17_715 VGND VGND VPWR VPWR sky130_ef_sc_hd__decap_12
XFILLER_0_25_781 VGND VGND VPWR VPWR sky130_ef_sc_hd__decap_12
XFILLER_0_32_729 VGND VGND VPWR VPWR sky130_ef_sc_hd__decap_12
Xinput82 WLBI VGND VGND VPWR VPWR net82 sky130_fd_sc_hd__clkbuf_2
XFILLER_0_142_797 VGND VGND VPWR VPWR sky130_fd_sc_hd__decap_4
Xinput60 DI[25] VGND VGND VPWR VPWR net60 sky130_fd_sc_hd__buf_4
Xinput71 DI[6] VGND VGND VPWR VPWR net71 sky130_fd_sc_hd__buf_4
XFILLER_0_118_783 VGND VGND VPWR VPWR sky130_fd_sc_hd__fill_1
XFILLER_0_31_751 VGND VGND VPWR VPWR sky130_fd_sc_hd__decap_4
XFILLER_0_124_753 VGND VGND VPWR VPWR sky130_ef_sc_hd__decap_12
XFILLER_0_5_417 VGND VGND VPWR VPWR sky130_ef_sc_hd__decap_12
XFILLER_0_14_729 VGND VGND VPWR VPWR sky130_ef_sc_hd__decap_12
XFILLER_0_124_797 VGND VGND VPWR VPWR sky130_fd_sc_hd__decap_4
XFILLER_0_0_133 VGND VGND VPWR VPWR sky130_fd_sc_hd__decap_6
XTAP_412 VGND VPWR sky130_fd_sc_hd__tapvpwrvgnd_1
XTAP_401 VGND VPWR sky130_fd_sc_hd__tapvpwrvgnd_1
XTAP_423 VGND VPWR sky130_fd_sc_hd__tapvpwrvgnd_1
XFILLER_0_89_751 VGND VGND VPWR VPWR sky130_fd_sc_hd__decap_4
XTAP_445 VGND VPWR sky130_fd_sc_hd__tapvpwrvgnd_1
XTAP_456 VGND VPWR sky130_fd_sc_hd__tapvpwrvgnd_1
XTAP_434 VGND VPWR sky130_fd_sc_hd__tapvpwrvgnd_1
XTAP_467 VGND VPWR sky130_fd_sc_hd__tapvpwrvgnd_1
XTAP_478 VGND VPWR sky130_fd_sc_hd__tapvpwrvgnd_1
XTAP_489 VGND VPWR sky130_fd_sc_hd__tapvpwrvgnd_1
XFILLER_0_8_61 VGND VGND VPWR VPWR sky130_ef_sc_hd__decap_12
XFILLER_0_8_277 VGND VGND VPWR VPWR sky130_fd_sc_hd__decap_3
XFILLER_0_13_751 VGND VGND VPWR VPWR sky130_fd_sc_hd__decap_4
XFILLER_0_106_797 VGND VGND VPWR VPWR sky130_fd_sc_hd__decap_4
XFILLER_0_106_753 VGND VGND VPWR VPWR sky130_ef_sc_hd__decap_12
XFILLER_0_86_765 VGND VGND VPWR VPWR sky130_ef_sc_hd__decap_12
XFILLER_0_5_225 VGND VGND VPWR VPWR sky130_ef_sc_hd__decap_12
XFILLER_0_6_737 VGND VGND VPWR VPWR sky130_ef_sc_hd__decap_12
XFILLER_0_1_497 VGND VGND VPWR VPWR sky130_fd_sc_hd__decap_6
XFILLER_0_10_765 VGND VGND VPWR VPWR sky130_ef_sc_hd__decap_12
XFILLER_0_68_765 VGND VGND VPWR VPWR sky130_ef_sc_hd__decap_12
XFILLER_0_83_757 VGND VGND VPWR VPWR sky130_ef_sc_hd__decap_12
XFILLER_0_3_729 VGND VGND VPWR VPWR sky130_ef_sc_hd__decap_12
XFILLER_0_6_501 VGND VGND VPWR VPWR sky130_ef_sc_hd__decap_12
XFILLER_0_6_545 VGND VGND VPWR VPWR sky130_ef_sc_hd__decap_12
XFILLER_0_100_715 VGND VGND VPWR VPWR sky130_ef_sc_hd__decap_12
XFILLER_0_1_261 VGND VGND VPWR VPWR sky130_ef_sc_hd__decap_12
XFILLER_0_6_589 VGND VGND VPWR VPWR sky130_ef_sc_hd__decap_12
XFILLER_0_80_727 VGND VGND VPWR VPWR sky130_fd_sc_hd__fill_1
XFILLER_0_65_757 VGND VGND VPWR VPWR sky130_ef_sc_hd__decap_12
XFILLER_0_71_727 VGND VGND VPWR VPWR sky130_ef_sc_hd__decap_12
XFILLER_0_3_559 VGND VGND VPWR VPWR sky130_fd_sc_hd__fill_1
Xinput3 AD[2] VGND VGND VPWR VPWR net3 sky130_fd_sc_hd__clkbuf_4
XFILLER_0_62_727 VGND VGND VPWR VPWR sky130_fd_sc_hd__fill_1
XFILLER_0_47_757 VGND VGND VPWR VPWR sky130_ef_sc_hd__decap_12
XFILLER_0_2_581 VGND VGND VPWR VPWR sky130_fd_sc_hd__decap_6
XFILLER_0_61_793 VGND VGND VPWR VPWR sky130_fd_sc_hd__decap_8
XFILLER_0_53_727 VGND VGND VPWR VPWR sky130_ef_sc_hd__decap_12
XFILLER_0_0_529 VGND VGND VPWR VPWR sky130_fd_sc_hd__decap_3
XFILLER_0_154_762 VGND VGND VPWR VPWR sky130_fd_sc_hd__fill_2
XFILLER_0_146_729 VGND VGND VPWR VPWR sky130_ef_sc_hd__decap_12
XFILLER_0_146_707 VGND VGND VPWR VPWR sky130_ef_sc_hd__decap_12
XFILLER_0_139_781 VGND VGND VPWR VPWR sky130_ef_sc_hd__decap_12
XFILLER_0_44_727 VGND VGND VPWR VPWR sky130_fd_sc_hd__fill_1
XFILLER_0_8_629 VGND VGND VPWR VPWR sky130_ef_sc_hd__decap_12
XFILLER_0_29_757 VGND VGND VPWR VPWR sky130_ef_sc_hd__decap_12
XFILLER_0_2_41 VGND VGND VPWR VPWR sky130_ef_sc_hd__decap_12
XPHY_129 VGND VGND VPWR VPWR sky130_fd_sc_hd__decap_3
XPHY_118 VGND VGND VPWR VPWR sky130_fd_sc_hd__decap_3
XPHY_107 VGND VGND VPWR VPWR sky130_fd_sc_hd__decap_3
XFILLER_0_2_85 VGND VGND VPWR VPWR sky130_ef_sc_hd__decap_12
XANTENNA_30 ScanInDR VGND VGND VPWR VPWR sky130_fd_sc_hd__diode_2
XFILLER_0_43_793 VGND VGND VPWR VPWR sky130_fd_sc_hd__decap_8
XANTENNA_52 net100 VGND VGND VPWR VPWR sky130_fd_sc_hd__diode_2
XANTENNA_41 net91 VGND VGND VPWR VPWR sky130_fd_sc_hd__diode_2
XANTENNA_63 net112 VGND VGND VPWR VPWR sky130_fd_sc_hd__diode_2
XFILLER_0_7_673 VGND VGND VPWR VPWR sky130_ef_sc_hd__decap_12
XFILLER_0_35_727 VGND VGND VPWR VPWR sky130_ef_sc_hd__decap_12
XPHY_9 VGND VGND VPWR VPWR sky130_fd_sc_hd__decap_3
XFILLER_0_128_729 VGND VGND VPWR VPWR sky130_ef_sc_hd__decap_12
XFILLER_0_4_109 VGND VGND VPWR VPWR sky130_ef_sc_hd__decap_12
XFILLER_0_26_727 VGND VGND VPWR VPWR sky130_fd_sc_hd__fill_1
XTAP_616 VGND VPWR sky130_fd_sc_hd__tapvpwrvgnd_1
XTAP_605 VGND VPWR sky130_fd_sc_hd__tapvpwrvgnd_1
XFILLER_0_0_337 VGND VGND VPWR VPWR sky130_fd_sc_hd__decap_3
XTAP_649 VGND VPWR sky130_fd_sc_hd__tapvpwrvgnd_1
XTAP_638 VGND VPWR sky130_fd_sc_hd__tapvpwrvgnd_1
XTAP_627 VGND VPWR sky130_fd_sc_hd__tapvpwrvgnd_1
XFILLER_0_142_765 VGND VGND VPWR VPWR sky130_ef_sc_hd__decap_12
XFILLER_0_127_751 VGND VGND VPWR VPWR sky130_fd_sc_hd__decap_4
Xinput61 DI[26] VGND VGND VPWR VPWR net61 sky130_fd_sc_hd__buf_4
Xinput50 DI[16] VGND VGND VPWR VPWR net50 sky130_fd_sc_hd__buf_4
Xinput72 DI[7] VGND VGND VPWR VPWR net72 sky130_fd_sc_hd__buf_4
XFILLER_0_4_643 VGND VGND VPWR VPWR sky130_fd_sc_hd__fill_1
XFILLER_0_17_727 VGND VGND VPWR VPWR sky130_ef_sc_hd__decap_12
XFILLER_0_25_793 VGND VGND VPWR VPWR sky130_fd_sc_hd__decap_8
Xinput83 WLOFF VGND VGND VPWR VPWR net83 sky130_fd_sc_hd__buf_4
XFILLER_0_40_741 VGND VGND VPWR VPWR sky130_ef_sc_hd__decap_12
XFILLER_0_40_785 VGND VGND VPWR VPWR sky130_ef_sc_hd__decap_12
XFILLER_0_98_785 VGND VGND VPWR VPWR sky130_ef_sc_hd__decap_12
XFILLER_0_98_741 VGND VGND VPWR VPWR sky130_ef_sc_hd__decap_12
XFILLER_0_124_765 VGND VGND VPWR VPWR sky130_ef_sc_hd__decap_12
XFILLER_0_109_751 VGND VGND VPWR VPWR sky130_fd_sc_hd__decap_4
XFILLER_0_5_429 VGND VGND VPWR VPWR sky130_ef_sc_hd__decap_12
XFILLER_0_0_167 VGND VGND VPWR VPWR sky130_fd_sc_hd__fill_1
XTAP_413 VGND VPWR sky130_fd_sc_hd__tapvpwrvgnd_1
XTAP_402 VGND VPWR sky130_fd_sc_hd__tapvpwrvgnd_1
XTAP_424 VGND VPWR sky130_fd_sc_hd__tapvpwrvgnd_1
XTAP_446 VGND VPWR sky130_fd_sc_hd__tapvpwrvgnd_1
XTAP_457 VGND VPWR sky130_fd_sc_hd__tapvpwrvgnd_1
XTAP_435 VGND VPWR sky130_fd_sc_hd__tapvpwrvgnd_1
XFILLER_0_22_741 VGND VGND VPWR VPWR sky130_ef_sc_hd__decap_12
XFILLER_0_22_785 VGND VGND VPWR VPWR sky130_fd_sc_hd__decap_8
XTAP_468 VGND VPWR sky130_fd_sc_hd__tapvpwrvgnd_1
XTAP_479 VGND VPWR sky130_fd_sc_hd__tapvpwrvgnd_1
XFILLER_0_9_757 VGND VGND VPWR VPWR sky130_ef_sc_hd__decap_12
XFILLER_0_8_73 VGND VGND VPWR VPWR sky130_fd_sc_hd__decap_8
XFILLER_0_95_755 VGND VGND VPWR VPWR sky130_fd_sc_hd__fill_1
XFILLER_0_106_765 VGND VGND VPWR VPWR sky130_ef_sc_hd__decap_12
XFILLER_0_121_757 VGND VGND VPWR VPWR sky130_ef_sc_hd__decap_12
XFILLER_0_86_777 VGND VGND VPWR VPWR sky130_fd_sc_hd__decap_6
XPHY_290 VGND VGND VPWR VPWR sky130_fd_sc_hd__decap_3
XFILLER_0_5_237 VGND VGND VPWR VPWR sky130_ef_sc_hd__decap_12
XFILLER_0_6_749 VGND VGND VPWR VPWR sky130_fd_sc_hd__decap_6
XFILLER_0_10_777 VGND VGND VPWR VPWR sky130_fd_sc_hd__decap_6
XFILLER_0_77_755 VGND VGND VPWR VPWR sky130_fd_sc_hd__fill_1
XFILLER_0_92_703 VGND VGND VPWR VPWR sky130_ef_sc_hd__decap_12
XFILLER_0_103_757 VGND VGND VPWR VPWR sky130_ef_sc_hd__decap_12
XFILLER_0_83_769 VGND VGND VPWR VPWR sky130_ef_sc_hd__decap_12
XFILLER_0_83_703 VGND VGND VPWR VPWR sky130_ef_sc_hd__decap_12
XFILLER_0_68_777 VGND VGND VPWR VPWR sky130_fd_sc_hd__decap_6
XFILLER_0_59_755 VGND VGND VPWR VPWR sky130_fd_sc_hd__fill_1
XFILLER_0_74_703 VGND VGND VPWR VPWR sky130_ef_sc_hd__decap_12
XFILLER_0_6_513 VGND VGND VPWR VPWR sky130_ef_sc_hd__decap_12
XFILLER_0_6_557 VGND VGND VPWR VPWR sky130_ef_sc_hd__decap_12
XFILLER_0_100_727 VGND VGND VPWR VPWR sky130_fd_sc_hd__fill_1
XFILLER_0_1_273 VGND VGND VPWR VPWR sky130_fd_sc_hd__decap_6
XFILLER_0_65_703 VGND VGND VPWR VPWR sky130_ef_sc_hd__decap_12
XFILLER_0_65_769 VGND VGND VPWR VPWR sky130_ef_sc_hd__decap_12
XFILLER_0_1_3 VGND VGND VPWR VPWR sky130_ef_sc_hd__decap_12
XFILLER_0_71_739 VGND VGND VPWR VPWR sky130_ef_sc_hd__decap_12
XFILLER_0_56_703 VGND VGND VPWR VPWR sky130_ef_sc_hd__decap_12
XFILLER_0_3_505 VGND VGND VPWR VPWR sky130_ef_sc_hd__decap_12
Xinput4 AD[3] VGND VGND VPWR VPWR net4 sky130_fd_sc_hd__clkbuf_4
XFILLER_0_47_703 VGND VGND VPWR VPWR sky130_ef_sc_hd__decap_12
XFILLER_0_70_783 VGND VGND VPWR VPWR sky130_fd_sc_hd__fill_1
XFILLER_0_47_769 VGND VGND VPWR VPWR sky130_ef_sc_hd__decap_12
XFILLER_0_6_321 VGND VGND VPWR VPWR sky130_ef_sc_hd__decap_12
XFILLER_0_6_365 VGND VGND VPWR VPWR sky130_ef_sc_hd__decap_12
XFILLER_0_53_739 VGND VGND VPWR VPWR sky130_ef_sc_hd__decap_12
XFILLER_0_38_703 VGND VGND VPWR VPWR sky130_ef_sc_hd__decap_12
XFILLER_0_146_719 VGND VGND VPWR VPWR sky130_fd_sc_hd__decap_8
XFILLER_0_29_703 VGND VGND VPWR VPWR sky130_ef_sc_hd__decap_12
XFILLER_0_154_785 VGND VGND VPWR VPWR sky130_ef_sc_hd__decap_12
XFILLER_0_154_774 VGND VGND VPWR VPWR sky130_fd_sc_hd__fill_2
XFILLER_0_139_793 VGND VGND VPWR VPWR sky130_fd_sc_hd__decap_8
XFILLER_0_3_335 VGND VGND VPWR VPWR sky130_fd_sc_hd__fill_1
XFILLER_0_29_769 VGND VGND VPWR VPWR sky130_ef_sc_hd__decap_12
XFILLER_0_52_783 VGND VGND VPWR VPWR sky130_fd_sc_hd__fill_1
XFILLER_0_2_53 VGND VGND VPWR VPWR sky130_ef_sc_hd__decap_12
XANTENNA_31 TM VGND VGND VPWR VPWR sky130_fd_sc_hd__diode_2
XANTENNA_20 BEN[7] VGND VGND VPWR VPWR sky130_fd_sc_hd__diode_2
XPHY_119 VGND VGND VPWR VPWR sky130_fd_sc_hd__decap_3
XPHY_108 VGND VGND VPWR VPWR sky130_fd_sc_hd__decap_3
XFILLER_0_2_97 VGND VGND VPWR VPWR sky130_ef_sc_hd__decap_12
XFILLER_0_7_641 VGND VGND VPWR VPWR sky130_ef_sc_hd__decap_12
XFILLER_0_35_739 VGND VGND VPWR VPWR sky130_ef_sc_hd__decap_12
XANTENNA_42 net93 VGND VGND VPWR VPWR sky130_fd_sc_hd__diode_2
XANTENNA_53 net100 VGND VGND VPWR VPWR sky130_fd_sc_hd__diode_2
XFILLER_0_6_195 VGND VGND VPWR VPWR sky130_fd_sc_hd__fill_1
XANTENNA_64 net113 VGND VGND VPWR VPWR sky130_fd_sc_hd__diode_2
XFILLER_0_7_685 VGND VGND VPWR VPWR sky130_ef_sc_hd__decap_12
XFILLER_0_151_744 VGND VGND VPWR VPWR sky130_fd_sc_hd__fill_2
XFILLER_0_136_785 VGND VGND VPWR VPWR sky130_ef_sc_hd__decap_12
XFILLER_0_136_741 VGND VGND VPWR VPWR sky130_ef_sc_hd__decap_12
XTAP_639 VGND VPWR sky130_fd_sc_hd__tapvpwrvgnd_1
XTAP_628 VGND VPWR sky130_fd_sc_hd__tapvpwrvgnd_1
XTAP_617 VGND VPWR sky130_fd_sc_hd__tapvpwrvgnd_1
XTAP_606 VGND VPWR sky130_fd_sc_hd__tapvpwrvgnd_1
XFILLER_0_34_783 VGND VGND VPWR VPWR sky130_fd_sc_hd__fill_1
XFILLER_0_8_405 VGND VGND VPWR VPWR sky130_ef_sc_hd__decap_12
XFILLER_0_8_449 VGND VGND VPWR VPWR sky130_ef_sc_hd__decap_12
XFILLER_0_17_739 VGND VGND VPWR VPWR sky130_ef_sc_hd__decap_12
Xinput84 vpwrac VGND VGND VPWR VPWR net84 sky130_fd_sc_hd__buf_6
Xinput40 BEN[7] VGND VGND VPWR VPWR net40 sky130_fd_sc_hd__buf_4
XFILLER_0_142_777 VGND VGND VPWR VPWR sky130_fd_sc_hd__decap_6
Xinput62 DI[27] VGND VGND VPWR VPWR net62 sky130_fd_sc_hd__buf_4
Xinput51 DI[17] VGND VGND VPWR VPWR net51 sky130_fd_sc_hd__buf_4
Xinput73 DI[8] VGND VGND VPWR VPWR net73 sky130_fd_sc_hd__buf_4
XFILLER_0_4_699 VGND VGND VPWR VPWR sky130_fd_sc_hd__fill_1
XFILLER_0_40_753 VGND VGND VPWR VPWR sky130_ef_sc_hd__decap_12
XFILLER_0_40_797 VGND VGND VPWR VPWR sky130_fd_sc_hd__decap_4
XFILLER_0_118_785 VGND VGND VPWR VPWR sky130_fd_sc_hd__decap_8
XFILLER_0_118_741 VGND VGND VPWR VPWR sky130_ef_sc_hd__decap_12
XFILLER_0_133_755 VGND VGND VPWR VPWR sky130_fd_sc_hd__fill_1
XFILLER_0_16_783 VGND VGND VPWR VPWR sky130_fd_sc_hd__fill_1
XFILLER_0_98_797 VGND VGND VPWR VPWR sky130_fd_sc_hd__decap_4
XFILLER_0_98_753 VGND VGND VPWR VPWR sky130_ef_sc_hd__decap_12
XFILLER_0_124_777 VGND VGND VPWR VPWR sky130_fd_sc_hd__decap_6
XFILLER_0_22_753 VGND VGND VPWR VPWR sky130_ef_sc_hd__decap_12
XFILLER_0_0_113 VGND VGND VPWR VPWR sky130_fd_sc_hd__fill_2
XTAP_414 VGND VPWR sky130_fd_sc_hd__tapvpwrvgnd_1
XTAP_403 VGND VPWR sky130_fd_sc_hd__tapvpwrvgnd_1
XTAP_425 VGND VPWR sky130_fd_sc_hd__tapvpwrvgnd_1
XTAP_447 VGND VPWR sky130_fd_sc_hd__tapvpwrvgnd_1
XTAP_458 VGND VPWR sky130_fd_sc_hd__tapvpwrvgnd_1
XTAP_436 VGND VPWR sky130_fd_sc_hd__tapvpwrvgnd_1
XTAP_469 VGND VPWR sky130_fd_sc_hd__tapvpwrvgnd_1
XFILLER_0_9_703 VGND VGND VPWR VPWR sky130_ef_sc_hd__decap_12
XFILLER_0_9_769 VGND VGND VPWR VPWR sky130_ef_sc_hd__decap_12
XFILLER_0_115_755 VGND VGND VPWR VPWR sky130_fd_sc_hd__fill_1
XFILLER_0_8_41 VGND VGND VPWR VPWR sky130_fd_sc_hd__decap_4
XFILLER_0_8_85 VGND VGND VPWR VPWR sky130_ef_sc_hd__decap_12
XFILLER_0_121_703 VGND VGND VPWR VPWR sky130_ef_sc_hd__decap_12
XFILLER_0_106_777 VGND VGND VPWR VPWR sky130_fd_sc_hd__decap_6
XFILLER_0_121_769 VGND VGND VPWR VPWR sky130_ef_sc_hd__decap_12
XPHY_291 VGND VGND VPWR VPWR sky130_fd_sc_hd__decap_3
XPHY_280 VGND VGND VPWR VPWR sky130_fd_sc_hd__decap_3
XFILLER_0_5_205 VGND VGND VPWR VPWR sky130_ef_sc_hd__decap_12
XFILLER_0_112_703 VGND VGND VPWR VPWR sky130_ef_sc_hd__decap_12
XFILLER_0_5_249 VGND VGND VPWR VPWR sky130_ef_sc_hd__decap_12
XFILLER_0_92_715 VGND VGND VPWR VPWR sky130_ef_sc_hd__decap_12
XFILLER_0_103_703 VGND VGND VPWR VPWR sky130_ef_sc_hd__decap_12
XFILLER_0_5_783 VGND VGND VPWR VPWR sky130_fd_sc_hd__fill_1
XFILLER_0_103_769 VGND VGND VPWR VPWR sky130_ef_sc_hd__decap_12
XFILLER_0_3_7 VGND VGND VPWR VPWR sky130_fd_sc_hd__fill_2
XFILLER_0_83_715 VGND VGND VPWR VPWR sky130_ef_sc_hd__decap_12
XFILLER_0_91_781 VGND VGND VPWR VPWR sky130_ef_sc_hd__decap_12
XFILLER_0_3_709 VGND VGND VPWR VPWR sky130_ef_sc_hd__decap_12
XFILLER_0_74_715 VGND VGND VPWR VPWR sky130_ef_sc_hd__decap_12
XFILLER_0_6_525 VGND VGND VPWR VPWR sky130_fd_sc_hd__decap_6
XFILLER_0_6_569 VGND VGND VPWR VPWR sky130_ef_sc_hd__decap_12
XFILLER_0_65_715 VGND VGND VPWR VPWR sky130_ef_sc_hd__decap_12
XFILLER_0_80_729 VGND VGND VPWR VPWR sky130_ef_sc_hd__decap_12
XFILLER_0_73_781 VGND VGND VPWR VPWR sky130_ef_sc_hd__decap_12
XFILLER_0_56_715 VGND VGND VPWR VPWR sky130_ef_sc_hd__decap_12
XFILLER_0_3_517 VGND VGND VPWR VPWR sky130_ef_sc_hd__decap_12
Xinput5 AD[4] VGND VGND VPWR VPWR net5 sky130_fd_sc_hd__buf_2
XFILLER_0_149_728 VGND VGND VPWR VPWR sky130_fd_sc_hd__fill_2
XFILLER_0_47_715 VGND VGND VPWR VPWR sky130_ef_sc_hd__decap_12
XFILLER_0_62_729 VGND VGND VPWR VPWR sky130_ef_sc_hd__decap_12
XFILLER_0_55_781 VGND VGND VPWR VPWR sky130_ef_sc_hd__decap_12
XFILLER_0_6_333 VGND VGND VPWR VPWR sky130_ef_sc_hd__decap_12
XFILLER_0_6_377 VGND VGND VPWR VPWR sky130_ef_sc_hd__decap_12
XFILLER_0_38_715 VGND VGND VPWR VPWR sky130_ef_sc_hd__decap_12
XFILLER_0_148_783 VGND VGND VPWR VPWR sky130_fd_sc_hd__fill_1
XFILLER_0_61_751 VGND VGND VPWR VPWR sky130_fd_sc_hd__decap_4
XFILLER_0_29_715 VGND VGND VPWR VPWR sky130_ef_sc_hd__decap_12
XFILLER_0_154_797 VGND VGND VPWR VPWR sky130_fd_sc_hd__decap_4
XFILLER_0_44_729 VGND VGND VPWR VPWR sky130_ef_sc_hd__decap_12
XFILLER_0_37_781 VGND VGND VPWR VPWR sky130_ef_sc_hd__decap_12
XFILLER_0_2_65 VGND VGND VPWR VPWR sky130_ef_sc_hd__decap_12
XANTENNA_32 WLBI VGND VGND VPWR VPWR sky130_fd_sc_hd__diode_2
XANTENNA_21 BEN[8] VGND VGND VPWR VPWR sky130_fd_sc_hd__diode_2
XANTENNA_10 BEN[18] VGND VGND VPWR VPWR sky130_fd_sc_hd__diode_2
XANTENNA_54 net101 VGND VGND VPWR VPWR sky130_fd_sc_hd__diode_2
XPHY_109 VGND VGND VPWR VPWR sky130_fd_sc_hd__decap_3
XANTENNA_43 net93 VGND VGND VPWR VPWR sky130_fd_sc_hd__diode_2
XANTENNA_65 net113 VGND VGND VPWR VPWR sky130_fd_sc_hd__diode_2
XFILLER_0_6_141 VGND VGND VPWR VPWR sky130_ef_sc_hd__decap_12
XFILLER_0_7_653 VGND VGND VPWR VPWR sky130_ef_sc_hd__decap_12
XFILLER_0_7_697 VGND VGND VPWR VPWR sky130_ef_sc_hd__decap_12
XFILLER_0_43_751 VGND VGND VPWR VPWR sky130_fd_sc_hd__decap_4
XFILLER_0_151_723 VGND VGND VPWR VPWR sky130_fd_sc_hd__fill_2
XFILLER_0_136_797 VGND VGND VPWR VPWR sky130_fd_sc_hd__decap_4
XFILLER_0_136_753 VGND VGND VPWR VPWR sky130_ef_sc_hd__decap_12
XFILLER_0_19_781 VGND VGND VPWR VPWR sky130_ef_sc_hd__decap_12
XFILLER_0_26_729 VGND VGND VPWR VPWR sky130_ef_sc_hd__decap_12
XTAP_629 VGND VPWR sky130_fd_sc_hd__tapvpwrvgnd_1
XTAP_618 VGND VPWR sky130_fd_sc_hd__tapvpwrvgnd_1
XTAP_607 VGND VPWR sky130_fd_sc_hd__tapvpwrvgnd_1
XFILLER_0_4_601 VGND VGND VPWR VPWR sky130_ef_sc_hd__decap_12
XFILLER_0_8_417 VGND VGND VPWR VPWR sky130_fd_sc_hd__decap_3
Xinput41 BEN[8] VGND VGND VPWR VPWR net41 sky130_fd_sc_hd__buf_4
Xinput30 BEN[27] VGND VGND VPWR VPWR net30 sky130_fd_sc_hd__buf_2
Xinput85 vpwrpc VGND VGND VPWR VPWR net85 sky130_fd_sc_hd__buf_6
Xinput63 DI[28] VGND VGND VPWR VPWR net63 sky130_fd_sc_hd__buf_4
Xinput52 DI[18] VGND VGND VPWR VPWR net52 sky130_fd_sc_hd__buf_4
Xinput74 DI[9] VGND VGND VPWR VPWR net74 sky130_fd_sc_hd__buf_4
XFILLER_0_3_111 VGND VGND VPWR VPWR sky130_fd_sc_hd__fill_1
XFILLER_0_4_645 VGND VGND VPWR VPWR sky130_ef_sc_hd__decap_12
XFILLER_0_25_751 VGND VGND VPWR VPWR sky130_fd_sc_hd__decap_4
XFILLER_0_40_765 VGND VGND VPWR VPWR sky130_ef_sc_hd__decap_12
XFILLER_0_118_753 VGND VGND VPWR VPWR sky130_ef_sc_hd__decap_12
XFILLER_0_7_461 VGND VGND VPWR VPWR sky130_ef_sc_hd__decap_12
XFILLER_0_98_765 VGND VGND VPWR VPWR sky130_ef_sc_hd__decap_12
XFILLER_0_1_615 VGND VGND VPWR VPWR sky130_fd_sc_hd__fill_1
XFILLER_0_22_765 VGND VGND VPWR VPWR sky130_ef_sc_hd__decap_12
XFILLER_0_0_147 VGND VGND VPWR VPWR sky130_ef_sc_hd__decap_12
XTAP_415 VGND VPWR sky130_fd_sc_hd__tapvpwrvgnd_1
XTAP_404 VGND VPWR sky130_fd_sc_hd__tapvpwrvgnd_1
XTAP_426 VGND VPWR sky130_fd_sc_hd__tapvpwrvgnd_1
XTAP_448 VGND VPWR sky130_fd_sc_hd__tapvpwrvgnd_1
XTAP_459 VGND VPWR sky130_fd_sc_hd__tapvpwrvgnd_1
XTAP_437 VGND VPWR sky130_fd_sc_hd__tapvpwrvgnd_1
XFILLER_0_9_715 VGND VGND VPWR VPWR sky130_ef_sc_hd__decap_12
XFILLER_0_8_20 VGND VGND VPWR VPWR sky130_fd_sc_hd__fill_2
XFILLER_0_8_225 VGND VGND VPWR VPWR sky130_ef_sc_hd__decap_12
XFILLER_0_4_475 VGND VGND VPWR VPWR sky130_fd_sc_hd__fill_1
XFILLER_0_8_97 VGND VGND VPWR VPWR sky130_ef_sc_hd__decap_12
XFILLER_0_95_757 VGND VGND VPWR VPWR sky130_ef_sc_hd__decap_12
XFILLER_0_121_715 VGND VGND VPWR VPWR sky130_ef_sc_hd__decap_12
XFILLER_0_8_781 VGND VGND VPWR VPWR sky130_fd_sc_hd__decap_3
XPHY_292 VGND VGND VPWR VPWR sky130_fd_sc_hd__decap_3
XPHY_281 VGND VGND VPWR VPWR sky130_fd_sc_hd__decap_3
XPHY_270 VGND VGND VPWR VPWR sky130_fd_sc_hd__decap_3
XFILLER_0_5_217 VGND VGND VPWR VPWR sky130_fd_sc_hd__decap_6
XFILLER_0_112_715 VGND VGND VPWR VPWR sky130_ef_sc_hd__decap_12
XFILLER_0_92_727 VGND VGND VPWR VPWR sky130_fd_sc_hd__fill_1
XFILLER_0_77_757 VGND VGND VPWR VPWR sky130_ef_sc_hd__decap_12
XFILLER_0_103_715 VGND VGND VPWR VPWR sky130_ef_sc_hd__decap_12
XFILLER_0_111_781 VGND VGND VPWR VPWR sky130_ef_sc_hd__decap_12
XFILLER_0_83_727 VGND VGND VPWR VPWR sky130_ef_sc_hd__decap_12
XFILLER_0_91_793 VGND VGND VPWR VPWR sky130_fd_sc_hd__decap_8
XFILLER_0_2_209 VGND VGND VPWR VPWR sky130_ef_sc_hd__decap_12
XFILLER_0_74_727 VGND VGND VPWR VPWR sky130_fd_sc_hd__fill_1
XFILLER_0_59_757 VGND VGND VPWR VPWR sky130_ef_sc_hd__decap_12
XFILLER_0_100_729 VGND VGND VPWR VPWR sky130_ef_sc_hd__decap_12
XFILLER_0_5_43 VGND VGND VPWR VPWR sky130_fd_sc_hd__decap_4
XFILLER_0_65_727 VGND VGND VPWR VPWR sky130_ef_sc_hd__decap_12
XFILLER_0_73_793 VGND VGND VPWR VPWR sky130_fd_sc_hd__decap_8
XFILLER_0_56_727 VGND VGND VPWR VPWR sky130_fd_sc_hd__fill_1
XFILLER_0_3_529 VGND VGND VPWR VPWR sky130_ef_sc_hd__decap_12
Xinput6 AD[5] VGND VGND VPWR VPWR net6 sky130_fd_sc_hd__buf_2
XFILLER_0_47_727 VGND VGND VPWR VPWR sky130_ef_sc_hd__decap_12
XFILLER_0_6_301 VGND VGND VPWR VPWR sky130_fd_sc_hd__decap_6
XFILLER_0_70_785 VGND VGND VPWR VPWR sky130_ef_sc_hd__decap_12
XFILLER_0_70_741 VGND VGND VPWR VPWR sky130_ef_sc_hd__decap_12
XFILLER_0_55_793 VGND VGND VPWR VPWR sky130_fd_sc_hd__decap_8
XFILLER_0_6_345 VGND VGND VPWR VPWR sky130_ef_sc_hd__decap_12
XFILLER_0_6_389 VGND VGND VPWR VPWR sky130_ef_sc_hd__decap_12
XFILLER_0_38_727 VGND VGND VPWR VPWR sky130_fd_sc_hd__fill_1
XFILLER_0_139_751 VGND VGND VPWR VPWR sky130_fd_sc_hd__decap_4
XPHY_90 VGND VGND VPWR VPWR sky130_fd_sc_hd__decap_3
XFILLER_0_29_727 VGND VGND VPWR VPWR sky130_ef_sc_hd__decap_12
XFILLER_0_154_754 VGND VGND VPWR VPWR sky130_fd_sc_hd__fill_2
XFILLER_0_52_785 VGND VGND VPWR VPWR sky130_ef_sc_hd__decap_12
XFILLER_0_52_741 VGND VGND VPWR VPWR sky130_ef_sc_hd__decap_12
XFILLER_0_3_337 VGND VGND VPWR VPWR sky130_ef_sc_hd__decap_12
XFILLER_0_37_793 VGND VGND VPWR VPWR sky130_fd_sc_hd__decap_8
XFILLER_0_2_77 VGND VGND VPWR VPWR sky130_fd_sc_hd__decap_6
XANTENNA_11 BEN[19] VGND VGND VPWR VPWR sky130_fd_sc_hd__diode_2
XANTENNA_22 BEN[9] VGND VGND VPWR VPWR sky130_fd_sc_hd__diode_2
XANTENNA_33 WLOFF VGND VGND VPWR VPWR sky130_fd_sc_hd__diode_2
XANTENNA_44 net94 VGND VGND VPWR VPWR sky130_fd_sc_hd__diode_2
XANTENNA_55 net101 VGND VGND VPWR VPWR sky130_fd_sc_hd__diode_2
XANTENNA_66 net114 VGND VGND VPWR VPWR sky130_fd_sc_hd__diode_2
XFILLER_0_6_153 VGND VGND VPWR VPWR sky130_ef_sc_hd__decap_12
XFILLER_0_7_665 VGND VGND VPWR VPWR sky130_fd_sc_hd__decap_6
XFILLER_0_6_197 VGND VGND VPWR VPWR sky130_ef_sc_hd__decap_12
XFILLER_0_151_757 VGND VGND VPWR VPWR sky130_ef_sc_hd__decap_12
XFILLER_0_136_765 VGND VGND VPWR VPWR sky130_ef_sc_hd__decap_12
XFILLER_0_19_793 VGND VGND VPWR VPWR sky130_fd_sc_hd__decap_8
XFILLER_0_34_741 VGND VGND VPWR VPWR sky130_ef_sc_hd__decap_12
XFILLER_0_34_785 VGND VGND VPWR VPWR sky130_ef_sc_hd__decap_12
XTAP_619 VGND VPWR sky130_fd_sc_hd__tapvpwrvgnd_1
XTAP_608 VGND VPWR sky130_fd_sc_hd__tapvpwrvgnd_1
Xinput31 BEN[28] VGND VGND VPWR VPWR net31 sky130_fd_sc_hd__buf_2
Xinput20 BEN[18] VGND VGND VPWR VPWR net20 sky130_fd_sc_hd__buf_2
XFILLER_0_4_613 VGND VGND VPWR VPWR sky130_ef_sc_hd__decap_12
Xinput75 EN VGND VGND VPWR VPWR net75 sky130_fd_sc_hd__buf_4
Xinput42 BEN[9] VGND VGND VPWR VPWR net42 sky130_fd_sc_hd__buf_4
Xinput64 DI[29] VGND VGND VPWR VPWR net64 sky130_fd_sc_hd__buf_4
Xinput53 DI[19] VGND VGND VPWR VPWR net53 sky130_fd_sc_hd__buf_4
XFILLER_0_3_167 VGND VGND VPWR VPWR sky130_fd_sc_hd__fill_1
XFILLER_0_4_657 VGND VGND VPWR VPWR sky130_ef_sc_hd__decap_12
XFILLER_0_40_777 VGND VGND VPWR VPWR sky130_fd_sc_hd__decap_6
XFILLER_0_133_757 VGND VGND VPWR VPWR sky130_ef_sc_hd__decap_12
XFILLER_0_118_765 VGND VGND VPWR VPWR sky130_ef_sc_hd__decap_12
XFILLER_0_7_473 VGND VGND VPWR VPWR sky130_ef_sc_hd__decap_12
XFILLER_0_16_741 VGND VGND VPWR VPWR sky130_ef_sc_hd__decap_12
XFILLER_0_16_785 VGND VGND VPWR VPWR sky130_ef_sc_hd__decap_12
XFILLER_0_31_755 VGND VGND VPWR VPWR sky130_fd_sc_hd__fill_1
XFILLER_0_98_777 VGND VGND VPWR VPWR sky130_fd_sc_hd__decap_6
XFILLER_0_0_159 VGND VGND VPWR VPWR sky130_fd_sc_hd__decap_8
XTAP_405 VGND VPWR sky130_fd_sc_hd__tapvpwrvgnd_1
XFILLER_0_22_777 VGND VGND VPWR VPWR sky130_fd_sc_hd__decap_6
XTAP_416 VGND VPWR sky130_fd_sc_hd__tapvpwrvgnd_1
XTAP_438 VGND VPWR sky130_fd_sc_hd__tapvpwrvgnd_1
XTAP_427 VGND VPWR sky130_fd_sc_hd__tapvpwrvgnd_1
XTAP_449 VGND VPWR sky130_fd_sc_hd__tapvpwrvgnd_1
XFILLER_0_89_755 VGND VGND VPWR VPWR sky130_fd_sc_hd__fill_1
XFILLER_0_9_727 VGND VGND VPWR VPWR sky130_ef_sc_hd__decap_12
XFILLER_0_130_727 VGND VGND VPWR VPWR sky130_fd_sc_hd__fill_1
XFILLER_0_115_757 VGND VGND VPWR VPWR sky130_ef_sc_hd__decap_12
XFILLER_0_4_421 VGND VGND VPWR VPWR sky130_ef_sc_hd__decap_12
XFILLER_0_8_237 VGND VGND VPWR VPWR sky130_ef_sc_hd__decap_12
XFILLER_0_0_671 VGND VGND VPWR VPWR sky130_fd_sc_hd__fill_1
XFILLER_0_13_755 VGND VGND VPWR VPWR sky130_fd_sc_hd__fill_1
XFILLER_0_95_703 VGND VGND VPWR VPWR sky130_ef_sc_hd__decap_12
XFILLER_0_95_769 VGND VGND VPWR VPWR sky130_ef_sc_hd__decap_12
XFILLER_0_121_727 VGND VGND VPWR VPWR sky130_ef_sc_hd__decap_12
XFILLER_0_7_281 VGND VGND VPWR VPWR sky130_ef_sc_hd__decap_12
XFILLER_0_86_703 VGND VGND VPWR VPWR sky130_ef_sc_hd__decap_12
XPHY_293 VGND VGND VPWR VPWR sky130_fd_sc_hd__decap_3
XPHY_282 VGND VGND VPWR VPWR sky130_fd_sc_hd__decap_3
XPHY_271 VGND VGND VPWR VPWR sky130_fd_sc_hd__decap_3
XPHY_260 VGND VGND VPWR VPWR sky130_fd_sc_hd__decap_3
XFILLER_0_112_727 VGND VGND VPWR VPWR sky130_fd_sc_hd__fill_1
XFILLER_0_10_703 VGND VGND VPWR VPWR sky130_ef_sc_hd__decap_12
XFILLER_0_77_703 VGND VGND VPWR VPWR sky130_ef_sc_hd__decap_12
XFILLER_0_77_769 VGND VGND VPWR VPWR sky130_ef_sc_hd__decap_12
XFILLER_0_103_727 VGND VGND VPWR VPWR sky130_ef_sc_hd__decap_12
XFILLER_0_4_251 VGND VGND VPWR VPWR sky130_fd_sc_hd__fill_1
XFILLER_0_5_741 VGND VGND VPWR VPWR sky130_ef_sc_hd__decap_12
XFILLER_0_5_785 VGND VGND VPWR VPWR sky130_ef_sc_hd__decap_12
XFILLER_0_111_793 VGND VGND VPWR VPWR sky130_fd_sc_hd__decap_8
XFILLER_0_68_703 VGND VGND VPWR VPWR sky130_ef_sc_hd__decap_12
XFILLER_0_83_739 VGND VGND VPWR VPWR sky130_ef_sc_hd__decap_12
XFILLER_0_102_793 VGND VGND VPWR VPWR sky130_fd_sc_hd__fill_2
XFILLER_0_59_703 VGND VGND VPWR VPWR sky130_ef_sc_hd__decap_12
XFILLER_0_59_769 VGND VGND VPWR VPWR sky130_ef_sc_hd__decap_12
XFILLER_0_82_783 VGND VGND VPWR VPWR sky130_fd_sc_hd__fill_1
XFILLER_0_2_755 VGND VGND VPWR VPWR sky130_fd_sc_hd__fill_1
XFILLER_0_5_55 VGND VGND VPWR VPWR sky130_fd_sc_hd__fill_1
XFILLER_0_65_739 VGND VGND VPWR VPWR sky130_ef_sc_hd__decap_12
XFILLER_0_64_783 VGND VGND VPWR VPWR sky130_fd_sc_hd__fill_1
Xinput7 AD[6] VGND VGND VPWR VPWR net7 sky130_fd_sc_hd__clkbuf_4
XFILLER_0_47_739 VGND VGND VPWR VPWR sky130_ef_sc_hd__decap_12
XFILLER_0_6_357 VGND VGND VPWR VPWR sky130_fd_sc_hd__decap_6
XFILLER_0_70_753 VGND VGND VPWR VPWR sky130_ef_sc_hd__decap_12
XFILLER_0_148_785 VGND VGND VPWR VPWR sky130_ef_sc_hd__decap_12
XFILLER_0_148_741 VGND VGND VPWR VPWR sky130_ef_sc_hd__decap_12
XFILLER_0_46_783 VGND VGND VPWR VPWR sky130_fd_sc_hd__fill_1
XFILLER_0_154_766 VGND VGND VPWR VPWR sky130_fd_sc_hd__fill_2
XPHY_91 VGND VGND VPWR VPWR sky130_fd_sc_hd__decap_3
XFILLER_0_29_739 VGND VGND VPWR VPWR sky130_ef_sc_hd__decap_12
XPHY_80 VGND VGND VPWR VPWR sky130_fd_sc_hd__decap_3
XFILLER_0_52_797 VGND VGND VPWR VPWR sky130_fd_sc_hd__decap_4
XFILLER_0_52_753 VGND VGND VPWR VPWR sky130_ef_sc_hd__decap_12
XFILLER_0_3_305 VGND VGND VPWR VPWR sky130_ef_sc_hd__decap_12
XFILLER_0_3_349 VGND VGND VPWR VPWR sky130_ef_sc_hd__decap_12
XANTENNA_34 vpwrac VGND VGND VPWR VPWR sky130_fd_sc_hd__diode_2
XANTENNA_23 EN VGND VGND VPWR VPWR sky130_fd_sc_hd__diode_2
XANTENNA_12 BEN[1] VGND VGND VPWR VPWR sky130_fd_sc_hd__diode_2
XANTENNA_45 net95 VGND VGND VPWR VPWR sky130_fd_sc_hd__diode_2
XANTENNA_56 net101 VGND VGND VPWR VPWR sky130_fd_sc_hd__diode_2
XANTENNA_67 net115 VGND VGND VPWR VPWR sky130_fd_sc_hd__diode_2
XFILLER_0_6_121 VGND VGND VPWR VPWR sky130_ef_sc_hd__decap_12
XFILLER_0_6_165 VGND VGND VPWR VPWR sky130_ef_sc_hd__decap_12
XFILLER_0_28_783 VGND VGND VPWR VPWR sky130_fd_sc_hd__fill_1
XFILLER_0_136_777 VGND VGND VPWR VPWR sky130_fd_sc_hd__decap_6
XFILLER_0_151_769 VGND VGND VPWR VPWR sky130_ef_sc_hd__decap_12
XFILLER_0_34_753 VGND VGND VPWR VPWR sky130_ef_sc_hd__decap_12
XFILLER_0_34_797 VGND VGND VPWR VPWR sky130_fd_sc_hd__decap_4
XTAP_609 VGND VPWR sky130_fd_sc_hd__tapvpwrvgnd_1
Xinput32 BEN[29] VGND VGND VPWR VPWR net32 sky130_fd_sc_hd__buf_2
Xinput21 BEN[19] VGND VGND VPWR VPWR net21 sky130_fd_sc_hd__buf_2
Xinput10 AD[9] VGND VGND VPWR VPWR net10 sky130_fd_sc_hd__clkbuf_4
XFILLER_0_142_703 VGND VGND VPWR VPWR sky130_ef_sc_hd__decap_12
XFILLER_0_127_755 VGND VGND VPWR VPWR sky130_fd_sc_hd__fill_1
Xinput43 DI[0] VGND VGND VPWR VPWR net43 sky130_fd_sc_hd__clkbuf_8
Xinput54 DI[1] VGND VGND VPWR VPWR net54 sky130_fd_sc_hd__buf_4
XFILLER_0_3_113 VGND VGND VPWR VPWR sky130_ef_sc_hd__decap_12
XFILLER_0_4_625 VGND VGND VPWR VPWR sky130_ef_sc_hd__decap_12
Xinput76 R_WB VGND VGND VPWR VPWR net76 sky130_fd_sc_hd__buf_4
Xinput65 DI[2] VGND VGND VPWR VPWR net65 sky130_fd_sc_hd__buf_4
XFILLER_0_4_669 VGND VGND VPWR VPWR sky130_ef_sc_hd__decap_12
XFILLER_0_7_441 VGND VGND VPWR VPWR sky130_fd_sc_hd__decap_6
XFILLER_0_133_769 VGND VGND VPWR VPWR sky130_ef_sc_hd__decap_12
XFILLER_0_133_703 VGND VGND VPWR VPWR sky130_ef_sc_hd__decap_12
XFILLER_0_118_777 VGND VGND VPWR VPWR sky130_fd_sc_hd__decap_6
XFILLER_0_7_485 VGND VGND VPWR VPWR sky130_ef_sc_hd__decap_12
XFILLER_0_16_753 VGND VGND VPWR VPWR sky130_ef_sc_hd__decap_12
XFILLER_0_16_797 VGND VGND VPWR VPWR sky130_fd_sc_hd__decap_4
XFILLER_0_124_703 VGND VGND VPWR VPWR sky130_ef_sc_hd__decap_12
XFILLER_0_109_755 VGND VGND VPWR VPWR sky130_fd_sc_hd__fill_1
XFILLER_0_1_617 VGND VGND VPWR VPWR sky130_ef_sc_hd__decap_12
XTAP_417 VGND VPWR sky130_fd_sc_hd__tapvpwrvgnd_1
XTAP_406 VGND VPWR sky130_fd_sc_hd__tapvpwrvgnd_1
XTAP_439 VGND VPWR sky130_fd_sc_hd__tapvpwrvgnd_1
XTAP_428 VGND VPWR sky130_fd_sc_hd__tapvpwrvgnd_1
XFILLER_0_8_249 VGND VGND VPWR VPWR sky130_fd_sc_hd__decap_3
XFILLER_0_9_739 VGND VGND VPWR VPWR sky130_ef_sc_hd__decap_12
XFILLER_0_115_769 VGND VGND VPWR VPWR sky130_ef_sc_hd__decap_12
XFILLER_0_115_703 VGND VGND VPWR VPWR sky130_ef_sc_hd__decap_12
XFILLER_0_4_433 VGND VGND VPWR VPWR sky130_ef_sc_hd__decap_12
XFILLER_0_4_477 VGND VGND VPWR VPWR sky130_ef_sc_hd__decap_12
XFILLER_0_8_55 VGND VGND VPWR VPWR sky130_fd_sc_hd__fill_1
XFILLER_0_95_715 VGND VGND VPWR VPWR sky130_ef_sc_hd__decap_12
XFILLER_0_106_703 VGND VGND VPWR VPWR sky130_ef_sc_hd__decap_12
XFILLER_0_7_293 VGND VGND VPWR VPWR sky130_ef_sc_hd__decap_12
XFILLER_0_121_739 VGND VGND VPWR VPWR sky130_ef_sc_hd__decap_12
XPHY_261 VGND VGND VPWR VPWR sky130_fd_sc_hd__decap_3
XPHY_250 VGND VGND VPWR VPWR sky130_fd_sc_hd__decap_3
XFILLER_0_86_715 VGND VGND VPWR VPWR sky130_ef_sc_hd__decap_12
XPHY_294 VGND VGND VPWR VPWR sky130_fd_sc_hd__decap_3
XPHY_283 VGND VGND VPWR VPWR sky130_fd_sc_hd__decap_3
XPHY_272 VGND VGND VPWR VPWR sky130_fd_sc_hd__decap_3
XFILLER_0_120_783 VGND VGND VPWR VPWR sky130_fd_sc_hd__fill_1
XFILLER_0_1_447 VGND VGND VPWR VPWR sky130_fd_sc_hd__fill_1
XFILLER_0_10_715 VGND VGND VPWR VPWR sky130_ef_sc_hd__decap_12
XFILLER_0_77_715 VGND VGND VPWR VPWR sky130_ef_sc_hd__decap_12
XFILLER_0_92_729 VGND VGND VPWR VPWR sky130_ef_sc_hd__decap_12
XFILLER_0_85_781 VGND VGND VPWR VPWR sky130_ef_sc_hd__decap_12
XFILLER_0_103_739 VGND VGND VPWR VPWR sky130_ef_sc_hd__decap_12
XFILLER_0_5_753 VGND VGND VPWR VPWR sky130_ef_sc_hd__decap_12
XFILLER_0_5_797 VGND VGND VPWR VPWR sky130_fd_sc_hd__decap_4
XFILLER_0_68_715 VGND VGND VPWR VPWR sky130_ef_sc_hd__decap_12
XFILLER_0_91_751 VGND VGND VPWR VPWR sky130_fd_sc_hd__decap_4
XFILLER_0_102_783 VGND VGND VPWR VPWR sky130_fd_sc_hd__fill_1
XFILLER_0_59_715 VGND VGND VPWR VPWR sky130_ef_sc_hd__decap_12
XFILLER_0_74_729 VGND VGND VPWR VPWR sky130_ef_sc_hd__decap_12
XFILLER_0_67_781 VGND VGND VPWR VPWR sky130_ef_sc_hd__decap_12
XFILLER_0_2_701 VGND VGND VPWR VPWR sky130_ef_sc_hd__decap_12
XFILLER_0_73_751 VGND VGND VPWR VPWR sky130_fd_sc_hd__decap_4
XFILLER_0_5_561 VGND VGND VPWR VPWR sky130_ef_sc_hd__decap_12
XFILLER_0_56_729 VGND VGND VPWR VPWR sky130_ef_sc_hd__decap_12
XFILLER_0_49_781 VGND VGND VPWR VPWR sky130_ef_sc_hd__decap_12
Xinput8 AD[7] VGND VGND VPWR VPWR net8 sky130_fd_sc_hd__clkbuf_4
XFILLER_0_149_709 VGND VGND VPWR VPWR sky130_fd_sc_hd__fill_2
XFILLER_0_70_765 VGND VGND VPWR VPWR sky130_ef_sc_hd__decap_12
XFILLER_0_55_751 VGND VGND VPWR VPWR sky130_fd_sc_hd__decap_4
XFILLER_0_2_531 VGND VGND VPWR VPWR sky130_fd_sc_hd__fill_1
XFILLER_0_148_797 VGND VGND VPWR VPWR sky130_fd_sc_hd__decap_4
XFILLER_0_148_753 VGND VGND VPWR VPWR sky130_ef_sc_hd__decap_12
XFILLER_0_38_729 VGND VGND VPWR VPWR sky130_ef_sc_hd__decap_12
XFILLER_0_5_391 VGND VGND VPWR VPWR sky130_fd_sc_hd__fill_1
XFILLER_0_154_778 VGND VGND VPWR VPWR sky130_fd_sc_hd__fill_2
XPHY_92 VGND VGND VPWR VPWR sky130_fd_sc_hd__decap_3
XFILLER_0_3_317 VGND VGND VPWR VPWR sky130_ef_sc_hd__decap_12
XPHY_70 VGND VGND VPWR VPWR sky130_fd_sc_hd__decap_3
XFILLER_0_37_751 VGND VGND VPWR VPWR sky130_fd_sc_hd__decap_4
XPHY_81 VGND VGND VPWR VPWR sky130_fd_sc_hd__decap_3
XFILLER_0_52_765 VGND VGND VPWR VPWR sky130_ef_sc_hd__decap_12
XANTENNA_13 BEN[20] VGND VGND VPWR VPWR sky130_fd_sc_hd__diode_2
XANTENNA_35 vpwrpc VGND VGND VPWR VPWR sky130_fd_sc_hd__diode_2
XANTENNA_24 R_WB VGND VGND VPWR VPWR sky130_fd_sc_hd__diode_2
XANTENNA_57 net102 VGND VGND VPWR VPWR sky130_fd_sc_hd__diode_2
XANTENNA_68 net116 VGND VGND VPWR VPWR sky130_fd_sc_hd__diode_2
XFILLER_0_6_133 VGND VGND VPWR VPWR sky130_fd_sc_hd__decap_6
XFILLER_0_6_177 VGND VGND VPWR VPWR sky130_ef_sc_hd__decap_12
XANTENNA_46 net96 VGND VGND VPWR VPWR sky130_fd_sc_hd__diode_2
XFILLER_0_19_751 VGND VGND VPWR VPWR sky130_fd_sc_hd__decap_4
XFILLER_0_151_748 VGND VGND VPWR VPWR sky130_fd_sc_hd__decap_8
XFILLER_0_0_309 VGND VGND VPWR VPWR sky130_fd_sc_hd__decap_6
XFILLER_0_34_765 VGND VGND VPWR VPWR sky130_ef_sc_hd__decap_12
Xinput33 BEN[2] VGND VGND VPWR VPWR net33 sky130_fd_sc_hd__buf_4
Xinput77 SM VGND VGND VPWR VPWR net77 sky130_fd_sc_hd__buf_4
Xinput11 BEN[0] VGND VGND VPWR VPWR net11 sky130_fd_sc_hd__buf_4
Xinput22 BEN[1] VGND VGND VPWR VPWR net22 sky130_fd_sc_hd__buf_4
XFILLER_0_142_715 VGND VGND VPWR VPWR sky130_ef_sc_hd__decap_12
Xinput66 DI[30] VGND VGND VPWR VPWR net66 sky130_fd_sc_hd__buf_4
Xinput55 DI[20] VGND VGND VPWR VPWR net55 sky130_fd_sc_hd__buf_4
Xinput44 DI[10] VGND VGND VPWR VPWR net44 sky130_fd_sc_hd__buf_4
XFILLER_0_3_125 VGND VGND VPWR VPWR sky130_ef_sc_hd__decap_12
XFILLER_0_3_169 VGND VGND VPWR VPWR sky130_ef_sc_hd__decap_12
XFILLER_0_4_637 VGND VGND VPWR VPWR sky130_fd_sc_hd__decap_6
XFILLER_0_150_781 VGND VGND VPWR VPWR sky130_fd_sc_hd__decap_3
XFILLER_0_133_715 VGND VGND VPWR VPWR sky130_ef_sc_hd__decap_12
XFILLER_0_141_781 VGND VGND VPWR VPWR sky130_ef_sc_hd__decap_12
XFILLER_0_7_497 VGND VGND VPWR VPWR sky130_fd_sc_hd__decap_6
XFILLER_0_16_765 VGND VGND VPWR VPWR sky130_ef_sc_hd__decap_12
XFILLER_0_31_757 VGND VGND VPWR VPWR sky130_ef_sc_hd__decap_12
XFILLER_0_124_715 VGND VGND VPWR VPWR sky130_ef_sc_hd__decap_12
XFILLER_0_1_629 VGND VGND VPWR VPWR sky130_ef_sc_hd__decap_12
XFILLER_0_0_139 VGND VGND VPWR VPWR sky130_fd_sc_hd__fill_1
XTAP_418 VGND VPWR sky130_fd_sc_hd__tapvpwrvgnd_1
XTAP_407 VGND VPWR sky130_fd_sc_hd__tapvpwrvgnd_1
XTAP_429 VGND VPWR sky130_fd_sc_hd__tapvpwrvgnd_1
XFILLER_0_89_757 VGND VGND VPWR VPWR sky130_ef_sc_hd__decap_12
XFILLER_0_115_715 VGND VGND VPWR VPWR sky130_ef_sc_hd__decap_12
XFILLER_0_130_729 VGND VGND VPWR VPWR sky130_ef_sc_hd__decap_12
XFILLER_0_123_781 VGND VGND VPWR VPWR sky130_ef_sc_hd__decap_12
XFILLER_0_4_401 VGND VGND VPWR VPWR sky130_ef_sc_hd__decap_12
XFILLER_0_4_445 VGND VGND VPWR VPWR sky130_ef_sc_hd__decap_12
XFILLER_0_4_489 VGND VGND VPWR VPWR sky130_ef_sc_hd__decap_12
XFILLER_0_13_757 VGND VGND VPWR VPWR sky130_ef_sc_hd__decap_12
XFILLER_0_0_673 VGND VGND VPWR VPWR sky130_ef_sc_hd__decap_12
XFILLER_0_0_651 VGND VGND VPWR VPWR sky130_ef_sc_hd__decap_12
XFILLER_0_95_727 VGND VGND VPWR VPWR sky130_ef_sc_hd__decap_12
XFILLER_0_106_715 VGND VGND VPWR VPWR sky130_ef_sc_hd__decap_12
XFILLER_0_7_261 VGND VGND VPWR VPWR sky130_ef_sc_hd__decap_12
XPHY_295 VGND VGND VPWR VPWR sky130_fd_sc_hd__decap_3
XPHY_284 VGND VGND VPWR VPWR sky130_fd_sc_hd__decap_3
XPHY_273 VGND VGND VPWR VPWR sky130_fd_sc_hd__decap_3
XPHY_262 VGND VGND VPWR VPWR sky130_fd_sc_hd__decap_3
XPHY_251 VGND VGND VPWR VPWR sky130_fd_sc_hd__decap_3
XPHY_240 VGND VGND VPWR VPWR sky130_fd_sc_hd__decap_3
XFILLER_0_86_727 VGND VGND VPWR VPWR sky130_fd_sc_hd__fill_1
XFILLER_0_112_729 VGND VGND VPWR VPWR sky130_ef_sc_hd__decap_12
XFILLER_0_105_781 VGND VGND VPWR VPWR sky130_ef_sc_hd__decap_12
XFILLER_0_10_727 VGND VGND VPWR VPWR sky130_fd_sc_hd__fill_1
XFILLER_0_77_727 VGND VGND VPWR VPWR sky130_ef_sc_hd__decap_12
XFILLER_0_85_793 VGND VGND VPWR VPWR sky130_fd_sc_hd__decap_8
XFILLER_0_5_721 VGND VGND VPWR VPWR sky130_fd_sc_hd__decap_6
XFILLER_0_5_765 VGND VGND VPWR VPWR sky130_ef_sc_hd__decap_12
XFILLER_0_111_751 VGND VGND VPWR VPWR sky130_fd_sc_hd__decap_4
XFILLER_0_4_253 VGND VGND VPWR VPWR sky130_ef_sc_hd__decap_12
XFILLER_0_68_727 VGND VGND VPWR VPWR sky130_fd_sc_hd__fill_1
XFILLER_0_59_727 VGND VGND VPWR VPWR sky130_ef_sc_hd__decap_12
XFILLER_0_82_785 VGND VGND VPWR VPWR sky130_ef_sc_hd__decap_12
XFILLER_0_82_741 VGND VGND VPWR VPWR sky130_ef_sc_hd__decap_12
XFILLER_0_67_793 VGND VGND VPWR VPWR sky130_fd_sc_hd__decap_8
XFILLER_0_2_757 VGND VGND VPWR VPWR sky130_ef_sc_hd__decap_12
XFILLER_0_2_713 VGND VGND VPWR VPWR sky130_ef_sc_hd__decap_12
XFILLER_0_1_223 VGND VGND VPWR VPWR sky130_fd_sc_hd__fill_1
XFILLER_0_5_35 VGND VGND VPWR VPWR sky130_fd_sc_hd__fill_2
XFILLER_0_5_57 VGND VGND VPWR VPWR sky130_ef_sc_hd__decap_12
XFILLER_0_5_573 VGND VGND VPWR VPWR sky130_ef_sc_hd__decap_12
XTAP_590 VGND VPWR sky130_fd_sc_hd__tapvpwrvgnd_1
XFILLER_0_64_785 VGND VGND VPWR VPWR sky130_ef_sc_hd__decap_12
XFILLER_0_64_741 VGND VGND VPWR VPWR sky130_ef_sc_hd__decap_12
XFILLER_0_49_793 VGND VGND VPWR VPWR sky130_fd_sc_hd__decap_8
Xinput9 AD[8] VGND VGND VPWR VPWR net9 sky130_fd_sc_hd__clkbuf_4
XFILLER_0_70_777 VGND VGND VPWR VPWR sky130_fd_sc_hd__decap_6
XFILLER_0_2_587 VGND VGND VPWR VPWR sky130_fd_sc_hd__fill_1
XFILLER_0_148_765 VGND VGND VPWR VPWR sky130_ef_sc_hd__decap_12
XFILLER_0_46_785 VGND VGND VPWR VPWR sky130_ef_sc_hd__decap_12
XFILLER_0_46_741 VGND VGND VPWR VPWR sky130_ef_sc_hd__decap_12
XFILLER_0_61_755 VGND VGND VPWR VPWR sky130_fd_sc_hd__fill_1
XPHY_60 VGND VGND VPWR VPWR sky130_fd_sc_hd__decap_3
XPHY_71 VGND VGND VPWR VPWR sky130_fd_sc_hd__decap_3
XPHY_82 VGND VGND VPWR VPWR sky130_fd_sc_hd__decap_3
XFILLER_0_52_777 VGND VGND VPWR VPWR sky130_fd_sc_hd__decap_6
XPHY_93 VGND VGND VPWR VPWR sky130_fd_sc_hd__decap_3
XFILLER_0_3_329 VGND VGND VPWR VPWR sky130_fd_sc_hd__decap_6
XANTENNA_14 BEN[21] VGND VGND VPWR VPWR sky130_fd_sc_hd__diode_2
XANTENNA_25 SM VGND VGND VPWR VPWR sky130_fd_sc_hd__diode_2
XFILLER_0_145_757 VGND VGND VPWR VPWR sky130_ef_sc_hd__decap_12
XANTENNA_47 net97 VGND VGND VPWR VPWR sky130_fd_sc_hd__diode_2
XANTENNA_36 net86 VGND VGND VPWR VPWR sky130_fd_sc_hd__diode_2
XFILLER_0_28_741 VGND VGND VPWR VPWR sky130_ef_sc_hd__decap_12
XFILLER_0_28_785 VGND VGND VPWR VPWR sky130_ef_sc_hd__decap_12
Xoutput110 net110 VGND VGND VPWR VPWR DO[31] sky130_fd_sc_hd__clkbuf_8
XANTENNA_69 net118 VGND VGND VPWR VPWR sky130_fd_sc_hd__diode_2
XFILLER_0_43_755 VGND VGND VPWR VPWR sky130_fd_sc_hd__fill_1
XANTENNA_58 net102 VGND VGND VPWR VPWR sky130_fd_sc_hd__diode_2
XFILLER_0_6_189 VGND VGND VPWR VPWR sky130_fd_sc_hd__decap_6
XFILLER_0_151_727 VGND VGND VPWR VPWR sky130_fd_sc_hd__fill_2
XFILLER_0_34_777 VGND VGND VPWR VPWR sky130_fd_sc_hd__decap_6
XFILLER_0_127_757 VGND VGND VPWR VPWR sky130_ef_sc_hd__decap_12
Xinput34 BEN[30] VGND VGND VPWR VPWR net34 sky130_fd_sc_hd__buf_2
Xinput12 BEN[10] VGND VGND VPWR VPWR net12 sky130_fd_sc_hd__buf_4
Xinput23 BEN[20] VGND VGND VPWR VPWR net23 sky130_fd_sc_hd__buf_2
XFILLER_0_150_793 VGND VGND VPWR VPWR sky130_fd_sc_hd__fill_2
Xinput78 ScanInCC VGND VGND VPWR VPWR net78 sky130_fd_sc_hd__buf_4
XFILLER_0_142_727 VGND VGND VPWR VPWR sky130_fd_sc_hd__fill_1
XFILLER_0_0_800 VGND VGND VPWR VPWR sky130_fd_sc_hd__fill_1
Xinput67 DI[31] VGND VGND VPWR VPWR net67 sky130_fd_sc_hd__buf_4
Xinput56 DI[21] VGND VGND VPWR VPWR net56 sky130_fd_sc_hd__buf_4
Xinput45 DI[11] VGND VGND VPWR VPWR net45 sky130_fd_sc_hd__clkbuf_4
XFILLER_0_3_137 VGND VGND VPWR VPWR sky130_ef_sc_hd__decap_12
XFILLER_0_25_755 VGND VGND VPWR VPWR sky130_fd_sc_hd__fill_1
XFILLER_0_40_703 VGND VGND VPWR VPWR sky130_ef_sc_hd__decap_12
XFILLER_0_133_727 VGND VGND VPWR VPWR sky130_ef_sc_hd__decap_12
XFILLER_0_16_777 VGND VGND VPWR VPWR sky130_fd_sc_hd__decap_6
XFILLER_0_31_703 VGND VGND VPWR VPWR sky130_ef_sc_hd__decap_12
XFILLER_0_141_793 VGND VGND VPWR VPWR sky130_fd_sc_hd__decap_8
XFILLER_0_3_671 VGND VGND VPWR VPWR sky130_fd_sc_hd__fill_1
XFILLER_0_31_769 VGND VGND VPWR VPWR sky130_ef_sc_hd__decap_12
XFILLER_0_98_703 VGND VGND VPWR VPWR sky130_ef_sc_hd__decap_12
XFILLER_0_109_757 VGND VGND VPWR VPWR sky130_ef_sc_hd__decap_12
XFILLER_0_124_727 VGND VGND VPWR VPWR sky130_fd_sc_hd__fill_1
XFILLER_0_22_703 VGND VGND VPWR VPWR sky130_ef_sc_hd__decap_12
XTAP_419 VGND VPWR sky130_fd_sc_hd__tapvpwrvgnd_1
XTAP_408 VGND VPWR sky130_fd_sc_hd__tapvpwrvgnd_1
XFILLER_0_89_769 VGND VGND VPWR VPWR sky130_ef_sc_hd__decap_12
XFILLER_0_89_703 VGND VGND VPWR VPWR sky130_ef_sc_hd__decap_12
XFILLER_0_115_727 VGND VGND VPWR VPWR sky130_ef_sc_hd__decap_12
XFILLER_0_4_413 VGND VGND VPWR VPWR sky130_fd_sc_hd__decap_6
XFILLER_0_123_793 VGND VGND VPWR VPWR sky130_fd_sc_hd__decap_8
XFILLER_0_0_663 VGND VGND VPWR VPWR sky130_fd_sc_hd__fill_2
XFILLER_0_4_457 VGND VGND VPWR VPWR sky130_ef_sc_hd__decap_12
XFILLER_0_8_24 VGND VGND VPWR VPWR sky130_fd_sc_hd__fill_2
XFILLER_0_8_57 VGND VGND VPWR VPWR sky130_fd_sc_hd__fill_2
XFILLER_0_13_703 VGND VGND VPWR VPWR sky130_ef_sc_hd__decap_12
XFILLER_0_13_769 VGND VGND VPWR VPWR sky130_ef_sc_hd__decap_12
XFILLER_0_0_696 VGND VGND VPWR VPWR sky130_fd_sc_hd__decap_4
XFILLER_0_0_685 VGND VGND VPWR VPWR sky130_fd_sc_hd__decap_4
XFILLER_0_95_739 VGND VGND VPWR VPWR sky130_ef_sc_hd__decap_12
XFILLER_0_106_727 VGND VGND VPWR VPWR sky130_fd_sc_hd__fill_1
XFILLER_0_7_273 VGND VGND VPWR VPWR sky130_fd_sc_hd__decap_6
XFILLER_0_8_741 VGND VGND VPWR VPWR sky130_ef_sc_hd__decap_12
XFILLER_0_8_785 VGND VGND VPWR VPWR sky130_ef_sc_hd__decap_12
XPHY_296 VGND VGND VPWR VPWR sky130_fd_sc_hd__decap_3
XPHY_285 VGND VGND VPWR VPWR sky130_fd_sc_hd__decap_3
XPHY_274 VGND VGND VPWR VPWR sky130_fd_sc_hd__decap_3
XPHY_263 VGND VGND VPWR VPWR sky130_fd_sc_hd__decap_3
XPHY_252 VGND VGND VPWR VPWR sky130_fd_sc_hd__decap_3
XPHY_241 VGND VGND VPWR VPWR sky130_fd_sc_hd__decap_3
XPHY_230 VGND VGND VPWR VPWR sky130_fd_sc_hd__decap_3
XFILLER_0_94_783 VGND VGND VPWR VPWR sky130_fd_sc_hd__fill_1
XFILLER_0_120_741 VGND VGND VPWR VPWR sky130_ef_sc_hd__decap_12
XFILLER_0_105_793 VGND VGND VPWR VPWR sky130_fd_sc_hd__decap_8
XFILLER_0_1_449 VGND VGND VPWR VPWR sky130_ef_sc_hd__decap_12
XFILLER_0_1_405 VGND VGND VPWR VPWR sky130_ef_sc_hd__decap_12
XFILLER_0_120_785 VGND VGND VPWR VPWR sky130_ef_sc_hd__decap_12
XFILLER_0_77_739 VGND VGND VPWR VPWR sky130_ef_sc_hd__decap_12
XFILLER_0_4_221 VGND VGND VPWR VPWR sky130_ef_sc_hd__decap_12
XFILLER_0_4_265 VGND VGND VPWR VPWR sky130_ef_sc_hd__decap_12
XFILLER_0_5_777 VGND VGND VPWR VPWR sky130_fd_sc_hd__decap_6
XFILLER_0_0_471 VGND VGND VPWR VPWR sky130_fd_sc_hd__decap_4
XFILLER_0_76_783 VGND VGND VPWR VPWR sky130_fd_sc_hd__fill_1
XFILLER_0_102_741 VGND VGND VPWR VPWR sky130_ef_sc_hd__decap_12
XFILLER_0_102_785 VGND VGND VPWR VPWR sky130_fd_sc_hd__decap_8
XFILLER_0_59_739 VGND VGND VPWR VPWR sky130_ef_sc_hd__decap_12
XFILLER_0_82_797 VGND VGND VPWR VPWR sky130_fd_sc_hd__decap_4
XFILLER_0_82_753 VGND VGND VPWR VPWR sky130_ef_sc_hd__decap_12
XFILLER_0_2_769 VGND VGND VPWR VPWR sky130_ef_sc_hd__decap_12
XFILLER_0_2_725 VGND VGND VPWR VPWR sky130_ef_sc_hd__decap_12
XFILLER_0_1_279 VGND VGND VPWR VPWR sky130_fd_sc_hd__fill_1
XFILLER_0_5_69 VGND VGND VPWR VPWR sky130_ef_sc_hd__decap_12
XFILLER_0_58_783 VGND VGND VPWR VPWR sky130_fd_sc_hd__fill_1
XFILLER_0_5_541 VGND VGND VPWR VPWR sky130_ef_sc_hd__decap_12
XFILLER_0_5_585 VGND VGND VPWR VPWR sky130_ef_sc_hd__decap_12
XTAP_591 VGND VPWR sky130_fd_sc_hd__tapvpwrvgnd_1
XTAP_580 VGND VPWR sky130_fd_sc_hd__tapvpwrvgnd_1
XFILLER_0_64_797 VGND VGND VPWR VPWR sky130_fd_sc_hd__decap_4
XFILLER_0_64_753 VGND VGND VPWR VPWR sky130_ef_sc_hd__decap_12
XFILLER_0_2_533 VGND VGND VPWR VPWR sky130_ef_sc_hd__decap_12
XFILLER_0_148_711 VGND VGND VPWR VPWR sky130_fd_sc_hd__fill_2
XFILLER_0_148_777 VGND VGND VPWR VPWR sky130_fd_sc_hd__decap_6
XFILLER_0_46_797 VGND VGND VPWR VPWR sky130_fd_sc_hd__decap_4
XFILLER_0_46_753 VGND VGND VPWR VPWR sky130_ef_sc_hd__decap_12
XFILLER_0_5_393 VGND VGND VPWR VPWR sky130_ef_sc_hd__decap_12
XFILLER_0_139_755 VGND VGND VPWR VPWR sky130_fd_sc_hd__fill_1
XPHY_94 VGND VGND VPWR VPWR sky130_fd_sc_hd__decap_3
XPHY_50 VGND VGND VPWR VPWR sky130_fd_sc_hd__decap_3
XPHY_61 VGND VGND VPWR VPWR sky130_fd_sc_hd__decap_3
XPHY_72 VGND VGND VPWR VPWR sky130_fd_sc_hd__decap_3
XPHY_83 VGND VGND VPWR VPWR sky130_fd_sc_hd__decap_3
XFILLER_0_154_758 VGND VGND VPWR VPWR sky130_fd_sc_hd__fill_2
XANTENNA_15 BEN[2] VGND VGND VPWR VPWR sky130_fd_sc_hd__diode_2
XANTENNA_26 ScanInCC VGND VGND VPWR VPWR sky130_fd_sc_hd__diode_2
XFILLER_0_145_769 VGND VGND VPWR VPWR sky130_ef_sc_hd__decap_12
XFILLER_0_145_714 VGND VGND VPWR VPWR sky130_ef_sc_hd__decap_12
XANTENNA_37 net86 VGND VGND VPWR VPWR sky130_fd_sc_hd__diode_2
XANTENNA_48 net98 VGND VGND VPWR VPWR sky130_fd_sc_hd__diode_2
XANTENNA_59 net103 VGND VGND VPWR VPWR sky130_fd_sc_hd__diode_2
XFILLER_0_28_753 VGND VGND VPWR VPWR sky130_ef_sc_hd__decap_12
XFILLER_0_28_797 VGND VGND VPWR VPWR sky130_fd_sc_hd__decap_4
XFILLER_0_2_363 VGND VGND VPWR VPWR sky130_fd_sc_hd__fill_1
Xoutput100 net100 VGND VGND VPWR VPWR DO[22] sky130_fd_sc_hd__buf_4
Xoutput111 net111 VGND VGND VPWR VPWR DO[3] sky130_fd_sc_hd__clkbuf_4
XFILLER_0_136_703 VGND VGND VPWR VPWR sky130_ef_sc_hd__decap_12
Xinput13 BEN[11] VGND VGND VPWR VPWR net13 sky130_fd_sc_hd__buf_4
XFILLER_0_127_769 VGND VGND VPWR VPWR sky130_ef_sc_hd__decap_12
XFILLER_0_127_703 VGND VGND VPWR VPWR sky130_ef_sc_hd__decap_12
Xinput35 BEN[31] VGND VGND VPWR VPWR net35 sky130_fd_sc_hd__buf_2
Xinput24 BEN[21] VGND VGND VPWR VPWR net24 sky130_fd_sc_hd__buf_2
Xinput79 ScanInDL VGND VGND VPWR VPWR net79 sky130_fd_sc_hd__buf_4
XFILLER_0_150_761 VGND VGND VPWR VPWR sky130_ef_sc_hd__decap_12
Xinput57 DI[22] VGND VGND VPWR VPWR net57 sky130_fd_sc_hd__buf_4
Xinput46 DI[12] VGND VGND VPWR VPWR net46 sky130_fd_sc_hd__clkbuf_4
Xinput68 DI[3] VGND VGND VPWR VPWR net68 sky130_fd_sc_hd__buf_4
XFILLER_0_3_105 VGND VGND VPWR VPWR sky130_fd_sc_hd__decap_6
XFILLER_0_3_149 VGND VGND VPWR VPWR sky130_ef_sc_hd__decap_12
XFILLER_0_40_715 VGND VGND VPWR VPWR sky130_ef_sc_hd__decap_12
XFILLER_0_118_703 VGND VGND VPWR VPWR sky130_fd_sc_hd__fill_2
XFILLER_0_133_739 VGND VGND VPWR VPWR sky130_ef_sc_hd__decap_12
XFILLER_0_31_715 VGND VGND VPWR VPWR sky130_ef_sc_hd__decap_12
XFILLER_0_98_715 VGND VGND VPWR VPWR sky130_ef_sc_hd__decap_12
XFILLER_0_109_769 VGND VGND VPWR VPWR sky130_ef_sc_hd__decap_12
XFILLER_0_109_703 VGND VGND VPWR VPWR sky130_ef_sc_hd__decap_12
XFILLER_0_132_783 VGND VGND VPWR VPWR sky130_fd_sc_hd__fill_1
XFILLER_0_1_609 VGND VGND VPWR VPWR sky130_fd_sc_hd__decap_6
XFILLER_0_0_108 VGND VGND VPWR VPWR sky130_fd_sc_hd__decap_4
XFILLER_0_22_715 VGND VGND VPWR VPWR sky130_ef_sc_hd__decap_12
XFILLER_0_89_715 VGND VGND VPWR VPWR sky130_ef_sc_hd__decap_12
XTAP_409 VGND VPWR sky130_fd_sc_hd__tapvpwrvgnd_1
XFILLER_0_97_781 VGND VGND VPWR VPWR sky130_ef_sc_hd__decap_12
XFILLER_0_130_709 VGND VGND VPWR VPWR sky130_ef_sc_hd__decap_12
XFILLER_0_115_739 VGND VGND VPWR VPWR sky130_ef_sc_hd__decap_12
XFILLER_0_8_47 VGND VGND VPWR VPWR sky130_fd_sc_hd__fill_2
XFILLER_0_13_715 VGND VGND VPWR VPWR sky130_ef_sc_hd__decap_12
XFILLER_0_4_469 VGND VGND VPWR VPWR sky130_fd_sc_hd__decap_6
XFILLER_0_21_781 VGND VGND VPWR VPWR sky130_ef_sc_hd__decap_12
XFILLER_0_8_753 VGND VGND VPWR VPWR sky130_fd_sc_hd__decap_3
XFILLER_0_114_783 VGND VGND VPWR VPWR sky130_fd_sc_hd__fill_1
XFILLER_0_8_797 VGND VGND VPWR VPWR sky130_fd_sc_hd__decap_4
XFILLER_0_86_729 VGND VGND VPWR VPWR sky130_ef_sc_hd__decap_12
XFILLER_0_79_781 VGND VGND VPWR VPWR sky130_ef_sc_hd__decap_12
XPHY_297 VGND VGND VPWR VPWR sky130_fd_sc_hd__decap_3
XPHY_286 VGND VGND VPWR VPWR sky130_fd_sc_hd__decap_3
XPHY_275 VGND VGND VPWR VPWR sky130_fd_sc_hd__decap_3
XPHY_264 VGND VGND VPWR VPWR sky130_fd_sc_hd__decap_3
XPHY_253 VGND VGND VPWR VPWR sky130_fd_sc_hd__decap_3
XPHY_242 VGND VGND VPWR VPWR sky130_fd_sc_hd__decap_3
XPHY_231 VGND VGND VPWR VPWR sky130_fd_sc_hd__decap_3
XPHY_220 VGND VGND VPWR VPWR sky130_fd_sc_hd__decap_3
XFILLER_0_120_797 VGND VGND VPWR VPWR sky130_fd_sc_hd__decap_4
XFILLER_0_120_753 VGND VGND VPWR VPWR sky130_ef_sc_hd__decap_12
XFILLER_0_1_417 VGND VGND VPWR VPWR sky130_ef_sc_hd__decap_12
XFILLER_0_10_729 VGND VGND VPWR VPWR sky130_ef_sc_hd__decap_12
XFILLER_0_85_751 VGND VGND VPWR VPWR sky130_fd_sc_hd__decap_4
XFILLER_0_4_233 VGND VGND VPWR VPWR sky130_ef_sc_hd__decap_12
XFILLER_0_4_277 VGND VGND VPWR VPWR sky130_ef_sc_hd__decap_12
XFILLER_0_0_461 VGND VGND VPWR VPWR sky130_fd_sc_hd__decap_4
XFILLER_0_68_729 VGND VGND VPWR VPWR sky130_ef_sc_hd__decap_12
XFILLER_0_8_561 VGND VGND VPWR VPWR sky130_ef_sc_hd__decap_12
XFILLER_0_102_753 VGND VGND VPWR VPWR sky130_ef_sc_hd__decap_12
XFILLER_0_8_3 VGND VGND VPWR VPWR sky130_fd_sc_hd__fill_1
XFILLER_0_67_751 VGND VGND VPWR VPWR sky130_fd_sc_hd__decap_4
XFILLER_0_82_765 VGND VGND VPWR VPWR sky130_ef_sc_hd__decap_12
XFILLER_0_2_737 VGND VGND VPWR VPWR sky130_ef_sc_hd__decap_12
XFILLER_0_1_225 VGND VGND VPWR VPWR sky130_ef_sc_hd__decap_12
XFILLER_0_5_15 VGND VGND VPWR VPWR sky130_fd_sc_hd__fill_2
XFILLER_0_5_553 VGND VGND VPWR VPWR sky130_fd_sc_hd__decap_6
XFILLER_0_5_597 VGND VGND VPWR VPWR sky130_ef_sc_hd__decap_12
XTAP_592 VGND VPWR sky130_fd_sc_hd__tapvpwrvgnd_1
XTAP_581 VGND VPWR sky130_fd_sc_hd__tapvpwrvgnd_1
XTAP_570 VGND VPWR sky130_fd_sc_hd__tapvpwrvgnd_1
XFILLER_0_49_751 VGND VGND VPWR VPWR sky130_fd_sc_hd__decap_4
XFILLER_0_64_765 VGND VGND VPWR VPWR sky130_ef_sc_hd__decap_12
XFILLER_0_2_589 VGND VGND VPWR VPWR sky130_ef_sc_hd__decap_12
XFILLER_0_2_545 VGND VGND VPWR VPWR sky130_ef_sc_hd__decap_12
XFILLER_0_2_501 VGND VGND VPWR VPWR sky130_ef_sc_hd__decap_12
XFILLER_0_148_723 VGND VGND VPWR VPWR sky130_fd_sc_hd__decap_4
XFILLER_0_61_757 VGND VGND VPWR VPWR sky130_ef_sc_hd__decap_12
XFILLER_0_46_765 VGND VGND VPWR VPWR sky130_ef_sc_hd__decap_12
XFILLER_0_5_361 VGND VGND VPWR VPWR sky130_ef_sc_hd__decap_12
XPHY_95 VGND VGND VPWR VPWR sky130_fd_sc_hd__decap_3
XPHY_40 VGND VGND VPWR VPWR sky130_fd_sc_hd__decap_3
XPHY_51 VGND VGND VPWR VPWR sky130_fd_sc_hd__decap_3
XPHY_62 VGND VGND VPWR VPWR sky130_fd_sc_hd__decap_3
XPHY_73 VGND VGND VPWR VPWR sky130_fd_sc_hd__decap_3
XPHY_84 VGND VGND VPWR VPWR sky130_fd_sc_hd__decap_3
XFILLER_0_2_27 VGND VGND VPWR VPWR sky130_fd_sc_hd__fill_1
XANTENNA_27 ScanInDL VGND VGND VPWR VPWR sky130_fd_sc_hd__diode_2
XANTENNA_16 BEN[3] VGND VGND VPWR VPWR sky130_fd_sc_hd__diode_2
XFILLER_0_145_726 VGND VGND VPWR VPWR sky130_ef_sc_hd__decap_12
XFILLER_0_43_757 VGND VGND VPWR VPWR sky130_ef_sc_hd__decap_12
XANTENNA_38 net88 VGND VGND VPWR VPWR sky130_fd_sc_hd__diode_2
XANTENNA_49 net98 VGND VGND VPWR VPWR sky130_fd_sc_hd__diode_2
XFILLER_0_7_615 VGND VGND VPWR VPWR sky130_fd_sc_hd__fill_1
XFILLER_0_28_765 VGND VGND VPWR VPWR sky130_ef_sc_hd__decap_12
Xoutput101 net101 VGND VGND VPWR VPWR DO[23] sky130_fd_sc_hd__buf_4
Xoutput112 net112 VGND VGND VPWR VPWR DO[4] sky130_fd_sc_hd__clkbuf_4
XFILLER_0_136_715 VGND VGND VPWR VPWR sky130_ef_sc_hd__decap_12
XFILLER_0_151_707 VGND VGND VPWR VPWR sky130_fd_sc_hd__fill_2
XFILLER_0_6_681 VGND VGND VPWR VPWR sky130_ef_sc_hd__decap_12
Xinput25 BEN[22] VGND VGND VPWR VPWR net25 sky130_fd_sc_hd__buf_2
Xinput14 BEN[12] VGND VGND VPWR VPWR net14 sky130_fd_sc_hd__buf_4
Xinput36 BEN[3] VGND VGND VPWR VPWR net36 sky130_fd_sc_hd__buf_4
XFILLER_0_142_729 VGND VGND VPWR VPWR sky130_ef_sc_hd__decap_12
XFILLER_0_135_781 VGND VGND VPWR VPWR sky130_ef_sc_hd__decap_12
XFILLER_0_127_715 VGND VGND VPWR VPWR sky130_ef_sc_hd__decap_12
XFILLER_0_25_757 VGND VGND VPWR VPWR sky130_ef_sc_hd__decap_12
XFILLER_0_150_773 VGND VGND VPWR VPWR sky130_fd_sc_hd__decap_8
Xinput58 DI[23] VGND VGND VPWR VPWR net58 sky130_fd_sc_hd__buf_4
Xinput47 DI[13] VGND VGND VPWR VPWR net47 sky130_fd_sc_hd__clkbuf_4
Xinput69 DI[4] VGND VGND VPWR VPWR net69 sky130_fd_sc_hd__buf_4
XFILLER_0_40_727 VGND VGND VPWR VPWR sky130_fd_sc_hd__fill_1
XFILLER_0_141_751 VGND VGND VPWR VPWR sky130_fd_sc_hd__decap_4
XFILLER_0_3_673 VGND VGND VPWR VPWR sky130_ef_sc_hd__decap_12
XFILLER_0_31_727 VGND VGND VPWR VPWR sky130_ef_sc_hd__decap_12
XFILLER_0_98_727 VGND VGND VPWR VPWR sky130_fd_sc_hd__fill_1
XFILLER_0_3_81 VGND VGND VPWR VPWR sky130_ef_sc_hd__decap_12
XFILLER_0_124_729 VGND VGND VPWR VPWR sky130_ef_sc_hd__decap_12
XFILLER_0_117_781 VGND VGND VPWR VPWR sky130_ef_sc_hd__decap_12
XFILLER_0_109_715 VGND VGND VPWR VPWR sky130_ef_sc_hd__decap_12
XFILLER_0_22_727 VGND VGND VPWR VPWR sky130_fd_sc_hd__fill_1
XFILLER_0_89_727 VGND VGND VPWR VPWR sky130_ef_sc_hd__decap_12
XFILLER_0_97_793 VGND VGND VPWR VPWR sky130_fd_sc_hd__decap_8
XFILLER_0_8_209 VGND VGND VPWR VPWR sky130_ef_sc_hd__decap_12
XFILLER_0_123_751 VGND VGND VPWR VPWR sky130_fd_sc_hd__decap_4
XFILLER_0_13_727 VGND VGND VPWR VPWR sky130_ef_sc_hd__decap_12
XFILLER_0_0_643 VGND VGND VPWR VPWR sky130_fd_sc_hd__fill_1
XFILLER_0_21_793 VGND VGND VPWR VPWR sky130_fd_sc_hd__decap_8
XFILLER_0_106_729 VGND VGND VPWR VPWR sky130_ef_sc_hd__decap_12
XPHY_243 VGND VGND VPWR VPWR sky130_fd_sc_hd__decap_3
XPHY_232 VGND VGND VPWR VPWR sky130_fd_sc_hd__decap_3
XPHY_221 VGND VGND VPWR VPWR sky130_fd_sc_hd__decap_3
XPHY_210 VGND VGND VPWR VPWR sky130_fd_sc_hd__decap_3
XFILLER_0_94_741 VGND VGND VPWR VPWR sky130_ef_sc_hd__decap_12
XFILLER_0_79_793 VGND VGND VPWR VPWR sky130_fd_sc_hd__decap_8
XPHY_298 VGND VGND VPWR VPWR sky130_fd_sc_hd__decap_3
XPHY_287 VGND VGND VPWR VPWR sky130_fd_sc_hd__decap_3
XPHY_276 VGND VGND VPWR VPWR sky130_fd_sc_hd__decap_3
XPHY_265 VGND VGND VPWR VPWR sky130_fd_sc_hd__decap_3
XPHY_254 VGND VGND VPWR VPWR sky130_fd_sc_hd__decap_3
XFILLER_0_105_751 VGND VGND VPWR VPWR sky130_fd_sc_hd__decap_4
XFILLER_0_94_785 VGND VGND VPWR VPWR sky130_ef_sc_hd__decap_12
XFILLER_0_120_765 VGND VGND VPWR VPWR sky130_ef_sc_hd__decap_12
XFILLER_0_1_429 VGND VGND VPWR VPWR sky130_ef_sc_hd__decap_12
XFILLER_0_4_245 VGND VGND VPWR VPWR sky130_fd_sc_hd__decap_6
XFILLER_0_4_289 VGND VGND VPWR VPWR sky130_ef_sc_hd__decap_12
XFILLER_0_76_741 VGND VGND VPWR VPWR sky130_ef_sc_hd__decap_12
XFILLER_0_91_755 VGND VGND VPWR VPWR sky130_fd_sc_hd__fill_1
XFILLER_0_76_785 VGND VGND VPWR VPWR sky130_ef_sc_hd__decap_12
XFILLER_0_0_71 VGND VGND VPWR VPWR sky130_ef_sc_hd__decap_12
XFILLER_0_8_573 VGND VGND VPWR VPWR sky130_ef_sc_hd__decap_12
XFILLER_0_102_765 VGND VGND VPWR VPWR sky130_ef_sc_hd__decap_12
XFILLER_0_82_777 VGND VGND VPWR VPWR sky130_fd_sc_hd__decap_6
XFILLER_0_2_749 VGND VGND VPWR VPWR sky130_fd_sc_hd__decap_6
XFILLER_0_1_237 VGND VGND VPWR VPWR sky130_ef_sc_hd__decap_12
XFILLER_0_5_49 VGND VGND VPWR VPWR sky130_fd_sc_hd__decap_4
XFILLER_0_58_741 VGND VGND VPWR VPWR sky130_ef_sc_hd__decap_12
XFILLER_0_73_755 VGND VGND VPWR VPWR sky130_fd_sc_hd__fill_1
XFILLER_0_58_785 VGND VGND VPWR VPWR sky130_ef_sc_hd__decap_12
XFILLER_0_0_281 VGND VGND VPWR VPWR sky130_fd_sc_hd__decap_8
XTAP_593 VGND VPWR sky130_fd_sc_hd__tapvpwrvgnd_1
XTAP_582 VGND VPWR sky130_fd_sc_hd__tapvpwrvgnd_1
XTAP_571 VGND VPWR sky130_fd_sc_hd__tapvpwrvgnd_1
XTAP_560 VGND VPWR sky130_fd_sc_hd__tapvpwrvgnd_1
XFILLER_0_64_777 VGND VGND VPWR VPWR sky130_fd_sc_hd__decap_6
XFILLER_0_70_703 VGND VGND VPWR VPWR sky130_ef_sc_hd__decap_12
XFILLER_0_55_755 VGND VGND VPWR VPWR sky130_fd_sc_hd__fill_1
XFILLER_0_6_307 VGND VGND VPWR VPWR sky130_fd_sc_hd__fill_1
XFILLER_0_2_557 VGND VGND VPWR VPWR sky130_ef_sc_hd__decap_12
XFILLER_0_2_513 VGND VGND VPWR VPWR sky130_ef_sc_hd__decap_12
XFILLER_0_61_769 VGND VGND VPWR VPWR sky130_ef_sc_hd__decap_12
XFILLER_0_61_703 VGND VGND VPWR VPWR sky130_ef_sc_hd__decap_12
XFILLER_0_46_777 VGND VGND VPWR VPWR sky130_fd_sc_hd__decap_6
XFILLER_0_5_373 VGND VGND VPWR VPWR sky130_ef_sc_hd__decap_12
XFILLER_0_6_81 VGND VGND VPWR VPWR sky130_fd_sc_hd__decap_3
XTAP_390 VGND VPWR sky130_fd_sc_hd__tapvpwrvgnd_1
XPHY_30 VGND VGND VPWR VPWR sky130_fd_sc_hd__decap_3
XFILLER_0_154_727 VGND VGND VPWR VPWR sky130_fd_sc_hd__fill_1
XFILLER_0_139_757 VGND VGND VPWR VPWR sky130_ef_sc_hd__decap_12
XFILLER_0_52_703 VGND VGND VPWR VPWR sky130_ef_sc_hd__decap_12
XPHY_96 VGND VGND VPWR VPWR sky130_fd_sc_hd__decap_3
XPHY_85 VGND VGND VPWR VPWR sky130_fd_sc_hd__decap_3
XPHY_41 VGND VGND VPWR VPWR sky130_fd_sc_hd__decap_3
XPHY_52 VGND VGND VPWR VPWR sky130_fd_sc_hd__decap_3
XPHY_63 VGND VGND VPWR VPWR sky130_fd_sc_hd__decap_3
XPHY_74 VGND VGND VPWR VPWR sky130_fd_sc_hd__decap_3
XFILLER_0_37_755 VGND VGND VPWR VPWR sky130_fd_sc_hd__fill_1
XANTENNA_28 ScanInDR VGND VGND VPWR VPWR sky130_fd_sc_hd__diode_2
XANTENNA_17 BEN[4] VGND VGND VPWR VPWR sky130_fd_sc_hd__diode_2
XFILLER_0_145_738 VGND VGND VPWR VPWR sky130_ef_sc_hd__decap_12
XFILLER_0_43_769 VGND VGND VPWR VPWR sky130_ef_sc_hd__decap_12
XFILLER_0_2_321 VGND VGND VPWR VPWR sky130_ef_sc_hd__decap_12
XANTENNA_39 net88 VGND VGND VPWR VPWR sky130_fd_sc_hd__diode_2
XFILLER_0_28_777 VGND VGND VPWR VPWR sky130_fd_sc_hd__decap_6
XFILLER_0_43_703 VGND VGND VPWR VPWR sky130_ef_sc_hd__decap_12
Xoutput102 net102 VGND VGND VPWR VPWR DO[24] sky130_fd_sc_hd__buf_4
XFILLER_0_2_365 VGND VGND VPWR VPWR sky130_ef_sc_hd__decap_12
Xoutput113 net113 VGND VGND VPWR VPWR DO[5] sky130_fd_sc_hd__clkbuf_4
XFILLER_0_136_727 VGND VGND VPWR VPWR sky130_fd_sc_hd__fill_1
XFILLER_0_19_755 VGND VGND VPWR VPWR sky130_fd_sc_hd__fill_1
XFILLER_0_34_703 VGND VGND VPWR VPWR sky130_ef_sc_hd__decap_12
XFILLER_0_151_719 VGND VGND VPWR VPWR sky130_fd_sc_hd__fill_2
XFILLER_0_5_181 VGND VGND VPWR VPWR sky130_ef_sc_hd__decap_12
XFILLER_0_6_693 VGND VGND VPWR VPWR sky130_fd_sc_hd__decap_6
Xinput15 BEN[13] VGND VGND VPWR VPWR net15 sky130_fd_sc_hd__buf_4
Xinput37 BEN[4] VGND VGND VPWR VPWR net37 sky130_fd_sc_hd__buf_4
Xinput26 BEN[23] VGND VGND VPWR VPWR net26 sky130_fd_sc_hd__buf_2
XFILLER_0_135_793 VGND VGND VPWR VPWR sky130_fd_sc_hd__decap_8
XFILLER_0_127_727 VGND VGND VPWR VPWR sky130_ef_sc_hd__decap_12
Xinput59 DI[24] VGND VGND VPWR VPWR net59 sky130_fd_sc_hd__buf_4
Xinput48 DI[14] VGND VGND VPWR VPWR net48 sky130_fd_sc_hd__clkbuf_4
XFILLER_0_25_703 VGND VGND VPWR VPWR sky130_ef_sc_hd__decap_12
XFILLER_0_25_769 VGND VGND VPWR VPWR sky130_ef_sc_hd__decap_12
XFILLER_0_150_785 VGND VGND VPWR VPWR sky130_fd_sc_hd__decap_8
XFILLER_0_118_727 VGND VGND VPWR VPWR sky130_fd_sc_hd__fill_1
XFILLER_0_16_703 VGND VGND VPWR VPWR sky130_ef_sc_hd__decap_12
XFILLER_0_3_641 VGND VGND VPWR VPWR sky130_ef_sc_hd__decap_12
XFILLER_0_3_685 VGND VGND VPWR VPWR sky130_ef_sc_hd__decap_12
XFILLER_0_31_739 VGND VGND VPWR VPWR sky130_ef_sc_hd__decap_12
XFILLER_0_2_195 VGND VGND VPWR VPWR sky130_fd_sc_hd__fill_1
XFILLER_0_3_93 VGND VGND VPWR VPWR sky130_ef_sc_hd__decap_12
XFILLER_0_117_793 VGND VGND VPWR VPWR sky130_fd_sc_hd__decap_8
XFILLER_0_109_727 VGND VGND VPWR VPWR sky130_ef_sc_hd__decap_12
XFILLER_0_132_785 VGND VGND VPWR VPWR sky130_ef_sc_hd__decap_12
XFILLER_0_132_741 VGND VGND VPWR VPWR sky130_ef_sc_hd__decap_12
XFILLER_0_30_783 VGND VGND VPWR VPWR sky130_fd_sc_hd__fill_1
XFILLER_0_89_739 VGND VGND VPWR VPWR sky130_ef_sc_hd__decap_12
XFILLER_0_8_16 VGND VGND VPWR VPWR sky130_fd_sc_hd__fill_2
XFILLER_0_13_739 VGND VGND VPWR VPWR sky130_ef_sc_hd__decap_12
XFILLER_0_88_783 VGND VGND VPWR VPWR sky130_fd_sc_hd__fill_1
XFILLER_0_114_785 VGND VGND VPWR VPWR sky130_ef_sc_hd__decap_12
XFILLER_0_114_741 VGND VGND VPWR VPWR sky130_ef_sc_hd__decap_12
XFILLER_0_12_783 VGND VGND VPWR VPWR sky130_fd_sc_hd__fill_1
XPHY_277 VGND VGND VPWR VPWR sky130_fd_sc_hd__decap_3
XPHY_266 VGND VGND VPWR VPWR sky130_fd_sc_hd__decap_3
XPHY_255 VGND VGND VPWR VPWR sky130_fd_sc_hd__decap_3
XPHY_244 VGND VGND VPWR VPWR sky130_fd_sc_hd__decap_3
XPHY_233 VGND VGND VPWR VPWR sky130_fd_sc_hd__decap_3
XPHY_222 VGND VGND VPWR VPWR sky130_fd_sc_hd__decap_3
XPHY_211 VGND VGND VPWR VPWR sky130_fd_sc_hd__decap_3
XPHY_200 VGND VGND VPWR VPWR sky130_fd_sc_hd__decap_3
XFILLER_0_94_797 VGND VGND VPWR VPWR sky130_fd_sc_hd__decap_4
XFILLER_0_94_753 VGND VGND VPWR VPWR sky130_ef_sc_hd__decap_12
XPHY_299 VGND VGND VPWR VPWR sky130_fd_sc_hd__decap_3
XPHY_288 VGND VGND VPWR VPWR sky130_fd_sc_hd__decap_3
XFILLER_0_120_777 VGND VGND VPWR VPWR sky130_fd_sc_hd__decap_6
XFILLER_0_111_755 VGND VGND VPWR VPWR sky130_fd_sc_hd__fill_1
XFILLER_0_0_496 VGND VGND VPWR VPWR sky130_fd_sc_hd__decap_8
XFILLER_0_76_797 VGND VGND VPWR VPWR sky130_fd_sc_hd__decap_4
XFILLER_0_76_753 VGND VGND VPWR VPWR sky130_ef_sc_hd__decap_12
XFILLER_0_0_83 VGND VGND VPWR VPWR sky130_fd_sc_hd__fill_1
XFILLER_0_8_585 VGND VGND VPWR VPWR sky130_fd_sc_hd__decap_3
XFILLER_0_102_777 VGND VGND VPWR VPWR sky130_fd_sc_hd__decap_6
XFILLER_0_1_249 VGND VGND VPWR VPWR sky130_ef_sc_hd__decap_12
XFILLER_0_1_205 VGND VGND VPWR VPWR sky130_ef_sc_hd__decap_12
XFILLER_0_5_39 VGND VGND VPWR VPWR sky130_fd_sc_hd__fill_2
XFILLER_0_58_753 VGND VGND VPWR VPWR sky130_ef_sc_hd__decap_12
XFILLER_0_58_797 VGND VGND VPWR VPWR sky130_fd_sc_hd__decap_4
XTAP_561 VGND VPWR sky130_fd_sc_hd__tapvpwrvgnd_1
XTAP_550 VGND VPWR sky130_fd_sc_hd__tapvpwrvgnd_1
XFILLER_0_1_783 VGND VGND VPWR VPWR sky130_fd_sc_hd__fill_1
XFILLER_0_0_271 VGND VGND VPWR VPWR sky130_fd_sc_hd__decap_8
XTAP_594 VGND VPWR sky130_fd_sc_hd__tapvpwrvgnd_1
XTAP_583 VGND VPWR sky130_fd_sc_hd__tapvpwrvgnd_1
XTAP_572 VGND VPWR sky130_fd_sc_hd__tapvpwrvgnd_1
XFILLER_0_8_393 VGND VGND VPWR VPWR sky130_ef_sc_hd__decap_12
XFILLER_0_70_715 VGND VGND VPWR VPWR sky130_ef_sc_hd__decap_12
XFILLER_0_2_569 VGND VGND VPWR VPWR sky130_ef_sc_hd__decap_12
XFILLER_0_2_525 VGND VGND VPWR VPWR sky130_fd_sc_hd__decap_6
XFILLER_0_148_703 VGND VGND VPWR VPWR sky130_fd_sc_hd__fill_2
XFILLER_0_61_715 VGND VGND VPWR VPWR sky130_ef_sc_hd__decap_12
XFILLER_0_5_385 VGND VGND VPWR VPWR sky130_fd_sc_hd__decap_6
XTAP_391 VGND VPWR sky130_fd_sc_hd__tapvpwrvgnd_1
XTAP_380 VGND VPWR sky130_fd_sc_hd__tapvpwrvgnd_1
XFILLER_0_139_703 VGND VGND VPWR VPWR sky130_ef_sc_hd__decap_12
XPHY_20 VGND VGND VPWR VPWR sky130_fd_sc_hd__decap_3
XPHY_31 VGND VGND VPWR VPWR sky130_fd_sc_hd__decap_3
XPHY_42 VGND VGND VPWR VPWR sky130_fd_sc_hd__decap_3
XPHY_53 VGND VGND VPWR VPWR sky130_fd_sc_hd__decap_3
XPHY_64 VGND VGND VPWR VPWR sky130_fd_sc_hd__decap_3
XFILLER_0_139_769 VGND VGND VPWR VPWR sky130_ef_sc_hd__decap_12
XFILLER_0_52_715 VGND VGND VPWR VPWR sky130_ef_sc_hd__decap_12
XPHY_97 VGND VGND VPWR VPWR sky130_fd_sc_hd__decap_3
XPHY_75 VGND VGND VPWR VPWR sky130_fd_sc_hd__decap_3
XPHY_86 VGND VGND VPWR VPWR sky130_fd_sc_hd__decap_3
XFILLER_0_2_29 VGND VGND VPWR VPWR sky130_ef_sc_hd__decap_12
XANTENNA_18 BEN[5] VGND VGND VPWR VPWR sky130_fd_sc_hd__diode_2
XANTENNA_29 ScanInDR VGND VGND VPWR VPWR sky130_fd_sc_hd__diode_2
XFILLER_0_7_617 VGND VGND VPWR VPWR sky130_ef_sc_hd__decap_12
XFILLER_0_153_750 VGND VGND VPWR VPWR sky130_fd_sc_hd__fill_2
XFILLER_0_51_781 VGND VGND VPWR VPWR sky130_ef_sc_hd__decap_12
XFILLER_0_2_333 VGND VGND VPWR VPWR sky130_ef_sc_hd__decap_12
Xoutput114 net114 VGND VGND VPWR VPWR DO[6] sky130_fd_sc_hd__clkbuf_4
Xoutput103 net103 VGND VGND VPWR VPWR DO[25] sky130_fd_sc_hd__buf_4
XFILLER_0_43_715 VGND VGND VPWR VPWR sky130_ef_sc_hd__decap_12
XFILLER_0_2_377 VGND VGND VPWR VPWR sky130_ef_sc_hd__decap_12
XFILLER_0_34_715 VGND VGND VPWR VPWR sky130_ef_sc_hd__decap_12
XFILLER_0_144_783 VGND VGND VPWR VPWR sky130_fd_sc_hd__fill_1
XFILLER_0_5_193 VGND VGND VPWR VPWR sky130_ef_sc_hd__decap_12
XFILLER_0_127_739 VGND VGND VPWR VPWR sky130_ef_sc_hd__decap_12
Xinput38 BEN[5] VGND VGND VPWR VPWR net38 sky130_fd_sc_hd__buf_4
Xinput16 BEN[14] VGND VGND VPWR VPWR net16 sky130_fd_sc_hd__buf_4
Xinput27 BEN[24] VGND VGND VPWR VPWR net27 sky130_fd_sc_hd__buf_2
Xinput49 DI[15] VGND VGND VPWR VPWR net49 sky130_fd_sc_hd__clkbuf_4
XFILLER_0_25_715 VGND VGND VPWR VPWR sky130_ef_sc_hd__decap_12
XFILLER_0_33_781 VGND VGND VPWR VPWR sky130_ef_sc_hd__decap_12
XFILLER_0_40_729 VGND VGND VPWR VPWR sky130_ef_sc_hd__decap_12
XFILLER_0_7_447 VGND VGND VPWR VPWR sky130_fd_sc_hd__fill_1
XFILLER_0_16_715 VGND VGND VPWR VPWR sky130_ef_sc_hd__decap_12
XFILLER_0_126_783 VGND VGND VPWR VPWR sky130_fd_sc_hd__fill_1
XFILLER_0_2_141 VGND VGND VPWR VPWR sky130_ef_sc_hd__decap_12
XFILLER_0_3_653 VGND VGND VPWR VPWR sky130_ef_sc_hd__decap_12
XFILLER_0_3_697 VGND VGND VPWR VPWR sky130_ef_sc_hd__decap_12
XFILLER_0_98_729 VGND VGND VPWR VPWR sky130_ef_sc_hd__decap_12
XFILLER_0_109_739 VGND VGND VPWR VPWR sky130_ef_sc_hd__decap_12
XFILLER_0_132_753 VGND VGND VPWR VPWR sky130_ef_sc_hd__decap_12
XFILLER_0_15_781 VGND VGND VPWR VPWR sky130_ef_sc_hd__decap_12
XFILLER_0_22_729 VGND VGND VPWR VPWR sky130_ef_sc_hd__decap_12
XFILLER_0_132_797 VGND VGND VPWR VPWR sky130_fd_sc_hd__decap_4
XFILLER_0_97_751 VGND VGND VPWR VPWR sky130_fd_sc_hd__decap_4
XFILLER_0_108_783 VGND VGND VPWR VPWR sky130_fd_sc_hd__fill_1
XFILLER_0_0_623 VGND VGND VPWR VPWR sky130_ef_sc_hd__decap_12
XFILLER_0_21_751 VGND VGND VPWR VPWR sky130_fd_sc_hd__decap_4
XFILLER_0_0_689 VGND VGND VPWR VPWR sky130_fd_sc_hd__fill_1
XFILLER_0_8_701 VGND VGND VPWR VPWR sky130_ef_sc_hd__decap_12
XFILLER_0_114_753 VGND VGND VPWR VPWR sky130_ef_sc_hd__decap_12
XFILLER_0_114_797 VGND VGND VPWR VPWR sky130_fd_sc_hd__decap_4
XFILLER_0_3_461 VGND VGND VPWR VPWR sky130_ef_sc_hd__decap_12
XFILLER_0_79_751 VGND VGND VPWR VPWR sky130_fd_sc_hd__decap_4
XPHY_289 VGND VGND VPWR VPWR sky130_fd_sc_hd__decap_3
XPHY_278 VGND VGND VPWR VPWR sky130_fd_sc_hd__decap_3
XPHY_267 VGND VGND VPWR VPWR sky130_fd_sc_hd__decap_3
XPHY_256 VGND VGND VPWR VPWR sky130_fd_sc_hd__decap_3
XPHY_245 VGND VGND VPWR VPWR sky130_fd_sc_hd__decap_3
XPHY_234 VGND VGND VPWR VPWR sky130_fd_sc_hd__decap_3
XPHY_223 VGND VGND VPWR VPWR sky130_fd_sc_hd__decap_3
XPHY_212 VGND VGND VPWR VPWR sky130_fd_sc_hd__decap_3
XPHY_201 VGND VGND VPWR VPWR sky130_fd_sc_hd__decap_3
XFILLER_0_94_765 VGND VGND VPWR VPWR sky130_ef_sc_hd__decap_12
XFILLER_0_0_475 VGND VGND VPWR VPWR sky130_fd_sc_hd__fill_1
XFILLER_0_76_765 VGND VGND VPWR VPWR sky130_ef_sc_hd__decap_12
XFILLER_0_91_757 VGND VGND VPWR VPWR sky130_ef_sc_hd__decap_12
XFILLER_0_4_781 VGND VGND VPWR VPWR sky130_ef_sc_hd__decap_12
XFILLER_0_1_217 VGND VGND VPWR VPWR sky130_fd_sc_hd__decap_6
XFILLER_0_58_765 VGND VGND VPWR VPWR sky130_ef_sc_hd__decap_12
XFILLER_0_73_757 VGND VGND VPWR VPWR sky130_ef_sc_hd__decap_12
XTAP_584 VGND VPWR sky130_fd_sc_hd__tapvpwrvgnd_1
XTAP_573 VGND VPWR sky130_fd_sc_hd__tapvpwrvgnd_1
XTAP_562 VGND VPWR sky130_fd_sc_hd__tapvpwrvgnd_1
XTAP_551 VGND VPWR sky130_fd_sc_hd__tapvpwrvgnd_1
XTAP_540 VGND VPWR sky130_fd_sc_hd__tapvpwrvgnd_1
XTAP_595 VGND VPWR sky130_fd_sc_hd__tapvpwrvgnd_1
XFILLER_0_8_361 VGND VGND VPWR VPWR sky130_fd_sc_hd__decap_3
XFILLER_0_6_3 VGND VGND VPWR VPWR sky130_fd_sc_hd__decap_4
XFILLER_0_70_727 VGND VGND VPWR VPWR sky130_fd_sc_hd__fill_1
XFILLER_0_55_757 VGND VGND VPWR VPWR sky130_ef_sc_hd__decap_12
XFILLER_0_6_309 VGND VGND VPWR VPWR sky130_ef_sc_hd__decap_12
XFILLER_0_61_727 VGND VGND VPWR VPWR sky130_ef_sc_hd__decap_12
XTAP_370 VGND VPWR sky130_fd_sc_hd__tapvpwrvgnd_1
XTAP_392 VGND VPWR sky130_fd_sc_hd__tapvpwrvgnd_1
XTAP_381 VGND VPWR sky130_fd_sc_hd__tapvpwrvgnd_1
XFILLER_0_6_61 VGND VGND VPWR VPWR sky130_ef_sc_hd__decap_12
XFILLER_0_139_715 VGND VGND VPWR VPWR sky130_ef_sc_hd__decap_12
XPHY_98 VGND VGND VPWR VPWR sky130_fd_sc_hd__decap_3
XPHY_87 VGND VGND VPWR VPWR sky130_fd_sc_hd__decap_3
XPHY_10 VGND VGND VPWR VPWR sky130_fd_sc_hd__decap_3
XPHY_21 VGND VGND VPWR VPWR sky130_fd_sc_hd__decap_3
XPHY_32 VGND VGND VPWR VPWR sky130_fd_sc_hd__decap_3
XPHY_43 VGND VGND VPWR VPWR sky130_fd_sc_hd__decap_3
XPHY_54 VGND VGND VPWR VPWR sky130_fd_sc_hd__decap_3
XPHY_65 VGND VGND VPWR VPWR sky130_fd_sc_hd__decap_3
XPHY_76 VGND VGND VPWR VPWR sky130_fd_sc_hd__decap_3
XFILLER_0_147_781 VGND VGND VPWR VPWR sky130_ef_sc_hd__decap_12
XFILLER_0_52_727 VGND VGND VPWR VPWR sky130_fd_sc_hd__fill_1
XFILLER_0_37_757 VGND VGND VPWR VPWR sky130_ef_sc_hd__decap_12
XFILLER_0_2_19 VGND VGND VPWR VPWR sky130_fd_sc_hd__decap_8
XANTENNA_19 BEN[6] VGND VGND VPWR VPWR sky130_fd_sc_hd__diode_2
XFILLER_0_6_139 VGND VGND VPWR VPWR sky130_fd_sc_hd__fill_1
XFILLER_0_7_629 VGND VGND VPWR VPWR sky130_ef_sc_hd__decap_12
XFILLER_0_43_727 VGND VGND VPWR VPWR sky130_ef_sc_hd__decap_12
XFILLER_0_153_773 VGND VGND VPWR VPWR sky130_ef_sc_hd__decap_12
Xoutput104 net104 VGND VGND VPWR VPWR DO[26] sky130_fd_sc_hd__buf_4
XFILLER_0_51_793 VGND VGND VPWR VPWR sky130_fd_sc_hd__decap_8
XFILLER_0_2_389 VGND VGND VPWR VPWR sky130_ef_sc_hd__decap_12
XFILLER_0_2_345 VGND VGND VPWR VPWR sky130_ef_sc_hd__decap_12
XFILLER_0_2_301 VGND VGND VPWR VPWR sky130_fd_sc_hd__decap_6
Xoutput115 net115 VGND VGND VPWR VPWR DO[7] sky130_fd_sc_hd__clkbuf_4
XFILLER_0_136_729 VGND VGND VPWR VPWR sky130_ef_sc_hd__decap_12
XFILLER_0_129_781 VGND VGND VPWR VPWR sky130_ef_sc_hd__decap_12
XFILLER_0_5_161 VGND VGND VPWR VPWR sky130_fd_sc_hd__decap_6
XFILLER_0_19_757 VGND VGND VPWR VPWR sky130_ef_sc_hd__decap_12
XFILLER_0_34_727 VGND VGND VPWR VPWR sky130_fd_sc_hd__fill_1
Xinput39 BEN[6] VGND VGND VPWR VPWR net39 sky130_fd_sc_hd__buf_4
Xinput17 BEN[15] VGND VGND VPWR VPWR net17 sky130_fd_sc_hd__buf_4
Xinput28 BEN[25] VGND VGND VPWR VPWR net28 sky130_fd_sc_hd__buf_2
XFILLER_0_25_727 VGND VGND VPWR VPWR sky130_ef_sc_hd__decap_12
XFILLER_0_33_793 VGND VGND VPWR VPWR sky130_fd_sc_hd__decap_8
XFILLER_0_118_729 VGND VGND VPWR VPWR sky130_ef_sc_hd__decap_12
XFILLER_0_118_707 VGND VGND VPWR VPWR sky130_ef_sc_hd__decap_12
XFILLER_0_16_727 VGND VGND VPWR VPWR sky130_fd_sc_hd__fill_1
XFILLER_0_2_153 VGND VGND VPWR VPWR sky130_ef_sc_hd__decap_12
XFILLER_0_2_197 VGND VGND VPWR VPWR sky130_ef_sc_hd__decap_12
XFILLER_0_3_665 VGND VGND VPWR VPWR sky130_fd_sc_hd__decap_6
XFILLER_0_132_765 VGND VGND VPWR VPWR sky130_ef_sc_hd__decap_12
XFILLER_0_117_751 VGND VGND VPWR VPWR sky130_fd_sc_hd__decap_4
XFILLER_0_15_793 VGND VGND VPWR VPWR sky130_fd_sc_hd__decap_8
XFILLER_0_30_741 VGND VGND VPWR VPWR sky130_ef_sc_hd__decap_12
XFILLER_0_30_785 VGND VGND VPWR VPWR sky130_ef_sc_hd__decap_12
XFILLER_0_0_635 VGND VGND VPWR VPWR sky130_fd_sc_hd__decap_8
XFILLER_0_88_785 VGND VGND VPWR VPWR sky130_ef_sc_hd__decap_12
XFILLER_0_88_741 VGND VGND VPWR VPWR sky130_ef_sc_hd__decap_12
XFILLER_0_7_223 VGND VGND VPWR VPWR sky130_fd_sc_hd__fill_1
XFILLER_0_8_713 VGND VGND VPWR VPWR sky130_ef_sc_hd__decap_12
XFILLER_0_114_765 VGND VGND VPWR VPWR sky130_ef_sc_hd__decap_12
XFILLER_0_8_757 VGND VGND VPWR VPWR sky130_ef_sc_hd__decap_12
XFILLER_0_12_741 VGND VGND VPWR VPWR sky130_ef_sc_hd__decap_12
XFILLER_0_3_473 VGND VGND VPWR VPWR sky130_ef_sc_hd__decap_12
XFILLER_0_12_785 VGND VGND VPWR VPWR sky130_ef_sc_hd__decap_12
XPHY_279 VGND VGND VPWR VPWR sky130_fd_sc_hd__decap_3
XPHY_268 VGND VGND VPWR VPWR sky130_fd_sc_hd__decap_3
XPHY_257 VGND VGND VPWR VPWR sky130_fd_sc_hd__decap_3
XPHY_246 VGND VGND VPWR VPWR sky130_fd_sc_hd__decap_3
XPHY_235 VGND VGND VPWR VPWR sky130_fd_sc_hd__decap_3
XPHY_224 VGND VGND VPWR VPWR sky130_fd_sc_hd__decap_3
XPHY_213 VGND VGND VPWR VPWR sky130_fd_sc_hd__decap_3
XPHY_202 VGND VGND VPWR VPWR sky130_fd_sc_hd__decap_3
XFILLER_0_94_777 VGND VGND VPWR VPWR sky130_fd_sc_hd__decap_6
XFILLER_0_85_755 VGND VGND VPWR VPWR sky130_fd_sc_hd__fill_1
XFILLER_0_5_727 VGND VGND VPWR VPWR sky130_fd_sc_hd__fill_1
XFILLER_0_111_757 VGND VGND VPWR VPWR sky130_ef_sc_hd__decap_12
XFILLER_0_91_769 VGND VGND VPWR VPWR sky130_ef_sc_hd__decap_12
XFILLER_0_91_703 VGND VGND VPWR VPWR sky130_ef_sc_hd__decap_12
XFILLER_0_76_777 VGND VGND VPWR VPWR sky130_fd_sc_hd__decap_6
XFILLER_0_0_85 VGND VGND VPWR VPWR sky130_fd_sc_hd__decap_4
XFILLER_0_0_96 VGND VGND VPWR VPWR sky130_ef_sc_hd__decap_12
XFILLER_0_3_281 VGND VGND VPWR VPWR sky130_ef_sc_hd__decap_12
XFILLER_0_4_793 VGND VGND VPWR VPWR sky130_fd_sc_hd__decap_8
XFILLER_0_82_703 VGND VGND VPWR VPWR sky130_ef_sc_hd__decap_12
XFILLER_0_67_755 VGND VGND VPWR VPWR sky130_fd_sc_hd__fill_1
XFILLER_0_73_769 VGND VGND VPWR VPWR sky130_ef_sc_hd__decap_12
XFILLER_0_73_703 VGND VGND VPWR VPWR sky130_ef_sc_hd__decap_12
XFILLER_0_58_777 VGND VGND VPWR VPWR sky130_fd_sc_hd__decap_6
XFILLER_0_1_741 VGND VGND VPWR VPWR sky130_ef_sc_hd__decap_12
XTAP_596 VGND VPWR sky130_fd_sc_hd__tapvpwrvgnd_1
XTAP_585 VGND VPWR sky130_fd_sc_hd__tapvpwrvgnd_1
XTAP_574 VGND VPWR sky130_fd_sc_hd__tapvpwrvgnd_1
XTAP_563 VGND VPWR sky130_fd_sc_hd__tapvpwrvgnd_1
XTAP_552 VGND VPWR sky130_fd_sc_hd__tapvpwrvgnd_1
XTAP_541 VGND VPWR sky130_fd_sc_hd__tapvpwrvgnd_1
XTAP_530 VGND VPWR sky130_fd_sc_hd__tapvpwrvgnd_1
XFILLER_0_1_785 VGND VGND VPWR VPWR sky130_ef_sc_hd__decap_12
XFILLER_0_64_703 VGND VGND VPWR VPWR sky130_ef_sc_hd__decap_12
XFILLER_0_49_755 VGND VGND VPWR VPWR sky130_fd_sc_hd__fill_1
XFILLER_0_55_769 VGND VGND VPWR VPWR sky130_ef_sc_hd__decap_12
XFILLER_0_55_703 VGND VGND VPWR VPWR sky130_ef_sc_hd__decap_12
XFILLER_0_148_727 VGND VGND VPWR VPWR sky130_fd_sc_hd__fill_1
XFILLER_0_61_739 VGND VGND VPWR VPWR sky130_ef_sc_hd__decap_12
XFILLER_0_46_703 VGND VGND VPWR VPWR sky130_ef_sc_hd__decap_12
XFILLER_0_6_73 VGND VGND VPWR VPWR sky130_fd_sc_hd__decap_8
XTAP_360 VGND VPWR sky130_fd_sc_hd__tapvpwrvgnd_1
XTAP_382 VGND VPWR sky130_fd_sc_hd__tapvpwrvgnd_1
XTAP_371 VGND VPWR sky130_fd_sc_hd__tapvpwrvgnd_1
XTAP_393 VGND VPWR sky130_fd_sc_hd__tapvpwrvgnd_1
XFILLER_0_139_727 VGND VGND VPWR VPWR sky130_ef_sc_hd__decap_12
XPHY_99 VGND VGND VPWR VPWR sky130_fd_sc_hd__decap_3
XPHY_88 VGND VGND VPWR VPWR sky130_fd_sc_hd__decap_3
XPHY_11 VGND VGND VPWR VPWR sky130_fd_sc_hd__decap_3
XPHY_22 VGND VGND VPWR VPWR sky130_fd_sc_hd__decap_3
XPHY_33 VGND VGND VPWR VPWR sky130_fd_sc_hd__decap_3
XPHY_44 VGND VGND VPWR VPWR sky130_fd_sc_hd__decap_3
XPHY_55 VGND VGND VPWR VPWR sky130_fd_sc_hd__decap_3
XPHY_66 VGND VGND VPWR VPWR sky130_fd_sc_hd__decap_3
XFILLER_0_37_703 VGND VGND VPWR VPWR sky130_ef_sc_hd__decap_12
XFILLER_0_37_769 VGND VGND VPWR VPWR sky130_ef_sc_hd__decap_12
XPHY_77 VGND VGND VPWR VPWR sky130_fd_sc_hd__decap_3
XFILLER_0_147_793 VGND VGND VPWR VPWR sky130_fd_sc_hd__decap_8
XFILLER_0_60_783 VGND VGND VPWR VPWR sky130_fd_sc_hd__fill_1
XFILLER_0_8_181 VGND VGND VPWR VPWR sky130_ef_sc_hd__decap_12
XFILLER_0_28_703 VGND VGND VPWR VPWR sky130_ef_sc_hd__decap_12
XFILLER_0_43_739 VGND VGND VPWR VPWR sky130_ef_sc_hd__decap_12
XFILLER_0_153_785 VGND VGND VPWR VPWR sky130_ef_sc_hd__decap_12
Xoutput105 net105 VGND VGND VPWR VPWR DO[27] sky130_fd_sc_hd__buf_4
Xoutput116 net116 VGND VGND VPWR VPWR DO[8] sky130_fd_sc_hd__clkbuf_4
XFILLER_0_2_357 VGND VGND VPWR VPWR sky130_fd_sc_hd__decap_6
XFILLER_0_19_703 VGND VGND VPWR VPWR sky130_ef_sc_hd__decap_12
XFILLER_0_144_785 VGND VGND VPWR VPWR sky130_ef_sc_hd__decap_12
XFILLER_0_144_741 VGND VGND VPWR VPWR sky130_ef_sc_hd__decap_12
XFILLER_0_129_793 VGND VGND VPWR VPWR sky130_fd_sc_hd__decap_8
XFILLER_0_42_783 VGND VGND VPWR VPWR sky130_fd_sc_hd__fill_1
XFILLER_0_19_769 VGND VGND VPWR VPWR sky130_ef_sc_hd__decap_12
Xinput18 BEN[16] VGND VGND VPWR VPWR net18 sky130_fd_sc_hd__clkbuf_4
XFILLER_0_25_739 VGND VGND VPWR VPWR sky130_ef_sc_hd__decap_12
XFILLER_0_150_733 VGND VGND VPWR VPWR sky130_fd_sc_hd__fill_2
Xinput29 BEN[26] VGND VGND VPWR VPWR net29 sky130_fd_sc_hd__buf_2
XFILLER_0_118_719 VGND VGND VPWR VPWR sky130_fd_sc_hd__decap_8
XFILLER_0_7_405 VGND VGND VPWR VPWR sky130_ef_sc_hd__decap_12
XFILLER_0_141_755 VGND VGND VPWR VPWR sky130_fd_sc_hd__fill_1
XFILLER_0_126_785 VGND VGND VPWR VPWR sky130_ef_sc_hd__decap_12
XFILLER_0_126_741 VGND VGND VPWR VPWR sky130_ef_sc_hd__decap_12
XFILLER_0_2_121 VGND VGND VPWR VPWR sky130_ef_sc_hd__decap_12
XFILLER_0_7_449 VGND VGND VPWR VPWR sky130_ef_sc_hd__decap_12
XFILLER_0_24_783 VGND VGND VPWR VPWR sky130_fd_sc_hd__fill_1
XFILLER_0_2_165 VGND VGND VPWR VPWR sky130_ef_sc_hd__decap_12
XFILLER_0_3_41 VGND VGND VPWR VPWR sky130_fd_sc_hd__fill_2
XFILLER_0_132_777 VGND VGND VPWR VPWR sky130_fd_sc_hd__decap_6
XFILLER_0_30_753 VGND VGND VPWR VPWR sky130_ef_sc_hd__decap_12
XFILLER_0_30_797 VGND VGND VPWR VPWR sky130_fd_sc_hd__decap_4
XFILLER_0_123_755 VGND VGND VPWR VPWR sky130_fd_sc_hd__fill_1
XFILLER_0_108_785 VGND VGND VPWR VPWR sky130_ef_sc_hd__decap_12
XFILLER_0_108_741 VGND VGND VPWR VPWR sky130_ef_sc_hd__decap_12
XFILLER_0_4_419 VGND VGND VPWR VPWR sky130_fd_sc_hd__fill_1
XFILLER_0_88_753 VGND VGND VPWR VPWR sky130_ef_sc_hd__decap_12
XFILLER_0_88_797 VGND VGND VPWR VPWR sky130_fd_sc_hd__decap_4
XFILLER_0_8_725 VGND VGND VPWR VPWR sky130_fd_sc_hd__decap_3
XFILLER_0_8_769 VGND VGND VPWR VPWR sky130_ef_sc_hd__decap_12
XFILLER_0_114_777 VGND VGND VPWR VPWR sky130_fd_sc_hd__decap_6
XFILLER_0_3_441 VGND VGND VPWR VPWR sky130_fd_sc_hd__decap_6
XFILLER_0_3_485 VGND VGND VPWR VPWR sky130_ef_sc_hd__decap_12
XFILLER_0_7_279 VGND VGND VPWR VPWR sky130_fd_sc_hd__fill_1
XFILLER_0_12_753 VGND VGND VPWR VPWR sky130_ef_sc_hd__decap_12
XFILLER_0_12_797 VGND VGND VPWR VPWR sky130_fd_sc_hd__decap_4
XPHY_225 VGND VGND VPWR VPWR sky130_fd_sc_hd__decap_3
XPHY_214 VGND VGND VPWR VPWR sky130_fd_sc_hd__decap_3
XPHY_203 VGND VGND VPWR VPWR sky130_fd_sc_hd__decap_3
XPHY_269 VGND VGND VPWR VPWR sky130_fd_sc_hd__decap_3
XPHY_258 VGND VGND VPWR VPWR sky130_fd_sc_hd__decap_3
XPHY_247 VGND VGND VPWR VPWR sky130_fd_sc_hd__decap_3
XPHY_236 VGND VGND VPWR VPWR sky130_fd_sc_hd__decap_3
XFILLER_0_120_703 VGND VGND VPWR VPWR sky130_ef_sc_hd__decap_12
XFILLER_0_105_755 VGND VGND VPWR VPWR sky130_fd_sc_hd__fill_1
XFILLER_0_111_703 VGND VGND VPWR VPWR sky130_ef_sc_hd__decap_12
XFILLER_0_0_411 VGND VGND VPWR VPWR sky130_fd_sc_hd__decap_8
XFILLER_0_111_769 VGND VGND VPWR VPWR sky130_ef_sc_hd__decap_12
XFILLER_0_0_477 VGND VGND VPWR VPWR sky130_ef_sc_hd__decap_12
XFILLER_0_91_715 VGND VGND VPWR VPWR sky130_ef_sc_hd__decap_12
XFILLER_0_8_533 VGND VGND VPWR VPWR sky130_ef_sc_hd__decap_12
XFILLER_0_102_703 VGND VGND VPWR VPWR sky130_ef_sc_hd__decap_12
XFILLER_0_3_293 VGND VGND VPWR VPWR sky130_ef_sc_hd__decap_12
XFILLER_0_82_715 VGND VGND VPWR VPWR sky130_ef_sc_hd__decap_12
XFILLER_0_73_715 VGND VGND VPWR VPWR sky130_ef_sc_hd__decap_12
XFILLER_0_5_503 VGND VGND VPWR VPWR sky130_fd_sc_hd__fill_1
XFILLER_0_81_781 VGND VGND VPWR VPWR sky130_ef_sc_hd__decap_12
XFILLER_0_1_753 VGND VGND VPWR VPWR sky130_ef_sc_hd__decap_12
XTAP_597 VGND VPWR sky130_fd_sc_hd__tapvpwrvgnd_1
XTAP_586 VGND VPWR sky130_fd_sc_hd__tapvpwrvgnd_1
XTAP_575 VGND VPWR sky130_fd_sc_hd__tapvpwrvgnd_1
XTAP_564 VGND VPWR sky130_fd_sc_hd__tapvpwrvgnd_1
XTAP_553 VGND VPWR sky130_fd_sc_hd__tapvpwrvgnd_1
XTAP_542 VGND VPWR sky130_fd_sc_hd__tapvpwrvgnd_1
XTAP_531 VGND VPWR sky130_fd_sc_hd__tapvpwrvgnd_1
XTAP_520 VGND VPWR sky130_fd_sc_hd__tapvpwrvgnd_1
XFILLER_0_1_797 VGND VGND VPWR VPWR sky130_fd_sc_hd__decap_4
XFILLER_0_0_296 VGND VGND VPWR VPWR sky130_ef_sc_hd__decap_12
XFILLER_0_64_715 VGND VGND VPWR VPWR sky130_ef_sc_hd__decap_12
XFILLER_0_70_729 VGND VGND VPWR VPWR sky130_ef_sc_hd__decap_12
XFILLER_0_55_715 VGND VGND VPWR VPWR sky130_ef_sc_hd__decap_12
XFILLER_0_63_781 VGND VGND VPWR VPWR sky130_ef_sc_hd__decap_12
XFILLER_0_46_715 VGND VGND VPWR VPWR sky130_ef_sc_hd__decap_12
XTAP_350 VGND VPWR sky130_fd_sc_hd__tapvpwrvgnd_1
XFILLER_0_1_561 VGND VGND VPWR VPWR sky130_ef_sc_hd__decap_12
XFILLER_0_6_85 VGND VGND VPWR VPWR sky130_ef_sc_hd__decap_12
XTAP_361 VGND VPWR sky130_fd_sc_hd__tapvpwrvgnd_1
XTAP_383 VGND VPWR sky130_fd_sc_hd__tapvpwrvgnd_1
XTAP_372 VGND VPWR sky130_fd_sc_hd__tapvpwrvgnd_1
XTAP_394 VGND VPWR sky130_fd_sc_hd__tapvpwrvgnd_1
XPHY_12 VGND VGND VPWR VPWR sky130_fd_sc_hd__decap_3
XFILLER_0_139_739 VGND VGND VPWR VPWR sky130_ef_sc_hd__decap_12
XPHY_89 VGND VGND VPWR VPWR sky130_fd_sc_hd__decap_3
XPHY_23 VGND VGND VPWR VPWR sky130_fd_sc_hd__decap_3
XPHY_34 VGND VGND VPWR VPWR sky130_fd_sc_hd__decap_3
XPHY_45 VGND VGND VPWR VPWR sky130_fd_sc_hd__decap_3
XPHY_56 VGND VGND VPWR VPWR sky130_fd_sc_hd__decap_3
XPHY_67 VGND VGND VPWR VPWR sky130_fd_sc_hd__decap_3
XFILLER_0_37_715 VGND VGND VPWR VPWR sky130_ef_sc_hd__decap_12
XPHY_78 VGND VGND VPWR VPWR sky130_fd_sc_hd__decap_3
XFILLER_0_52_729 VGND VGND VPWR VPWR sky130_ef_sc_hd__decap_12
XFILLER_0_45_781 VGND VGND VPWR VPWR sky130_ef_sc_hd__decap_12
XFILLER_0_8_193 VGND VGND VPWR VPWR sky130_fd_sc_hd__decap_3
XFILLER_0_28_715 VGND VGND VPWR VPWR sky130_ef_sc_hd__decap_12
XFILLER_0_153_797 VGND VGND VPWR VPWR sky130_fd_sc_hd__decap_4
XFILLER_0_138_783 VGND VGND VPWR VPWR sky130_fd_sc_hd__fill_1
XFILLER_0_51_751 VGND VGND VPWR VPWR sky130_fd_sc_hd__decap_4
XFILLER_0_7_609 VGND VGND VPWR VPWR sky130_fd_sc_hd__decap_6
Xoutput106 net106 VGND VGND VPWR VPWR DO[28] sky130_fd_sc_hd__buf_4
Xoutput117 net117 VGND VGND VPWR VPWR DO[9] sky130_fd_sc_hd__clkbuf_4
XFILLER_0_19_715 VGND VGND VPWR VPWR sky130_ef_sc_hd__decap_12
XFILLER_0_144_797 VGND VGND VPWR VPWR sky130_fd_sc_hd__decap_4
XFILLER_0_144_753 VGND VGND VPWR VPWR sky130_ef_sc_hd__decap_12
XFILLER_0_27_781 VGND VGND VPWR VPWR sky130_ef_sc_hd__decap_12
XFILLER_0_34_729 VGND VGND VPWR VPWR sky130_ef_sc_hd__decap_12
XFILLER_0_1_391 VGND VGND VPWR VPWR sky130_fd_sc_hd__fill_1
Xinput19 BEN[17] VGND VGND VPWR VPWR net19 sky130_fd_sc_hd__clkbuf_4
XFILLER_0_135_753 VGND VGND VPWR VPWR sky130_fd_sc_hd__decap_3
XFILLER_0_33_751 VGND VGND VPWR VPWR sky130_fd_sc_hd__decap_4
XFILLER_0_7_417 VGND VGND VPWR VPWR sky130_ef_sc_hd__decap_12
XFILLER_0_126_797 VGND VGND VPWR VPWR sky130_fd_sc_hd__decap_4
XFILLER_0_126_753 VGND VGND VPWR VPWR sky130_ef_sc_hd__decap_12
XFILLER_0_2_133 VGND VGND VPWR VPWR sky130_fd_sc_hd__decap_6
XFILLER_0_16_729 VGND VGND VPWR VPWR sky130_ef_sc_hd__decap_12
XFILLER_0_2_177 VGND VGND VPWR VPWR sky130_ef_sc_hd__decap_12
XFILLER_0_3_53 VGND VGND VPWR VPWR sky130_fd_sc_hd__decap_3
XFILLER_0_15_751 VGND VGND VPWR VPWR sky130_fd_sc_hd__decap_4
XFILLER_0_30_765 VGND VGND VPWR VPWR sky130_ef_sc_hd__decap_12
XFILLER_0_108_797 VGND VGND VPWR VPWR sky130_fd_sc_hd__decap_4
XFILLER_0_108_753 VGND VGND VPWR VPWR sky130_ef_sc_hd__decap_12
XFILLER_0_88_765 VGND VGND VPWR VPWR sky130_ef_sc_hd__decap_12
XFILLER_0_7_225 VGND VGND VPWR VPWR sky130_ef_sc_hd__decap_12
XFILLER_0_3_497 VGND VGND VPWR VPWR sky130_fd_sc_hd__decap_6
XFILLER_0_12_765 VGND VGND VPWR VPWR sky130_ef_sc_hd__decap_12
XPHY_259 VGND VGND VPWR VPWR sky130_fd_sc_hd__decap_3
XPHY_248 VGND VGND VPWR VPWR sky130_fd_sc_hd__decap_3
XPHY_237 VGND VGND VPWR VPWR sky130_fd_sc_hd__decap_3
XPHY_226 VGND VGND VPWR VPWR sky130_fd_sc_hd__decap_3
XPHY_215 VGND VGND VPWR VPWR sky130_fd_sc_hd__decap_3
XPHY_204 VGND VGND VPWR VPWR sky130_fd_sc_hd__decap_3
XFILLER_0_120_715 VGND VGND VPWR VPWR sky130_ef_sc_hd__decap_12
XFILLER_0_85_757 VGND VGND VPWR VPWR sky130_ef_sc_hd__decap_12
XFILLER_0_5_729 VGND VGND VPWR VPWR sky130_ef_sc_hd__decap_12
XFILLER_0_111_715 VGND VGND VPWR VPWR sky130_ef_sc_hd__decap_12
XFILLER_0_0_489 VGND VGND VPWR VPWR sky130_fd_sc_hd__fill_1
XFILLER_0_0_54 VGND VGND VPWR VPWR sky130_fd_sc_hd__fill_2
XFILLER_0_8_501 VGND VGND VPWR VPWR sky130_fd_sc_hd__decap_3
XFILLER_0_91_727 VGND VGND VPWR VPWR sky130_ef_sc_hd__decap_12
XFILLER_0_8_545 VGND VGND VPWR VPWR sky130_ef_sc_hd__decap_12
XFILLER_0_8_589 VGND VGND VPWR VPWR sky130_ef_sc_hd__decap_12
XFILLER_0_102_715 VGND VGND VPWR VPWR sky130_ef_sc_hd__decap_12
XFILLER_0_3_261 VGND VGND VPWR VPWR sky130_ef_sc_hd__decap_12
XFILLER_0_82_727 VGND VGND VPWR VPWR sky130_fd_sc_hd__fill_1
XFILLER_0_67_757 VGND VGND VPWR VPWR sky130_ef_sc_hd__decap_12
XFILLER_0_101_781 VGND VGND VPWR VPWR sky130_ef_sc_hd__decap_12
XFILLER_0_81_793 VGND VGND VPWR VPWR sky130_fd_sc_hd__decap_8
XFILLER_0_73_727 VGND VGND VPWR VPWR sky130_ef_sc_hd__decap_12
XFILLER_0_5_559 VGND VGND VPWR VPWR sky130_fd_sc_hd__fill_1
XTAP_543 VGND VPWR sky130_fd_sc_hd__tapvpwrvgnd_1
XTAP_532 VGND VPWR sky130_fd_sc_hd__tapvpwrvgnd_1
XTAP_521 VGND VPWR sky130_fd_sc_hd__tapvpwrvgnd_1
XFILLER_0_1_765 VGND VGND VPWR VPWR sky130_ef_sc_hd__decap_12
XFILLER_0_1_721 VGND VGND VPWR VPWR sky130_fd_sc_hd__decap_6
XFILLER_0_0_253 VGND VGND VPWR VPWR sky130_ef_sc_hd__decap_12
XTAP_510 VGND VPWR sky130_fd_sc_hd__tapvpwrvgnd_1
XTAP_598 VGND VPWR sky130_fd_sc_hd__tapvpwrvgnd_1
XTAP_587 VGND VPWR sky130_fd_sc_hd__tapvpwrvgnd_1
XTAP_576 VGND VPWR sky130_fd_sc_hd__tapvpwrvgnd_1
XTAP_565 VGND VPWR sky130_fd_sc_hd__tapvpwrvgnd_1
XTAP_554 VGND VPWR sky130_fd_sc_hd__tapvpwrvgnd_1
XFILLER_0_64_727 VGND VGND VPWR VPWR sky130_fd_sc_hd__fill_1
XFILLER_0_49_757 VGND VGND VPWR VPWR sky130_ef_sc_hd__decap_12
XFILLER_0_4_581 VGND VGND VPWR VPWR sky130_fd_sc_hd__decap_6
Xi_sram net93 net18 net94 net19 net95 net20 net96 net21 net98 net23 net99 net24 net100
+ net25 net101 net26 net102 net27 net103 net28 net104 net29 net105 net30 net106 net31
+ net107 net32 net109 net34 net110 net35 net1 net2 net3 net82 net83 CLKin net75 net76
+ net77 net81 net80 net118 net79 net117 net42 net87 net12 net88 net13 net89 net14
+ net90 net15 net91 net16 net92 net17 net41 net4 net5 net6 net7 net8 net9 net10 net78
+ net86 net11 net97 net22 net108 net33 net111 net36 net112 net37 net113 net38 net114
+ net39 net115 net40 net116 net68 net46 net43 net69 net48 net45 net70 net54 net74
+ net71 net49 net65 net72 net47 net44 net73 net58 net62 net53 net56 net63 net59 net52
+ net64 net50 net60 net66 net57 net55 net61 net51 net67 VGND VPWR VPWR VPWR VGND VPWR
+ net85 net84 CF_SRAM_1024x32
XFILLER_0_63_793 VGND VGND VPWR VPWR sky130_fd_sc_hd__decap_8
XFILLER_0_55_727 VGND VGND VPWR VPWR sky130_ef_sc_hd__decap_12
XFILLER_0_148_729 VGND VGND VPWR VPWR sky130_ef_sc_hd__decap_12
XFILLER_0_148_707 VGND VGND VPWR VPWR sky130_fd_sc_hd__fill_2
XFILLER_0_46_727 VGND VGND VPWR VPWR sky130_fd_sc_hd__fill_1
XFILLER_0_54_793 VGND VGND VPWR VPWR sky130_fd_sc_hd__fill_2
XTAP_351 VGND VPWR sky130_fd_sc_hd__tapvpwrvgnd_1
XFILLER_0_1_573 VGND VGND VPWR VPWR sky130_ef_sc_hd__decap_12
XTAP_362 VGND VPWR sky130_fd_sc_hd__tapvpwrvgnd_1
XTAP_340 VGND VPWR sky130_fd_sc_hd__tapvpwrvgnd_1
XTAP_384 VGND VPWR sky130_fd_sc_hd__tapvpwrvgnd_1
XTAP_373 VGND VPWR sky130_fd_sc_hd__tapvpwrvgnd_1
XFILLER_0_6_53 VGND VGND VPWR VPWR sky130_fd_sc_hd__fill_2
XFILLER_0_6_97 VGND VGND VPWR VPWR sky130_ef_sc_hd__decap_12
XTAP_395 VGND VPWR sky130_fd_sc_hd__tapvpwrvgnd_1
XPHY_13 VGND VGND VPWR VPWR sky130_fd_sc_hd__decap_3
XPHY_24 VGND VGND VPWR VPWR sky130_fd_sc_hd__decap_3
XPHY_35 VGND VGND VPWR VPWR sky130_fd_sc_hd__decap_3
XPHY_46 VGND VGND VPWR VPWR sky130_fd_sc_hd__decap_3
XPHY_57 VGND VGND VPWR VPWR sky130_fd_sc_hd__decap_3
XPHY_68 VGND VGND VPWR VPWR sky130_fd_sc_hd__decap_3
XFILLER_0_37_727 VGND VGND VPWR VPWR sky130_ef_sc_hd__decap_12
XPHY_79 VGND VGND VPWR VPWR sky130_fd_sc_hd__decap_3
XFILLER_0_60_785 VGND VGND VPWR VPWR sky130_ef_sc_hd__decap_12
XFILLER_0_60_741 VGND VGND VPWR VPWR sky130_ef_sc_hd__decap_12
XFILLER_0_45_793 VGND VGND VPWR VPWR sky130_fd_sc_hd__decap_8
XFILLER_0_28_727 VGND VGND VPWR VPWR sky130_fd_sc_hd__fill_1
XFILLER_0_153_765 VGND VGND VPWR VPWR sky130_fd_sc_hd__fill_2
XFILLER_0_153_754 VGND VGND VPWR VPWR sky130_fd_sc_hd__fill_2
Xoutput107 net107 VGND VGND VPWR VPWR DO[29] sky130_fd_sc_hd__clkbuf_8
XFILLER_0_6_109 VGND VGND VPWR VPWR sky130_ef_sc_hd__decap_12
Xoutput118 net118 VGND VGND VPWR VPWR ScanOutCC sky130_fd_sc_hd__buf_4
XFILLER_0_129_751 VGND VGND VPWR VPWR sky130_fd_sc_hd__decap_4
XFILLER_0_6_643 VGND VGND VPWR VPWR sky130_fd_sc_hd__fill_1
XFILLER_0_19_727 VGND VGND VPWR VPWR sky130_ef_sc_hd__decap_12
XFILLER_0_144_765 VGND VGND VPWR VPWR sky130_ef_sc_hd__decap_12
XFILLER_0_42_785 VGND VGND VPWR VPWR sky130_ef_sc_hd__decap_12
XFILLER_0_27_793 VGND VGND VPWR VPWR sky130_fd_sc_hd__decap_8
XFILLER_0_42_741 VGND VGND VPWR VPWR sky130_ef_sc_hd__decap_12
XFILLER_0_135_721 VGND VGND VPWR VPWR sky130_ef_sc_hd__decap_12
XFILLER_0_7_429 VGND VGND VPWR VPWR sky130_ef_sc_hd__decap_12
XFILLER_0_141_757 VGND VGND VPWR VPWR sky130_ef_sc_hd__decap_12
XFILLER_0_126_765 VGND VGND VPWR VPWR sky130_ef_sc_hd__decap_12
XFILLER_0_2_189 VGND VGND VPWR VPWR sky130_fd_sc_hd__decap_6
XFILLER_0_24_741 VGND VGND VPWR VPWR sky130_ef_sc_hd__decap_12
XFILLER_0_24_785 VGND VGND VPWR VPWR sky130_ef_sc_hd__decap_12
XFILLER_0_30_777 VGND VGND VPWR VPWR sky130_fd_sc_hd__decap_6
XFILLER_0_97_755 VGND VGND VPWR VPWR sky130_fd_sc_hd__fill_1
XFILLER_0_123_757 VGND VGND VPWR VPWR sky130_ef_sc_hd__decap_12
XFILLER_0_108_765 VGND VGND VPWR VPWR sky130_ef_sc_hd__decap_12
XFILLER_0_21_755 VGND VGND VPWR VPWR sky130_fd_sc_hd__fill_1
XFILLER_0_88_777 VGND VGND VPWR VPWR sky130_fd_sc_hd__decap_6
XFILLER_0_7_237 VGND VGND VPWR VPWR sky130_ef_sc_hd__decap_12
XFILLER_0_12_777 VGND VGND VPWR VPWR sky130_fd_sc_hd__decap_6
XPHY_249 VGND VGND VPWR VPWR sky130_fd_sc_hd__decap_3
XPHY_238 VGND VGND VPWR VPWR sky130_fd_sc_hd__decap_3
XPHY_227 VGND VGND VPWR VPWR sky130_fd_sc_hd__decap_3
XPHY_216 VGND VGND VPWR VPWR sky130_fd_sc_hd__decap_3
XPHY_205 VGND VGND VPWR VPWR sky130_fd_sc_hd__decap_3
XFILLER_0_94_703 VGND VGND VPWR VPWR sky130_ef_sc_hd__decap_12
XFILLER_0_79_755 VGND VGND VPWR VPWR sky130_fd_sc_hd__fill_1
XFILLER_0_120_727 VGND VGND VPWR VPWR sky130_fd_sc_hd__fill_1
XFILLER_0_105_757 VGND VGND VPWR VPWR sky130_ef_sc_hd__decap_12
XFILLER_0_85_703 VGND VGND VPWR VPWR sky130_ef_sc_hd__decap_12
XFILLER_0_85_769 VGND VGND VPWR VPWR sky130_ef_sc_hd__decap_12
XFILLER_0_111_727 VGND VGND VPWR VPWR sky130_ef_sc_hd__decap_12
XFILLER_0_0_446 VGND VGND VPWR VPWR sky130_fd_sc_hd__fill_2
XFILLER_0_76_703 VGND VGND VPWR VPWR sky130_ef_sc_hd__decap_12
XFILLER_0_102_727 VGND VGND VPWR VPWR sky130_fd_sc_hd__fill_1
XFILLER_0_91_739 VGND VGND VPWR VPWR sky130_ef_sc_hd__decap_12
XFILLER_0_8_557 VGND VGND VPWR VPWR sky130_fd_sc_hd__decap_3
XFILLER_0_3_273 VGND VGND VPWR VPWR sky130_fd_sc_hd__decap_6
XFILLER_0_67_703 VGND VGND VPWR VPWR sky130_ef_sc_hd__decap_12
XFILLER_0_67_769 VGND VGND VPWR VPWR sky130_ef_sc_hd__decap_12
XFILLER_0_90_783 VGND VGND VPWR VPWR sky130_fd_sc_hd__fill_1
XFILLER_0_101_793 VGND VGND VPWR VPWR sky130_fd_sc_hd__decap_8
XFILLER_0_58_703 VGND VGND VPWR VPWR sky130_ef_sc_hd__decap_12
XFILLER_0_73_739 VGND VGND VPWR VPWR sky130_ef_sc_hd__decap_12
XFILLER_0_5_505 VGND VGND VPWR VPWR sky130_ef_sc_hd__decap_12
XTAP_566 VGND VPWR sky130_fd_sc_hd__tapvpwrvgnd_1
XTAP_555 VGND VPWR sky130_fd_sc_hd__tapvpwrvgnd_1
XTAP_544 VGND VPWR sky130_fd_sc_hd__tapvpwrvgnd_1
XTAP_533 VGND VPWR sky130_fd_sc_hd__tapvpwrvgnd_1
XTAP_522 VGND VPWR sky130_fd_sc_hd__tapvpwrvgnd_1
XFILLER_0_1_777 VGND VGND VPWR VPWR sky130_fd_sc_hd__decap_6
XFILLER_0_0_221 VGND VGND VPWR VPWR sky130_fd_sc_hd__decap_3
XTAP_500 VGND VPWR sky130_fd_sc_hd__tapvpwrvgnd_1
XTAP_511 VGND VPWR sky130_fd_sc_hd__tapvpwrvgnd_1
XTAP_599 VGND VPWR sky130_fd_sc_hd__tapvpwrvgnd_1
XTAP_588 VGND VPWR sky130_fd_sc_hd__tapvpwrvgnd_1
XTAP_577 VGND VPWR sky130_fd_sc_hd__tapvpwrvgnd_1
XFILLER_0_49_703 VGND VGND VPWR VPWR sky130_ef_sc_hd__decap_12
XFILLER_0_49_769 VGND VGND VPWR VPWR sky130_ef_sc_hd__decap_12
XFILLER_0_8_321 VGND VGND VPWR VPWR sky130_ef_sc_hd__decap_12
XFILLER_0_8_365 VGND VGND VPWR VPWR sky130_ef_sc_hd__decap_12
XFILLER_0_72_783 VGND VGND VPWR VPWR sky130_fd_sc_hd__fill_1
XFILLER_0_55_739 VGND VGND VPWR VPWR sky130_ef_sc_hd__decap_12
XFILLER_0_148_719 VGND VGND VPWR VPWR sky130_fd_sc_hd__fill_2
XFILLER_0_54_783 VGND VGND VPWR VPWR sky130_fd_sc_hd__fill_1
XFILLER_0_1_541 VGND VGND VPWR VPWR sky130_ef_sc_hd__decap_12
XFILLER_0_5_335 VGND VGND VPWR VPWR sky130_fd_sc_hd__fill_1
XTAP_352 VGND VPWR sky130_fd_sc_hd__tapvpwrvgnd_1
XFILLER_0_1_585 VGND VGND VPWR VPWR sky130_ef_sc_hd__decap_12
XTAP_330 VGND VPWR sky130_fd_sc_hd__tapvpwrvgnd_1
XTAP_363 VGND VPWR sky130_fd_sc_hd__tapvpwrvgnd_1
XTAP_341 VGND VPWR sky130_fd_sc_hd__tapvpwrvgnd_1
XTAP_385 VGND VPWR sky130_fd_sc_hd__tapvpwrvgnd_1
XTAP_374 VGND VPWR sky130_fd_sc_hd__tapvpwrvgnd_1
XTAP_396 VGND VPWR sky130_fd_sc_hd__tapvpwrvgnd_1
XPHY_14 VGND VGND VPWR VPWR sky130_fd_sc_hd__decap_3
XPHY_25 VGND VGND VPWR VPWR sky130_fd_sc_hd__decap_3
XPHY_36 VGND VGND VPWR VPWR sky130_fd_sc_hd__decap_3
XPHY_47 VGND VGND VPWR VPWR sky130_fd_sc_hd__decap_3
XPHY_58 VGND VGND VPWR VPWR sky130_fd_sc_hd__decap_3
XPHY_69 VGND VGND VPWR VPWR sky130_fd_sc_hd__decap_3
XFILLER_0_37_739 VGND VGND VPWR VPWR sky130_ef_sc_hd__decap_12
XFILLER_0_60_797 VGND VGND VPWR VPWR sky130_fd_sc_hd__decap_4
XFILLER_0_60_753 VGND VGND VPWR VPWR sky130_ef_sc_hd__decap_12
XFILLER_0_138_785 VGND VGND VPWR VPWR sky130_ef_sc_hd__decap_12
XFILLER_0_138_741 VGND VGND VPWR VPWR sky130_ef_sc_hd__decap_12
Xoutput108 net108 VGND VGND VPWR VPWR DO[2] sky130_fd_sc_hd__clkbuf_4
XFILLER_0_36_783 VGND VGND VPWR VPWR sky130_fd_sc_hd__fill_1
Xoutput90 net90 VGND VGND VPWR VPWR DO[13] sky130_fd_sc_hd__buf_4
XFILLER_0_144_777 VGND VGND VPWR VPWR sky130_fd_sc_hd__decap_6
XFILLER_0_19_739 VGND VGND VPWR VPWR sky130_ef_sc_hd__decap_12
XFILLER_0_42_797 VGND VGND VPWR VPWR sky130_fd_sc_hd__decap_4
XFILLER_0_42_753 VGND VGND VPWR VPWR sky130_ef_sc_hd__decap_12
XFILLER_0_1_393 VGND VGND VPWR VPWR sky130_ef_sc_hd__decap_12
XFILLER_0_6_699 VGND VGND VPWR VPWR sky130_fd_sc_hd__fill_1
XFILLER_0_150_725 VGND VGND VPWR VPWR sky130_fd_sc_hd__decap_3
XFILLER_0_135_733 VGND VGND VPWR VPWR sky130_ef_sc_hd__decap_12
XFILLER_0_18_783 VGND VGND VPWR VPWR sky130_fd_sc_hd__fill_1
XFILLER_0_141_703 VGND VGND VPWR VPWR sky130_ef_sc_hd__decap_12
XFILLER_0_126_777 VGND VGND VPWR VPWR sky130_fd_sc_hd__decap_6
XFILLER_0_141_769 VGND VGND VPWR VPWR sky130_ef_sc_hd__decap_12
XFILLER_0_24_753 VGND VGND VPWR VPWR sky130_ef_sc_hd__decap_12
XFILLER_0_24_797 VGND VGND VPWR VPWR sky130_fd_sc_hd__decap_4
XFILLER_0_3_33 VGND VGND VPWR VPWR sky130_fd_sc_hd__fill_2
XFILLER_0_132_703 VGND VGND VPWR VPWR sky130_ef_sc_hd__decap_12
XFILLER_0_117_755 VGND VGND VPWR VPWR sky130_fd_sc_hd__fill_1
XFILLER_0_123_703 VGND VGND VPWR VPWR sky130_ef_sc_hd__decap_12
XFILLER_0_108_777 VGND VGND VPWR VPWR sky130_fd_sc_hd__decap_6
XFILLER_0_123_769 VGND VGND VPWR VPWR sky130_ef_sc_hd__decap_12
XFILLER_0_7_205 VGND VGND VPWR VPWR sky130_ef_sc_hd__decap_12
XFILLER_0_114_703 VGND VGND VPWR VPWR sky130_ef_sc_hd__decap_12
XFILLER_0_7_249 VGND VGND VPWR VPWR sky130_ef_sc_hd__decap_12
XPHY_239 VGND VGND VPWR VPWR sky130_fd_sc_hd__decap_3
XPHY_228 VGND VGND VPWR VPWR sky130_fd_sc_hd__decap_3
XPHY_217 VGND VGND VPWR VPWR sky130_fd_sc_hd__decap_3
XFILLER_0_105_703 VGND VGND VPWR VPWR sky130_ef_sc_hd__decap_12
XPHY_206 VGND VGND VPWR VPWR sky130_fd_sc_hd__decap_3
XFILLER_0_94_715 VGND VGND VPWR VPWR sky130_ef_sc_hd__decap_12
XFILLER_0_105_769 VGND VGND VPWR VPWR sky130_ef_sc_hd__decap_12
XFILLER_0_7_783 VGND VGND VPWR VPWR sky130_fd_sc_hd__fill_1
XFILLER_0_85_715 VGND VGND VPWR VPWR sky130_ef_sc_hd__decap_12
XFILLER_0_93_781 VGND VGND VPWR VPWR sky130_ef_sc_hd__decap_12
XFILLER_0_5_709 VGND VGND VPWR VPWR sky130_ef_sc_hd__decap_12
XFILLER_0_111_739 VGND VGND VPWR VPWR sky130_ef_sc_hd__decap_12
XFILLER_0_76_715 VGND VGND VPWR VPWR sky130_ef_sc_hd__decap_12
XFILLER_0_0_89 VGND VGND VPWR VPWR sky130_fd_sc_hd__fill_1
XFILLER_0_110_783 VGND VGND VPWR VPWR sky130_fd_sc_hd__fill_1
XFILLER_0_67_715 VGND VGND VPWR VPWR sky130_ef_sc_hd__decap_12
XFILLER_0_82_729 VGND VGND VPWR VPWR sky130_ef_sc_hd__decap_12
XFILLER_0_75_781 VGND VGND VPWR VPWR sky130_ef_sc_hd__decap_12
XFILLER_0_58_715 VGND VGND VPWR VPWR sky130_ef_sc_hd__decap_12
XFILLER_0_81_751 VGND VGND VPWR VPWR sky130_fd_sc_hd__decap_4
XFILLER_0_5_517 VGND VGND VPWR VPWR sky130_ef_sc_hd__decap_12
XTAP_589 VGND VPWR sky130_fd_sc_hd__tapvpwrvgnd_1
XTAP_578 VGND VPWR sky130_fd_sc_hd__tapvpwrvgnd_1
XTAP_567 VGND VPWR sky130_fd_sc_hd__tapvpwrvgnd_1
XTAP_556 VGND VPWR sky130_fd_sc_hd__tapvpwrvgnd_1
XTAP_545 VGND VPWR sky130_fd_sc_hd__tapvpwrvgnd_1
XTAP_534 VGND VPWR sky130_fd_sc_hd__tapvpwrvgnd_1
XTAP_523 VGND VPWR sky130_fd_sc_hd__tapvpwrvgnd_1
XTAP_501 VGND VPWR sky130_fd_sc_hd__tapvpwrvgnd_1
XTAP_512 VGND VPWR sky130_fd_sc_hd__tapvpwrvgnd_1
XFILLER_0_49_715 VGND VGND VPWR VPWR sky130_ef_sc_hd__decap_12
XFILLER_0_64_729 VGND VGND VPWR VPWR sky130_ef_sc_hd__decap_12
XFILLER_0_57_781 VGND VGND VPWR VPWR sky130_ef_sc_hd__decap_12
XFILLER_0_8_333 VGND VGND VPWR VPWR sky130_fd_sc_hd__decap_3
XFILLER_0_8_377 VGND VGND VPWR VPWR sky130_ef_sc_hd__decap_12
XFILLER_0_63_751 VGND VGND VPWR VPWR sky130_fd_sc_hd__decap_4
XFILLER_0_46_729 VGND VGND VPWR VPWR sky130_ef_sc_hd__decap_12
XFILLER_0_39_781 VGND VGND VPWR VPWR sky130_ef_sc_hd__decap_12
XFILLER_0_1_553 VGND VGND VPWR VPWR sky130_fd_sc_hd__decap_6
XTAP_353 VGND VPWR sky130_fd_sc_hd__tapvpwrvgnd_1
XFILLER_0_1_597 VGND VGND VPWR VPWR sky130_ef_sc_hd__decap_12
XTAP_364 VGND VPWR sky130_fd_sc_hd__tapvpwrvgnd_1
XTAP_331 VGND VPWR sky130_fd_sc_hd__tapvpwrvgnd_1
XTAP_320 VGND VPWR sky130_fd_sc_hd__tapvpwrvgnd_1
XTAP_342 VGND VPWR sky130_fd_sc_hd__tapvpwrvgnd_1
XTAP_386 VGND VPWR sky130_fd_sc_hd__tapvpwrvgnd_1
XTAP_375 VGND VPWR sky130_fd_sc_hd__tapvpwrvgnd_1
XTAP_397 VGND VPWR sky130_fd_sc_hd__tapvpwrvgnd_1
XPHY_15 VGND VGND VPWR VPWR sky130_fd_sc_hd__decap_3
XPHY_26 VGND VGND VPWR VPWR sky130_fd_sc_hd__decap_3
XPHY_37 VGND VGND VPWR VPWR sky130_fd_sc_hd__decap_3
XPHY_48 VGND VGND VPWR VPWR sky130_fd_sc_hd__decap_3
XPHY_59 VGND VGND VPWR VPWR sky130_fd_sc_hd__decap_3
XFILLER_0_60_765 VGND VGND VPWR VPWR sky130_ef_sc_hd__decap_12
XFILLER_0_45_751 VGND VGND VPWR VPWR sky130_fd_sc_hd__decap_4
XFILLER_0_8_141 VGND VGND VPWR VPWR sky130_ef_sc_hd__decap_12
XFILLER_0_138_797 VGND VGND VPWR VPWR sky130_fd_sc_hd__decap_4
XFILLER_0_138_753 VGND VGND VPWR VPWR sky130_ef_sc_hd__decap_12
XFILLER_0_28_729 VGND VGND VPWR VPWR sky130_ef_sc_hd__decap_12
Xoutput109 net109 VGND VGND VPWR VPWR DO[30] sky130_fd_sc_hd__clkbuf_8
Xoutput91 net91 VGND VGND VPWR VPWR DO[14] sky130_fd_sc_hd__buf_4
XFILLER_0_42_765 VGND VGND VPWR VPWR sky130_ef_sc_hd__decap_12
XFILLER_0_5_111 VGND VGND VPWR VPWR sky130_fd_sc_hd__fill_1
XFILLER_0_6_601 VGND VGND VPWR VPWR sky130_ef_sc_hd__decap_12
XFILLER_0_6_645 VGND VGND VPWR VPWR sky130_ef_sc_hd__decap_12
XFILLER_0_27_751 VGND VGND VPWR VPWR sky130_fd_sc_hd__decap_4
XFILLER_0_1_361 VGND VGND VPWR VPWR sky130_ef_sc_hd__decap_12
XFILLER_0_135_745 VGND VGND VPWR VPWR sky130_fd_sc_hd__decap_8
XFILLER_0_150_737 VGND VGND VPWR VPWR sky130_ef_sc_hd__decap_12
XFILLER_0_150_715 VGND VGND VPWR VPWR sky130_fd_sc_hd__fill_2
XFILLER_0_141_715 VGND VGND VPWR VPWR sky130_ef_sc_hd__decap_12
XFILLER_0_3_615 VGND VGND VPWR VPWR sky130_fd_sc_hd__fill_1
XFILLER_0_24_765 VGND VGND VPWR VPWR sky130_ef_sc_hd__decap_12
XFILLER_0_3_45 VGND VGND VPWR VPWR sky130_fd_sc_hd__decap_8
XFILLER_0_132_715 VGND VGND VPWR VPWR sky130_ef_sc_hd__decap_12
XFILLER_0_6_475 VGND VGND VPWR VPWR sky130_fd_sc_hd__fill_1
XFILLER_0_2_681 VGND VGND VPWR VPWR sky130_ef_sc_hd__decap_12
XFILLER_0_97_757 VGND VGND VPWR VPWR sky130_ef_sc_hd__decap_12
XFILLER_0_123_715 VGND VGND VPWR VPWR sky130_ef_sc_hd__decap_12
XFILLER_0_131_781 VGND VGND VPWR VPWR sky130_ef_sc_hd__decap_12
XFILLER_0_21_757 VGND VGND VPWR VPWR sky130_ef_sc_hd__decap_12
XFILLER_0_7_217 VGND VGND VPWR VPWR sky130_fd_sc_hd__decap_6
XFILLER_0_8_729 VGND VGND VPWR VPWR sky130_ef_sc_hd__decap_12
XFILLER_0_114_715 VGND VGND VPWR VPWR sky130_ef_sc_hd__decap_12
XPHY_207 VGND VGND VPWR VPWR sky130_fd_sc_hd__decap_3
XFILLER_0_94_727 VGND VGND VPWR VPWR sky130_fd_sc_hd__fill_1
XFILLER_0_79_757 VGND VGND VPWR VPWR sky130_ef_sc_hd__decap_12
XPHY_229 VGND VGND VPWR VPWR sky130_fd_sc_hd__decap_3
XPHY_218 VGND VGND VPWR VPWR sky130_fd_sc_hd__decap_3
XFILLER_0_105_715 VGND VGND VPWR VPWR sky130_ef_sc_hd__decap_12
XFILLER_0_120_729 VGND VGND VPWR VPWR sky130_ef_sc_hd__decap_12
XFILLER_0_113_781 VGND VGND VPWR VPWR sky130_ef_sc_hd__decap_12
XFILLER_0_85_727 VGND VGND VPWR VPWR sky130_ef_sc_hd__decap_12
XFILLER_0_93_793 VGND VGND VPWR VPWR sky130_fd_sc_hd__decap_8
XFILLER_0_4_209 VGND VGND VPWR VPWR sky130_ef_sc_hd__decap_12
XFILLER_0_76_727 VGND VGND VPWR VPWR sky130_fd_sc_hd__fill_1
XFILLER_0_0_13 VGND VGND VPWR VPWR sky130_fd_sc_hd__fill_2
XFILLER_0_0_46 VGND VGND VPWR VPWR sky130_fd_sc_hd__decap_8
XFILLER_0_0_57 VGND VGND VPWR VPWR sky130_fd_sc_hd__decap_8
XFILLER_0_102_729 VGND VGND VPWR VPWR sky130_ef_sc_hd__decap_12
XFILLER_0_67_727 VGND VGND VPWR VPWR sky130_ef_sc_hd__decap_12
XFILLER_0_90_785 VGND VGND VPWR VPWR sky130_ef_sc_hd__decap_12
XFILLER_0_90_741 VGND VGND VPWR VPWR sky130_ef_sc_hd__decap_12
XFILLER_0_75_793 VGND VGND VPWR VPWR sky130_fd_sc_hd__decap_8
XFILLER_0_101_751 VGND VGND VPWR VPWR sky130_fd_sc_hd__decap_4
XFILLER_0_58_727 VGND VGND VPWR VPWR sky130_fd_sc_hd__fill_1
XFILLER_0_5_529 VGND VGND VPWR VPWR sky130_ef_sc_hd__decap_12
XTAP_579 VGND VPWR sky130_fd_sc_hd__tapvpwrvgnd_1
XTAP_568 VGND VPWR sky130_fd_sc_hd__tapvpwrvgnd_1
XTAP_557 VGND VPWR sky130_fd_sc_hd__tapvpwrvgnd_1
XTAP_546 VGND VPWR sky130_fd_sc_hd__tapvpwrvgnd_1
XTAP_535 VGND VPWR sky130_fd_sc_hd__tapvpwrvgnd_1
XTAP_524 VGND VPWR sky130_fd_sc_hd__tapvpwrvgnd_1
XFILLER_0_0_289 VGND VGND VPWR VPWR sky130_fd_sc_hd__fill_1
XTAP_502 VGND VPWR sky130_fd_sc_hd__tapvpwrvgnd_1
XTAP_513 VGND VPWR sky130_fd_sc_hd__tapvpwrvgnd_1
XFILLER_0_49_727 VGND VGND VPWR VPWR sky130_ef_sc_hd__decap_12
XFILLER_0_72_785 VGND VGND VPWR VPWR sky130_ef_sc_hd__decap_12
XFILLER_0_72_741 VGND VGND VPWR VPWR sky130_ef_sc_hd__decap_12
XFILLER_0_57_793 VGND VGND VPWR VPWR sky130_fd_sc_hd__decap_8
XFILLER_0_8_389 VGND VGND VPWR VPWR sky130_fd_sc_hd__decap_3
XFILLER_0_54_785 VGND VGND VPWR VPWR sky130_fd_sc_hd__decap_8
XFILLER_0_54_741 VGND VGND VPWR VPWR sky130_ef_sc_hd__decap_12
XFILLER_0_5_337 VGND VGND VPWR VPWR sky130_ef_sc_hd__decap_12
XFILLER_0_39_793 VGND VGND VPWR VPWR sky130_fd_sc_hd__decap_8
XTAP_332 VGND VPWR sky130_fd_sc_hd__tapvpwrvgnd_1
XTAP_321 VGND VPWR sky130_fd_sc_hd__tapvpwrvgnd_1
XFILLER_0_6_45 VGND VGND VPWR VPWR sky130_fd_sc_hd__fill_2
XTAP_365 VGND VPWR sky130_fd_sc_hd__tapvpwrvgnd_1
XTAP_343 VGND VPWR sky130_fd_sc_hd__tapvpwrvgnd_1
XTAP_354 VGND VPWR sky130_fd_sc_hd__tapvpwrvgnd_1
XTAP_387 VGND VPWR sky130_fd_sc_hd__tapvpwrvgnd_1
XTAP_376 VGND VPWR sky130_fd_sc_hd__tapvpwrvgnd_1
XTAP_398 VGND VPWR sky130_fd_sc_hd__tapvpwrvgnd_1
XPHY_16 VGND VGND VPWR VPWR sky130_fd_sc_hd__decap_3
XFILLER_0_8_153 VGND VGND VPWR VPWR sky130_ef_sc_hd__decap_12
XPHY_27 VGND VGND VPWR VPWR sky130_fd_sc_hd__decap_3
XPHY_38 VGND VGND VPWR VPWR sky130_fd_sc_hd__decap_3
XPHY_49 VGND VGND VPWR VPWR sky130_fd_sc_hd__decap_3
XFILLER_0_60_777 VGND VGND VPWR VPWR sky130_fd_sc_hd__decap_6
XFILLER_0_8_197 VGND VGND VPWR VPWR sky130_ef_sc_hd__decap_12
XFILLER_0_153_757 VGND VGND VPWR VPWR sky130_fd_sc_hd__fill_2
XFILLER_0_153_746 VGND VGND VPWR VPWR sky130_fd_sc_hd__fill_2
XFILLER_0_138_765 VGND VGND VPWR VPWR sky130_ef_sc_hd__decap_12
XFILLER_0_36_741 VGND VGND VPWR VPWR sky130_ef_sc_hd__decap_12
XFILLER_0_36_785 VGND VGND VPWR VPWR sky130_ef_sc_hd__decap_12
XFILLER_0_51_755 VGND VGND VPWR VPWR sky130_fd_sc_hd__fill_1
XFILLER_0_2_307 VGND VGND VPWR VPWR sky130_fd_sc_hd__fill_1
Xoutput92 net92 VGND VGND VPWR VPWR DO[15] sky130_fd_sc_hd__buf_4
XFILLER_0_42_777 VGND VGND VPWR VPWR sky130_fd_sc_hd__decap_6
XFILLER_0_5_167 VGND VGND VPWR VPWR sky130_fd_sc_hd__fill_1
XFILLER_0_6_613 VGND VGND VPWR VPWR sky130_ef_sc_hd__decap_12
XFILLER_0_6_657 VGND VGND VPWR VPWR sky130_ef_sc_hd__decap_12
XFILLER_0_1_373 VGND VGND VPWR VPWR sky130_ef_sc_hd__decap_12
XFILLER_0_135_757 VGND VGND VPWR VPWR sky130_ef_sc_hd__decap_12
XFILLER_0_18_741 VGND VGND VPWR VPWR sky130_ef_sc_hd__decap_12
XFILLER_0_18_785 VGND VGND VPWR VPWR sky130_ef_sc_hd__decap_12
XFILLER_0_150_749 VGND VGND VPWR VPWR sky130_ef_sc_hd__decap_12
XFILLER_0_33_755 VGND VGND VPWR VPWR sky130_fd_sc_hd__fill_1
XFILLER_0_141_727 VGND VGND VPWR VPWR sky130_ef_sc_hd__decap_12
XFILLER_0_24_777 VGND VGND VPWR VPWR sky130_fd_sc_hd__decap_6
XFILLER_0_3_57 VGND VGND VPWR VPWR sky130_ef_sc_hd__decap_12
XFILLER_0_117_757 VGND VGND VPWR VPWR sky130_ef_sc_hd__decap_12
XFILLER_0_6_421 VGND VGND VPWR VPWR sky130_ef_sc_hd__decap_12
XFILLER_0_132_727 VGND VGND VPWR VPWR sky130_fd_sc_hd__fill_1
XFILLER_0_2_693 VGND VGND VPWR VPWR sky130_fd_sc_hd__decap_6
XFILLER_0_15_755 VGND VGND VPWR VPWR sky130_fd_sc_hd__fill_1
XFILLER_0_30_703 VGND VGND VPWR VPWR sky130_ef_sc_hd__decap_12
XFILLER_0_97_703 VGND VGND VPWR VPWR sky130_ef_sc_hd__decap_12
XFILLER_0_1_181 VGND VGND VPWR VPWR sky130_ef_sc_hd__decap_12
XFILLER_0_97_769 VGND VGND VPWR VPWR sky130_ef_sc_hd__decap_12
XFILLER_0_123_727 VGND VGND VPWR VPWR sky130_ef_sc_hd__decap_12
XFILLER_0_21_703 VGND VGND VPWR VPWR sky130_ef_sc_hd__decap_12
XFILLER_0_131_793 VGND VGND VPWR VPWR sky130_fd_sc_hd__decap_8
XFILLER_0_0_608 VGND VGND VPWR VPWR sky130_fd_sc_hd__decap_8
XFILLER_0_21_769 VGND VGND VPWR VPWR sky130_ef_sc_hd__decap_12
XFILLER_0_88_703 VGND VGND VPWR VPWR sky130_ef_sc_hd__decap_12
XFILLER_0_114_727 VGND VGND VPWR VPWR sky130_fd_sc_hd__fill_1
XFILLER_0_12_703 VGND VGND VPWR VPWR sky130_ef_sc_hd__decap_12
XPHY_219 VGND VGND VPWR VPWR sky130_fd_sc_hd__decap_3
XPHY_208 VGND VGND VPWR VPWR sky130_fd_sc_hd__decap_3
XFILLER_0_79_769 VGND VGND VPWR VPWR sky130_ef_sc_hd__decap_12
XFILLER_0_79_703 VGND VGND VPWR VPWR sky130_ef_sc_hd__decap_12
XFILLER_0_105_727 VGND VGND VPWR VPWR sky130_ef_sc_hd__decap_12
XFILLER_0_6_251 VGND VGND VPWR VPWR sky130_fd_sc_hd__fill_1
XFILLER_0_7_741 VGND VGND VPWR VPWR sky130_ef_sc_hd__decap_12
XFILLER_0_7_785 VGND VGND VPWR VPWR sky130_ef_sc_hd__decap_12
XFILLER_0_113_793 VGND VGND VPWR VPWR sky130_fd_sc_hd__decap_8
XFILLER_0_85_739 VGND VGND VPWR VPWR sky130_ef_sc_hd__decap_12
XFILLER_0_0_427 VGND VGND VPWR VPWR sky130_ef_sc_hd__decap_12
XFILLER_0_0_449 VGND VGND VPWR VPWR sky130_ef_sc_hd__decap_12
XFILLER_0_84_783 VGND VGND VPWR VPWR sky130_fd_sc_hd__fill_1
XFILLER_0_8_505 VGND VGND VPWR VPWR sky130_ef_sc_hd__decap_12
XFILLER_0_110_785 VGND VGND VPWR VPWR sky130_ef_sc_hd__decap_12
XFILLER_0_110_741 VGND VGND VPWR VPWR sky130_ef_sc_hd__decap_12
XFILLER_0_4_755 VGND VGND VPWR VPWR sky130_fd_sc_hd__fill_1
XFILLER_0_67_739 VGND VGND VPWR VPWR sky130_ef_sc_hd__decap_12
XFILLER_0_90_797 VGND VGND VPWR VPWR sky130_fd_sc_hd__decap_4
XFILLER_0_90_753 VGND VGND VPWR VPWR sky130_ef_sc_hd__decap_12
XFILLER_0_66_783 VGND VGND VPWR VPWR sky130_fd_sc_hd__fill_1
XTAP_525 VGND VPWR sky130_fd_sc_hd__tapvpwrvgnd_1
XFILLER_0_0_279 VGND VGND VPWR VPWR sky130_fd_sc_hd__fill_1
XFILLER_0_0_246 VGND VGND VPWR VPWR sky130_fd_sc_hd__decap_6
XTAP_503 VGND VPWR sky130_fd_sc_hd__tapvpwrvgnd_1
XTAP_514 VGND VPWR sky130_fd_sc_hd__tapvpwrvgnd_1
XTAP_569 VGND VPWR sky130_fd_sc_hd__tapvpwrvgnd_1
XTAP_558 VGND VPWR sky130_fd_sc_hd__tapvpwrvgnd_1
XTAP_547 VGND VPWR sky130_fd_sc_hd__tapvpwrvgnd_1
XTAP_536 VGND VPWR sky130_fd_sc_hd__tapvpwrvgnd_1
XFILLER_0_49_739 VGND VGND VPWR VPWR sky130_ef_sc_hd__decap_12
XFILLER_0_72_797 VGND VGND VPWR VPWR sky130_fd_sc_hd__decap_4
XFILLER_0_72_753 VGND VGND VPWR VPWR sky130_ef_sc_hd__decap_12
XFILLER_0_48_783 VGND VGND VPWR VPWR sky130_fd_sc_hd__fill_1
XANTENNA_1 BEN[0] VGND VGND VPWR VPWR sky130_fd_sc_hd__diode_2
XFILLER_0_54_753 VGND VGND VPWR VPWR sky130_ef_sc_hd__decap_12
XFILLER_0_5_305 VGND VGND VPWR VPWR sky130_ef_sc_hd__decap_12
XFILLER_0_5_349 VGND VGND VPWR VPWR sky130_ef_sc_hd__decap_12
XTAP_366 VGND VPWR sky130_fd_sc_hd__tapvpwrvgnd_1
XTAP_333 VGND VPWR sky130_fd_sc_hd__tapvpwrvgnd_1
XTAP_322 VGND VPWR sky130_fd_sc_hd__tapvpwrvgnd_1
XTAP_344 VGND VPWR sky130_fd_sc_hd__tapvpwrvgnd_1
XTAP_355 VGND VPWR sky130_fd_sc_hd__tapvpwrvgnd_1
XFILLER_0_6_35 VGND VGND VPWR VPWR sky130_fd_sc_hd__fill_2
XFILLER_0_6_57 VGND VGND VPWR VPWR sky130_fd_sc_hd__fill_2
XTAP_388 VGND VPWR sky130_fd_sc_hd__tapvpwrvgnd_1
XTAP_377 VGND VPWR sky130_fd_sc_hd__tapvpwrvgnd_1
XTAP_399 VGND VPWR sky130_fd_sc_hd__tapvpwrvgnd_1
XPHY_17 VGND VGND VPWR VPWR sky130_fd_sc_hd__decap_3
XPHY_28 VGND VGND VPWR VPWR sky130_fd_sc_hd__decap_3
XFILLER_0_147_755 VGND VGND VPWR VPWR sky130_fd_sc_hd__fill_1
XFILLER_0_147_711 VGND VGND VPWR VPWR sky130_ef_sc_hd__decap_12
XFILLER_0_8_165 VGND VGND VPWR VPWR sky130_fd_sc_hd__decap_3
XPHY_39 VGND VGND VPWR VPWR sky130_fd_sc_hd__decap_3
XFILLER_0_153_769 VGND VGND VPWR VPWR sky130_fd_sc_hd__fill_2
XFILLER_0_138_777 VGND VGND VPWR VPWR sky130_fd_sc_hd__decap_6
XFILLER_0_36_753 VGND VGND VPWR VPWR sky130_ef_sc_hd__decap_12
XFILLER_0_36_797 VGND VGND VPWR VPWR sky130_fd_sc_hd__decap_4
Xoutput93 net93 VGND VGND VPWR VPWR DO[16] sky130_fd_sc_hd__buf_4
XFILLER_0_144_703 VGND VGND VPWR VPWR sky130_ef_sc_hd__decap_12
XFILLER_0_129_755 VGND VGND VPWR VPWR sky130_fd_sc_hd__fill_1
XFILLER_0_6_625 VGND VGND VPWR VPWR sky130_ef_sc_hd__decap_12
XFILLER_0_5_113 VGND VGND VPWR VPWR sky130_ef_sc_hd__decap_12
XFILLER_0_6_669 VGND VGND VPWR VPWR sky130_ef_sc_hd__decap_12
XFILLER_0_1_385 VGND VGND VPWR VPWR sky130_fd_sc_hd__decap_6
XFILLER_0_135_769 VGND VGND VPWR VPWR sky130_ef_sc_hd__decap_12
XFILLER_0_18_753 VGND VGND VPWR VPWR sky130_ef_sc_hd__decap_12
XFILLER_0_18_797 VGND VGND VPWR VPWR sky130_fd_sc_hd__decap_4
XFILLER_0_126_703 VGND VGND VPWR VPWR sky130_ef_sc_hd__decap_12
XFILLER_0_141_739 VGND VGND VPWR VPWR sky130_ef_sc_hd__decap_12
XFILLER_0_3_617 VGND VGND VPWR VPWR sky130_ef_sc_hd__decap_12
XFILLER_0_3_25 VGND VGND VPWR VPWR sky130_fd_sc_hd__fill_2
XFILLER_0_3_69 VGND VGND VPWR VPWR sky130_ef_sc_hd__decap_12
XFILLER_0_117_769 VGND VGND VPWR VPWR sky130_ef_sc_hd__decap_12
XFILLER_0_117_703 VGND VGND VPWR VPWR sky130_ef_sc_hd__decap_12
XFILLER_0_6_433 VGND VGND VPWR VPWR sky130_ef_sc_hd__decap_12
XFILLER_0_6_477 VGND VGND VPWR VPWR sky130_ef_sc_hd__decap_12
XFILLER_0_140_783 VGND VGND VPWR VPWR sky130_fd_sc_hd__fill_1
XFILLER_0_1_193 VGND VGND VPWR VPWR sky130_ef_sc_hd__decap_12
XFILLER_0_30_715 VGND VGND VPWR VPWR sky130_ef_sc_hd__decap_12
XFILLER_0_97_715 VGND VGND VPWR VPWR sky130_ef_sc_hd__decap_12
XFILLER_0_108_703 VGND VGND VPWR VPWR sky130_ef_sc_hd__decap_12
XFILLER_0_123_739 VGND VGND VPWR VPWR sky130_ef_sc_hd__decap_12
XFILLER_0_21_715 VGND VGND VPWR VPWR sky130_ef_sc_hd__decap_12
XFILLER_0_88_715 VGND VGND VPWR VPWR sky130_ef_sc_hd__decap_12
XFILLER_0_122_783 VGND VGND VPWR VPWR sky130_fd_sc_hd__fill_1
XFILLER_0_3_447 VGND VGND VPWR VPWR sky130_fd_sc_hd__fill_1
XFILLER_0_12_715 VGND VGND VPWR VPWR sky130_ef_sc_hd__decap_12
XFILLER_0_79_715 VGND VGND VPWR VPWR sky130_ef_sc_hd__decap_12
XPHY_209 VGND VGND VPWR VPWR sky130_fd_sc_hd__decap_3
XFILLER_0_94_729 VGND VGND VPWR VPWR sky130_ef_sc_hd__decap_12
XFILLER_0_87_781 VGND VGND VPWR VPWR sky130_ef_sc_hd__decap_12
XFILLER_0_105_739 VGND VGND VPWR VPWR sky130_ef_sc_hd__decap_12
XFILLER_0_7_753 VGND VGND VPWR VPWR sky130_ef_sc_hd__decap_12
XFILLER_0_7_797 VGND VGND VPWR VPWR sky130_fd_sc_hd__decap_4
XFILLER_0_11_781 VGND VGND VPWR VPWR sky130_ef_sc_hd__decap_12
XFILLER_0_93_751 VGND VGND VPWR VPWR sky130_fd_sc_hd__decap_4
XFILLER_0_104_783 VGND VGND VPWR VPWR sky130_fd_sc_hd__fill_1
XFILLER_0_0_439 VGND VGND VPWR VPWR sky130_fd_sc_hd__fill_1
XFILLER_0_76_729 VGND VGND VPWR VPWR sky130_ef_sc_hd__decap_12
XFILLER_0_69_781 VGND VGND VPWR VPWR sky130_ef_sc_hd__decap_12
XFILLER_0_0_37 VGND VGND VPWR VPWR sky130_fd_sc_hd__decap_3
XFILLER_0_8_517 VGND VGND VPWR VPWR sky130_ef_sc_hd__decap_12
XFILLER_0_4_701 VGND VGND VPWR VPWR sky130_ef_sc_hd__decap_12
XFILLER_0_110_797 VGND VGND VPWR VPWR sky130_fd_sc_hd__decap_4
XFILLER_0_110_753 VGND VGND VPWR VPWR sky130_ef_sc_hd__decap_12
XFILLER_0_75_751 VGND VGND VPWR VPWR sky130_fd_sc_hd__decap_4
XFILLER_0_90_765 VGND VGND VPWR VPWR sky130_ef_sc_hd__decap_12
XFILLER_0_7_561 VGND VGND VPWR VPWR sky130_ef_sc_hd__decap_12
XFILLER_0_58_729 VGND VGND VPWR VPWR sky130_ef_sc_hd__decap_12
XTAP_548 VGND VPWR sky130_fd_sc_hd__tapvpwrvgnd_1
XTAP_537 VGND VPWR sky130_fd_sc_hd__tapvpwrvgnd_1
XTAP_526 VGND VPWR sky130_fd_sc_hd__tapvpwrvgnd_1
XFILLER_0_0_225 VGND VGND VPWR VPWR sky130_ef_sc_hd__decap_12
XTAP_504 VGND VPWR sky130_fd_sc_hd__tapvpwrvgnd_1
XTAP_515 VGND VPWR sky130_fd_sc_hd__tapvpwrvgnd_1
XTAP_559 VGND VPWR sky130_fd_sc_hd__tapvpwrvgnd_1
XFILLER_0_57_751 VGND VGND VPWR VPWR sky130_fd_sc_hd__decap_4
XFILLER_0_72_765 VGND VGND VPWR VPWR sky130_ef_sc_hd__decap_12
XFILLER_0_4_531 VGND VGND VPWR VPWR sky130_fd_sc_hd__fill_1
XFILLER_0_7_391 VGND VGND VPWR VPWR sky130_fd_sc_hd__fill_1
XFILLER_0_39_751 VGND VGND VPWR VPWR sky130_fd_sc_hd__decap_4
XANTENNA_2 BEN[10] VGND VGND VPWR VPWR sky130_fd_sc_hd__diode_2
XFILLER_0_54_765 VGND VGND VPWR VPWR sky130_ef_sc_hd__decap_12
XFILLER_0_5_317 VGND VGND VPWR VPWR sky130_ef_sc_hd__decap_12
XTAP_367 VGND VPWR sky130_fd_sc_hd__tapvpwrvgnd_1
XTAP_334 VGND VPWR sky130_fd_sc_hd__tapvpwrvgnd_1
XTAP_323 VGND VPWR sky130_fd_sc_hd__tapvpwrvgnd_1
XTAP_345 VGND VPWR sky130_fd_sc_hd__tapvpwrvgnd_1
XTAP_312 VGND VPWR sky130_fd_sc_hd__tapvpwrvgnd_1
XTAP_356 VGND VPWR sky130_fd_sc_hd__tapvpwrvgnd_1
XTAP_389 VGND VPWR sky130_fd_sc_hd__tapvpwrvgnd_1
XTAP_378 VGND VPWR sky130_fd_sc_hd__tapvpwrvgnd_1
XPHY_18 VGND VGND VPWR VPWR sky130_fd_sc_hd__decap_3
XPHY_29 VGND VGND VPWR VPWR sky130_fd_sc_hd__decap_3
XFILLER_0_147_723 VGND VGND VPWR VPWR sky130_ef_sc_hd__decap_12
XFILLER_0_51_757 VGND VGND VPWR VPWR sky130_ef_sc_hd__decap_12
XFILLER_0_2_309 VGND VGND VPWR VPWR sky130_ef_sc_hd__decap_12
XFILLER_0_36_765 VGND VGND VPWR VPWR sky130_ef_sc_hd__decap_12
Xoutput94 net94 VGND VGND VPWR VPWR DO[17] sky130_fd_sc_hd__buf_4
XFILLER_0_144_715 VGND VGND VPWR VPWR sky130_ef_sc_hd__decap_12
XFILLER_0_5_125 VGND VGND VPWR VPWR sky130_ef_sc_hd__decap_12
XFILLER_0_6_637 VGND VGND VPWR VPWR sky130_fd_sc_hd__decap_6
XFILLER_0_5_169 VGND VGND VPWR VPWR sky130_ef_sc_hd__decap_12
XFILLER_0_143_781 VGND VGND VPWR VPWR sky130_ef_sc_hd__decap_12
XFILLER_0_18_765 VGND VGND VPWR VPWR sky130_ef_sc_hd__decap_12
XFILLER_0_33_757 VGND VGND VPWR VPWR sky130_ef_sc_hd__decap_12
XFILLER_0_126_715 VGND VGND VPWR VPWR sky130_ef_sc_hd__decap_12
XFILLER_0_2_139 VGND VGND VPWR VPWR sky130_fd_sc_hd__fill_1
XFILLER_0_3_629 VGND VGND VPWR VPWR sky130_ef_sc_hd__decap_12
XFILLER_0_3_15 VGND VGND VPWR VPWR sky130_fd_sc_hd__fill_2
XFILLER_0_3_37 VGND VGND VPWR VPWR sky130_fd_sc_hd__fill_2
XFILLER_0_132_729 VGND VGND VPWR VPWR sky130_ef_sc_hd__decap_12
XFILLER_0_125_781 VGND VGND VPWR VPWR sky130_ef_sc_hd__decap_12
XFILLER_0_117_715 VGND VGND VPWR VPWR sky130_ef_sc_hd__decap_12
XFILLER_0_6_401 VGND VGND VPWR VPWR sky130_ef_sc_hd__decap_12
XFILLER_0_6_445 VGND VGND VPWR VPWR sky130_ef_sc_hd__decap_12
XFILLER_0_6_489 VGND VGND VPWR VPWR sky130_ef_sc_hd__decap_12
XFILLER_0_15_757 VGND VGND VPWR VPWR sky130_ef_sc_hd__decap_12
XFILLER_0_1_161 VGND VGND VPWR VPWR sky130_fd_sc_hd__decap_6
XFILLER_0_30_727 VGND VGND VPWR VPWR sky130_fd_sc_hd__fill_1
XFILLER_0_97_727 VGND VGND VPWR VPWR sky130_ef_sc_hd__decap_12
XFILLER_0_108_715 VGND VGND VPWR VPWR sky130_ef_sc_hd__decap_12
XFILLER_0_131_751 VGND VGND VPWR VPWR sky130_fd_sc_hd__decap_4
XFILLER_0_21_727 VGND VGND VPWR VPWR sky130_ef_sc_hd__decap_12
XFILLER_0_88_727 VGND VGND VPWR VPWR sky130_fd_sc_hd__fill_1
XFILLER_0_114_729 VGND VGND VPWR VPWR sky130_ef_sc_hd__decap_12
XFILLER_0_107_781 VGND VGND VPWR VPWR sky130_ef_sc_hd__decap_12
XFILLER_0_12_727 VGND VGND VPWR VPWR sky130_fd_sc_hd__fill_1
XFILLER_0_79_727 VGND VGND VPWR VPWR sky130_ef_sc_hd__decap_12
XFILLER_0_87_793 VGND VGND VPWR VPWR sky130_fd_sc_hd__decap_8
XFILLER_0_7_721 VGND VGND VPWR VPWR sky130_fd_sc_hd__decap_6
XFILLER_0_113_751 VGND VGND VPWR VPWR sky130_fd_sc_hd__decap_4
XFILLER_0_6_253 VGND VGND VPWR VPWR sky130_ef_sc_hd__decap_12
XFILLER_0_7_765 VGND VGND VPWR VPWR sky130_ef_sc_hd__decap_12
XFILLER_0_11_793 VGND VGND VPWR VPWR sky130_fd_sc_hd__decap_8
XFILLER_0_84_741 VGND VGND VPWR VPWR sky130_ef_sc_hd__decap_12
XFILLER_0_69_793 VGND VGND VPWR VPWR sky130_fd_sc_hd__decap_8
XFILLER_0_8_529 VGND VGND VPWR VPWR sky130_fd_sc_hd__decap_3
XFILLER_0_84_785 VGND VGND VPWR VPWR sky130_ef_sc_hd__decap_12
XFILLER_0_3_223 VGND VGND VPWR VPWR sky130_fd_sc_hd__fill_1
XFILLER_0_4_713 VGND VGND VPWR VPWR sky130_ef_sc_hd__decap_12
XFILLER_0_4_757 VGND VGND VPWR VPWR sky130_ef_sc_hd__decap_12
XFILLER_0_110_765 VGND VGND VPWR VPWR sky130_ef_sc_hd__decap_12
XFILLER_0_90_777 VGND VGND VPWR VPWR sky130_fd_sc_hd__decap_6
XFILLER_0_7_573 VGND VGND VPWR VPWR sky130_ef_sc_hd__decap_12
XFILLER_0_66_741 VGND VGND VPWR VPWR sky130_ef_sc_hd__decap_12
XFILLER_0_81_755 VGND VGND VPWR VPWR sky130_fd_sc_hd__fill_1
XFILLER_0_66_785 VGND VGND VPWR VPWR sky130_ef_sc_hd__decap_12
XFILLER_0_1_727 VGND VGND VPWR VPWR sky130_fd_sc_hd__fill_1
XTAP_549 VGND VPWR sky130_fd_sc_hd__tapvpwrvgnd_1
XTAP_538 VGND VPWR sky130_fd_sc_hd__tapvpwrvgnd_1
XTAP_527 VGND VPWR sky130_fd_sc_hd__tapvpwrvgnd_1
XTAP_516 VGND VPWR sky130_fd_sc_hd__tapvpwrvgnd_1
XFILLER_0_0_237 VGND VGND VPWR VPWR sky130_fd_sc_hd__decap_3
XTAP_505 VGND VPWR sky130_fd_sc_hd__tapvpwrvgnd_1
XFILLER_0_8_337 VGND VGND VPWR VPWR sky130_ef_sc_hd__decap_12
XFILLER_0_72_777 VGND VGND VPWR VPWR sky130_fd_sc_hd__decap_6
XFILLER_0_4_587 VGND VGND VPWR VPWR sky130_fd_sc_hd__fill_1
XFILLER_0_0_771 VGND VGND VPWR VPWR sky130_ef_sc_hd__decap_12
XFILLER_0_48_741 VGND VGND VPWR VPWR sky130_ef_sc_hd__decap_12
XFILLER_0_1_81 VGND VGND VPWR VPWR sky130_ef_sc_hd__decap_12
XFILLER_0_63_755 VGND VGND VPWR VPWR sky130_fd_sc_hd__fill_1
XFILLER_0_48_785 VGND VGND VPWR VPWR sky130_ef_sc_hd__decap_12
XFILLER_0_5_329 VGND VGND VPWR VPWR sky130_fd_sc_hd__decap_6
XANTENNA_3 BEN[11] VGND VGND VPWR VPWR sky130_fd_sc_hd__diode_2
XFILLER_0_54_777 VGND VGND VPWR VPWR sky130_fd_sc_hd__decap_6
XTAP_335 VGND VPWR sky130_fd_sc_hd__tapvpwrvgnd_1
XTAP_346 VGND VPWR sky130_fd_sc_hd__tapvpwrvgnd_1
XTAP_324 VGND VPWR sky130_fd_sc_hd__tapvpwrvgnd_1
XTAP_313 VGND VPWR sky130_fd_sc_hd__tapvpwrvgnd_1
XTAP_357 VGND VPWR sky130_fd_sc_hd__tapvpwrvgnd_1
XTAP_368 VGND VPWR sky130_fd_sc_hd__tapvpwrvgnd_1
XTAP_379 VGND VPWR sky130_fd_sc_hd__tapvpwrvgnd_1
XFILLER_0_147_735 VGND VGND VPWR VPWR sky130_ef_sc_hd__decap_12
XPHY_19 VGND VGND VPWR VPWR sky130_fd_sc_hd__decap_3
XFILLER_0_147_757 VGND VGND VPWR VPWR sky130_ef_sc_hd__decap_12
XFILLER_0_60_703 VGND VGND VPWR VPWR sky130_ef_sc_hd__decap_12
XFILLER_0_45_755 VGND VGND VPWR VPWR sky130_fd_sc_hd__fill_1
XFILLER_0_51_769 VGND VGND VPWR VPWR sky130_ef_sc_hd__decap_12
XFILLER_0_51_703 VGND VGND VPWR VPWR sky130_ef_sc_hd__decap_12
XFILLER_0_36_777 VGND VGND VPWR VPWR sky130_fd_sc_hd__decap_6
Xoutput95 net95 VGND VGND VPWR VPWR DO[18] sky130_fd_sc_hd__buf_4
XFILLER_0_144_727 VGND VGND VPWR VPWR sky130_fd_sc_hd__fill_1
XFILLER_0_129_757 VGND VGND VPWR VPWR sky130_ef_sc_hd__decap_12
XPHY_190 VGND VGND VPWR VPWR sky130_fd_sc_hd__decap_3
XFILLER_0_5_137 VGND VGND VPWR VPWR sky130_ef_sc_hd__decap_12
XFILLER_0_27_755 VGND VGND VPWR VPWR sky130_fd_sc_hd__fill_1
XFILLER_0_42_703 VGND VGND VPWR VPWR sky130_ef_sc_hd__decap_12
XFILLER_0_152_771 VGND VGND VPWR VPWR sky130_ef_sc_hd__decap_12
XFILLER_0_150_719 VGND VGND VPWR VPWR sky130_fd_sc_hd__fill_2
XFILLER_0_143_793 VGND VGND VPWR VPWR sky130_fd_sc_hd__decap_8
XFILLER_0_5_671 VGND VGND VPWR VPWR sky130_fd_sc_hd__fill_1
XFILLER_0_18_777 VGND VGND VPWR VPWR sky130_fd_sc_hd__decap_6
XFILLER_0_33_703 VGND VGND VPWR VPWR sky130_ef_sc_hd__decap_12
XFILLER_0_33_769 VGND VGND VPWR VPWR sky130_ef_sc_hd__decap_12
XFILLER_0_126_727 VGND VGND VPWR VPWR sky130_fd_sc_hd__fill_1
XFILLER_0_24_703 VGND VGND VPWR VPWR sky130_ef_sc_hd__decap_12
XFILLER_0_134_793 VGND VGND VPWR VPWR sky130_fd_sc_hd__fill_2
XFILLER_0_117_727 VGND VGND VPWR VPWR sky130_ef_sc_hd__decap_12
XFILLER_0_140_741 VGND VGND VPWR VPWR sky130_ef_sc_hd__decap_12
XFILLER_0_125_793 VGND VGND VPWR VPWR sky130_fd_sc_hd__decap_8
XFILLER_0_6_413 VGND VGND VPWR VPWR sky130_fd_sc_hd__decap_6
XFILLER_0_6_457 VGND VGND VPWR VPWR sky130_ef_sc_hd__decap_12
XFILLER_0_15_703 VGND VGND VPWR VPWR sky130_ef_sc_hd__decap_12
XFILLER_0_15_769 VGND VGND VPWR VPWR sky130_ef_sc_hd__decap_12
XFILLER_0_140_785 VGND VGND VPWR VPWR sky130_ef_sc_hd__decap_12
XFILLER_0_97_739 VGND VGND VPWR VPWR sky130_ef_sc_hd__decap_12
XFILLER_0_108_727 VGND VGND VPWR VPWR sky130_fd_sc_hd__fill_1
XFILLER_0_21_739 VGND VGND VPWR VPWR sky130_ef_sc_hd__decap_12
XFILLER_0_96_783 VGND VGND VPWR VPWR sky130_fd_sc_hd__fill_1
XFILLER_0_122_741 VGND VGND VPWR VPWR sky130_ef_sc_hd__decap_12
XFILLER_0_107_793 VGND VGND VPWR VPWR sky130_fd_sc_hd__decap_8
XFILLER_0_3_405 VGND VGND VPWR VPWR sky130_ef_sc_hd__decap_12
XFILLER_0_3_449 VGND VGND VPWR VPWR sky130_ef_sc_hd__decap_12
XFILLER_0_122_785 VGND VGND VPWR VPWR sky130_ef_sc_hd__decap_12
XFILLER_0_20_783 VGND VGND VPWR VPWR sky130_fd_sc_hd__fill_1
XFILLER_0_79_739 VGND VGND VPWR VPWR sky130_ef_sc_hd__decap_12
XFILLER_0_6_221 VGND VGND VPWR VPWR sky130_ef_sc_hd__decap_12
XFILLER_0_7_777 VGND VGND VPWR VPWR sky130_fd_sc_hd__decap_6
XFILLER_0_6_265 VGND VGND VPWR VPWR sky130_ef_sc_hd__decap_12
XFILLER_0_78_783 VGND VGND VPWR VPWR sky130_fd_sc_hd__fill_1
XFILLER_0_104_741 VGND VGND VPWR VPWR sky130_ef_sc_hd__decap_12
XFILLER_0_104_785 VGND VGND VPWR VPWR sky130_ef_sc_hd__decap_12
XFILLER_0_0_419 VGND VGND VPWR VPWR sky130_fd_sc_hd__fill_1
XFILLER_0_84_797 VGND VGND VPWR VPWR sky130_fd_sc_hd__decap_4
XFILLER_0_84_753 VGND VGND VPWR VPWR sky130_ef_sc_hd__decap_12
XFILLER_0_3_279 VGND VGND VPWR VPWR sky130_fd_sc_hd__fill_1
XFILLER_0_4_725 VGND VGND VPWR VPWR sky130_ef_sc_hd__decap_12
XFILLER_0_4_769 VGND VGND VPWR VPWR sky130_ef_sc_hd__decap_12
XFILLER_0_110_777 VGND VGND VPWR VPWR sky130_fd_sc_hd__decap_6
XFILLER_0_7_541 VGND VGND VPWR VPWR sky130_ef_sc_hd__decap_12
XFILLER_0_7_585 VGND VGND VPWR VPWR sky130_ef_sc_hd__decap_12
XFILLER_0_101_755 VGND VGND VPWR VPWR sky130_fd_sc_hd__fill_1
XFILLER_0_66_797 VGND VGND VPWR VPWR sky130_fd_sc_hd__decap_4
XFILLER_0_66_753 VGND VGND VPWR VPWR sky130_ef_sc_hd__decap_12
XTAP_539 VGND VPWR sky130_fd_sc_hd__tapvpwrvgnd_1
XTAP_528 VGND VPWR sky130_fd_sc_hd__tapvpwrvgnd_1
XTAP_517 VGND VPWR sky130_fd_sc_hd__tapvpwrvgnd_1
XTAP_506 VGND VPWR sky130_fd_sc_hd__tapvpwrvgnd_1
XFILLER_0_4_533 VGND VGND VPWR VPWR sky130_ef_sc_hd__decap_12
XFILLER_0_8_305 VGND VGND VPWR VPWR sky130_fd_sc_hd__decap_3
XFILLER_0_8_349 VGND VGND VPWR VPWR sky130_ef_sc_hd__decap_12
XFILLER_0_0_783 VGND VGND VPWR VPWR sky130_fd_sc_hd__fill_1
XFILLER_0_48_797 VGND VGND VPWR VPWR sky130_fd_sc_hd__decap_4
XFILLER_0_48_753 VGND VGND VPWR VPWR sky130_ef_sc_hd__decap_12
XFILLER_0_1_93 VGND VGND VPWR VPWR sky130_ef_sc_hd__decap_12
XFILLER_0_7_393 VGND VGND VPWR VPWR sky130_ef_sc_hd__decap_12
XANTENNA_4 BEN[12] VGND VGND VPWR VPWR sky130_fd_sc_hd__diode_2
XFILLER_0_1_503 VGND VGND VPWR VPWR sky130_fd_sc_hd__fill_1
XTAP_314 VGND VPWR sky130_fd_sc_hd__tapvpwrvgnd_1
XFILLER_0_6_27 VGND VGND VPWR VPWR sky130_fd_sc_hd__fill_1
XFILLER_0_6_49 VGND VGND VPWR VPWR sky130_fd_sc_hd__fill_2
XTAP_336 VGND VPWR sky130_fd_sc_hd__tapvpwrvgnd_1
XTAP_347 VGND VPWR sky130_fd_sc_hd__tapvpwrvgnd_1
XTAP_325 VGND VPWR sky130_fd_sc_hd__tapvpwrvgnd_1
XTAP_358 VGND VPWR sky130_fd_sc_hd__tapvpwrvgnd_1
XTAP_369 VGND VPWR sky130_fd_sc_hd__tapvpwrvgnd_1
XFILLER_0_147_769 VGND VGND VPWR VPWR sky130_ef_sc_hd__decap_12
XFILLER_0_147_747 VGND VGND VPWR VPWR sky130_fd_sc_hd__decap_8
XFILLER_0_147_703 VGND VGND VPWR VPWR sky130_fd_sc_hd__fill_2
XFILLER_0_8_113 VGND VGND VPWR VPWR sky130_ef_sc_hd__decap_12
XFILLER_0_60_715 VGND VGND VPWR VPWR sky130_ef_sc_hd__decap_12
XFILLER_0_4_363 VGND VGND VPWR VPWR sky130_fd_sc_hd__fill_1
XFILLER_0_138_703 VGND VGND VPWR VPWR sky130_ef_sc_hd__decap_12
XFILLER_0_51_715 VGND VGND VPWR VPWR sky130_ef_sc_hd__decap_12
Xoutput96 net96 VGND VGND VPWR VPWR DO[19] sky130_fd_sc_hd__buf_4
XFILLER_0_129_769 VGND VGND VPWR VPWR sky130_ef_sc_hd__decap_12
XFILLER_0_129_703 VGND VGND VPWR VPWR sky130_ef_sc_hd__decap_12
XFILLER_0_152_783 VGND VGND VPWR VPWR sky130_fd_sc_hd__fill_1
XPHY_191 VGND VGND VPWR VPWR sky130_fd_sc_hd__decap_3
XPHY_180 VGND VGND VPWR VPWR sky130_fd_sc_hd__decap_3
XFILLER_0_5_105 VGND VGND VPWR VPWR sky130_fd_sc_hd__decap_6
XFILLER_0_5_149 VGND VGND VPWR VPWR sky130_ef_sc_hd__decap_12
XFILLER_0_42_715 VGND VGND VPWR VPWR sky130_ef_sc_hd__decap_12
.ends
